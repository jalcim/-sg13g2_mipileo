* ESD bench IOVss_seul_pdk_HBM_P_vs_vss : HBM + on iovss vs vss
* generated by gen_decks.py -- corner tt/typ, 25 C, unpowered (supplies floating)
.param vz=1
.lib /home/lsaintecluque/IHP-Open-PDK/ihp-sg13g2/libs.tech/ngspice/models/cornerMOShv.lib mos_tt
.lib /home/lsaintecluque/IHP-Open-PDK/ihp-sg13g2/libs.tech/ngspice/models/cornerMOSlv.lib mos_tt
.lib /home/lsaintecluque/IHP-Open-PDK/ihp-sg13g2/libs.tech/ngspice/models/cornerRES.lib res_typ
.lib /home/lsaintecluque/IHP-Open-PDK/ihp-sg13g2/libs.tech/ngspice/models/cornerDIO.lib dio_tt
.include /home/lsaintecluque/LAYOUT/mipi-analog/2_analog/CSI2_DPHY_RING/COLLATERALS/signoff/esd_bench/io_probe_pdk.spice
.global sub!
.temp 25
.options reltol=1e-3 abstol=1e-9 vntol=1e-5 itl4=200
xiovss vdd vss iovdd iovss sg13g2_IOPadIOVss
Rleak_vdd vdd 0 1G
Rleak_iovdd iovdd 0 1G
Rleak_iovss iovss 0 1G
Rleak_sub sub! 0 1G
Vstep hv 0 PWL(0 0 10p {vz})
Cs hv c1 100p
Ls c1 n1 2.5u
Rs n1 iovss 1500
Vref vss 0 0
.control
pre_osdi /home/lsaintecluque/IHP-Open-PDK/ihp-sg13g2/libs.tech/ngspice/osdi/psp103.osdi
pre_osdi /home/lsaintecluque/IHP-Open-PDK/ihp-sg13g2/libs.tech/ngspice/osdi/r3_cmc.osdi
foreach lvl 2000
  alterparam vz=$lvl
  reset
  tran 0.05n 400n 0 0.5n
  let vpair = vecmax(abs(v(iovss)-v(vss)))
  let vio = vecmax(abs(v(iovdd)-v(iovss)))
  let vgnd = vecmax(abs(v(iovss)-v(vss)))
  let viovss = vecmax(abs(v(iovdd)-v(vss)))
  let izap = vecmax(abs(i(Ls)))
  let tend = time[length(time)-1]
  let Idcp_iovss = vecmax(abs(v.xiovss.xi2.vsp#branch))
  let Idcn_iovss = vecmax(abs(v.xiovss.xi3.vsn#branch))
  echo RES IOVss seul pdk HBM iovss vss $lvl tend=$&tend vpair=$&vpair vio=$&vio vgnd=$&vgnd viovss=$&viovss izap=$&izap Idcp_iovss=$&Idcp_iovss Idcn_iovss=$&Idcn_iovss
end
quit
.endc
.end
