* cml_to_cmos_pex -- cml_to_cmos POST-LAYOUT : extrait Magic MAG/cml_to_cmos_pex_raw.spice (md5 c08238dd117a8ca816f8c6fbb9a2d14b)
* enveloppe par shared/magic/pex_wrap.tcl aux bornes de la livrable COLLATERALS/SPICE/cml_to_cmos.spice (md5 0dec5e85f985706f003c37e045cb63a0) ;
* sous-circuit du layout cml_to_cmos_yg renomme cml_to_cmos_routed ; bornes appariees par nom : VDD VSS INN INP Y
* noeuds flottants (capacites seules) ramenes a VSS dans cml_to_cmos_routed : a_364_2912#
* --- extrait Magic, verbatim (cml_to_cmos_yg -> cml_to_cmos_routed) ---
* NGSPICE file created from cml_to_cmos_yg.ext - technology: ihp-sg13g2

.subckt cml_to_cmos_routed VDD VSS INN INP Y
X0 VDD D0 D0 VDD sg13_lv_pmos ad=0.38p pd=2.38u as=0.38p ps=2.38u w=2u l=0.13u
X1 D G_uq1 VDD VDD sg13_lv_pmos ad=0.85p pd=5.68u as=0.85p ps=5.68u w=2.5u l=0.13u
X2 VSS D Y VSS sg13_lv_nmos ad=0.34p pd=2.68u as=0.34p ps=2.68u w=1u l=0.13u
X3 G_uq1 D0 VDD VDD sg13_lv_pmos ad=0.38p pd=2.38u as=0.38p ps=2.38u w=2u l=0.13u
X4 VDD D0 G_uq1 VDD sg13_lv_pmos ad=0.38p pd=2.38u as=0.38p ps=2.38u w=2u l=0.13u
X5 D0 INP R1 VSS sg13_lv_nmos ad=0.304p pd=1.98u as=0.304p ps=1.98u w=1.6u l=0.13u
X6 D0 INP R1 VSS sg13_lv_nmos ad=0.544p pd=3.88u as=0.304p ps=1.98u w=1.6u l=0.13u
X7 VDD D0 D0 VDD sg13_lv_pmos ad=0.38p pd=2.38u as=0.38p ps=2.38u w=2u l=0.13u
X8 D0 D0 VDD VDD sg13_lv_pmos ad=0.68p pd=4.68u as=0.38p ps=2.38u w=2u l=0.13u
X9 Y D VDD VDD sg13_lv_pmos ad=0.68p pd=4.68u as=0.68p ps=4.68u w=2u l=0.13u
X10 VSS R1 VSS rppd l=4.86u w=1u
X11 VDD D0 G_uq1 VDD sg13_lv_pmos ad=0.38p pd=2.38u as=0.38p ps=2.38u w=2u l=0.13u
X12 R1 INN G_uq1 VSS sg13_lv_nmos ad=0.304p pd=1.98u as=0.544p ps=3.88u w=1.6u l=0.13u
X13 VDD D0 G_uq1 VDD sg13_lv_pmos ad=0.38p pd=2.38u as=0.38p ps=2.38u w=2u l=0.13u
X14 VDD D0 D0 VDD sg13_lv_pmos ad=0.38p pd=2.38u as=0.68p ps=4.68u w=2u l=0.13u
X15 R1 INN G_uq1 VSS sg13_lv_nmos ad=0.304p pd=1.98u as=0.304p ps=1.98u w=1.6u l=0.13u
X16 D0 D0 VDD VDD sg13_lv_pmos ad=0.38p pd=2.38u as=0.38p ps=2.38u w=2u l=0.13u
X17 D0 D0 VDD VDD sg13_lv_pmos ad=0.38p pd=2.38u as=0.38p ps=2.38u w=2u l=0.13u
X18 VSS G_uq1 D VSS sg13_lv_nmos ad=0.17p pd=1.68u as=0.17p ps=1.68u w=0.5u l=0.13u
X19 VDD D0 G_uq1 VDD sg13_lv_pmos ad=0.38p pd=2.38u as=0.68p ps=4.68u w=2u l=0.13u
X20 G_uq1 D0 VDD VDD sg13_lv_pmos ad=0.38p pd=2.38u as=0.38p ps=2.38u w=2u l=0.13u
X21 R1 INP D0 VSS sg13_lv_nmos ad=0.304p pd=1.98u as=0.544p ps=3.88u w=1.6u l=0.13u
X22 G_uq1 D0 VDD VDD sg13_lv_pmos ad=0.38p pd=2.38u as=0.38p ps=2.38u w=2u l=0.13u
X23 R1 INP D0 VSS sg13_lv_nmos ad=0.304p pd=1.98u as=0.304p ps=1.98u w=1.6u l=0.13u
X24 G_uq1 INN R1 VSS sg13_lv_nmos ad=0.304p pd=1.98u as=0.304p ps=1.98u w=1.6u l=0.13u
X25 G_uq1 INN R1 VSS sg13_lv_nmos ad=0.544p pd=3.88u as=0.304p ps=1.98u w=1.6u l=0.13u
X26 G_uq1 D0 VDD VDD sg13_lv_pmos ad=0.68p pd=4.68u as=0.38p ps=2.38u w=2u l=0.13u
X27 D0 D0 VDD VDD sg13_lv_pmos ad=0.38p pd=2.38u as=0.38p ps=2.38u w=2u l=0.13u
X28 VDD D0 D0 VDD sg13_lv_pmos ad=0.38p pd=2.38u as=0.38p ps=2.38u w=2u l=0.13u
C0 D0 R1 1.06832f
C1 VDD INP 0.01547f
C2 G_uq1 R1 1.05593f
C3 D0 INN 0.23459f
C4 D VDD 0.42672f
C5 G_uq1 INN 0.48295f
C6 R1 INP 0.21947f
C7 a_364_2912# R1 0.06378f
C8 INN INP 0.44953f
C9 VDD R1 0.00701f
C10 G_uq1 D0 0.58739f
C11 INN a_364_2912# 0
C12 INN VDD 0.11103f
C13 D INN 0
C14 D0 Y 0
C15 G_uq1 Y 0
C16 D0 INP 0.47056f
C17 G_uq1 INP 0.00386f
C18 INN R1 0.23086f
C19 D0 VDD 4.58906f
C20 D D0 0.00131f
C21 G_uq1 VDD 2.90573f
C22 D G_uq1 0.14168f
C23 VDD Y 0.21372f
C24 D Y 0.11873f
C25 Y VSS 0.63257f
C26 VDD VSS 1.78824f
C27 D VSS 0.21352f
C28 R1 VSS 2.2528f
R_pex_flottant_1 a_364_2912# VSS 1m
.ends

* --- enveloppe ---
.subckt cml_to_cmos_pex INP INN Y VDD VSS
Xcml_to_cmos_routed VDD VSS INN INP Y cml_to_cmos_routed
.ends
