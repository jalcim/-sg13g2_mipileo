* cmos_to_cml_pex -- cmos_to_cml POST-LAYOUT : extrait Magic MAG/cmos_to_cml_pex_raw.spice (md5 a5525fa1e00c537423c6885ab42b1616)
* enveloppe par shared/magic/pex_wrap.tcl aux bornes de la livrable COLLATERALS/SPICE/cmos_to_cml.spice (md5 3b66b9857690e71288850bc1ab094f78) ;
* sous-circuit du layout cmos_to_cml_autoroute renomme cmos_to_cml_routed ; bornes appariees par nom : VDD VSS A OUTN OUTP POLN
* noeuds flottants (capacites seules) ramenes a VSS dans cmos_to_cml_routed : xrln/a_n100_n742# xrlp/a_n100_n742#
* --- extrait Magic, verbatim (cmos_to_cml_autoroute -> cmos_to_cml_routed) ---
* NGSPICE file created from cmos_to_cml_autoroute.ext - technology: ihp-sg13g2

.subckt sg13_lv_nmos_MPRQC6 G D0 S1 D2 S3 sub a_166_n160#
X0 D2 G S1 sub sg13_lv_nmos ad=0.304p pd=1.98u as=0.304p ps=1.98u w=1.6u l=0.13u
X1 a_166_n160# G S3 sub sg13_lv_nmos ad=0.544p pd=3.88u as=0.304p ps=1.98u w=1.6u l=0.13u
X2 S1 G D0 sub sg13_lv_nmos ad=0.304p pd=1.98u as=0.544p ps=3.88u w=1.6u l=0.13u
X3 S3 G D2 sub sg13_lv_nmos ad=0.304p pd=1.98u as=0.304p ps=1.98u w=1.6u l=0.13u
C0 G a_166_n160# 0.03707f
C1 S3 a_166_n160# 0.11033f
C2 S1 D2 0.11033f
C3 G D2 0.07414f
C4 G S1 0.07414f
C5 S1 D0 0.11033f
C6 G D0 0.03707f
C7 S3 D2 0.11033f
C8 G S3 0.07414f
C9 S3 sub 0.00115f
C10 D2 sub 0.30747f
C11 S1 sub 0.30747f
C12 D0 sub 0.06782f
C13 a_166_n160# sub 0.06782f
.ends

.subckt rppd_W2KASE B R1 R2 a_n100_n742#
X0 R1 R2 B rppd l=7.42u w=1u
C0 a_n100_n742# R1 0.06687f
C1 a_n100_n742# R2 0.06687f
C2 R1 R2 0.00433f
C3 R2 B 1.04708f
C4 R1 B 1.04708f
.ends

.subckt sg13_lv_nmos_JJSYDV D S G sub
X0 S G D sub sg13_lv_nmos ad=0.68p pd=4.68u as=0.68p ps=4.68u w=2u l=0.13u
C0 D G 0.03985f
C1 S G 0.03985f
C2 D S 0.14056f
C3 S sub 0.19061f
C4 D sub 0.19061f
.ends

.subckt sg13_lv_nmos_58FPXY D S G sub
X0 S G D sub sg13_lv_nmos ad=2.9138p pd=17.82u as=2.9138p ps=17.82u w=8.57u l=0.13u
C0 D G 0.08151f
C1 S G 0.08151f
C2 D S 0.63705f
C3 S sub 0.48803f
C4 D sub 0.48803f
.ends

.subckt sg13_lv_pmos_X7J6WZ D S G w_n143_n462# sub
X0 S G D w_n143_n462# sg13_lv_pmos ad=1.36p pd=8.68u as=1.36p ps=8.68u w=4u l=0.13u
C0 G w_n143_n462# 0.1204f
C1 D w_n143_n462# 0.02308f
C2 G S 0.05291f
C3 S D 0.2917f
C4 G D 0.05291f
C5 S w_n143_n462# 0.02308f
C6 S sub 0.20314f
C7 D sub 0.20314f
.ends

.subckt cmos_to_cml_routed VDD VSS A OUTN OUTP POLN
Xxan xip/D OUTP xap/S3 OUTP xap/S3 VSS OUTP sg13_lv_nmos_MPRQC6
Xxap A OUTN xap/S3 OUTN xap/S3 VSS OUTN sg13_lv_nmos_MPRQC6
Xxrln VSS OUTN VDD xrln/a_n100_n742# rppd_W2KASE
Xxin xip/D VSS A VSS sg13_lv_nmos_JJSYDV
Xxrlp VSS VDD OUTP xrlp/a_n100_n742# rppd_W2KASE
Xxtail xap/S3 VSS POLN VSS sg13_lv_nmos_58FPXY
Xxip xip/D VDD A VDD VSS sg13_lv_pmos_X7J6WZ
C0 xip/D xrlp/a_n100_n742# 0.03305f
C1 A xrln/a_n100_n742# 0
C2 POLN xap/S3 0.13357f
C3 OUTP xrlp/a_n100_n742# 0.09758f
C4 xap/S3 xrlp/a_n100_n742# 0.01025f
C5 POLN OUTN 0.00172f
C6 VDD xrlp/a_n100_n742# -0.00158f
C7 xrlp/a_n100_n742# OUTN 0.01575f
C8 xip/D OUTP 0.2865f
C9 xip/D xap/S3 0.0466f
C10 xip/D VDD 0.04838f
C11 xap/S3 OUTP 0.36582f
C12 xip/D OUTN 0.06711f
C13 OUTP VDD 0.01939f
C14 A xrlp/a_n100_n742# 0.02366f
C15 xip/D xrln/a_n100_n742# 0.00453f
C16 xap/S3 VDD 0
C17 OUTP OUTN 0.4894f
C18 OUTP xrln/a_n100_n742# 0.03127f
C19 xap/S3 OUTN 0.41441f
C20 xap/S3 xrln/a_n100_n742# 0.00193f
C21 VDD OUTN 0.13342f
C22 A xip/D 0.25387f
C23 VDD xrln/a_n100_n742# -0.00572f
C24 A OUTP 0.09112f
C25 xrln/a_n100_n742# OUTN 0.112f
C26 A xap/S3 0.05008f
C27 xip/D POLN 0.01177f
C28 A VDD 0.16738f
C29 A OUTN 0.11432f
C30 POLN OUTP 0
C31 A VSS 0.7683f
C32 xip/D VSS 0.49197f
C33 POLN VSS 0.20793f
C34 xap/S3 VSS 1.16574f
C35 OUTP VSS 0.89971f
C36 VDD VSS 3.26971f
C37 xrlp/a_n100_n742# VSS 0
C38 xrln/a_n100_n742# VSS 0
C39 OUTN VSS 0.98388f
R_pex_flottant_1 xrln/a_n100_n742# VSS 1m
R_pex_flottant_2 xrlp/a_n100_n742# VSS 1m
.ends

* --- enveloppe ---
.subckt cmos_to_cml_pex A OUTP OUTN POLN VDD VSS
Xcmos_to_cml_routed VDD VSS A OUTN OUTP POLN cmos_to_cml_routed
.ends
