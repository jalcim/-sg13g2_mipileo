* NGSPICE file created from dphy_rx.ext - technology: ihp-sg13g2

* Black-box entry subcircuit for sg13g2_decap_8 abstract view
.subckt sg13g2_decap_8 VDD VSS
.ends

* Black-box entry subcircuit for sg13g2_buf_1 abstract view
.subckt sg13g2_buf_1 X A VDD VSS
.ends

* Black-box entry subcircuit for sg13g2_fill_1 abstract view
.subckt sg13g2_fill_1 VDD VSS
.ends

* Black-box entry subcircuit for sg13g2_decap_4 abstract view
.subckt sg13g2_decap_4 VDD VSS
.ends

* Black-box entry subcircuit for sg13g2_and2_1 abstract view
.subckt sg13g2_and2_1 X A B VDD VSS
.ends

* Black-box entry subcircuit for sg13g2_or2_1 abstract view
.subckt sg13g2_or2_1 X A B VDD VSS
.ends

* Black-box entry subcircuit for tempo_t24n abstract view
.subckt tempo_t24n VDD VSS RESET ARM INGRESS PG PROGRESS
.ends

* Black-box entry subcircuit for sg13g2_fill_2 abstract view
.subckt sg13g2_fill_2 VDD VSS
.ends

* Black-box entry subcircuit for sg13g2_inv_1 abstract view
.subckt sg13g2_inv_1 Y A VDD VSS
.ends

* Black-box entry subcircuit for sg13g2_dlygate4sd3_1 abstract view
.subckt sg13g2_dlygate4sd3_1 X A VDD VSS
.ends

* Black-box entry subcircuit for sg13g2_tielo abstract view
.subckt sg13g2_tielo L_LO VDD VSS
.ends

* Black-box entry subcircuit for sg13g2_xnor2_1 abstract view
.subckt sg13g2_xnor2_1 Y A B VDD VSS
.ends

* Black-box entry subcircuit for sg13g2_dfrbpq_1 abstract view
.subckt sg13g2_dfrbpq_1 Q CLK D RESET_B VDD VSS
.ends

* Black-box entry subcircuit for sg13g2_buf_4 abstract view
.subckt sg13g2_buf_4 X A VDD VSS
.ends

* Black-box entry subcircuit for sg13g2_o21ai_1 abstract view
.subckt sg13g2_o21ai_1 Y A1 A2 B1 VDD VSS
.ends

* Black-box entry subcircuit for sg13g2_inv_2 abstract view
.subckt sg13g2_inv_2 Y A VDD VSS
.ends

* Black-box entry subcircuit for sg13g2_nor2_1 abstract view
.subckt sg13g2_nor2_1 Y A B VDD VSS
.ends

* Black-box entry subcircuit for sg13g2_a21oi_1 abstract view
.subckt sg13g2_a21oi_1 Y A1 A2 B1 VDD VSS
.ends

* Black-box entry subcircuit for sg13g2_buf_16 abstract view
.subckt sg13g2_buf_16 X A VDD VSS
.ends

* Black-box entry subcircuit for sg13g2_nand3_1 abstract view
.subckt sg13g2_nand3_1 Y A B C VDD VSS
.ends

* Black-box entry subcircuit for sg13g2_tiehi abstract view
.subckt sg13g2_tiehi L_HI VDD VSS
.ends

* Black-box entry subcircuit for tempo_t40n abstract view
.subckt tempo_t40n VDD VSS RESET ARM INGRESS PG PROGRESS
.ends

* Black-box entry subcircuit for sg13g2_nand2b_1 abstract view
.subckt sg13g2_nand2b_1 Y A_N B VDD VSS
.ends

* Black-box entry subcircuit for sg13g2_dlhrq_1 abstract view
.subckt sg13g2_dlhrq_1 Q D GATE RESET_B VDD VSS
.ends

* Black-box entry subcircuit for sg13g2_nand2_1 abstract view
.subckt sg13g2_nand2_1 Y A B VDD VSS
.ends

* Black-box entry subcircuit for sg13g2_a21o_1 abstract view
.subckt sg13g2_a21o_1 X A1 A2 B1 VDD VSS
.ends

* Black-box entry subcircuit for sg13g2_nand4_1 abstract view
.subckt sg13g2_nand4_1 Y A B C D VDD VSS
.ends

* Black-box entry subcircuit for tempo_t180n abstract view
.subckt tempo_t180n VDD VSS RESET ARM INGRESS PG PROGRESS
.ends

* Black-box entry subcircuit for sg13g2_buf_8 abstract view
.subckt sg13g2_buf_8 X A VDD VSS
.ends

* Black-box entry subcircuit for sg13g2_a22oi_1 abstract view
.subckt sg13g2_a22oi_1 Y A1 A2 B1 B2 VDD VSS
.ends

* Black-box entry subcircuit for sg13g2_xor2_1 abstract view
.subckt sg13g2_xor2_1 X A B VDD VSS
.ends

.subckt dphy_rx PG VGND VPWR clk_lp_n clk_lp_p clk_miss clk_rx_en clk_stop clk_term_en
+ hs_rx_en[0] hs_rx_en[1] hs_rx_en[2] hs_rx_en[3] hspr[0] hspr[1] hspr[2] hspr[3]
+ hsreq[0] hsreq[1] hsreq[2] hsreq[3] lp_n[0] lp_n[1] lp_n[2] lp_n[3] lp_p[0] lp_p[1]
+ lp_p[2] lp_p[3] rx_clk stop[0] stop[1] stop[2] stop[3] term_en[0] term_en[1] term_en[2]
+ term_en[3]
XFILLER_27_417 VPWR VGND sg13g2_decap_8
XFILLER_22_133 VPWR VGND sg13g2_decap_8
XFILLER_23_634 VPWR VGND sg13g2_decap_8
XFILLER_13_100 VPWR VGND sg13g2_decap_8
XFILLER_13_199 VPWR VGND sg13g2_decap_8
X_294_ _294_/X _294_/A VPWR VGND sg13g2_buf_1
XFILLER_9_137 VPWR VGND sg13g2_decap_8
XFILLER_5_343 VPWR VGND sg13g2_decap_8
XFILLER_3_67 VPWR VGND sg13g2_fill_1
XFILLER_24_409 VPWR VGND sg13g2_decap_8
XFILLER_17_483 VPWR VGND sg13g2_decap_8
XFILLER_9_693 VPWR VGND sg13g2_decap_8
XFILLER_23_420 VPWR VGND sg13g2_decap_8
XFILLER_27_214 VPWR VGND sg13g2_decap_8
XFILLER_10_147 VPWR VGND sg13g2_decap_8
XFILLER_11_615 VPWR VGND sg13g2_decap_8
XFILLER_12_21 VPWR VGND sg13g2_decap_8
XFILLER_23_497 VPWR VGND sg13g2_decap_8
XFILLER_12_98 VPWR VGND sg13g2_decap_8
XFILLER_18_203 VPWR VGND sg13g2_decap_8
XFILLER_19_715 VPWR VGND sg13g2_decap_4
XFILLER_10_692 VPWR VGND sg13g2_decap_8
XFILLER_6_674 VPWR VGND sg13g2_decap_8
XFILLER_5_140 VPWR VGND sg13g2_decap_8
XFILLER_17_280 VPWR VGND sg13g2_decap_8
XFILLER_24_206 VPWR VGND sg13g2_decap_8
XFILLER_9_490 VPWR VGND sg13g2_decap_8
XFILLER_28_567 VPWR VGND sg13g2_decap_8
XFILLER_15_217 VPWR VGND sg13g2_decap_8
X_200_ _206_/B _246_/Q _247_/Q VPWR VGND sg13g2_and2_1
XFILLER_11_434 VPWR VGND sg13g2_decap_8
XFILLER_23_294 VPWR VGND sg13g2_decap_8
XFILLER_23_42 VPWR VGND sg13g2_decap_8
X_131_ _131_/X _131_/A _131_/B VPWR VGND sg13g2_or2_1
XFILLER_7_449 VPWR VGND sg13g2_decap_4
XFILLER_3_699 VPWR VGND sg13g2_decap_8
XFILLER_3_622 VPWR VGND sg13g2_decap_8
XFILLER_0_46 VPWR VGND sg13g2_decap_8
XFILLER_9_88 VPWR VGND sg13g2_decap_8
Xlane2.lp.c_hsprp.tempo VPWR VGND _146_/X _144_/A _301_/A fanout39/X _297_/A tempo_t24n
XFILLER_9_11 VPWR VGND sg13g2_decap_8
XFILLER_6_493 VPWR VGND sg13g2_decap_8
XFILLER_29_0 VPWR VGND sg13g2_decap_8
XFILLER_25_526 VPWR VGND sg13g2_decap_8
XFILLER_25_504 VPWR VGND sg13g2_decap_8
XFILLER_4_419 VPWR VGND sg13g2_decap_8
XFILLER_16_504 VPWR VGND sg13g2_decap_8
XFILLER_18_42 VPWR VGND sg13g2_decap_8
XFILLER_28_364 VPWR VGND sg13g2_decap_8
XFILLER_11_231 VPWR VGND sg13g2_decap_8
XFILLER_12_721 VPWR VGND sg13g2_fill_2
XFILLER_24_592 VPWR VGND sg13g2_decap_8
X_114_ _114_/Y _233_/Q VPWR VGND sg13g2_inv_1
XFILLER_7_235 VPWR VGND sg13g2_decap_8
XFILLER_19_320 VPWR VGND sg13g2_decap_8
XFILLER_22_7 VPWR VGND sg13g2_decap_8
XFILLER_6_290 VPWR VGND sg13g2_decap_8
XFILLER_25_334 VPWR VGND sg13g2_decap_8
XFILLER_4_227 VPWR VGND sg13g2_decap_8
Xhold74 hold74/X _125_/Y VPWR VGND sg13g2_dlygate4sd3_1
XFILLER_29_63 VPWR VGND sg13g2_decap_8
XFILLER_16_312 VPWR VGND sg13g2_decap_8
XFILLER_28_161 VPWR VGND sg13g2_decap_8
XFILLER_12_562 VPWR VGND sg13g2_decap_8
XFILLER_12_573 VPWR VGND sg13g2_fill_2
XFILLER_6_56 VPWR VGND sg13g2_decap_8
XFILLER_19_150 VPWR VGND sg13g2_decap_8
XFILLER_22_348 VPWR VGND sg13g2_decap_8
XFILLER_15_21 VPWR VGND sg13g2_decap_8
XFILLER_25_164 VPWR VGND sg13g2_decap_8
XFILLER_13_348 VPWR VGND sg13g2_decap_8
XFILLER_15_98 VPWR VGND sg13g2_decap_8
XFILLER_9_319 VPWR VGND sg13g2_decap_8
Xoutput31 term_en[0] _307_/X VPWR VGND sg13g2_buf_1
Xoutput20 hspr[1] _296_/X VPWR VGND sg13g2_buf_1
XFILLER_5_547 VPWR VGND sg13g2_decap_8
XFILLER_5_525 VPWR VGND sg13g2_decap_8
XFILLER_16_186 VPWR VGND sg13g2_decap_8
XFILLER_17_676 VPWR VGND sg13g2_decap_8
XFILLER_12_381 VPWR VGND sg13g2_decap_8
XFILLER_4_591 VPWR VGND sg13g2_fill_2
XFILLER_4_580 VPWR VGND sg13g2_decap_8
XFILLER_11_0 VPWR VGND sg13g2_decap_8
XFILLER_10_329 VPWR VGND sg13g2_decap_8
XFILLER_22_112 VPWR VGND sg13g2_decap_8
XFILLER_22_189 VPWR VGND sg13g2_decap_8
XFILLER_13_145 VPWR VGND sg13g2_fill_1
XFILLER_9_116 VPWR VGND sg13g2_decap_8
XFILLER_13_178 VPWR VGND sg13g2_decap_8
X_293_ _293_/X _293_/A VPWR VGND sg13g2_buf_1
XFILLER_5_322 VPWR VGND sg13g2_decap_8
XFILLER_5_399 VPWR VGND sg13g2_decap_8
XFILLER_3_79 VPWR VGND sg13g2_decap_8
XFILLER_3_46 VPWR VGND sg13g2_decap_8
XFILLER_17_440 VPWR VGND sg13g2_fill_2
XFILLER_17_451 VPWR VGND sg13g2_fill_2
XFILLER_17_462 VPWR VGND sg13g2_decap_8
XFILLER_13_690 VPWR VGND sg13g2_fill_2
Xlane1.lp.c_stop.tempo VPWR VGND _141_/A _158_/Y lane1.lp.c_stop.tempo_64/L_HI fanout36/X
+ _304_/A tempo_t24n
XFILLER_9_672 VPWR VGND sg13g2_decap_8
XFILLER_10_126 VPWR VGND sg13g2_decap_8
XFILLER_12_77 VPWR VGND sg13g2_decap_8
XFILLER_23_476 VPWR VGND sg13g2_decap_8
XFILLER_6_119 VPWR VGND sg13g2_decap_8
Xhold160 _228_/B _225_/Y VPWR VGND sg13g2_dlygate4sd3_1
XFILLER_18_259 VPWR VGND sg13g2_decap_8
XFILLER_10_671 VPWR VGND sg13g2_decap_8
XFILLER_6_653 VPWR VGND sg13g2_decap_8
XFILLER_5_196 VPWR VGND sg13g2_decap_8
XFILLER_28_546 VPWR VGND sg13g2_decap_8
XFILLER_11_413 VPWR VGND sg13g2_decap_8
XFILLER_23_21 VPWR VGND sg13g2_decap_8
XFILLER_23_273 VPWR VGND sg13g2_decap_8
X_130_ _130_/X _130_/A _130_/B VPWR VGND sg13g2_and2_1
XFILLER_23_98 VPWR VGND sg13g2_decap_8
XFILLER_3_678 VPWR VGND sg13g2_decap_8
XFILLER_0_25 VPWR VGND sg13g2_decap_8
XFILLER_9_67 VPWR VGND sg13g2_decap_8
XFILLER_30_711 VPWR VGND sg13g2_decap_8
XFILLER_10_490 VPWR VGND sg13g2_decap_8
XFILLER_6_472 VPWR VGND sg13g2_decap_8
XFILLER_25_516 VPWR VGND sg13g2_fill_1
XFILLER_21_722 VPWR VGND sg13g2_fill_1
XFILLER_18_21 VPWR VGND sg13g2_decap_8
XFILLER_18_98 VPWR VGND sg13g2_decap_8
XFILLER_28_343 VPWR VGND sg13g2_decap_8
XFILLER_11_210 VPWR VGND sg13g2_decap_8
XFILLER_11_287 VPWR VGND sg13g2_decap_8
XFILLER_12_700 VPWR VGND sg13g2_decap_8
X_113_ _113_/Y _130_/B VPWR VGND sg13g2_inv_1
XFILLER_3_497 VPWR VGND sg13g2_decap_8
XFILLER_15_7 VPWR VGND sg13g2_decap_8
Xlane3.lp.f11.tempo VPWR VGND _164_/Y lane3.lp.f11.tempo/ARM lane3.lp.f11.tempo_72/L_HI
+ fanout40/X _151_/B tempo_t24n
XFILLER_19_398 VPWR VGND sg13g2_decap_8
XFILLER_30_585 VPWR VGND sg13g2_decap_8
XFILLER_25_313 VPWR VGND sg13g2_decap_8
XFILLER_4_206 VPWR VGND sg13g2_decap_8
Xhold86 _234_/D _176_/Y VPWR VGND sg13g2_dlygate4sd3_1
XFILLER_29_42 VPWR VGND sg13g2_decap_8
XFILLER_28_140 VPWR VGND sg13g2_decap_8
XFILLER_16_368 VPWR VGND sg13g2_decap_8
XFILLER_29_685 VPWR VGND sg13g2_decap_8
XFILLER_6_35 VPWR VGND sg13g2_decap_8
XFILLER_13_4 VPWR VGND sg13g2_decap_8
XFILLER_22_327 VPWR VGND sg13g2_decap_8
Xclk_lane.lp.f11.tempo_44 clk_lane.lp.f11.tempo/ARM VPWR VGND sg13g2_tielo
XFILLER_30_382 VPWR VGND sg13g2_decap_8
XFILLER_13_327 VPWR VGND sg13g2_decap_8
XFILLER_25_132 VPWR VGND sg13g2_decap_8
XFILLER_15_77 VPWR VGND sg13g2_decap_8
XFILLER_21_393 VPWR VGND sg13g2_decap_8
XFILLER_5_504 VPWR VGND sg13g2_decap_8
XFILLER_1_710 VPWR VGND sg13g2_decap_8
Xoutput32 term_en[1] _308_/X VPWR VGND sg13g2_buf_1
Xoutput21 hspr[2] _297_/X VPWR VGND sg13g2_buf_1
XFILLER_17_655 VPWR VGND sg13g2_decap_8
XFILLER_29_482 VPWR VGND sg13g2_decap_8
XFILLER_12_360 VPWR VGND sg13g2_decap_8
XFILLER_16_165 VPWR VGND sg13g2_decap_8
XFILLER_10_308 VPWR VGND sg13g2_decap_8
XFILLER_22_168 VPWR VGND sg13g2_decap_8
XFILLER_23_669 VPWR VGND sg13g2_decap_8
XFILLER_18_419 VPWR VGND sg13g2_decap_8
XFILLER_13_157 VPWR VGND sg13g2_decap_8
X_292_ _292_/X _292_/A VPWR VGND sg13g2_buf_1
XFILLER_5_378 VPWR VGND sg13g2_decap_8
XFILLER_5_301 VPWR VGND sg13g2_decap_8
XFILLER_3_25 VPWR VGND sg13g2_decap_8
XFILLER_9_651 VPWR VGND sg13g2_decap_8
XFILLER_27_249 VPWR VGND sg13g2_decap_8
XFILLER_10_105 VPWR VGND sg13g2_decap_8
XFILLER_23_455 VPWR VGND sg13g2_decap_8
XFILLER_12_56 VPWR VGND sg13g2_decap_8
XFILLER_18_238 VPWR VGND sg13g2_decap_8
XFILLER_10_650 VPWR VGND sg13g2_decap_8
XFILLER_6_632 VPWR VGND sg13g2_decap_8
XFILLER_5_175 VPWR VGND sg13g2_decap_8
XFILLER_28_525 VPWR VGND sg13g2_decap_8
XFILLER_24_720 VPWR VGND sg13g2_decap_8
XFILLER_11_469 VPWR VGND sg13g2_decap_8
XFILLER_23_252 VPWR VGND sg13g2_decap_8
XFILLER_7_418 VPWR VGND sg13g2_decap_8
XFILLER_23_77 VPWR VGND sg13g2_decap_8
XFILLER_3_657 VPWR VGND sg13g2_decap_8
XFILLER_9_46 VPWR VGND sg13g2_decap_8
X_189_ _239_/D _239_/Q _189_/B VPWR VGND sg13g2_xnor2_1
X_258_ _258_/Q _258_/CLK _258_/D _135_/Y VPWR VGND sg13g2_dfrbpq_1
XFILLER_6_451 VPWR VGND sg13g2_decap_8
XFILLER_28_322 VPWR VGND sg13g2_decap_8
XFILLER_18_77 VPWR VGND sg13g2_decap_8
XFILLER_28_399 VPWR VGND sg13g2_decap_8
XFILLER_11_266 VPWR VGND sg13g2_decap_8
XFILLER_1_0 VPWR VGND sg13g2_decap_8
XFILLER_3_476 VPWR VGND sg13g2_decap_8
XFILLER_3_454 VPWR VGND sg13g2_decap_4
XFILLER_19_355 VPWR VGND sg13g2_fill_2
XFILLER_22_509 VPWR VGND sg13g2_decap_4
XFILLER_30_564 VPWR VGND sg13g2_decap_8
XFILLER_29_119 VPWR VGND sg13g2_decap_8
Xdelaybuf_2_rx_clk clkbuf_0_rx_clk/A delaybuf_2_rx_clk/A VPWR VGND sg13g2_buf_4
XFILLER_25_369 VPWR VGND sg13g2_decap_8
XFILLER_5_719 VPWR VGND sg13g2_decap_8
Xhold98 _255_/D _224_/Y VPWR VGND sg13g2_dlygate4sd3_1
XFILLER_29_98 VPWR VGND sg13g2_decap_8
XFILLER_29_664 VPWR VGND sg13g2_decap_8
XFILLER_29_21 VPWR VGND sg13g2_decap_8
XFILLER_16_347 VPWR VGND sg13g2_decap_8
XFILLER_28_196 VPWR VGND sg13g2_decap_8
XFILLER_6_14 VPWR VGND sg13g2_decap_8
XFILLER_3_284 VPWR VGND sg13g2_fill_1
XFILLER_19_185 VPWR VGND sg13g2_decap_8
XFILLER_22_306 VPWR VGND sg13g2_decap_8
XFILLER_15_391 VPWR VGND sg13g2_decap_8
XFILLER_30_361 VPWR VGND sg13g2_decap_8
XFILLER_13_306 VPWR VGND sg13g2_decap_8
XFILLER_15_56 VPWR VGND sg13g2_decap_8
Xlane3.lp.f10.tempo VPWR VGND _166_/Y lane3.lp.f10.tempo/ARM lane3.lp.f10.tempo_71/L_HI
+ fanout40/X _151_/A tempo_t24n
XFILLER_25_199 VPWR VGND sg13g2_decap_4
XFILLER_25_100 VPWR VGND sg13g2_decap_8
XFILLER_21_372 VPWR VGND sg13g2_decap_8
Xoutput33 term_en[2] _309_/X VPWR VGND sg13g2_buf_1
Xoutput22 hspr[3] _298_/X VPWR VGND sg13g2_buf_1
Xoutput11 clk_miss output11/A VPWR VGND sg13g2_buf_1
XFILLER_16_144 VPWR VGND sg13g2_decap_8
XFILLER_29_461 VPWR VGND sg13g2_decap_8
XFILLER_22_147 VPWR VGND sg13g2_decap_8
XFILLER_23_648 VPWR VGND sg13g2_decap_8
XFILLER_13_114 VPWR VGND sg13g2_decap_8
XFILLER_13_125 VPWR VGND sg13g2_decap_8
X_291_ _291_/X _291_/A VPWR VGND sg13g2_buf_1
XFILLER_5_357 VPWR VGND sg13g2_decap_8
XFILLER_17_420 VPWR VGND sg13g2_decap_8
XFILLER_17_431 VPWR VGND sg13g2_fill_2
XFILLER_17_497 VPWR VGND sg13g2_decap_8
XFILLER_29_280 VPWR VGND sg13g2_decap_8
XFILLER_13_692 VPWR VGND sg13g2_fill_1
XFILLER_9_630 VPWR VGND sg13g2_decap_8
XFILLER_28_707 VPWR VGND sg13g2_decap_8
XFILLER_27_228 VPWR VGND sg13g2_decap_8
XFILLER_11_629 VPWR VGND sg13g2_decap_8
XFILLER_23_434 VPWR VGND sg13g2_decap_8
XFILLER_12_35 VPWR VGND sg13g2_decap_8
Xhold140 _227_/A2 _226_/X VPWR VGND sg13g2_dlygate4sd3_1
Xhold162 _180_/B _177_/Y VPWR VGND sg13g2_dlygate4sd3_1
XFILLER_5_7 VPWR VGND sg13g2_decap_8
XFILLER_18_217 VPWR VGND sg13g2_decap_8
XFILLER_6_688 VPWR VGND sg13g2_decap_8
XFILLER_5_154 VPWR VGND sg13g2_decap_8
XFILLER_17_294 VPWR VGND sg13g2_decap_8
XFILLER_4_91 VPWR VGND sg13g2_decap_8
XFILLER_28_504 VPWR VGND sg13g2_decap_8
XFILLER_23_231 VPWR VGND sg13g2_decap_8
XFILLER_11_448 VPWR VGND sg13g2_decap_8
XFILLER_23_56 VPWR VGND sg13g2_decap_8
XFILLER_3_636 VPWR VGND sg13g2_decap_8
XFILLER_3_603 VPWR VGND sg13g2_decap_4
XFILLER_3_4 VPWR VGND sg13g2_decap_8
XFILLER_19_504 VPWR VGND sg13g2_decap_8
XFILLER_9_25 VPWR VGND sg13g2_decap_8
XFILLER_27_592 VPWR VGND sg13g2_decap_8
X_188_ _188_/Y _190_/A _186_/B _239_/Q VPWR VGND sg13g2_o21ai_1
X_257_ _257_/Q _258_/CLK _257_/D _135_/Y VPWR VGND sg13g2_dfrbpq_1
XFILLER_6_430 VPWR VGND sg13g2_decap_8
XFILLER_21_702 VPWR VGND sg13g2_decap_8
XFILLER_21_713 VPWR VGND sg13g2_decap_8
XFILLER_18_56 VPWR VGND sg13g2_decap_8
XFILLER_28_301 VPWR VGND sg13g2_decap_8
XFILLER_28_378 VPWR VGND sg13g2_decap_8
XFILLER_24_562 VPWR VGND sg13g2_decap_8
XFILLER_11_245 VPWR VGND sg13g2_decap_8
XFILLER_7_249 VPWR VGND sg13g2_decap_8
XFILLER_3_433 VPWR VGND sg13g2_decap_8
XFILLER_19_334 VPWR VGND sg13g2_decap_8
X_309_ _309_/X _309_/A VPWR VGND sg13g2_buf_1
XFILLER_30_543 VPWR VGND sg13g2_decap_8
XFILLER_25_348 VPWR VGND sg13g2_decap_8
XFILLER_21_565 VPWR VGND sg13g2_decap_8
XFILLER_21_576 VPWR VGND sg13g2_fill_2
XFILLER_21_587 VPWR VGND sg13g2_decap_8
XFILLER_16_326 VPWR VGND sg13g2_decap_8
Xhold99 _203_/A _292_/A VPWR VGND sg13g2_dlygate4sd3_1
Xhold88 hold88/X _114_/Y VPWR VGND sg13g2_dlygate4sd3_1
Xhold77 hold77/X _116_/Y VPWR VGND sg13g2_dlygate4sd3_1
XFILLER_29_77 VPWR VGND sg13g2_decap_8
XFILLER_29_643 VPWR VGND sg13g2_decap_8
XFILLER_28_175 VPWR VGND sg13g2_decap_8
XFILLER_24_381 VPWR VGND sg13g2_decap_8
XFILLER_4_720 VPWR VGND sg13g2_decap_8
XFILLER_3_263 VPWR VGND sg13g2_decap_8
XFILLER_19_164 VPWR VGND sg13g2_decap_8
XFILLER_30_340 VPWR VGND sg13g2_decap_8
XFILLER_15_35 VPWR VGND sg13g2_decap_8
XFILLER_21_351 VPWR VGND sg13g2_decap_8
XFILLER_25_178 VPWR VGND sg13g2_decap_8
XFILLER_25_145 VPWR VGND sg13g2_fill_1
Xoutput34 term_en[3] _310_/X VPWR VGND sg13g2_buf_1
Xoutput23 hsreq[0] _299_/X VPWR VGND sg13g2_buf_1
Xoutput12 clk_rx_en _130_/B VPWR VGND sg13g2_buf_1
XFILLER_16_123 VPWR VGND sg13g2_decap_8
XFILLER_12_395 VPWR VGND sg13g2_decap_8
Xlane2.lp.f10.tempo_52 lane2.lp.f10.tempo/ARM VPWR VGND sg13g2_tielo
XFILLER_22_126 VPWR VGND sg13g2_decap_8
XFILLER_23_627 VPWR VGND sg13g2_decap_8
Xlane3.lp.f11.tempo_56 lane3.lp.f11.tempo/ARM VPWR VGND sg13g2_tielo
XFILLER_21_192 VPWR VGND sg13g2_decap_8
XFILLER_22_682 VPWR VGND sg13g2_decap_8
XFILLER_5_336 VPWR VGND sg13g2_decap_8
XFILLER_17_476 VPWR VGND sg13g2_decap_8
XFILLER_12_192 VPWR VGND sg13g2_decap_8
XFILLER_9_686 VPWR VGND sg13g2_decap_8
XFILLER_4_391 VPWR VGND sg13g2_decap_8
XFILLER_23_413 VPWR VGND sg13g2_decap_8
XFILLER_27_207 VPWR VGND sg13g2_decap_8
XFILLER_12_14 VPWR VGND sg13g2_decap_8
Xhold130 _196_/A _118_/Y VPWR VGND sg13g2_dlygate4sd3_1
Xhold152 _191_/B1 _188_/Y VPWR VGND sg13g2_dlygate4sd3_1
XFILLER_19_708 VPWR VGND sg13g2_decap_8
XFILLER_10_685 VPWR VGND sg13g2_decap_8
XFILLER_6_667 VPWR VGND sg13g2_decap_8
XFILLER_5_133 VPWR VGND sg13g2_decap_8
XFILLER_17_273 VPWR VGND sg13g2_decap_8
XFILLER_13_490 VPWR VGND sg13g2_decap_8
XFILLER_9_483 VPWR VGND sg13g2_decap_8
XFILLER_4_70 VPWR VGND sg13g2_decap_8
XFILLER_23_210 VPWR VGND sg13g2_decap_8
XFILLER_11_427 VPWR VGND sg13g2_decap_8
XFILLER_23_287 VPWR VGND sg13g2_decap_8
XFILLER_23_35 VPWR VGND sg13g2_decap_8
XFILLER_3_615 VPWR VGND sg13g2_decap_8
XFILLER_0_39 VPWR VGND sg13g2_decap_8
XFILLER_15_700 VPWR VGND sg13g2_decap_4
XFILLER_27_571 VPWR VGND sg13g2_decap_8
XFILLER_15_722 VPWR VGND sg13g2_fill_1
X_187_ _238_/D _187_/A _189_/B VPWR VGND sg13g2_or2_1
X_256_ _256_/Q _258_/CLK _256_/D _135_/Y VPWR VGND sg13g2_dfrbpq_1
XFILLER_6_486 VPWR VGND sg13g2_decap_8
XFILLER_9_291 VPWR VGND sg13g2_decap_8
XFILLER_18_35 VPWR VGND sg13g2_decap_8
XFILLER_28_357 VPWR VGND sg13g2_decap_8
XFILLER_11_224 VPWR VGND sg13g2_decap_8
XFILLER_12_714 VPWR VGND sg13g2_decap_8
Xclkload0 clkload0/Y clkload0/A VPWR VGND sg13g2_inv_2
XFILLER_7_228 VPWR VGND sg13g2_decap_8
XFILLER_3_412 VPWR VGND sg13g2_decap_8
XFILLER_19_313 VPWR VGND sg13g2_decap_8
X_239_ _239_/Q _250_/CLK _239_/D _145_/Y VPWR VGND sg13g2_dfrbpq_1
X_308_ _308_/X _308_/A VPWR VGND sg13g2_buf_1
XFILLER_30_599 VPWR VGND sg13g2_decap_8
XFILLER_30_522 VPWR VGND sg13g2_decap_8
XFILLER_6_283 VPWR VGND sg13g2_decap_8
XFILLER_25_327 VPWR VGND sg13g2_decap_8
XFILLER_29_622 VPWR VGND sg13g2_decap_8
XFILLER_29_56 VPWR VGND sg13g2_decap_8
XFILLER_16_305 VPWR VGND sg13g2_decap_8
XFILLER_29_699 VPWR VGND sg13g2_decap_8
XFILLER_28_154 VPWR VGND sg13g2_decap_8
XFILLER_12_500 VPWR VGND sg13g2_decap_8
XFILLER_24_360 VPWR VGND sg13g2_decap_8
XFILLER_10_91 VPWR VGND sg13g2_decap_8
XFILLER_6_49 VPWR VGND sg13g2_decap_8
XFILLER_3_242 VPWR VGND sg13g2_decap_8
XFILLER_19_121 VPWR VGND sg13g2_decap_8
XFILLER_30_396 VPWR VGND sg13g2_decap_8
XFILLER_15_14 VPWR VGND sg13g2_decap_8
XFILLER_25_157 VPWR VGND sg13g2_decap_8
XFILLER_21_330 VPWR VGND sg13g2_decap_8
Xoutput24 hsreq[1] _300_/X VPWR VGND sg13g2_buf_1
Xoutput13 clk_stop output13/A VPWR VGND sg13g2_buf_1
XFILLER_5_518 VPWR VGND sg13g2_decap_8
XFILLER_29_441 VPWR VGND sg13g2_fill_2
XFILLER_16_102 VPWR VGND sg13g2_decap_8
XFILLER_16_179 VPWR VGND sg13g2_decap_8
XFILLER_17_669 VPWR VGND sg13g2_decap_8
XFILLER_29_496 VPWR VGND sg13g2_decap_8
XFILLER_12_374 VPWR VGND sg13g2_decap_8
XFILLER_4_573 VPWR VGND sg13g2_decap_8
XFILLER_22_105 VPWR VGND sg13g2_decap_8
XFILLER_30_193 VPWR VGND sg13g2_decap_8
XFILLER_21_171 VPWR VGND sg13g2_decap_8
XFILLER_22_661 VPWR VGND sg13g2_decap_8
XFILLER_9_109 VPWR VGND sg13g2_decap_8
XFILLER_5_315 VPWR VGND sg13g2_decap_8
XFILLER_3_39 VPWR VGND sg13g2_decap_8
XFILLER_12_171 VPWR VGND sg13g2_decap_8
XFILLER_13_683 VPWR VGND sg13g2_decap_8
XFILLER_9_621 VPWR VGND sg13g2_decap_4
Xlane1.lp.f10.tempo_49 lane1.lp.f10.tempo/ARM VPWR VGND sg13g2_tielo
XFILLER_9_665 VPWR VGND sg13g2_decap_8
XFILLER_10_119 VPWR VGND sg13g2_decap_8
XFILLER_23_469 VPWR VGND sg13g2_decap_8
Xhold142 _211_/A2 _210_/X VPWR VGND sg13g2_dlygate4sd3_1
Xhold164 _196_/B _193_/Y VPWR VGND sg13g2_dlygate4sd3_1
XFILLER_27_720 VPWR VGND sg13g2_fill_2
XFILLER_10_664 VPWR VGND sg13g2_decap_8
Xlane2.lp.c_hsreq.tempo VPWR VGND _146_/X _162_/Y _305_/A fanout37/X _301_/A tempo_t24n
XFILLER_6_646 VPWR VGND sg13g2_decap_8
XFILLER_5_189 VPWR VGND sg13g2_decap_8
XFILLER_5_112 VPWR VGND sg13g2_decap_8
XFILLER_17_252 VPWR VGND sg13g2_decap_8
XFILLER_9_462 VPWR VGND sg13g2_decap_8
XFILLER_28_539 VPWR VGND sg13g2_decap_8
XFILLER_11_406 VPWR VGND sg13g2_decap_8
XFILLER_23_14 VPWR VGND sg13g2_decap_8
XFILLER_23_266 VPWR VGND sg13g2_decap_8
XFILLER_0_18 VPWR VGND sg13g2_decap_8
XFILLER_27_550 VPWR VGND sg13g2_decap_8
X_255_ _255_/Q _258_/CLK _255_/D _135_/Y VPWR VGND sg13g2_dfrbpq_1
XFILLER_30_704 VPWR VGND sg13g2_decap_8
XFILLER_10_483 VPWR VGND sg13g2_decap_8
X_186_ _189_/B _190_/A _186_/B VPWR VGND sg13g2_nor2_1
XFILLER_6_465 VPWR VGND sg13g2_decap_8
XFILLER_9_270 VPWR VGND sg13g2_decap_8
XFILLER_18_14 VPWR VGND sg13g2_decap_8
XFILLER_28_336 VPWR VGND sg13g2_decap_8
XFILLER_11_203 VPWR VGND sg13g2_decap_8
XFILLER_7_218 VPWR VGND sg13g2_decap_4
Xclk_lane.arm.u_dly clk_lane.arm.u_xor/B clkload0/A VPWR VGND sg13g2_dlygate4sd3_1
Xlane0.c_term.tempo VPWR VGND _135_/A lane0.c_term.tempo/ARM _135_/Y fanout38/X _307_/A
+ tempo_t24n
XFILLER_30_501 VPWR VGND sg13g2_decap_8
XFILLER_10_280 VPWR VGND sg13g2_decap_8
X_169_ _170_/B _233_/Q _232_/Q _234_/Q VPWR VGND sg13g2_a21oi_1
X_238_ _293_/A _250_/CLK _238_/D _145_/Y VPWR VGND sg13g2_dfrbpq_1
X_307_ _307_/X _307_/A VPWR VGND sg13g2_buf_1
XFILLER_6_262 VPWR VGND sg13g2_decap_8
XFILLER_30_578 VPWR VGND sg13g2_decap_8
XFILLER_25_306 VPWR VGND sg13g2_decap_8
XFILLER_18_391 VPWR VGND sg13g2_decap_8
XFILLER_29_601 VPWR VGND sg13g2_decap_8
XFILLER_29_35 VPWR VGND sg13g2_decap_8
XFILLER_29_678 VPWR VGND sg13g2_decap_8
XFILLER_28_133 VPWR VGND sg13g2_decap_8
XFILLER_12_545 VPWR VGND sg13g2_fill_1
XFILLER_6_28 VPWR VGND sg13g2_decap_8
XFILLER_10_70 VPWR VGND sg13g2_decap_8
XFILLER_19_100 VPWR VGND sg13g2_decap_8
XFILLER_19_199 VPWR VGND sg13g2_decap_4
XFILLER_15_350 VPWR VGND sg13g2_decap_8
XFILLER_7_582 VPWR VGND sg13g2_decap_8
XFILLER_30_375 VPWR VGND sg13g2_decap_8
XFILLER_25_125 VPWR VGND sg13g2_decap_8
XFILLER_25_114 VPWR VGND sg13g2_decap_8
XFILLER_21_386 VPWR VGND sg13g2_decap_8
XFILLER_1_703 VPWR VGND sg13g2_decap_8
Xoutput25 hsreq[2] _301_/X VPWR VGND sg13g2_buf_1
Xoutput14 clk_term_en output14/A VPWR VGND sg13g2_buf_1
XFILLER_29_475 VPWR VGND sg13g2_decap_8
XFILLER_29_420 VPWR VGND sg13g2_decap_8
XFILLER_12_353 VPWR VGND sg13g2_decap_8
XFILLER_16_158 VPWR VGND sg13g2_decap_8
XFILLER_17_648 VPWR VGND sg13g2_decap_8
XFILLER_25_692 VPWR VGND sg13g2_decap_8
XFILLER_4_552 VPWR VGND sg13g2_decap_8
XFILLER_16_692 VPWR VGND sg13g2_decap_8
XFILLER_30_172 VPWR VGND sg13g2_decap_8
XFILLER_7_93 VPWR VGND sg13g2_decap_8
XFILLER_7_60 VPWR VGND sg13g2_decap_4
XFILLER_7_390 VPWR VGND sg13g2_decap_8
XFILLER_13_139 VPWR VGND sg13g2_fill_2
XFILLER_22_640 VPWR VGND sg13g2_decap_8
XFILLER_21_150 VPWR VGND sg13g2_decap_8
XFILLER_3_18 VPWR VGND sg13g2_decap_8
XFILLER_29_294 VPWR VGND sg13g2_decap_8
XFILLER_12_150 VPWR VGND sg13g2_decap_8
XFILLER_13_662 VPWR VGND sg13g2_decap_8
XFILLER_9_644 VPWR VGND sg13g2_decap_8
XFILLER_23_448 VPWR VGND sg13g2_decap_8
XFILLER_12_49 VPWR VGND sg13g2_decap_8
Xhold110 _187_/A _293_/A VPWR VGND sg13g2_dlygate4sd3_1
XFILLER_10_643 VPWR VGND sg13g2_decap_8
XFILLER_22_481 VPWR VGND sg13g2_decap_8
XFILLER_6_625 VPWR VGND sg13g2_decap_8
XFILLER_5_168 VPWR VGND sg13g2_decap_8
XFILLER_17_231 VPWR VGND sg13g2_decap_8
XFILLER_9_452 VPWR VGND sg13g2_decap_4
XFILLER_5_691 VPWR VGND sg13g2_decap_8
XFILLER_28_518 VPWR VGND sg13g2_decap_8
XFILLER_24_713 VPWR VGND sg13g2_decap_8
XFILLER_23_245 VPWR VGND sg13g2_decap_8
Xclkbuf_2_1__f_rx_clk_regs _237_/CLK clkbuf_0_rx_clk_regs/X VPWR VGND sg13g2_buf_16
XFILLER_10_462 VPWR VGND sg13g2_decap_8
XFILLER_9_39 VPWR VGND sg13g2_decap_8
X_185_ _186_/B _240_/Q _239_/Q _241_/Q VPWR VGND sg13g2_a21oi_1
X_254_ _254_/Q _258_/CLK _254_/D _135_/Y VPWR VGND sg13g2_dfrbpq_1
XFILLER_6_444 VPWR VGND sg13g2_decap_8
XFILLER_28_315 VPWR VGND sg13g2_decap_8
XFILLER_11_259 VPWR VGND sg13g2_decap_8
XFILLER_24_576 VPWR VGND sg13g2_fill_2
Xlane0.c_term.tempo_45 lane0.c_term.tempo/ARM VPWR VGND sg13g2_tielo
XFILLER_3_469 VPWR VGND sg13g2_decap_8
XFILLER_3_447 VPWR VGND sg13g2_decap_8
XFILLER_19_348 VPWR VGND sg13g2_decap_8
XFILLER_15_565 VPWR VGND sg13g2_decap_4
X_306_ _306_/X _306_/A VPWR VGND sg13g2_buf_1
X_168_ _174_/B _233_/Q _232_/Q VPWR VGND sg13g2_and2_1
X_237_ _237_/Q _237_/CLK _237_/D _150_/Y VPWR VGND sg13g2_dfrbpq_1
XFILLER_7_720 VPWR VGND sg13g2_fill_2
XFILLER_6_241 VPWR VGND sg13g2_decap_8
XFILLER_30_557 VPWR VGND sg13g2_decap_8
XFILLER_29_657 VPWR VGND sg13g2_decap_8
XFILLER_29_14 VPWR VGND sg13g2_decap_8
XFILLER_28_112 VPWR VGND sg13g2_decap_8
XFILLER_28_189 VPWR VGND sg13g2_decap_8
XFILLER_24_395 VPWR VGND sg13g2_decap_8
XFILLER_3_277 VPWR VGND sg13g2_decap_8
XFILLER_3_222 VPWR VGND sg13g2_fill_2
XFILLER_19_178 VPWR VGND sg13g2_decap_8
XFILLER_15_384 VPWR VGND sg13g2_decap_8
XFILLER_30_354 VPWR VGND sg13g2_decap_8
XFILLER_7_561 VPWR VGND sg13g2_decap_8
XFILLER_25_0 VPWR VGND sg13g2_decap_8
XFILLER_15_49 VPWR VGND sg13g2_decap_8
XFILLER_21_365 VPWR VGND sg13g2_decap_8
Xoutput26 hsreq[3] _302_/X VPWR VGND sg13g2_buf_1
Xoutput15 hs_rx_en[0] _291_/X VPWR VGND sg13g2_buf_1
XFILLER_16_137 VPWR VGND sg13g2_decap_8
XFILLER_29_454 VPWR VGND sg13g2_decap_8
XFILLER_12_332 VPWR VGND sg13g2_decap_8
Xclk_lane.c_term.tempo VPWR VGND _129_/A clk_lane.c_term.tempo/ARM _129_/Y fanout38/X
+ output14/A tempo_t24n
XFILLER_25_671 VPWR VGND sg13g2_decap_8
XFILLER_24_192 VPWR VGND sg13g2_decap_8
XFILLER_4_531 VPWR VGND sg13g2_decap_8
XFILLER_16_671 VPWR VGND sg13g2_decap_8
XFILLER_7_72 VPWR VGND sg13g2_decap_8
XFILLER_30_151 VPWR VGND sg13g2_decap_8
XFILLER_13_107 VPWR VGND sg13g2_decap_8
XFILLER_22_696 VPWR VGND sg13g2_decap_8
XFILLER_17_413 VPWR VGND sg13g2_decap_8
XFILLER_29_273 VPWR VGND sg13g2_decap_8
XFILLER_12_140 VPWR VGND sg13g2_decap_4
XFILLER_13_641 VPWR VGND sg13g2_decap_8
XFILLER_16_81 VPWR VGND sg13g2_decap_8
XFILLER_25_490 VPWR VGND sg13g2_decap_8
XFILLER_4_350 VPWR VGND sg13g2_decap_8
XFILLER_16_490 VPWR VGND sg13g2_decap_8
XFILLER_23_427 VPWR VGND sg13g2_decap_8
XFILLER_12_28 VPWR VGND sg13g2_decap_8
Xhold122 _228_/A _124_/Y VPWR VGND sg13g2_dlygate4sd3_1
Xhold144 _195_/A2 _194_/X VPWR VGND sg13g2_dlygate4sd3_1
Xhold166 _207_/B1 _204_/Y VPWR VGND sg13g2_dlygate4sd3_1
XFILLER_27_722 VPWR VGND sg13g2_fill_1
XFILLER_10_622 VPWR VGND sg13g2_decap_8
XFILLER_22_460 VPWR VGND sg13g2_decap_8
XFILLER_10_699 VPWR VGND sg13g2_decap_8
XFILLER_5_147 VPWR VGND sg13g2_decap_8
XFILLER_17_210 VPWR VGND sg13g2_decap_8
XFILLER_18_711 VPWR VGND sg13g2_decap_8
XFILLER_17_287 VPWR VGND sg13g2_decap_8
XFILLER_9_431 VPWR VGND sg13g2_decap_8
XFILLER_9_497 VPWR VGND sg13g2_decap_8
XFILLER_5_670 VPWR VGND sg13g2_decap_8
XFILLER_4_84 VPWR VGND sg13g2_decap_8
XFILLER_23_224 VPWR VGND sg13g2_decap_8
XFILLER_23_49 VPWR VGND sg13g2_decap_8
XFILLER_3_629 VPWR VGND sg13g2_decap_8
XFILLER_9_18 VPWR VGND sg13g2_decap_8
XFILLER_27_585 VPWR VGND sg13g2_decap_8
XFILLER_10_441 VPWR VGND sg13g2_decap_8
XFILLER_13_60 VPWR VGND sg13g2_decap_4
XFILLER_13_93 VPWR VGND sg13g2_decap_8
X_184_ _190_/B _240_/Q _239_/Q VPWR VGND sg13g2_and2_1
X_253_ _253_/Q _258_/CLK _253_/D _135_/Y VPWR VGND sg13g2_dfrbpq_1
XFILLER_6_423 VPWR VGND sg13g2_decap_8
Xlane0.lp.c_hsprp.tempo VPWR VGND _136_/X _134_/A _299_/A fanout38/X _295_/A tempo_t24n
XFILLER_29_7 VPWR VGND sg13g2_decap_8
XFILLER_18_49 VPWR VGND sg13g2_decap_8
XFILLER_24_555 VPWR VGND sg13g2_decap_8
XFILLER_24_500 VPWR VGND sg13g2_decap_8
XFILLER_11_238 VPWR VGND sg13g2_decap_8
XFILLER_3_426 VPWR VGND sg13g2_decap_8
XFILLER_19_327 VPWR VGND sg13g2_decap_8
X_305_ _305_/X _305_/A VPWR VGND sg13g2_buf_1
XFILLER_30_536 VPWR VGND sg13g2_decap_8
XFILLER_27_382 VPWR VGND sg13g2_decap_8
XFILLER_24_81 VPWR VGND sg13g2_decap_8
X_167_ _174_/A _235_/Q _236_/Q _237_/Q VPWR VGND sg13g2_nand3_1
X_236_ _236_/Q _237_/CLK _236_/D _150_/Y VPWR VGND sg13g2_dfrbpq_1
XFILLER_6_297 VPWR VGND sg13g2_decap_8
XFILLER_6_220 VPWR VGND sg13g2_decap_8
XFILLER_27_4 VPWR VGND sg13g2_decap_8
XFILLER_16_319 VPWR VGND sg13g2_decap_8
XFILLER_29_636 VPWR VGND sg13g2_decap_8
XFILLER_28_168 VPWR VGND sg13g2_decap_8
XFILLER_12_569 VPWR VGND sg13g2_decap_4
XFILLER_24_374 VPWR VGND sg13g2_decap_8
XFILLER_4_713 VPWR VGND sg13g2_decap_8
XFILLER_3_256 VPWR VGND sg13g2_decap_8
XFILLER_19_135 VPWR VGND sg13g2_decap_8
XFILLER_19_157 VPWR VGND sg13g2_decap_8
X_219_ _252_/D _219_/A _221_/B VPWR VGND sg13g2_or2_1
XFILLER_7_540 VPWR VGND sg13g2_decap_8
XFILLER_30_333 VPWR VGND sg13g2_decap_8
XFILLER_18_0 VPWR VGND sg13g2_decap_8
Xlane3.lp.f10.tempo_71 lane3.lp.f10.tempo_71/L_HI VPWR VGND sg13g2_tiehi
XFILLER_15_28 VPWR VGND sg13g2_decap_8
XFILLER_21_344 VPWR VGND sg13g2_decap_8
Xoutput27 stop[0] _303_/X VPWR VGND sg13g2_buf_1
Xoutput16 hs_rx_en[1] _292_/X VPWR VGND sg13g2_buf_1
XFILLER_16_116 VPWR VGND sg13g2_decap_8
XFILLER_25_650 VPWR VGND sg13g2_decap_8
XFILLER_12_311 VPWR VGND sg13g2_decap_8
XFILLER_12_388 VPWR VGND sg13g2_decap_8
XFILLER_24_171 VPWR VGND sg13g2_decap_8
XFILLER_21_93 VPWR VGND sg13g2_decap_8
XFILLER_4_587 VPWR VGND sg13g2_decap_4
XFILLER_4_510 VPWR VGND sg13g2_decap_8
XFILLER_11_7 VPWR VGND sg13g2_decap_8
XFILLER_15_182 VPWR VGND sg13g2_decap_8
XFILLER_22_119 VPWR VGND sg13g2_decap_8
Xclk_lane.lp.c_hsprp.tempo VPWR VGND _131_/X _128_/A _127_/B fanout38/X _127_/A tempo_t24n
Xlane2.lp.c_stop.tempo VPWR VGND _146_/A _161_/Y lane2.lp.c_stop.tempo_67/L_HI fanout37/X
+ _305_/A tempo_t24n
XFILLER_30_130 VPWR VGND sg13g2_decap_8
XFILLER_21_185 VPWR VGND sg13g2_decap_8
XFILLER_22_675 VPWR VGND sg13g2_decap_8
XFILLER_5_329 VPWR VGND sg13g2_decap_8
XFILLER_29_252 VPWR VGND sg13g2_decap_8
XFILLER_13_620 VPWR VGND sg13g2_decap_8
XFILLER_16_60 VPWR VGND sg13g2_decap_8
XFILLER_17_469 VPWR VGND sg13g2_decap_8
XFILLER_12_185 VPWR VGND sg13g2_decap_8
XFILLER_13_697 VPWR VGND sg13g2_decap_8
XFILLER_9_679 VPWR VGND sg13g2_decap_8
XFILLER_4_384 VPWR VGND sg13g2_decap_8
XFILLER_23_406 VPWR VGND sg13g2_decap_8
Xhold112 _171_/A _294_/A VPWR VGND sg13g2_dlygate4sd3_1
Xhold134 _212_/A _121_/Y VPWR VGND sg13g2_dlygate4sd3_1
Xhold156 _175_/B1 _172_/Y VPWR VGND sg13g2_dlygate4sd3_1
Xclk_lane.c_miss.tempo VPWR VGND _113_/Y clk_lane.arm.u_xor/X _130_/X fanout38/X output11/A
+ tempo_t40n
XFILLER_10_678 VPWR VGND sg13g2_decap_8
XFILLER_5_126 VPWR VGND sg13g2_decap_8
XFILLER_27_81 VPWR VGND sg13g2_decap_8
XFILLER_13_483 VPWR VGND sg13g2_decap_8
XFILLER_17_266 VPWR VGND sg13g2_decap_8
XFILLER_9_410 VPWR VGND sg13g2_decap_8
XFILLER_9_476 VPWR VGND sg13g2_decap_8
XFILLER_4_63 VPWR VGND sg13g2_decap_8
XFILLER_4_192 VPWR VGND sg13g2_decap_8
XFILLER_23_203 VPWR VGND sg13g2_decap_8
XFILLER_23_28 VPWR VGND sg13g2_decap_8
XFILLER_10_420 VPWR VGND sg13g2_decap_8
XFILLER_15_715 VPWR VGND sg13g2_decap_8
X_252_ _291_/A _258_/CLK _252_/D _135_/Y VPWR VGND sg13g2_dfrbpq_1
Xfanout40 fanout40/X PG VPWR VGND sg13g2_buf_1
XFILLER_30_718 VPWR VGND sg13g2_fill_1
XFILLER_27_564 VPWR VGND sg13g2_decap_8
XFILLER_10_497 VPWR VGND sg13g2_decap_8
XFILLER_13_72 VPWR VGND sg13g2_decap_8
XFILLER_22_280 VPWR VGND sg13g2_decap_8
X_183_ _190_/A _242_/Q _243_/Q _244_/Q VPWR VGND sg13g2_nand3_1
XFILLER_6_479 VPWR VGND sg13g2_decap_8
XFILLER_6_402 VPWR VGND sg13g2_decap_8
XFILLER_9_284 VPWR VGND sg13g2_decap_8
XFILLER_5_490 VPWR VGND sg13g2_decap_8
XFILLER_18_28 VPWR VGND sg13g2_decap_8
XFILLER_11_217 VPWR VGND sg13g2_decap_8
XFILLER_12_707 VPWR VGND sg13g2_decap_8
XFILLER_24_545 VPWR VGND sg13g2_fill_1
XFILLER_3_405 VPWR VGND sg13g2_decap_8
XFILLER_19_306 VPWR VGND sg13g2_decap_8
XFILLER_27_361 VPWR VGND sg13g2_decap_8
X_235_ _235_/Q _237_/CLK _235_/D _150_/Y VPWR VGND sg13g2_dfrbpq_1
X_304_ _304_/X _304_/A VPWR VGND sg13g2_buf_1
XFILLER_7_722 VPWR VGND sg13g2_fill_1
XFILLER_30_515 VPWR VGND sg13g2_decap_8
XFILLER_24_60 VPWR VGND sg13g2_decap_8
XFILLER_10_294 VPWR VGND sg13g2_decap_8
X_166_ _166_/Y _165_/B _166_/B VPWR VGND sg13g2_nand2b_1
XFILLER_6_276 VPWR VGND sg13g2_decap_8
XFILLER_1_42 VPWR VGND sg13g2_decap_8
XFILLER_18_350 VPWR VGND sg13g2_decap_8
XFILLER_29_49 VPWR VGND sg13g2_decap_8
XFILLER_29_615 VPWR VGND sg13g2_decap_8
XFILLER_28_147 VPWR VGND sg13g2_decap_8
XFILLER_24_353 VPWR VGND sg13g2_decap_8
XFILLER_3_235 VPWR VGND sg13g2_decap_8
XFILLER_10_84 VPWR VGND sg13g2_decap_8
XFILLER_19_114 VPWR VGND sg13g2_decap_8
XFILLER_19_60 VPWR VGND sg13g2_decap_4
XFILLER_19_93 VPWR VGND sg13g2_decap_8
XFILLER_30_312 VPWR VGND sg13g2_decap_8
X_149_ _150_/A _149_/A _149_/B VPWR VGND sg13g2_or2_1
X_218_ _221_/B _222_/A _218_/B VPWR VGND sg13g2_nor2_1
XFILLER_30_389 VPWR VGND sg13g2_decap_8
XFILLER_7_596 VPWR VGND sg13g2_decap_8
XFILLER_25_139 VPWR VGND sg13g2_fill_2
XFILLER_21_323 VPWR VGND sg13g2_decap_8
XFILLER_1_717 VPWR VGND sg13g2_fill_2
Xoutput28 stop[1] _304_/X VPWR VGND sg13g2_buf_1
Xoutput17 hs_rx_en[2] _293_/X VPWR VGND sg13g2_buf_1
XFILLER_29_434 VPWR VGND sg13g2_decap_8
XFILLER_29_489 VPWR VGND sg13g2_decap_8
XFILLER_24_150 VPWR VGND sg13g2_decap_8
XFILLER_12_367 VPWR VGND sg13g2_decap_8
XFILLER_21_72 VPWR VGND sg13g2_decap_8
XFILLER_4_566 VPWR VGND sg13g2_decap_8
Xlane2.lp.f10.tempo_68 lane2.lp.f10.tempo_68/L_HI VPWR VGND sg13g2_tiehi
XFILLER_15_161 VPWR VGND sg13g2_decap_8
XFILLER_30_186 VPWR VGND sg13g2_decap_8
Xclk_lane.arm.u_arm_57 clk_lane.arm.u_arm/D VPWR VGND sg13g2_tiehi
XFILLER_21_142 VPWR VGND sg13g2_fill_2
XFILLER_21_164 VPWR VGND sg13g2_decap_8
XFILLER_22_654 VPWR VGND sg13g2_decap_8
XFILLER_5_308 VPWR VGND sg13g2_decap_8
XFILLER_29_231 VPWR VGND sg13g2_decap_8
XFILLER_13_676 VPWR VGND sg13g2_decap_8
XFILLER_9_625 VPWR VGND sg13g2_fill_1
XFILLER_12_164 VPWR VGND sg13g2_decap_8
XFILLER_9_658 VPWR VGND sg13g2_decap_8
Xhold168 _212_/B _209_/Y VPWR VGND sg13g2_dlygate4sd3_1
XFILLER_27_713 VPWR VGND sg13g2_decap_8
XFILLER_10_657 VPWR VGND sg13g2_decap_8
XFILLER_22_495 VPWR VGND sg13g2_decap_8
XFILLER_6_639 VPWR VGND sg13g2_decap_8
XFILLER_5_105 VPWR VGND sg13g2_decap_8
XFILLER_17_245 VPWR VGND sg13g2_decap_8
XFILLER_27_60 VPWR VGND sg13g2_decap_8
XFILLER_13_462 VPWR VGND sg13g2_decap_8
XFILLER_4_42 VPWR VGND sg13g2_decap_8
XFILLER_4_171 VPWR VGND sg13g2_decap_8
XFILLER_23_259 VPWR VGND sg13g2_decap_8
XFILLER_27_543 VPWR VGND sg13g2_decap_8
X_182_ _237_/D _180_/A _180_/B hold77/X VPWR VGND sg13g2_o21ai_1
X_251_ _251_/Q _251_/CLK _251_/D _140_/Y VPWR VGND sg13g2_dfrbpq_1
XFILLER_10_476 VPWR VGND sg13g2_decap_8
XFILLER_6_458 VPWR VGND sg13g2_decap_8
XFILLER_13_270 VPWR VGND sg13g2_decap_8
XFILLER_9_263 VPWR VGND sg13g2_decap_8
XFILLER_28_329 VPWR VGND sg13g2_decap_8
XFILLER_1_7 VPWR VGND sg13g2_decap_8
XFILLER_27_340 VPWR VGND sg13g2_decap_8
XFILLER_10_273 VPWR VGND sg13g2_decap_8
X_165_ _165_/Y _166_/B _165_/B VPWR VGND sg13g2_nand2b_1
X_234_ _234_/Q _237_/CLK _234_/D _150_/Y VPWR VGND sg13g2_dfrbpq_1
X_303_ _303_/X _303_/A VPWR VGND sg13g2_buf_1
XFILLER_6_255 VPWR VGND sg13g2_decap_8
XFILLER_1_21 VPWR VGND sg13g2_decap_8
XFILLER_18_384 VPWR VGND sg13g2_decap_8
XFILLER_21_505 VPWR VGND sg13g2_decap_4
XFILLER_29_28 VPWR VGND sg13g2_decap_8
XFILLER_28_126 VPWR VGND sg13g2_decap_8
XFILLER_24_332 VPWR VGND sg13g2_decap_8
XFILLER_12_538 VPWR VGND sg13g2_decap_8
XFILLER_10_63 VPWR VGND sg13g2_decap_8
XFILLER_19_72 VPWR VGND sg13g2_decap_8
XFILLER_15_343 VPWR VGND sg13g2_decap_8
XFILLER_15_398 VPWR VGND sg13g2_decap_8
XFILLER_28_693 VPWR VGND sg13g2_decap_8
XFILLER_11_582 VPWR VGND sg13g2_decap_4
X_148_ _149_/B _298_/A _302_/A VPWR VGND sg13g2_nor2_1
X_217_ _218_/B _254_/Q _253_/Q _255_/Q VPWR VGND sg13g2_a21oi_1
XFILLER_7_575 VPWR VGND sg13g2_decap_8
XFILLER_30_368 VPWR VGND sg13g2_decap_8
XFILLER_19_693 VPWR VGND sg13g2_decap_8
XFILLER_25_107 VPWR VGND sg13g2_decap_8
XFILLER_21_302 VPWR VGND sg13g2_decap_8
XFILLER_21_379 VPWR VGND sg13g2_decap_8
Xoutput29 stop[2] _305_/X VPWR VGND sg13g2_buf_1
Xoutput18 hs_rx_en[3] _294_/X VPWR VGND sg13g2_buf_1
XFILLER_29_468 VPWR VGND sg13g2_decap_8
XFILLER_29_413 VPWR VGND sg13g2_decap_8
XFILLER_25_685 VPWR VGND sg13g2_decap_8
XFILLER_12_346 VPWR VGND sg13g2_decap_8
XFILLER_4_545 VPWR VGND sg13g2_decap_8
XFILLER_28_490 VPWR VGND sg13g2_decap_8
XFILLER_15_140 VPWR VGND sg13g2_decap_8
XFILLER_16_685 VPWR VGND sg13g2_decap_8
XFILLER_30_165 VPWR VGND sg13g2_decap_8
XFILLER_7_86 VPWR VGND sg13g2_decap_8
XFILLER_7_53 VPWR VGND sg13g2_decap_8
XFILLER_7_383 VPWR VGND sg13g2_decap_8
XFILLER_23_0 VPWR VGND sg13g2_decap_8
XFILLER_19_490 VPWR VGND sg13g2_decap_8
XFILLER_21_121 VPWR VGND sg13g2_decap_8
XFILLER_22_633 VPWR VGND sg13g2_decap_8
XFILLER_17_427 VPWR VGND sg13g2_decap_4
XFILLER_29_287 VPWR VGND sg13g2_decap_8
XFILLER_29_210 VPWR VGND sg13g2_decap_8
XFILLER_13_655 VPWR VGND sg13g2_decap_8
XFILLER_16_95 VPWR VGND sg13g2_decap_8
XFILLER_9_637 VPWR VGND sg13g2_decap_8
XFILLER_4_364 VPWR VGND sg13g2_decap_8
Xhold158 _223_/B1 _220_/Y VPWR VGND sg13g2_dlygate4sd3_1
XFILLER_10_636 VPWR VGND sg13g2_decap_8
XFILLER_22_474 VPWR VGND sg13g2_decap_8
XFILLER_6_618 VPWR VGND sg13g2_decap_8
XFILLER_17_224 VPWR VGND sg13g2_decap_8
XFILLER_18_725 VPWR VGND sg13g2_fill_2
XFILLER_9_445 VPWR VGND sg13g2_decap_8
XFILLER_9_456 VPWR VGND sg13g2_fill_2
XFILLER_5_684 VPWR VGND sg13g2_decap_8
XFILLER_4_21 VPWR VGND sg13g2_decap_8
XFILLER_4_150 VPWR VGND sg13g2_decap_8
XFILLER_4_98 VPWR VGND sg13g2_decap_8
XFILLER_23_238 VPWR VGND sg13g2_decap_8
XFILLER_24_706 VPWR VGND sg13g2_decap_8
Xclk_lane.arm.u_arm _130_/A clk_lane.arm.u_arm/D clk_lane.arm.u_xor/X _130_/B VPWR
+ VGND sg13g2_dlhrq_1
XFILLER_27_599 VPWR VGND sg13g2_decap_8
XFILLER_27_522 VPWR VGND sg13g2_decap_8
XFILLER_10_455 VPWR VGND sg13g2_decap_8
X_181_ _236_/D _173_/B _181_/B VPWR VGND sg13g2_nand2b_1
X_250_ _250_/Q _250_/CLK _250_/D _140_/Y VPWR VGND sg13g2_dfrbpq_1
XFILLER_6_437 VPWR VGND sg13g2_decap_8
XFILLER_18_533 VPWR VGND sg13g2_fill_2
XFILLER_9_242 VPWR VGND sg13g2_decap_8
XFILLER_28_308 VPWR VGND sg13g2_decap_8
XFILLER_24_569 VPWR VGND sg13g2_decap_8
X_302_ _302_/X _302_/A VPWR VGND sg13g2_buf_1
XFILLER_27_396 VPWR VGND sg13g2_decap_8
XFILLER_10_252 VPWR VGND sg13g2_decap_8
XFILLER_11_720 VPWR VGND sg13g2_decap_8
X_164_ _164_/Y _165_/B _166_/B VPWR VGND sg13g2_nand2_1
X_233_ _233_/Q _237_/CLK _233_/D _150_/Y VPWR VGND sg13g2_dfrbpq_1
XFILLER_7_713 VPWR VGND sg13g2_decap_8
XFILLER_6_234 VPWR VGND sg13g2_decap_8
XFILLER_24_95 VPWR VGND sg13g2_decap_8
XFILLER_28_105 VPWR VGND sg13g2_decap_8
XFILLER_24_388 VPWR VGND sg13g2_decap_8
XFILLER_24_311 VPWR VGND sg13g2_decap_8
XFILLER_10_42 VPWR VGND sg13g2_decap_8
XFILLER_3_215 VPWR VGND sg13g2_decap_8
Xlane2.lp.c_stop.tempo_67 lane2.lp.c_stop.tempo_67/L_HI VPWR VGND sg13g2_tiehi
XFILLER_28_672 VPWR VGND sg13g2_decap_8
XFILLER_15_322 VPWR VGND sg13g2_decap_8
XFILLER_30_347 VPWR VGND sg13g2_decap_8
XFILLER_27_193 VPWR VGND sg13g2_decap_8
X_147_ _149_/A _165_/B _166_/B VPWR VGND sg13g2_or2_1
X_216_ _222_/B _254_/Q _253_/Q VPWR VGND sg13g2_and2_1
XFILLER_7_554 VPWR VGND sg13g2_decap_8
XFILLER_7_532 VPWR VGND sg13g2_decap_4
XFILLER_18_182 VPWR VGND sg13g2_decap_8
XFILLER_19_672 VPWR VGND sg13g2_decap_8
XFILLER_21_358 VPWR VGND sg13g2_decap_8
Xoutput19 hspr[0] _295_/X VPWR VGND sg13g2_buf_1
XFILLER_29_447 VPWR VGND sg13g2_decap_8
XFILLER_12_325 VPWR VGND sg13g2_decap_8
XFILLER_25_664 VPWR VGND sg13g2_decap_8
XFILLER_24_185 VPWR VGND sg13g2_decap_8
XFILLER_24_130 VPWR VGND sg13g2_decap_8
XFILLER_21_63 VPWR VGND sg13g2_decap_4
XFILLER_4_524 VPWR VGND sg13g2_decap_8
XFILLER_16_664 VPWR VGND sg13g2_decap_8
XFILLER_15_196 VPWR VGND sg13g2_decap_8
XFILLER_7_32 VPWR VGND sg13g2_decap_8
XFILLER_30_144 VPWR VGND sg13g2_decap_8
XFILLER_7_362 VPWR VGND sg13g2_decap_8
XFILLER_21_100 VPWR VGND sg13g2_decap_8
XFILLER_21_144 VPWR VGND sg13g2_fill_1
XFILLER_22_612 VPWR VGND sg13g2_decap_8
XFILLER_21_199 VPWR VGND sg13g2_decap_8
XFILLER_22_689 VPWR VGND sg13g2_decap_8
Xclkbuf_1_1__f_rx_clk clk_lane.arm.u_xor/A clkbuf_0_rx_clk/X VPWR VGND sg13g2_buf_16
XFILLER_17_406 VPWR VGND sg13g2_decap_8
XFILLER_29_266 VPWR VGND sg13g2_decap_8
XFILLER_12_133 VPWR VGND sg13g2_decap_8
XFILLER_12_144 VPWR VGND sg13g2_fill_1
XFILLER_12_199 VPWR VGND sg13g2_decap_8
XFILLER_13_634 VPWR VGND sg13g2_decap_8
XFILLER_16_74 VPWR VGND sg13g2_decap_8
XFILLER_25_483 VPWR VGND sg13g2_decap_8
XFILLER_4_398 VPWR VGND sg13g2_decap_8
XFILLER_4_343 VPWR VGND sg13g2_decap_8
XFILLER_16_483 VPWR VGND sg13g2_decap_8
Xhold115 _248_/D _208_/Y VPWR VGND sg13g2_dlygate4sd3_1
Xhold126 _180_/A _115_/Y VPWR VGND sg13g2_dlygate4sd3_1
XFILLER_7_192 VPWR VGND sg13g2_decap_8
XFILLER_10_615 VPWR VGND sg13g2_decap_8
XFILLER_22_453 VPWR VGND sg13g2_decap_8
XFILLER_17_203 VPWR VGND sg13g2_decap_8
XFILLER_18_704 VPWR VGND sg13g2_decap_8
XFILLER_13_442 VPWR VGND sg13g2_decap_8
XFILLER_27_95 VPWR VGND sg13g2_decap_8
XFILLER_13_497 VPWR VGND sg13g2_decap_8
XFILLER_9_424 VPWR VGND sg13g2_decap_8
XFILLER_5_663 VPWR VGND sg13g2_decap_8
XFILLER_4_77 VPWR VGND sg13g2_decap_8
XFILLER_4_140 VPWR VGND sg13g2_decap_4
XFILLER_16_291 VPWR VGND sg13g2_decap_8
XFILLER_23_217 VPWR VGND sg13g2_decap_8
XFILLER_27_501 VPWR VGND sg13g2_decap_8
XFILLER_27_578 VPWR VGND sg13g2_decap_8
XFILLER_10_434 VPWR VGND sg13g2_decap_8
XFILLER_13_53 VPWR VGND sg13g2_decap_8
XFILLER_13_86 VPWR VGND sg13g2_decap_8
X_180_ _181_/B _180_/A _180_/B VPWR VGND sg13g2_xnor2_1
XFILLER_6_416 VPWR VGND sg13g2_decap_8
XFILLER_13_294 VPWR VGND sg13g2_decap_8
XFILLER_9_221 VPWR VGND sg13g2_decap_8
XFILLER_9_298 VPWR VGND sg13g2_decap_8
XFILLER_3_419 VPWR VGND sg13g2_decap_8
Xclk_lane.lp.f10.tempo_43 clk_lane.lp.f10.tempo/ARM VPWR VGND sg13g2_tielo
XFILLER_15_504 VPWR VGND sg13g2_decap_8
X_232_ _232_/Q _237_/CLK _232_/D _150_/Y VPWR VGND sg13g2_dfrbpq_1
X_301_ _301_/X _301_/A VPWR VGND sg13g2_buf_1
XFILLER_30_529 VPWR VGND sg13g2_decap_8
XFILLER_27_375 VPWR VGND sg13g2_decap_8
XFILLER_24_74 VPWR VGND sg13g2_decap_8
XFILLER_10_231 VPWR VGND sg13g2_decap_8
X_163_ _163_/Y _162_/B _163_/B VPWR VGND sg13g2_nand2b_1
XFILLER_6_213 VPWR VGND sg13g2_decap_8
XFILLER_29_629 VPWR VGND sg13g2_decap_8
XFILLER_12_507 VPWR VGND sg13g2_decap_4
XFILLER_24_367 VPWR VGND sg13g2_decap_8
XFILLER_10_21 VPWR VGND sg13g2_decap_8
XFILLER_4_706 VPWR VGND sg13g2_decap_8
XFILLER_10_98 VPWR VGND sg13g2_decap_8
XFILLER_3_249 VPWR VGND sg13g2_decap_8
XFILLER_15_301 VPWR VGND sg13g2_decap_8
XFILLER_19_128 VPWR VGND sg13g2_decap_8
XFILLER_28_651 VPWR VGND sg13g2_decap_8
XFILLER_27_172 VPWR VGND sg13g2_decap_8
X_215_ _222_/A _256_/Q _257_/Q _258_/Q VPWR VGND sg13g2_nand3_1
XFILLER_7_511 VPWR VGND sg13g2_decap_8
XFILLER_30_326 VPWR VGND sg13g2_decap_8
X_146_ _146_/X _146_/A _146_/B VPWR VGND sg13g2_or2_1
XFILLER_18_161 VPWR VGND sg13g2_decap_8
XFILLER_21_337 VPWR VGND sg13g2_decap_8
XFILLER_16_109 VPWR VGND sg13g2_decap_8
XFILLER_25_643 VPWR VGND sg13g2_decap_8
XFILLER_12_304 VPWR VGND sg13g2_decap_8
XFILLER_24_164 VPWR VGND sg13g2_decap_8
XFILLER_21_42 VPWR VGND sg13g2_decap_8
XFILLER_21_86 VPWR VGND sg13g2_decap_8
XFILLER_4_503 VPWR VGND sg13g2_decap_8
XFILLER_15_175 VPWR VGND sg13g2_decap_8
XFILLER_11_392 VPWR VGND sg13g2_decap_8
XFILLER_7_341 VPWR VGND sg13g2_decap_8
XFILLER_7_11 VPWR VGND sg13g2_decap_8
XFILLER_30_123 VPWR VGND sg13g2_decap_8
X_129_ _129_/Y _129_/A VPWR VGND sg13g2_inv_1
XFILLER_21_178 VPWR VGND sg13g2_decap_8
XFILLER_22_668 VPWR VGND sg13g2_decap_8
XFILLER_30_690 VPWR VGND sg13g2_decap_8
XFILLER_29_245 VPWR VGND sg13g2_decap_8
XFILLER_13_613 VPWR VGND sg13g2_decap_8
XFILLER_16_53 VPWR VGND sg13g2_decap_8
XFILLER_25_462 VPWR VGND sg13g2_decap_8
XFILLER_12_112 VPWR VGND sg13g2_decap_8
XFILLER_12_178 VPWR VGND sg13g2_decap_8
XFILLER_4_322 VPWR VGND sg13g2_decap_8
XFILLER_16_462 VPWR VGND sg13g2_decap_8
Xhold138 _179_/A2 _178_/X VPWR VGND sg13g2_dlygate4sd3_1
XFILLER_7_171 VPWR VGND sg13g2_decap_8
XFILLER_10_605 VPWR VGND sg13g2_fill_1
XFILLER_22_432 VPWR VGND sg13g2_decap_8
XFILLER_5_119 VPWR VGND sg13g2_decap_8
Xlane0.lp.c_hsreq.tempo VPWR VGND _136_/X _156_/Y _303_/A fanout36/X _299_/A tempo_t24n
XFILLER_13_432 VPWR VGND sg13g2_fill_1
XFILLER_13_454 VPWR VGND sg13g2_decap_4
XFILLER_13_476 VPWR VGND sg13g2_decap_8
XFILLER_17_259 VPWR VGND sg13g2_decap_8
XFILLER_9_403 VPWR VGND sg13g2_decap_8
XFILLER_27_74 VPWR VGND sg13g2_decap_8
XFILLER_25_270 VPWR VGND sg13g2_decap_8
XFILLER_9_469 VPWR VGND sg13g2_decap_8
XFILLER_5_642 VPWR VGND sg13g2_decap_8
XFILLER_4_56 VPWR VGND sg13g2_decap_8
XFILLER_4_185 VPWR VGND sg13g2_decap_8
XFILLER_16_270 VPWR VGND sg13g2_decap_8
XFILLER_15_708 VPWR VGND sg13g2_decap_8
XFILLER_27_557 VPWR VGND sg13g2_decap_8
XFILLER_10_413 VPWR VGND sg13g2_decap_8
XFILLER_13_32 VPWR VGND sg13g2_decap_8
XFILLER_22_273 VPWR VGND sg13g2_decap_8
XFILLER_9_277 VPWR VGND sg13g2_decap_8
XFILLER_9_200 VPWR VGND sg13g2_decap_8
XFILLER_5_483 VPWR VGND sg13g2_decap_8
XFILLER_27_354 VPWR VGND sg13g2_decap_8
XFILLER_10_210 VPWR VGND sg13g2_decap_8
X_162_ _162_/Y _163_/B _162_/B VPWR VGND sg13g2_nand2b_1
X_231_ _294_/A _237_/CLK _231_/D _150_/Y VPWR VGND sg13g2_dfrbpq_1
X_300_ _300_/X _300_/A VPWR VGND sg13g2_buf_1
XFILLER_30_508 VPWR VGND sg13g2_decap_8
XFILLER_24_53 VPWR VGND sg13g2_decap_8
XFILLER_10_287 VPWR VGND sg13g2_decap_8
XFILLER_6_269 VPWR VGND sg13g2_decap_8
XFILLER_6_0 VPWR VGND sg13g2_decap_8
XFILLER_1_35 VPWR VGND sg13g2_decap_8
XFILLER_18_343 VPWR VGND sg13g2_decap_8
XFILLER_18_398 VPWR VGND sg13g2_decap_8
XFILLER_5_280 VPWR VGND sg13g2_decap_8
Xinput1 _153_/B clk_lp_n VPWR VGND sg13g2_buf_1
XFILLER_29_608 VPWR VGND sg13g2_decap_8
XFILLER_24_346 VPWR VGND sg13g2_decap_8
XFILLER_3_228 VPWR VGND sg13g2_decap_8
XFILLER_10_77 VPWR VGND sg13g2_decap_8
XFILLER_19_107 VPWR VGND sg13g2_decap_8
XFILLER_19_53 VPWR VGND sg13g2_decap_8
XFILLER_19_86 VPWR VGND sg13g2_decap_8
XFILLER_28_630 VPWR VGND sg13g2_decap_8
XFILLER_27_151 VPWR VGND sg13g2_decap_8
XFILLER_11_552 VPWR VGND sg13g2_fill_1
X_145_ _145_/Y _145_/A VPWR VGND sg13g2_inv_1
X_214_ _251_/D _212_/A _212_/B hold80/X VPWR VGND sg13g2_o21ai_1
Xclk_lane.lp.c_hsreq.tempo VPWR VGND _131_/X _153_/Y output13/A fanout35/X _127_/B
+ tempo_t24n
XFILLER_30_305 VPWR VGND sg13g2_decap_8
XFILLER_7_589 VPWR VGND sg13g2_decap_8
XFILLER_18_140 VPWR VGND sg13g2_decap_8
XFILLER_21_316 VPWR VGND sg13g2_decap_8
Xclk_lane.c_settle.tempo_41 clk_lane.c_settle.tempo/ARM VPWR VGND sg13g2_tielo
Xlane1.lp.c_stop.tempo_64 lane1.lp.c_stop.tempo_64/L_HI VPWR VGND sg13g2_tiehi
XFILLER_29_427 VPWR VGND sg13g2_decap_8
XFILLER_25_622 VPWR VGND sg13g2_decap_8
XFILLER_21_21 VPWR VGND sg13g2_decap_8
Xlane1.c_term.tempo VPWR VGND _140_/A lane1.c_term.tempo/ARM _140_/Y fanout38/X _308_/A
+ tempo_t24n
XFILLER_25_699 VPWR VGND sg13g2_decap_8
XFILLER_0_710 VPWR VGND sg13g2_decap_8
XFILLER_0_721 VPWR VGND sg13g2_fill_2
XFILLER_4_559 VPWR VGND sg13g2_decap_8
XFILLER_15_154 VPWR VGND sg13g2_decap_8
XFILLER_16_699 VPWR VGND sg13g2_decap_8
XFILLER_30_102 VPWR VGND sg13g2_decap_8
XFILLER_11_371 VPWR VGND sg13g2_decap_8
X_128_ _129_/A _128_/A _128_/B VPWR VGND sg13g2_or2_1
XFILLER_7_397 VPWR VGND sg13g2_decap_8
XFILLER_7_320 VPWR VGND sg13g2_decap_8
XFILLER_30_179 VPWR VGND sg13g2_decap_8
XFILLER_30_4 VPWR VGND sg13g2_decap_8
XFILLER_21_135 VPWR VGND sg13g2_decap_8
XFILLER_21_157 VPWR VGND sg13g2_decap_8
XFILLER_22_647 VPWR VGND sg13g2_decap_8
XFILLER_29_224 VPWR VGND sg13g2_decap_8
XFILLER_16_32 VPWR VGND sg13g2_decap_8
XFILLER_12_157 VPWR VGND sg13g2_decap_8
XFILLER_13_669 VPWR VGND sg13g2_decap_8
XFILLER_4_301 VPWR VGND sg13g2_decap_8
XFILLER_16_441 VPWR VGND sg13g2_fill_1
Xhold106 _223_/B2 _123_/Y VPWR VGND sg13g2_dlygate4sd3_1
Xhold117 _207_/B2 _120_/Y VPWR VGND sg13g2_dlygate4sd3_1
XFILLER_7_150 VPWR VGND sg13g2_decap_8
XFILLER_21_0 VPWR VGND sg13g2_decap_8
XFILLER_27_706 VPWR VGND sg13g2_decap_8
XFILLER_22_411 VPWR VGND sg13g2_decap_8
XFILLER_22_488 VPWR VGND sg13g2_decap_8
XFILLER_17_238 VPWR VGND sg13g2_decap_8
XFILLER_27_53 VPWR VGND sg13g2_decap_8
XFILLER_13_411 VPWR VGND sg13g2_decap_8
XFILLER_5_698 VPWR VGND sg13g2_decap_8
XFILLER_5_621 VPWR VGND sg13g2_decap_8
XFILLER_4_164 VPWR VGND sg13g2_decap_8
XFILLER_4_35 VPWR VGND sg13g2_decap_8
Xclkbuf_0_rx_clk clkbuf_0_rx_clk/X clkbuf_0_rx_clk/A VPWR VGND sg13g2_buf_16
XFILLER_27_536 VPWR VGND sg13g2_decap_8
XFILLER_13_11 VPWR VGND sg13g2_decap_8
XFILLER_22_252 VPWR VGND sg13g2_decap_8
XFILLER_23_720 VPWR VGND sg13g2_decap_8
XFILLER_10_469 VPWR VGND sg13g2_decap_8
XFILLER_13_263 VPWR VGND sg13g2_decap_8
XFILLER_9_256 VPWR VGND sg13g2_decap_8
XFILLER_5_462 VPWR VGND sg13g2_decap_8
Xclk_lane.lp.c_stop.tempo VPWR VGND _131_/A _152_/Y clk_lane.lp.c_stop.tempo_58/L_HI
+ fanout35/X output13/A tempo_t24n
XFILLER_27_333 VPWR VGND sg13g2_decap_8
XFILLER_10_266 VPWR VGND sg13g2_decap_8
XFILLER_23_561 VPWR VGND sg13g2_decap_8
XFILLER_23_572 VPWR VGND sg13g2_fill_1
X_161_ _161_/Y _162_/B _163_/B VPWR VGND sg13g2_nand2_1
X_230_ _258_/D _228_/A _228_/B hold74/X VPWR VGND sg13g2_o21ai_1
XFILLER_24_32 VPWR VGND sg13g2_decap_8
XFILLER_6_248 VPWR VGND sg13g2_decap_8
XFILLER_18_322 VPWR VGND sg13g2_decap_8
XFILLER_1_14 VPWR VGND sg13g2_decap_8
XFILLER_21_509 VPWR VGND sg13g2_fill_2
Xinput2 _154_/B clk_lp_p VPWR VGND sg13g2_buf_1
XFILLER_28_119 VPWR VGND sg13g2_decap_8
XFILLER_24_325 VPWR VGND sg13g2_decap_8
XFILLER_10_56 VPWR VGND sg13g2_decap_8
XFILLER_19_32 VPWR VGND sg13g2_decap_8
XFILLER_15_336 VPWR VGND sg13g2_decap_8
XFILLER_28_686 VPWR VGND sg13g2_decap_8
XFILLER_27_130 VPWR VGND sg13g2_decap_8
XFILLER_11_586 VPWR VGND sg13g2_fill_2
X_144_ _145_/A _144_/A _144_/B VPWR VGND sg13g2_or2_1
X_213_ _250_/D _205_/B _213_/B VPWR VGND sg13g2_nand2b_1
XFILLER_7_568 VPWR VGND sg13g2_decap_8
Xlane3.lp.f10.tempo_55 lane3.lp.f10.tempo/ARM VPWR VGND sg13g2_tielo
XFILLER_25_7 VPWR VGND sg13g2_decap_8
XFILLER_19_620 VPWR VGND sg13g2_decap_4
XFILLER_19_686 VPWR VGND sg13g2_decap_8
XFILLER_18_196 VPWR VGND sg13g2_decap_8
XFILLER_29_406 VPWR VGND sg13g2_decap_8
XFILLER_25_678 VPWR VGND sg13g2_decap_8
XFILLER_24_144 VPWR VGND sg13g2_fill_1
XFILLER_12_339 VPWR VGND sg13g2_decap_8
XFILLER_24_199 VPWR VGND sg13g2_decap_8
XFILLER_4_538 VPWR VGND sg13g2_decap_8
XFILLER_16_634 VPWR VGND sg13g2_fill_2
XFILLER_28_483 VPWR VGND sg13g2_decap_8
XFILLER_11_350 VPWR VGND sg13g2_decap_8
XFILLER_15_133 VPWR VGND sg13g2_decap_8
XFILLER_16_678 VPWR VGND sg13g2_decap_8
XFILLER_30_158 VPWR VGND sg13g2_decap_8
X_127_ _128_/B _127_/A _127_/B VPWR VGND sg13g2_nor2_1
XFILLER_7_79 VPWR VGND sg13g2_decap_8
XFILLER_7_46 VPWR VGND sg13g2_decap_8
XFILLER_7_376 VPWR VGND sg13g2_decap_8
XFILLER_3_582 VPWR VGND sg13g2_decap_8
XFILLER_19_483 VPWR VGND sg13g2_decap_8
XFILLER_22_626 VPWR VGND sg13g2_decap_8
XFILLER_21_114 VPWR VGND sg13g2_decap_8
XFILLER_16_11 VPWR VGND sg13g2_decap_8
XFILLER_29_203 VPWR VGND sg13g2_decap_8
XFILLER_13_648 VPWR VGND sg13g2_decap_8
XFILLER_16_88 VPWR VGND sg13g2_decap_8
XFILLER_25_497 VPWR VGND sg13g2_decap_8
XFILLER_25_453 VPWR VGND sg13g2_fill_2
XFILLER_25_442 VPWR VGND sg13g2_decap_8
XFILLER_21_681 VPWR VGND sg13g2_decap_8
XFILLER_4_357 VPWR VGND sg13g2_decap_8
XFILLER_28_280 VPWR VGND sg13g2_decap_8
XFILLER_16_497 VPWR VGND sg13g2_decap_8
XFILLER_19_291 VPWR VGND sg13g2_decap_8
XFILLER_22_467 VPWR VGND sg13g2_decap_8
XFILLER_10_629 VPWR VGND sg13g2_decap_8
XFILLER_17_217 VPWR VGND sg13g2_decap_8
XFILLER_18_718 VPWR VGND sg13g2_decap_8
XFILLER_27_32 VPWR VGND sg13g2_decap_8
XFILLER_9_438 VPWR VGND sg13g2_decap_8
XFILLER_5_677 VPWR VGND sg13g2_decap_8
XFILLER_4_14 VPWR VGND sg13g2_decap_8
XFILLER_27_515 VPWR VGND sg13g2_decap_8
XFILLER_10_448 VPWR VGND sg13g2_decap_8
XFILLER_22_231 VPWR VGND sg13g2_decap_8
Xfanout35 fanout35/X fanout37/X VPWR VGND sg13g2_buf_1
XFILLER_18_504 VPWR VGND sg13g2_decap_8
XFILLER_13_242 VPWR VGND sg13g2_decap_8
XFILLER_9_235 VPWR VGND sg13g2_decap_8
XFILLER_5_441 VPWR VGND sg13g2_decap_8
XFILLER_24_507 VPWR VGND sg13g2_decap_4
XFILLER_17_570 VPWR VGND sg13g2_fill_1
XFILLER_27_389 VPWR VGND sg13g2_decap_8
XFILLER_27_312 VPWR VGND sg13g2_decap_8
XFILLER_24_11 VPWR VGND sg13g2_decap_8
XFILLER_10_245 VPWR VGND sg13g2_decap_8
XFILLER_11_713 VPWR VGND sg13g2_decap_8
XFILLER_23_584 VPWR VGND sg13g2_fill_1
X_160_ _160_/Y _159_/B _160_/B VPWR VGND sg13g2_nand2b_1
XFILLER_7_706 VPWR VGND sg13g2_decap_8
XFILLER_6_227 VPWR VGND sg13g2_decap_8
XFILLER_24_88 VPWR VGND sg13g2_decap_8
XFILLER_18_301 VPWR VGND sg13g2_decap_8
Xinput3 _156_/B lp_n[0] VPWR VGND sg13g2_buf_1
XFILLER_24_304 VPWR VGND sg13g2_decap_8
XFILLER_10_35 VPWR VGND sg13g2_decap_8
XFILLER_3_208 VPWR VGND sg13g2_decap_8
XFILLER_19_11 VPWR VGND sg13g2_decap_8
XFILLER_28_665 VPWR VGND sg13g2_decap_8
XFILLER_15_315 VPWR VGND sg13g2_decap_8
XFILLER_23_392 VPWR VGND sg13g2_decap_8
X_212_ _213_/B _212_/A _212_/B VPWR VGND sg13g2_xnor2_1
XFILLER_27_186 VPWR VGND sg13g2_decap_8
X_143_ _144_/B _297_/A _301_/A VPWR VGND sg13g2_nor2_1
XFILLER_7_547 VPWR VGND sg13g2_decap_8
XFILLER_7_525 VPWR VGND sg13g2_decap_8
XFILLER_18_175 VPWR VGND sg13g2_decap_8
XFILLER_18_7 VPWR VGND sg13g2_decap_8
XFILLER_19_665 VPWR VGND sg13g2_decap_8
Xlane3.lp.c_stop.tempo VPWR VGND _151_/A _164_/Y lane3.lp.c_stop.tempo_70/L_HI fanout37/X
+ _306_/A tempo_t24n
XFILLER_6_591 VPWR VGND sg13g2_fill_2
XFILLER_12_318 VPWR VGND sg13g2_decap_8
XFILLER_25_657 VPWR VGND sg13g2_decap_8
XFILLER_24_178 VPWR VGND sg13g2_decap_8
XFILLER_24_123 VPWR VGND sg13g2_decap_8
XFILLER_21_56 VPWR VGND sg13g2_decap_8
XFILLER_21_67 VPWR VGND sg13g2_fill_1
XFILLER_4_517 VPWR VGND sg13g2_decap_8
Xlane3.lp.c_hsprp.tempo VPWR VGND _151_/X _149_/A _302_/A fanout39/X _298_/A tempo_t24n
XFILLER_15_112 VPWR VGND sg13g2_decap_8
XFILLER_28_462 VPWR VGND sg13g2_decap_8
XFILLER_15_189 VPWR VGND sg13g2_decap_8
XFILLER_7_25 VPWR VGND sg13g2_decap_8
XFILLER_30_137 VPWR VGND sg13g2_decap_8
X_126_ _128_/A _153_/B _154_/B VPWR VGND sg13g2_or2_1
Xlane0.lp.c_stop.tempo_61 lane0.lp.c_stop.tempo_61/L_HI VPWR VGND sg13g2_tiehi
XFILLER_7_355 VPWR VGND sg13g2_decap_8
XFILLER_3_561 VPWR VGND sg13g2_decap_8
XFILLER_16_4 VPWR VGND sg13g2_decap_8
XFILLER_19_462 VPWR VGND sg13g2_decap_8
XFILLER_29_259 VPWR VGND sg13g2_decap_8
XFILLER_25_432 VPWR VGND sg13g2_fill_1
XFILLER_12_126 VPWR VGND sg13g2_decap_8
XFILLER_13_627 VPWR VGND sg13g2_decap_8
XFILLER_16_67 VPWR VGND sg13g2_decap_8
XFILLER_25_476 VPWR VGND sg13g2_decap_8
XFILLER_4_336 VPWR VGND sg13g2_decap_8
XFILLER_16_476 VPWR VGND sg13g2_decap_8
XFILLER_12_693 VPWR VGND sg13g2_decap_8
XFILLER_7_185 VPWR VGND sg13g2_decap_8
XFILLER_3_391 VPWR VGND sg13g2_decap_8
XFILLER_19_270 VPWR VGND sg13g2_decap_8
XFILLER_22_446 VPWR VGND sg13g2_decap_8
XFILLER_27_11 VPWR VGND sg13g2_decap_8
XFILLER_27_88 VPWR VGND sg13g2_decap_8
XFILLER_25_284 VPWR VGND sg13g2_decap_4
XFILLER_9_417 VPWR VGND sg13g2_decap_8
Xlane2.c_term.tempo_51 lane2.c_term.tempo/ARM VPWR VGND sg13g2_tielo
XFILLER_5_656 VPWR VGND sg13g2_decap_8
XFILLER_4_199 VPWR VGND sg13g2_decap_8
XFILLER_4_144 VPWR VGND sg13g2_fill_1
XFILLER_4_133 VPWR VGND sg13g2_decap_8
XFILLER_16_284 VPWR VGND sg13g2_decap_8
XFILLER_22_210 VPWR VGND sg13g2_decap_8
XFILLER_10_427 VPWR VGND sg13g2_decap_8
XFILLER_13_46 VPWR VGND sg13g2_decap_8
XFILLER_13_79 VPWR VGND sg13g2_decap_8
XFILLER_22_287 VPWR VGND sg13g2_decap_8
Xfanout36 fanout36/X fanout37/X VPWR VGND sg13g2_buf_1
XFILLER_6_409 VPWR VGND sg13g2_decap_8
XFILLER_9_214 VPWR VGND sg13g2_decap_8
XFILLER_13_287 VPWR VGND sg13g2_decap_8
XFILLER_5_420 VPWR VGND sg13g2_decap_8
Xlane0.lp.f11.tempo_63 lane0.lp.f11.tempo_63/L_HI VPWR VGND sg13g2_tiehi
XFILLER_5_497 VPWR VGND sg13g2_decap_8
XFILLER_5_91 VPWR VGND sg13g2_decap_8
XFILLER_27_368 VPWR VGND sg13g2_decap_8
XFILLER_24_67 VPWR VGND sg13g2_decap_8
XFILLER_10_224 VPWR VGND sg13g2_decap_8
Xlane0.lp.f11.tempo VPWR VGND _155_/Y lane0.lp.f11.tempo/ARM lane0.lp.f11.tempo_63/L_HI
+ fanout35/X _136_/B tempo_t24n
XFILLER_6_206 VPWR VGND sg13g2_decap_8
XFILLER_5_294 VPWR VGND sg13g2_decap_8
Xinput4 _159_/B lp_n[1] VPWR VGND sg13g2_buf_1
XFILLER_10_14 VPWR VGND sg13g2_decap_8
XFILLER_28_644 VPWR VGND sg13g2_decap_8
XFILLER_27_165 VPWR VGND sg13g2_decap_8
XFILLER_11_511 VPWR VGND sg13g2_fill_1
XFILLER_11_566 VPWR VGND sg13g2_fill_2
XFILLER_23_371 VPWR VGND sg13g2_decap_8
X_142_ _144_/A _162_/B _163_/B VPWR VGND sg13g2_or2_1
X_211_ _249_/D _212_/B _211_/A2 _205_/B VPWR VGND sg13g2_a21o_1
XFILLER_7_504 VPWR VGND sg13g2_decap_8
XFILLER_30_319 VPWR VGND sg13g2_decap_8
XFILLER_4_0 VPWR VGND sg13g2_decap_8
XFILLER_18_154 VPWR VGND sg13g2_decap_8
XFILLER_6_570 VPWR VGND sg13g2_decap_8
XFILLER_24_102 VPWR VGND sg13g2_decap_8
XFILLER_25_636 VPWR VGND sg13g2_decap_8
XFILLER_24_157 VPWR VGND sg13g2_decap_8
XFILLER_21_35 VPWR VGND sg13g2_decap_8
XFILLER_21_79 VPWR VGND sg13g2_decap_8
XFILLER_15_168 VPWR VGND sg13g2_decap_8
XFILLER_16_636 VPWR VGND sg13g2_fill_1
Xclkbuf_2_0__f_rx_clk_regs _250_/CLK clkbuf_0_rx_clk_regs/X VPWR VGND sg13g2_buf_16
XFILLER_28_441 VPWR VGND sg13g2_decap_8
XFILLER_11_385 VPWR VGND sg13g2_decap_8
X_125_ _125_/Y _258_/Q VPWR VGND sg13g2_inv_1
XFILLER_7_334 VPWR VGND sg13g2_decap_8
XFILLER_30_116 VPWR VGND sg13g2_decap_8
XFILLER_3_540 VPWR VGND sg13g2_decap_8
XFILLER_30_683 VPWR VGND sg13g2_decap_8
XFILLER_13_606 VPWR VGND sg13g2_decap_8
XFILLER_16_46 VPWR VGND sg13g2_decap_8
XFILLER_29_238 VPWR VGND sg13g2_decap_8
XFILLER_25_411 VPWR VGND sg13g2_decap_8
XFILLER_12_105 VPWR VGND sg13g2_decap_8
XFILLER_21_650 VPWR VGND sg13g2_decap_8
XFILLER_21_661 VPWR VGND sg13g2_fill_2
XFILLER_4_315 VPWR VGND sg13g2_decap_8
XFILLER_11_182 VPWR VGND sg13g2_decap_8
XFILLER_12_672 VPWR VGND sg13g2_decap_8
XFILLER_7_164 VPWR VGND sg13g2_decap_8
XFILLER_22_425 VPWR VGND sg13g2_decap_8
XFILLER_30_480 VPWR VGND sg13g2_decap_8
XFILLER_13_425 VPWR VGND sg13g2_decap_8
XFILLER_27_67 VPWR VGND sg13g2_decap_8
XFILLER_25_263 VPWR VGND sg13g2_decap_8
XFILLER_13_469 VPWR VGND sg13g2_decap_8
XFILLER_21_491 VPWR VGND sg13g2_decap_8
XFILLER_5_635 VPWR VGND sg13g2_decap_8
XFILLER_4_112 VPWR VGND sg13g2_decap_8
XFILLER_4_49 VPWR VGND sg13g2_decap_8
XFILLER_4_178 VPWR VGND sg13g2_decap_8
XFILLER_29_580 VPWR VGND sg13g2_decap_8
XFILLER_16_263 VPWR VGND sg13g2_decap_8
Xfanout37 fanout37/X fanout40/X VPWR VGND sg13g2_buf_1
XFILLER_10_406 VPWR VGND sg13g2_decap_8
XFILLER_13_25 VPWR VGND sg13g2_decap_8
XFILLER_22_266 VPWR VGND sg13g2_decap_8
XFILLER_22_299 VPWR VGND sg13g2_decap_8
Xlane1.c_term.tempo_48 lane1.c_term.tempo/ARM VPWR VGND sg13g2_tielo
XFILLER_13_211 VPWR VGND sg13g2_decap_8
XFILLER_13_222 VPWR VGND sg13g2_fill_2
XFILLER_5_476 VPWR VGND sg13g2_decap_8
XFILLER_1_682 VPWR VGND sg13g2_decap_8
XFILLER_5_70 VPWR VGND sg13g2_decap_8
Xclk_lane.lp.f10.tempo_59 clk_lane.lp.f10.tempo_59/L_HI VPWR VGND sg13g2_tiehi
XFILLER_27_347 VPWR VGND sg13g2_decap_8
XFILLER_10_203 VPWR VGND sg13g2_decap_8
XFILLER_23_553 VPWR VGND sg13g2_fill_2
XFILLER_24_46 VPWR VGND sg13g2_decap_8
XFILLER_1_28 VPWR VGND sg13g2_decap_8
XFILLER_18_336 VPWR VGND sg13g2_decap_8
XFILLER_5_273 VPWR VGND sg13g2_decap_8
Xinput5 _162_/B lp_n[2] VPWR VGND sg13g2_buf_1
XFILLER_24_339 VPWR VGND sg13g2_decap_8
XFILLER_19_46 VPWR VGND sg13g2_decap_8
XFILLER_19_79 VPWR VGND sg13g2_decap_8
XFILLER_28_623 VPWR VGND sg13g2_decap_8
XFILLER_27_144 VPWR VGND sg13g2_decap_8
XFILLER_23_350 VPWR VGND sg13g2_decap_8
X_141_ _141_/X _141_/A _141_/B VPWR VGND sg13g2_or2_1
X_210_ _210_/X _248_/Q _206_/B _249_/Q VPWR VGND sg13g2_a21o_1
XFILLER_18_133 VPWR VGND sg13g2_decap_8
XFILLER_21_309 VPWR VGND sg13g2_decap_8
Xlane0.lp.f10.tempo VPWR VGND _157_/Y lane0.lp.f10.tempo/ARM lane0.lp.f10.tempo_62/L_HI
+ fanout35/X _136_/A tempo_t24n
XFILLER_25_615 VPWR VGND sg13g2_decap_8
XFILLER_0_703 VPWR VGND sg13g2_decap_8
XFILLER_21_14 VPWR VGND sg13g2_decap_8
Xclk_lane.lp.f11.tempo VPWR VGND _152_/Y clk_lane.lp.f11.tempo/ARM clk_lane.lp.f11.tempo_60/L_HI
+ fanout35/X _131_/B tempo_t24n
XFILLER_28_420 VPWR VGND sg13g2_decap_8
XFILLER_15_147 VPWR VGND sg13g2_decap_8
XFILLER_28_497 VPWR VGND sg13g2_decap_8
XFILLER_11_364 VPWR VGND sg13g2_decap_8
X_124_ _124_/Y _257_/Q VPWR VGND sg13g2_inv_1
XFILLER_7_313 VPWR VGND sg13g2_decap_8
XFILLER_24_692 VPWR VGND sg13g2_decap_8
XFILLER_11_91 VPWR VGND sg13g2_decap_8
XFILLER_3_596 VPWR VGND sg13g2_decap_8
XFILLER_23_7 VPWR VGND sg13g2_decap_8
XFILLER_19_453 VPWR VGND sg13g2_fill_2
XFILLER_19_497 VPWR VGND sg13g2_decap_8
XFILLER_21_128 VPWR VGND sg13g2_decap_8
XFILLER_30_662 VPWR VGND sg13g2_decap_8
XFILLER_29_217 VPWR VGND sg13g2_decap_8
XFILLER_16_25 VPWR VGND sg13g2_decap_8
XFILLER_21_695 VPWR VGND sg13g2_decap_8
XFILLER_16_412 VPWR VGND sg13g2_decap_8
XFILLER_12_651 VPWR VGND sg13g2_decap_8
XFILLER_28_294 VPWR VGND sg13g2_decap_8
XFILLER_11_161 VPWR VGND sg13g2_decap_8
XFILLER_7_132 VPWR VGND sg13g2_decap_8
XFILLER_22_404 VPWR VGND sg13g2_decap_8
XFILLER_27_46 VPWR VGND sg13g2_decap_8
XFILLER_13_404 VPWR VGND sg13g2_decap_8
XFILLER_25_242 VPWR VGND sg13g2_decap_8
XFILLER_21_470 VPWR VGND sg13g2_decap_8
XFILLER_5_614 VPWR VGND sg13g2_decap_8
XFILLER_4_157 VPWR VGND sg13g2_decap_8
XFILLER_4_28 VPWR VGND sg13g2_decap_8
XFILLER_16_242 VPWR VGND sg13g2_decap_8
XFILLER_12_0 VPWR VGND sg13g2_decap_8
XFILLER_27_529 VPWR VGND sg13g2_decap_8
XFILLER_22_245 VPWR VGND sg13g2_decap_8
Xfanout38 fanout38/X fanout40/X VPWR VGND sg13g2_buf_1
XFILLER_23_713 VPWR VGND sg13g2_decap_8
XFILLER_13_256 VPWR VGND sg13g2_decap_8
XFILLER_9_249 VPWR VGND sg13g2_decap_8
XFILLER_5_455 VPWR VGND sg13g2_decap_8
XFILLER_27_326 VPWR VGND sg13g2_decap_8
XFILLER_10_259 VPWR VGND sg13g2_decap_8
XFILLER_23_543 VPWR VGND sg13g2_fill_2
XFILLER_24_25 VPWR VGND sg13g2_decap_8
XFILLER_18_315 VPWR VGND sg13g2_decap_8
XFILLER_5_252 VPWR VGND sg13g2_decap_8
Xinput6 _165_/B lp_n[3] VPWR VGND sg13g2_buf_1
XFILLER_24_318 VPWR VGND sg13g2_decap_8
XFILLER_17_392 VPWR VGND sg13g2_decap_8
XFILLER_10_49 VPWR VGND sg13g2_decap_8
XFILLER_19_25 VPWR VGND sg13g2_decap_8
XFILLER_28_602 VPWR VGND sg13g2_decap_8
XFILLER_15_329 VPWR VGND sg13g2_decap_8
XFILLER_28_679 VPWR VGND sg13g2_decap_8
XFILLER_27_123 VPWR VGND sg13g2_decap_8
XFILLER_11_568 VPWR VGND sg13g2_fill_1
X_140_ _140_/Y _140_/A VPWR VGND sg13g2_inv_1
XFILLER_18_112 VPWR VGND sg13g2_decap_8
XFILLER_19_679 VPWR VGND sg13g2_decap_8
XFILLER_18_189 VPWR VGND sg13g2_decap_8
XFILLER_18_690 VPWR VGND sg13g2_decap_8
XFILLER_24_137 VPWR VGND sg13g2_decap_8
XFILLER_28_476 VPWR VGND sg13g2_decap_8
XFILLER_15_126 VPWR VGND sg13g2_decap_8
XFILLER_24_671 VPWR VGND sg13g2_decap_8
XFILLER_11_343 VPWR VGND sg13g2_decap_8
X_123_ _123_/Y _254_/Q VPWR VGND sg13g2_inv_1
XFILLER_7_39 VPWR VGND sg13g2_decap_8
XFILLER_7_369 VPWR VGND sg13g2_decap_8
XFILLER_11_70 VPWR VGND sg13g2_decap_8
XFILLER_3_575 VPWR VGND sg13g2_decap_8
XFILLER_19_476 VPWR VGND sg13g2_decap_8
XFILLER_15_693 VPWR VGND sg13g2_decap_8
XFILLER_21_107 VPWR VGND sg13g2_decap_8
XFILLER_22_619 VPWR VGND sg13g2_decap_8
XFILLER_30_641 VPWR VGND sg13g2_decap_8
XFILLER_21_674 VPWR VGND sg13g2_decap_8
XFILLER_28_273 VPWR VGND sg13g2_decap_8
XFILLER_11_140 VPWR VGND sg13g2_decap_8
XFILLER_12_630 VPWR VGND sg13g2_decap_8
XFILLER_7_100 VPWR VGND sg13g2_decap_8
XFILLER_22_91 VPWR VGND sg13g2_decap_8
XFILLER_7_199 VPWR VGND sg13g2_decap_8
XFILLER_15_490 VPWR VGND sg13g2_decap_8
XFILLER_19_284 VPWR VGND sg13g2_decap_8
Xclk_lane.lp.f10.tempo VPWR VGND _154_/Y clk_lane.lp.f10.tempo/ARM clk_lane.lp.f10.tempo_59/L_HI
+ fanout35/X _131_/A tempo_t24n
XFILLER_27_25 VPWR VGND sg13g2_decap_8
XFILLER_13_449 VPWR VGND sg13g2_fill_2
XFILLER_25_298 VPWR VGND sg13g2_decap_4
XFILLER_16_221 VPWR VGND sg13g2_decap_8
XFILLER_16_298 VPWR VGND sg13g2_decap_8
XFILLER_17_711 VPWR VGND sg13g2_decap_8
XFILLER_17_722 VPWR VGND sg13g2_fill_1
XFILLER_17_91 VPWR VGND sg13g2_decap_8
XFILLER_12_493 VPWR VGND sg13g2_decap_8
XFILLER_4_692 VPWR VGND sg13g2_decap_8
XFILLER_27_508 VPWR VGND sg13g2_decap_8
XFILLER_22_224 VPWR VGND sg13g2_decap_8
Xfanout39 fanout39/X fanout40/X VPWR VGND sg13g2_buf_1
XFILLER_13_235 VPWR VGND sg13g2_decap_8
XFILLER_9_228 VPWR VGND sg13g2_decap_8
XFILLER_5_434 VPWR VGND sg13g2_decap_8
XFILLER_12_290 VPWR VGND sg13g2_decap_8
XFILLER_23_522 VPWR VGND sg13g2_decap_8
XFILLER_27_305 VPWR VGND sg13g2_decap_8
XFILLER_10_238 VPWR VGND sg13g2_decap_8
XFILLER_11_706 VPWR VGND sg13g2_decap_8
XFILLER_5_231 VPWR VGND sg13g2_decap_8
XFILLER_17_371 VPWR VGND sg13g2_decap_8
Xinput7 _157_/B lp_p[0] VPWR VGND sg13g2_buf_1
XFILLER_10_28 VPWR VGND sg13g2_decap_8
XFILLER_9_581 VPWR VGND sg13g2_decap_8
XFILLER_28_658 VPWR VGND sg13g2_decap_8
XFILLER_27_102 VPWR VGND sg13g2_decap_8
XFILLER_15_308 VPWR VGND sg13g2_decap_8
XFILLER_27_179 VPWR VGND sg13g2_decap_8
XFILLER_23_385 VPWR VGND sg13g2_decap_8
XFILLER_7_518 VPWR VGND sg13g2_decap_8
XFILLER_3_713 VPWR VGND sg13g2_decap_4
XFILLER_18_168 VPWR VGND sg13g2_decap_8
XFILLER_10_591 VPWR VGND sg13g2_decap_8
X_199_ _206_/A _249_/Q _250_/Q _251_/Q VPWR VGND sg13g2_nand3_1
XFILLER_6_584 VPWR VGND sg13g2_decap_8
XFILLER_24_116 VPWR VGND sg13g2_decap_8
XFILLER_21_49 VPWR VGND sg13g2_decap_8
XFILLER_15_105 VPWR VGND sg13g2_decap_8
XFILLER_28_455 VPWR VGND sg13g2_decap_8
XFILLER_11_322 VPWR VGND sg13g2_decap_8
XFILLER_23_182 VPWR VGND sg13g2_decap_8
XFILLER_7_18 VPWR VGND sg13g2_decap_8
XFILLER_24_650 VPWR VGND sg13g2_decap_8
XFILLER_11_399 VPWR VGND sg13g2_decap_8
X_122_ _122_/Y _251_/Q VPWR VGND sg13g2_inv_1
XFILLER_7_348 VPWR VGND sg13g2_decap_8
XFILLER_3_554 VPWR VGND sg13g2_decap_8
XFILLER_3_521 VPWR VGND sg13g2_fill_1
XFILLER_19_433 VPWR VGND sg13g2_fill_2
XFILLER_15_672 VPWR VGND sg13g2_decap_8
Xinput10 _166_/B lp_p[3] VPWR VGND sg13g2_buf_1
XFILLER_30_697 VPWR VGND sg13g2_decap_8
XFILLER_30_620 VPWR VGND sg13g2_decap_8
XFILLER_6_381 VPWR VGND sg13g2_decap_8
XFILLER_25_425 VPWR VGND sg13g2_decap_8
XFILLER_12_119 VPWR VGND sg13g2_decap_8
XFILLER_25_469 VPWR VGND sg13g2_decap_8
XFILLER_4_329 VPWR VGND sg13g2_decap_8
XFILLER_29_720 VPWR VGND sg13g2_decap_8
XFILLER_16_469 VPWR VGND sg13g2_decap_8
XFILLER_28_252 VPWR VGND sg13g2_decap_8
XFILLER_11_196 VPWR VGND sg13g2_decap_8
XFILLER_12_686 VPWR VGND sg13g2_decap_8
XFILLER_22_70 VPWR VGND sg13g2_decap_8
XFILLER_7_145 VPWR VGND sg13g2_fill_1
XFILLER_7_178 VPWR VGND sg13g2_decap_8
XFILLER_3_384 VPWR VGND sg13g2_decap_8
XFILLER_3_373 VPWR VGND sg13g2_fill_2
XFILLER_3_362 VPWR VGND sg13g2_decap_8
XFILLER_19_263 VPWR VGND sg13g2_decap_8
XFILLER_22_439 VPWR VGND sg13g2_decap_8
XFILLER_30_494 VPWR VGND sg13g2_decap_8
XFILLER_25_277 VPWR VGND sg13g2_decap_8
XFILLER_5_649 VPWR VGND sg13g2_decap_8
XFILLER_4_126 VPWR VGND sg13g2_decap_8
XFILLER_16_200 VPWR VGND sg13g2_decap_8
XFILLER_16_277 VPWR VGND sg13g2_decap_8
XFILLER_17_70 VPWR VGND sg13g2_decap_8
XFILLER_29_594 VPWR VGND sg13g2_decap_8
XFILLER_12_472 VPWR VGND sg13g2_decap_8
XFILLER_3_192 VPWR VGND sg13g2_decap_8
XFILLER_23_704 VPWR VGND sg13g2_decap_4
XFILLER_13_39 VPWR VGND sg13g2_decap_8
XFILLER_22_203 VPWR VGND sg13g2_decap_8
XFILLER_30_291 VPWR VGND sg13g2_decap_8
XFILLER_9_207 VPWR VGND sg13g2_decap_8
XFILLER_5_413 VPWR VGND sg13g2_decap_8
XFILLER_1_696 VPWR VGND sg13g2_decap_8
XFILLER_28_91 VPWR VGND sg13g2_decap_8
XFILLER_5_84 VPWR VGND sg13g2_decap_8
XFILLER_23_545 VPWR VGND sg13g2_fill_1
XFILLER_10_217 VPWR VGND sg13g2_decap_8
XFILLER_23_578 VPWR VGND sg13g2_fill_1
XFILLER_6_7 VPWR VGND sg13g2_decap_8
XFILLER_5_287 VPWR VGND sg13g2_decap_8
XFILLER_5_210 VPWR VGND sg13g2_decap_8
XFILLER_30_81 VPWR VGND sg13g2_decap_8
Xinput8 _160_/B lp_p[1] VPWR VGND sg13g2_buf_1
XFILLER_17_350 VPWR VGND sg13g2_decap_8
Xlane3.lp.c_hsreq.tempo VPWR VGND _151_/X _165_/Y _306_/A fanout37/X _302_/A tempo_t24n
XFILLER_28_637 VPWR VGND sg13g2_decap_8
XFILLER_27_158 VPWR VGND sg13g2_decap_8
XFILLER_11_504 VPWR VGND sg13g2_decap_8
XFILLER_11_548 VPWR VGND sg13g2_decap_4
XFILLER_23_364 VPWR VGND sg13g2_decap_8
XFILLER_11_559 VPWR VGND sg13g2_decap_8
XFILLER_18_147 VPWR VGND sg13g2_decap_8
Xclkbuf_1_0__f_rx_clk clkload0/A clkbuf_0_rx_clk/X VPWR VGND sg13g2_buf_16
XFILLER_27_692 VPWR VGND sg13g2_decap_8
X_198_ _244_/D _196_/A _196_/B hold83/X VPWR VGND sg13g2_o21ai_1
XFILLER_6_563 VPWR VGND sg13g2_decap_8
XFILLER_25_629 VPWR VGND sg13g2_decap_8
XFILLER_21_28 VPWR VGND sg13g2_decap_8
XFILLER_0_717 VPWR VGND sg13g2_decap_4
XFILLER_28_434 VPWR VGND sg13g2_fill_2
XFILLER_11_301 VPWR VGND sg13g2_decap_8
XFILLER_11_378 VPWR VGND sg13g2_decap_8
XFILLER_23_161 VPWR VGND sg13g2_decap_8
X_121_ _121_/Y _250_/Q VPWR VGND sg13g2_inv_1
XFILLER_7_327 VPWR VGND sg13g2_decap_8
XFILLER_30_109 VPWR VGND sg13g2_decap_8
XFILLER_19_412 VPWR VGND sg13g2_decap_8
XFILLER_15_651 VPWR VGND sg13g2_decap_8
XFILLER_6_360 VPWR VGND sg13g2_decap_8
XFILLER_30_676 VPWR VGND sg13g2_decap_8
XFILLER_28_0 VPWR VGND sg13g2_decap_8
XFILLER_16_39 VPWR VGND sg13g2_decap_8
XFILLER_25_404 VPWR VGND sg13g2_decap_8
XFILLER_21_643 VPWR VGND sg13g2_decap_8
XFILLER_4_308 VPWR VGND sg13g2_decap_8
XFILLER_28_231 VPWR VGND sg13g2_decap_8
XFILLER_16_426 VPWR VGND sg13g2_decap_8
XFILLER_11_175 VPWR VGND sg13g2_decap_8
XFILLER_12_665 VPWR VGND sg13g2_decap_8
XFILLER_7_157 VPWR VGND sg13g2_decap_8
XFILLER_3_341 VPWR VGND sg13g2_decap_8
XFILLER_19_242 VPWR VGND sg13g2_decap_8
XFILLER_21_7 VPWR VGND sg13g2_decap_8
XFILLER_22_418 VPWR VGND sg13g2_decap_8
XFILLER_30_473 VPWR VGND sg13g2_decap_8
Xlane2.c_term.tempo VPWR VGND _145_/A lane2.c_term.tempo/ARM _145_/Y fanout39/X _309_/A
+ tempo_t24n
XFILLER_13_418 VPWR VGND sg13g2_decap_8
XFILLER_25_256 VPWR VGND sg13g2_decap_8
XFILLER_25_223 VPWR VGND sg13g2_fill_1
XFILLER_21_484 VPWR VGND sg13g2_decap_8
XFILLER_5_628 VPWR VGND sg13g2_decap_8
XFILLER_4_105 VPWR VGND sg13g2_decap_8
XFILLER_29_573 VPWR VGND sg13g2_decap_8
XFILLER_12_451 VPWR VGND sg13g2_decap_8
XFILLER_16_256 VPWR VGND sg13g2_decap_8
Xclkbuf_regs_0_rx_clk clkbuf_regs_0_rx_clk/X rx_clk VPWR VGND sg13g2_buf_16
Xlane1.lp.f11.tempo_50 lane1.lp.f11.tempo/ARM VPWR VGND sg13g2_tielo
XFILLER_3_171 VPWR VGND sg13g2_decap_8
XFILLER_13_18 VPWR VGND sg13g2_decap_8
XFILLER_22_259 VPWR VGND sg13g2_decap_8
XFILLER_30_270 VPWR VGND sg13g2_decap_8
XFILLER_5_469 VPWR VGND sg13g2_decap_8
XFILLER_29_392 VPWR VGND sg13g2_decap_8
XFILLER_28_70 VPWR VGND sg13g2_decap_8
XFILLER_5_63 VPWR VGND sg13g2_decap_8
XFILLER_10_0 VPWR VGND sg13g2_decap_8
XFILLER_24_39 VPWR VGND sg13g2_decap_8
XFILLER_18_329 VPWR VGND sg13g2_decap_8
XFILLER_5_266 VPWR VGND sg13g2_decap_8
XFILLER_30_60 VPWR VGND sg13g2_decap_8
Xinput9 _163_/B lp_p[2] VPWR VGND sg13g2_buf_1
XFILLER_19_39 VPWR VGND sg13g2_decap_8
XFILLER_28_616 VPWR VGND sg13g2_decap_8
XFILLER_27_137 VPWR VGND sg13g2_decap_8
XFILLER_23_343 VPWR VGND sg13g2_decap_8
XFILLER_18_126 VPWR VGND sg13g2_decap_8
XFILLER_27_682 VPWR VGND sg13g2_decap_4
X_197_ _243_/D _189_/B _197_/B VPWR VGND sg13g2_nand2b_1
XFILLER_6_542 VPWR VGND sg13g2_decap_8
XFILLER_25_93 VPWR VGND sg13g2_decap_8
XFILLER_25_608 VPWR VGND sg13g2_decap_8
XFILLER_28_413 VPWR VGND sg13g2_decap_8
XFILLER_23_140 VPWR VGND sg13g2_decap_8
XFILLER_11_357 VPWR VGND sg13g2_decap_8
X_120_ _120_/Y _247_/Q VPWR VGND sg13g2_inv_1
XFILLER_7_306 VPWR VGND sg13g2_decap_8
XFILLER_24_685 VPWR VGND sg13g2_decap_8
XFILLER_11_84 VPWR VGND sg13g2_decap_8
XFILLER_3_589 VPWR VGND sg13g2_decap_8
XFILLER_30_655 VPWR VGND sg13g2_decap_8
X_249_ _249_/Q _251_/CLK _249_/D _140_/Y VPWR VGND sg13g2_dfrbpq_1
XFILLER_16_18 VPWR VGND sg13g2_decap_8
XFILLER_18_490 VPWR VGND sg13g2_decap_8
XFILLER_25_449 VPWR VGND sg13g2_decap_4
XFILLER_21_622 VPWR VGND sg13g2_decap_8
XFILLER_21_688 VPWR VGND sg13g2_decap_8
XFILLER_16_405 VPWR VGND sg13g2_decap_8
XFILLER_28_210 VPWR VGND sg13g2_decap_8
XFILLER_12_644 VPWR VGND sg13g2_decap_8
XFILLER_28_287 VPWR VGND sg13g2_decap_8
XFILLER_24_493 VPWR VGND sg13g2_decap_8
XFILLER_11_154 VPWR VGND sg13g2_decap_8
XFILLER_7_125 VPWR VGND sg13g2_decap_8
XFILLER_7_114 VPWR VGND sg13g2_decap_8
XFILLER_3_320 VPWR VGND sg13g2_decap_8
XFILLER_19_210 VPWR VGND sg13g2_decap_8
XFILLER_19_298 VPWR VGND sg13g2_decap_4
XFILLER_30_452 VPWR VGND sg13g2_decap_8
XFILLER_7_692 VPWR VGND sg13g2_decap_8
XFILLER_27_39 VPWR VGND sg13g2_decap_8
XFILLER_25_235 VPWR VGND sg13g2_decap_8
XFILLER_21_463 VPWR VGND sg13g2_decap_8
XFILLER_16_235 VPWR VGND sg13g2_decap_8
XFILLER_29_552 VPWR VGND sg13g2_decap_8
XFILLER_12_430 VPWR VGND sg13g2_decap_8
XFILLER_24_290 VPWR VGND sg13g2_decap_8
XFILLER_3_150 VPWR VGND sg13g2_decap_8
XFILLER_22_238 VPWR VGND sg13g2_decap_8
XFILLER_13_249 VPWR VGND sg13g2_decap_8
XFILLER_5_448 VPWR VGND sg13g2_decap_8
Xlane0.lp.f11.tempo_47 lane0.lp.f11.tempo/ARM VPWR VGND sg13g2_tielo
XFILLER_17_566 VPWR VGND sg13g2_decap_4
XFILLER_29_371 VPWR VGND sg13g2_decap_8
XFILLER_5_42 VPWR VGND sg13g2_decap_8
XFILLER_27_319 VPWR VGND sg13g2_decap_8
XFILLER_23_536 VPWR VGND sg13g2_fill_2
XFILLER_24_18 VPWR VGND sg13g2_decap_8
XFILLER_18_308 VPWR VGND sg13g2_decap_8
XFILLER_10_720 VPWR VGND sg13g2_decap_8
XFILLER_6_702 VPWR VGND sg13g2_decap_8
XFILLER_5_245 VPWR VGND sg13g2_decap_8
XFILLER_17_385 VPWR VGND sg13g2_decap_8
XFILLER_19_18 VPWR VGND sg13g2_decap_8
XFILLER_23_322 VPWR VGND sg13g2_decap_8
XFILLER_27_116 VPWR VGND sg13g2_decap_8
XFILLER_11_517 VPWR VGND sg13g2_fill_2
XFILLER_23_399 VPWR VGND sg13g2_decap_8
XFILLER_18_105 VPWR VGND sg13g2_decap_8
XFILLER_27_661 VPWR VGND sg13g2_decap_8
XFILLER_25_72 VPWR VGND sg13g2_decap_8
X_196_ _197_/B _196_/A _196_/B VPWR VGND sg13g2_xnor2_1
XFILLER_6_521 VPWR VGND sg13g2_decap_8
XFILLER_17_182 VPWR VGND sg13g2_decap_8
XFILLER_18_683 VPWR VGND sg13g2_decap_8
XFILLER_28_436 VPWR VGND sg13g2_fill_1
XFILLER_15_119 VPWR VGND sg13g2_decap_8
Xlane1.lp.c_hsprp.tempo VPWR VGND _141_/X _139_/A _300_/A fanout38/X _296_/A tempo_t24n
XFILLER_28_469 VPWR VGND sg13g2_decap_8
XFILLER_24_664 VPWR VGND sg13g2_decap_8
XFILLER_11_336 VPWR VGND sg13g2_decap_8
XFILLER_23_196 VPWR VGND sg13g2_decap_8
XFILLER_11_63 VPWR VGND sg13g2_decap_8
XFILLER_3_568 VPWR VGND sg13g2_decap_8
XFILLER_19_469 VPWR VGND sg13g2_decap_8
XFILLER_27_480 VPWR VGND sg13g2_decap_8
XFILLER_15_686 VPWR VGND sg13g2_decap_8
Xclkbuf_0_rx_clk_regs clkbuf_0_rx_clk_regs/X clkbuf_regs_0_rx_clk/X VPWR VGND sg13g2_buf_16
XFILLER_30_634 VPWR VGND sg13g2_decap_8
X_179_ _235_/D _180_/B _179_/A2 _173_/B VPWR VGND sg13g2_a21o_1
X_248_ _248_/Q _251_/CLK _248_/D _140_/Y VPWR VGND sg13g2_dfrbpq_1
XFILLER_6_395 VPWR VGND sg13g2_decap_8
XFILLER_21_601 VPWR VGND sg13g2_decap_8
XFILLER_21_667 VPWR VGND sg13g2_decap_8
XFILLER_28_266 VPWR VGND sg13g2_decap_8
XFILLER_11_133 VPWR VGND sg13g2_decap_8
XFILLER_12_623 VPWR VGND sg13g2_decap_8
XFILLER_24_472 VPWR VGND sg13g2_decap_8
XFILLER_22_84 VPWR VGND sg13g2_decap_8
XFILLER_3_398 VPWR VGND sg13g2_decap_8
XFILLER_19_277 VPWR VGND sg13g2_decap_8
XFILLER_15_483 VPWR VGND sg13g2_decap_8
XFILLER_7_660 VPWR VGND sg13g2_decap_8
XFILLER_30_431 VPWR VGND sg13g2_decap_8
XFILLER_7_671 VPWR VGND sg13g2_decap_8
XFILLER_6_192 VPWR VGND sg13g2_decap_8
XFILLER_27_18 VPWR VGND sg13g2_decap_8
XFILLER_25_203 VPWR VGND sg13g2_fill_1
XFILLER_29_531 VPWR VGND sg13g2_decap_8
XFILLER_16_214 VPWR VGND sg13g2_decap_8
XFILLER_17_704 VPWR VGND sg13g2_decap_8
XFILLER_17_84 VPWR VGND sg13g2_decap_8
XFILLER_12_486 VPWR VGND sg13g2_decap_8
XFILLER_4_663 VPWR VGND sg13g2_decap_4
XFILLER_15_280 VPWR VGND sg13g2_decap_8
XFILLER_22_217 VPWR VGND sg13g2_decap_8
XFILLER_7_490 VPWR VGND sg13g2_decap_8
XFILLER_13_228 VPWR VGND sg13g2_decap_8
XFILLER_21_283 VPWR VGND sg13g2_decap_8
XFILLER_5_427 VPWR VGND sg13g2_decap_8
XFILLER_29_350 VPWR VGND sg13g2_decap_8
XFILLER_17_534 VPWR VGND sg13g2_fill_2
XFILLER_9_700 VPWR VGND sg13g2_decap_8
XFILLER_12_283 VPWR VGND sg13g2_decap_8
XFILLER_5_21 VPWR VGND sg13g2_decap_8
XFILLER_5_98 VPWR VGND sg13g2_decap_8
XFILLER_4_482 VPWR VGND sg13g2_decap_8
XFILLER_23_504 VPWR VGND sg13g2_decap_8
XFILLER_22_570 VPWR VGND sg13g2_fill_1
XFILLER_5_224 VPWR VGND sg13g2_decap_8
XFILLER_30_95 VPWR VGND sg13g2_decap_8
XFILLER_17_364 VPWR VGND sg13g2_decap_8
XFILLER_9_574 VPWR VGND sg13g2_decap_8
XFILLER_23_301 VPWR VGND sg13g2_decap_8
XFILLER_23_378 VPWR VGND sg13g2_decap_8
XFILLER_4_7 VPWR VGND sg13g2_decap_8
XFILLER_3_717 VPWR VGND sg13g2_fill_2
XFILLER_3_706 VPWR VGND sg13g2_decap_8
XFILLER_27_640 VPWR VGND sg13g2_decap_8
X_195_ _242_/D _196_/B _195_/A2 _189_/B VPWR VGND sg13g2_a21o_1
XFILLER_6_577 VPWR VGND sg13g2_decap_8
XFILLER_6_500 VPWR VGND sg13g2_decap_8
XFILLER_17_161 VPWR VGND sg13g2_decap_8
XFILLER_18_662 VPWR VGND sg13g2_decap_8
Xclk_lane.c_term.tempo_42 clk_lane.c_term.tempo/ARM VPWR VGND sg13g2_tielo
XFILLER_24_109 VPWR VGND sg13g2_decap_8
XFILLER_9_382 VPWR VGND sg13g2_decap_8
Xlane1.lp.f11.tempo VPWR VGND _158_/Y lane1.lp.f11.tempo/ARM lane1.lp.f11.tempo_66/L_HI
+ fanout35/X _141_/B tempo_t24n
XFILLER_28_448 VPWR VGND sg13g2_decap_8
XFILLER_11_315 VPWR VGND sg13g2_decap_8
XFILLER_23_175 VPWR VGND sg13g2_decap_8
XFILLER_24_643 VPWR VGND sg13g2_decap_8
XFILLER_11_42 VPWR VGND sg13g2_decap_8
XFILLER_3_525 VPWR VGND sg13g2_fill_2
XFILLER_3_547 VPWR VGND sg13g2_decap_8
XFILLER_19_426 VPWR VGND sg13g2_decap_8
XFILLER_15_665 VPWR VGND sg13g2_decap_8
X_247_ _247_/Q _250_/CLK _247_/D _140_/Y VPWR VGND sg13g2_dfrbpq_1
XFILLER_30_613 VPWR VGND sg13g2_decap_8
XFILLER_10_392 VPWR VGND sg13g2_decap_8
X_178_ _178_/X _234_/Q _174_/B _235_/Q VPWR VGND sg13g2_a21o_1
XFILLER_6_374 VPWR VGND sg13g2_decap_8
XFILLER_25_418 VPWR VGND sg13g2_decap_8
XFILLER_21_657 VPWR VGND sg13g2_decap_4
XFILLER_29_713 VPWR VGND sg13g2_decap_8
XFILLER_28_245 VPWR VGND sg13g2_decap_8
XFILLER_11_112 VPWR VGND sg13g2_decap_8
XFILLER_11_189 VPWR VGND sg13g2_decap_8
XFILLER_12_602 VPWR VGND sg13g2_decap_8
XFILLER_12_679 VPWR VGND sg13g2_decap_8
XFILLER_24_451 VPWR VGND sg13g2_decap_8
XFILLER_22_63 VPWR VGND sg13g2_decap_8
XFILLER_3_355 VPWR VGND sg13g2_decap_8
XFILLER_19_256 VPWR VGND sg13g2_decap_8
XFILLER_15_462 VPWR VGND sg13g2_decap_8
XFILLER_30_410 VPWR VGND sg13g2_decap_8
XFILLER_6_171 VPWR VGND sg13g2_decap_8
XFILLER_30_487 VPWR VGND sg13g2_decap_8
XFILLER_21_421 VPWR VGND sg13g2_decap_8
XFILLER_21_498 VPWR VGND sg13g2_decap_8
XFILLER_4_119 VPWR VGND sg13g2_decap_8
Xclkbuf_2_3__f_rx_clk_regs _251_/CLK clkbuf_0_rx_clk_regs/X VPWR VGND sg13g2_buf_16
XFILLER_29_510 VPWR VGND sg13g2_decap_8
XFILLER_17_63 VPWR VGND sg13g2_decap_8
XFILLER_29_587 VPWR VGND sg13g2_decap_8
XFILLER_12_465 VPWR VGND sg13g2_decap_8
XFILLER_4_642 VPWR VGND sg13g2_decap_8
XFILLER_3_185 VPWR VGND sg13g2_decap_8
XFILLER_23_708 VPWR VGND sg13g2_fill_1
XFILLER_30_284 VPWR VGND sg13g2_decap_8
XFILLER_13_218 VPWR VGND sg13g2_decap_4
XFILLER_21_262 VPWR VGND sg13g2_decap_8
XFILLER_21_295 VPWR VGND sg13g2_decap_8
XFILLER_5_406 VPWR VGND sg13g2_decap_8
XFILLER_1_689 VPWR VGND sg13g2_decap_8
XFILLER_28_84 VPWR VGND sg13g2_decap_8
XFILLER_12_262 VPWR VGND sg13g2_decap_8
XFILLER_4_461 VPWR VGND sg13g2_decap_8
XFILLER_5_77 VPWR VGND sg13g2_decap_8
XFILLER_5_203 VPWR VGND sg13g2_decap_8
XFILLER_30_74 VPWR VGND sg13g2_decap_8
XFILLER_17_343 VPWR VGND sg13g2_decap_8
XFILLER_23_357 VPWR VGND sg13g2_decap_8
XFILLER_10_541 VPWR VGND sg13g2_decap_8
XFILLER_22_390 VPWR VGND sg13g2_decap_8
XFILLER_25_63 VPWR VGND sg13g2_fill_1
X_194_ _194_/X _241_/Q _190_/B _242_/Q VPWR VGND sg13g2_a21o_1
XFILLER_6_556 VPWR VGND sg13g2_decap_8
XFILLER_17_140 VPWR VGND sg13g2_decap_8
XFILLER_13_390 VPWR VGND sg13g2_decap_8
XFILLER_9_361 VPWR VGND sg13g2_decap_8
XFILLER_28_427 VPWR VGND sg13g2_decap_8
XFILLER_23_154 VPWR VGND sg13g2_decap_8
XFILLER_24_699 VPWR VGND sg13g2_decap_8
XFILLER_24_622 VPWR VGND sg13g2_decap_8
XFILLER_11_21 VPWR VGND sg13g2_decap_8
XFILLER_11_98 VPWR VGND sg13g2_decap_8
XFILLER_3_504 VPWR VGND sg13g2_decap_8
XFILLER_19_405 VPWR VGND sg13g2_decap_8
XFILLER_15_644 VPWR VGND sg13g2_decap_8
XFILLER_10_371 VPWR VGND sg13g2_decap_8
X_177_ _177_/Y _233_/Q _232_/Q _234_/Q _235_/Q VPWR VGND sg13g2_nand4_1
X_246_ _246_/Q _250_/CLK _246_/D _140_/Y VPWR VGND sg13g2_dfrbpq_1
XFILLER_6_353 VPWR VGND sg13g2_decap_8
XFILLER_30_669 VPWR VGND sg13g2_decap_8
XFILLER_21_636 VPWR VGND sg13g2_decap_8
XFILLER_16_419 VPWR VGND sg13g2_decap_8
XFILLER_28_224 VPWR VGND sg13g2_decap_8
XFILLER_24_430 VPWR VGND sg13g2_decap_8
XFILLER_11_168 VPWR VGND sg13g2_decap_8
XFILLER_12_658 VPWR VGND sg13g2_decap_8
XFILLER_22_42 VPWR VGND sg13g2_decap_8
XFILLER_7_139 VPWR VGND sg13g2_fill_2
XFILLER_3_334 VPWR VGND sg13g2_decap_8
XFILLER_19_235 VPWR VGND sg13g2_decap_8
X_229_ _257_/D _221_/B _229_/B VPWR VGND sg13g2_nand2b_1
Xlane1.lp.f10.tempo VPWR VGND _160_/Y lane1.lp.f10.tempo/ARM lane1.lp.f10.tempo_65/L_HI
+ fanout35/X _141_/A tempo_t24n
XFILLER_6_150 VPWR VGND sg13g2_decap_8
XFILLER_30_466 VPWR VGND sg13g2_decap_8
XFILLER_25_249 VPWR VGND sg13g2_decap_8
XFILLER_25_216 VPWR VGND sg13g2_decap_8
XFILLER_21_400 VPWR VGND sg13g2_decap_8
XFILLER_21_477 VPWR VGND sg13g2_decap_8
XFILLER_29_566 VPWR VGND sg13g2_decap_8
XFILLER_12_444 VPWR VGND sg13g2_decap_8
XFILLER_16_249 VPWR VGND sg13g2_decap_8
XFILLER_17_42 VPWR VGND sg13g2_decap_8
XFILLER_4_621 VPWR VGND sg13g2_decap_8
XFILLER_3_164 VPWR VGND sg13g2_decap_8
XFILLER_12_7 VPWR VGND sg13g2_decap_8
XFILLER_30_263 VPWR VGND sg13g2_decap_8
XFILLER_21_241 VPWR VGND sg13g2_decap_8
XFILLER_29_385 VPWR VGND sg13g2_decap_8
XFILLER_28_63 VPWR VGND sg13g2_decap_8
XFILLER_12_241 VPWR VGND sg13g2_decap_8
XFILLER_5_56 VPWR VGND sg13g2_decap_8
XFILLER_4_440 VPWR VGND sg13g2_decap_8
XFILLER_16_580 VPWR VGND sg13g2_fill_2
XFILLER_22_561 VPWR VGND sg13g2_decap_8
XFILLER_6_716 VPWR VGND sg13g2_decap_8
XFILLER_5_259 VPWR VGND sg13g2_decap_8
XFILLER_30_53 VPWR VGND sg13g2_decap_8
XFILLER_17_322 VPWR VGND sg13g2_decap_8
XFILLER_17_399 VPWR VGND sg13g2_decap_8
Xclk_lane.c_settle.tempo VPWR VGND _129_/A clk_lane.c_settle.tempo/ARM _129_/Y fanout38/X
+ _130_/B tempo_t180n
XFILLER_29_182 VPWR VGND sg13g2_decap_8
XFILLER_9_565 VPWR VGND sg13g2_decap_4
XFILLER_28_609 VPWR VGND sg13g2_decap_8
XFILLER_23_336 VPWR VGND sg13g2_decap_8
XFILLER_18_119 VPWR VGND sg13g2_decap_8
XFILLER_27_686 VPWR VGND sg13g2_fill_2
XFILLER_27_675 VPWR VGND sg13g2_decap_8
XFILLER_27_620 VPWR VGND sg13g2_fill_2
XFILLER_25_42 VPWR VGND sg13g2_decap_8
XFILLER_10_531 VPWR VGND sg13g2_fill_2
X_193_ _193_/Y _240_/Q _239_/Q _241_/Q _242_/Q VPWR VGND sg13g2_nand4_1
XFILLER_6_535 VPWR VGND sg13g2_decap_8
XFILLER_25_86 VPWR VGND sg13g2_decap_8
XFILLER_17_196 VPWR VGND sg13g2_decap_8
XFILLER_18_697 VPWR VGND sg13g2_decap_8
XFILLER_9_340 VPWR VGND sg13g2_decap_8
XFILLER_28_406 VPWR VGND sg13g2_decap_8
XFILLER_23_133 VPWR VGND sg13g2_decap_8
XFILLER_24_678 VPWR VGND sg13g2_decap_8
XFILLER_11_77 VPWR VGND sg13g2_decap_8
XFILLER_3_527 VPWR VGND sg13g2_fill_1
XFILLER_27_494 VPWR VGND sg13g2_decap_8
XFILLER_10_350 VPWR VGND sg13g2_decap_8
X_176_ _176_/Y _234_/Q _176_/B VPWR VGND sg13g2_xnor2_1
X_245_ _292_/A _251_/CLK _245_/D _140_/Y VPWR VGND sg13g2_dfrbpq_1
XFILLER_6_332 VPWR VGND sg13g2_decap_8
XFILLER_30_648 VPWR VGND sg13g2_decap_8
XFILLER_18_483 VPWR VGND sg13g2_decap_8
XFILLER_21_615 VPWR VGND sg13g2_decap_8
XFILLER_28_203 VPWR VGND sg13g2_decap_8
XFILLER_12_637 VPWR VGND sg13g2_decap_8
Xlane3.c_term.tempo_54 lane3.c_term.tempo/ARM VPWR VGND sg13g2_tielo
XFILLER_24_486 VPWR VGND sg13g2_decap_8
XFILLER_11_147 VPWR VGND sg13g2_decap_8
XFILLER_22_21 VPWR VGND sg13g2_decap_8
XFILLER_22_98 VPWR VGND sg13g2_decap_8
XFILLER_7_107 VPWR VGND sg13g2_decap_8
XFILLER_3_313 VPWR VGND sg13g2_decap_8
XFILLER_19_203 VPWR VGND sg13g2_fill_2
XFILLER_15_497 VPWR VGND sg13g2_decap_8
XFILLER_30_445 VPWR VGND sg13g2_decap_8
XFILLER_27_291 VPWR VGND sg13g2_decap_8
XFILLER_11_692 VPWR VGND sg13g2_decap_8
X_159_ _159_/Y _160_/B _159_/B VPWR VGND sg13g2_nand2b_1
X_228_ _229_/B _228_/A _228_/B VPWR VGND sg13g2_xnor2_1
XFILLER_7_685 VPWR VGND sg13g2_decap_8
XFILLER_6_140 VPWR VGND sg13g2_decap_4
XFILLER_18_280 VPWR VGND sg13g2_decap_8
XFILLER_25_228 VPWR VGND sg13g2_decap_8
XFILLER_21_456 VPWR VGND sg13g2_decap_8
Xlane0.lp.f10.tempo_62 lane0.lp.f10.tempo_62/L_HI VPWR VGND sg13g2_tiehi
XFILLER_16_228 VPWR VGND sg13g2_decap_8
XFILLER_17_21 VPWR VGND sg13g2_decap_8
XFILLER_17_718 VPWR VGND sg13g2_decap_4
XFILLER_29_545 VPWR VGND sg13g2_decap_8
XFILLER_12_423 VPWR VGND sg13g2_decap_8
XFILLER_17_98 VPWR VGND sg13g2_decap_8
XFILLER_24_283 VPWR VGND sg13g2_decap_8
Xlane1.lp.f11.tempo_66 lane1.lp.f11.tempo_66/L_HI VPWR VGND sg13g2_tiehi
XFILLER_3_121 VPWR VGND sg13g2_decap_8
XFILLER_4_699 VPWR VGND sg13g2_decap_8
XFILLER_15_294 VPWR VGND sg13g2_decap_8
XFILLER_30_242 VPWR VGND sg13g2_decap_8
XFILLER_21_220 VPWR VGND sg13g2_decap_8
XFILLER_22_710 VPWR VGND sg13g2_decap_8
XFILLER_22_721 VPWR VGND sg13g2_fill_2
XFILLER_17_504 VPWR VGND sg13g2_decap_8
XFILLER_29_364 VPWR VGND sg13g2_decap_8
XFILLER_28_42 VPWR VGND sg13g2_decap_8
XFILLER_12_220 VPWR VGND sg13g2_decap_8
XFILLER_12_297 VPWR VGND sg13g2_decap_8
XFILLER_9_714 VPWR VGND sg13g2_decap_4
XFILLER_5_35 VPWR VGND sg13g2_decap_8
XFILLER_4_496 VPWR VGND sg13g2_decap_8
XFILLER_23_529 VPWR VGND sg13g2_decap_8
XFILLER_10_713 VPWR VGND sg13g2_decap_8
XFILLER_5_238 VPWR VGND sg13g2_decap_8
XFILLER_30_32 VPWR VGND sg13g2_decap_8
XFILLER_17_301 VPWR VGND sg13g2_decap_8
XFILLER_29_161 VPWR VGND sg13g2_decap_8
XFILLER_17_378 VPWR VGND sg13g2_decap_8
XFILLER_13_573 VPWR VGND sg13g2_decap_4
XFILLER_9_588 VPWR VGND sg13g2_fill_1
XFILLER_27_109 VPWR VGND sg13g2_decap_8
XFILLER_23_315 VPWR VGND sg13g2_decap_8
Xdelaybuf_0_rx_clk delaybuf_1_rx_clk/A rx_clk VPWR VGND sg13g2_buf_8
XFILLER_27_654 VPWR VGND sg13g2_decap_8
XFILLER_25_21 VPWR VGND sg13g2_decap_8
XFILLER_10_598 VPWR VGND sg13g2_decap_8
X_192_ _192_/Y _241_/Q _192_/B VPWR VGND sg13g2_xnor2_1
XFILLER_6_514 VPWR VGND sg13g2_decap_8
XFILLER_18_676 VPWR VGND sg13g2_decap_8
XFILLER_17_175 VPWR VGND sg13g2_decap_8
XFILLER_9_396 VPWR VGND sg13g2_decap_8
XFILLER_23_112 VPWR VGND sg13g2_decap_8
XFILLER_24_657 VPWR VGND sg13g2_decap_8
XFILLER_11_329 VPWR VGND sg13g2_decap_8
XFILLER_23_189 VPWR VGND sg13g2_decap_8
XFILLER_11_56 VPWR VGND sg13g2_decap_8
XFILLER_15_679 VPWR VGND sg13g2_decap_8
X_244_ _244_/Q _251_/CLK _244_/D _145_/Y VPWR VGND sg13g2_dfrbpq_1
XFILLER_30_627 VPWR VGND sg13g2_decap_8
XFILLER_27_473 VPWR VGND sg13g2_decap_8
XFILLER_23_690 VPWR VGND sg13g2_decap_8
X_175_ _233_/D _174_/A _174_/B _175_/B1 hold88/X VPWR VGND sg13g2_a22oi_1
XFILLER_6_388 VPWR VGND sg13g2_decap_8
XFILLER_6_311 VPWR VGND sg13g2_decap_8
XFILLER_18_462 VPWR VGND sg13g2_decap_8
XFILLER_9_193 VPWR VGND sg13g2_decap_8
XFILLER_28_259 VPWR VGND sg13g2_decap_8
XFILLER_11_126 VPWR VGND sg13g2_decap_8
XFILLER_12_616 VPWR VGND sg13g2_decap_8
XFILLER_24_465 VPWR VGND sg13g2_decap_8
XFILLER_22_77 VPWR VGND sg13g2_decap_8
XFILLER_0_4 VPWR VGND sg13g2_decap_8
XFILLER_3_369 VPWR VGND sg13g2_decap_4
XFILLER_27_270 VPWR VGND sg13g2_decap_8
XFILLER_11_671 VPWR VGND sg13g2_decap_8
XFILLER_15_476 VPWR VGND sg13g2_decap_8
X_227_ _256_/D _228_/B _227_/A2 _221_/B VPWR VGND sg13g2_a21o_1
XFILLER_30_424 VPWR VGND sg13g2_decap_8
X_158_ _158_/Y _159_/B _160_/B VPWR VGND sg13g2_nand2_1
XFILLER_7_653 VPWR VGND sg13g2_decap_8
XFILLER_6_185 VPWR VGND sg13g2_decap_8
XFILLER_21_435 VPWR VGND sg13g2_decap_4
XFILLER_16_207 VPWR VGND sg13g2_decap_8
XFILLER_17_77 VPWR VGND sg13g2_decap_8
XFILLER_29_524 VPWR VGND sg13g2_decap_8
XFILLER_12_402 VPWR VGND sg13g2_decap_8
XFILLER_12_479 VPWR VGND sg13g2_decap_8
XFILLER_24_262 VPWR VGND sg13g2_decap_8
XFILLER_4_656 VPWR VGND sg13g2_decap_8
XFILLER_3_100 VPWR VGND sg13g2_decap_8
XFILLER_3_199 VPWR VGND sg13g2_decap_4
XFILLER_15_273 VPWR VGND sg13g2_decap_8
XFILLER_30_221 VPWR VGND sg13g2_decap_8
XFILLER_11_490 VPWR VGND sg13g2_decap_8
XFILLER_7_483 VPWR VGND sg13g2_decap_8
XFILLER_30_298 VPWR VGND sg13g2_decap_8
XFILLER_21_276 VPWR VGND sg13g2_decap_8
XFILLER_29_343 VPWR VGND sg13g2_decap_8
XFILLER_28_21 VPWR VGND sg13g2_decap_8
XFILLER_28_98 VPWR VGND sg13g2_decap_8
XFILLER_25_560 VPWR VGND sg13g2_decap_8
XFILLER_12_276 VPWR VGND sg13g2_decap_8
XFILLER_5_14 VPWR VGND sg13g2_decap_8
XFILLER_4_475 VPWR VGND sg13g2_decap_8
XFILLER_22_530 VPWR VGND sg13g2_fill_1
XFILLER_5_217 VPWR VGND sg13g2_decap_8
XFILLER_30_11 VPWR VGND sg13g2_decap_8
XFILLER_30_88 VPWR VGND sg13g2_decap_8
XFILLER_29_140 VPWR VGND sg13g2_decap_8
XFILLER_13_530 VPWR VGND sg13g2_fill_2
XFILLER_17_357 VPWR VGND sg13g2_decap_8
XFILLER_25_390 VPWR VGND sg13g2_decap_8
XFILLER_4_294 VPWR VGND sg13g2_decap_8
Xlane1.lp.c_hsreq.tempo VPWR VGND _141_/X _159_/Y _304_/A fanout36/X _300_/A tempo_t24n
XFILLER_27_633 VPWR VGND sg13g2_decap_8
XFILLER_27_699 VPWR VGND sg13g2_decap_8
XFILLER_10_555 VPWR VGND sg13g2_decap_4
X_191_ _240_/D _190_/A _190_/B _191_/B1 hold95/X VPWR VGND sg13g2_a22oi_1
XFILLER_17_154 VPWR VGND sg13g2_decap_8
XFILLER_18_655 VPWR VGND sg13g2_decap_8
XFILLER_9_375 VPWR VGND sg13g2_decap_8
XFILLER_11_308 VPWR VGND sg13g2_decap_8
XFILLER_23_168 VPWR VGND sg13g2_decap_8
XFILLER_24_636 VPWR VGND sg13g2_decap_8
XFILLER_11_35 VPWR VGND sg13g2_decap_8
XFILLER_19_419 VPWR VGND sg13g2_decap_8
XFILLER_27_452 VPWR VGND sg13g2_decap_8
XFILLER_15_658 VPWR VGND sg13g2_decap_8
X_243_ _243_/Q _250_/CLK _243_/D _145_/Y VPWR VGND sg13g2_dfrbpq_1
XFILLER_30_606 VPWR VGND sg13g2_decap_8
XFILLER_10_385 VPWR VGND sg13g2_decap_8
X_174_ _176_/B _174_/A _174_/B VPWR VGND sg13g2_nand2_1
XFILLER_6_367 VPWR VGND sg13g2_decap_8
XFILLER_28_7 VPWR VGND sg13g2_decap_8
XFILLER_9_172 VPWR VGND sg13g2_decap_8
XFILLER_29_706 VPWR VGND sg13g2_decap_8
XFILLER_28_238 VPWR VGND sg13g2_decap_8
XFILLER_11_105 VPWR VGND sg13g2_decap_8
XFILLER_24_444 VPWR VGND sg13g2_decap_8
XFILLER_22_56 VPWR VGND sg13g2_decap_8
XFILLER_3_348 VPWR VGND sg13g2_decap_8
XFILLER_15_433 VPWR VGND sg13g2_fill_2
XFILLER_19_249 VPWR VGND sg13g2_decap_8
XFILLER_30_403 VPWR VGND sg13g2_decap_8
XFILLER_10_182 VPWR VGND sg13g2_decap_8
XFILLER_11_650 VPWR VGND sg13g2_decap_8
X_157_ _157_/Y _156_/B _157_/B VPWR VGND sg13g2_nand2b_1
X_226_ _226_/X _255_/Q _222_/B _256_/Q VPWR VGND sg13g2_a21o_1
XFILLER_7_632 VPWR VGND sg13g2_decap_8
XFILLER_6_164 VPWR VGND sg13g2_decap_8
XFILLER_21_414 VPWR VGND sg13g2_decap_8
XFILLER_29_503 VPWR VGND sg13g2_decap_8
XFILLER_17_56 VPWR VGND sg13g2_decap_8
XFILLER_24_241 VPWR VGND sg13g2_decap_8
XFILLER_12_458 VPWR VGND sg13g2_decap_8
XFILLER_4_635 VPWR VGND sg13g2_decap_8
XFILLER_3_178 VPWR VGND sg13g2_decap_8
XFILLER_3_145 VPWR VGND sg13g2_fill_1
XFILLER_15_252 VPWR VGND sg13g2_decap_8
XFILLER_16_720 VPWR VGND sg13g2_decap_8
XFILLER_30_200 VPWR VGND sg13g2_decap_8
X_209_ _209_/Y _246_/Q _247_/Q _248_/Q _249_/Q VPWR VGND sg13g2_nand4_1
XFILLER_7_462 VPWR VGND sg13g2_decap_8
XFILLER_30_277 VPWR VGND sg13g2_decap_8
XFILLER_17_0 VPWR VGND sg13g2_decap_8
XFILLER_21_255 VPWR VGND sg13g2_decap_8
XFILLER_29_322 VPWR VGND sg13g2_decap_8
XFILLER_28_77 VPWR VGND sg13g2_decap_8
XFILLER_29_399 VPWR VGND sg13g2_decap_8
XFILLER_12_255 VPWR VGND sg13g2_decap_8
XFILLER_0_682 VPWR VGND sg13g2_decap_8
XFILLER_4_454 VPWR VGND sg13g2_decap_8
XFILLER_10_7 VPWR VGND sg13g2_decap_8
Xlane3.c_term.tempo VPWR VGND _150_/A lane3.c_term.tempo/ARM _150_/Y fanout39/X _310_/A
+ tempo_t24n
XFILLER_7_270 VPWR VGND sg13g2_decap_8
XFILLER_30_67 VPWR VGND sg13g2_decap_8
XFILLER_17_336 VPWR VGND sg13g2_decap_8
XFILLER_29_196 VPWR VGND sg13g2_decap_8
XFILLER_4_262 VPWR VGND sg13g2_decap_8
XFILLER_16_391 VPWR VGND sg13g2_decap_8
XFILLER_6_91 VPWR VGND sg13g2_decap_8
XFILLER_22_383 VPWR VGND sg13g2_decap_8
X_190_ _192_/B _190_/A _190_/B VPWR VGND sg13g2_nand2_1
XFILLER_25_56 VPWR VGND sg13g2_decap_8
XFILLER_6_549 VPWR VGND sg13g2_decap_8
XFILLER_17_133 VPWR VGND sg13g2_decap_8
XFILLER_13_383 VPWR VGND sg13g2_decap_8
XFILLER_9_354 VPWR VGND sg13g2_decap_8
XFILLER_5_582 VPWR VGND sg13g2_decap_8
XFILLER_23_147 VPWR VGND sg13g2_decap_8
XFILLER_24_615 VPWR VGND sg13g2_decap_8
XFILLER_11_14 VPWR VGND sg13g2_decap_8
XFILLER_3_519 VPWR VGND sg13g2_fill_2
XFILLER_15_637 VPWR VGND sg13g2_decap_8
XFILLER_27_431 VPWR VGND sg13g2_decap_8
XFILLER_10_364 VPWR VGND sg13g2_decap_8
X_173_ _232_/D _232_/Q _173_/B VPWR VGND sg13g2_xnor2_1
X_242_ _242_/Q _251_/CLK _242_/D _145_/Y VPWR VGND sg13g2_dfrbpq_1
XFILLER_6_346 VPWR VGND sg13g2_decap_8
XFILLER_18_497 VPWR VGND sg13g2_decap_8
XFILLER_21_629 VPWR VGND sg13g2_decap_8
XFILLER_9_151 VPWR VGND sg13g2_decap_8
XFILLER_28_217 VPWR VGND sg13g2_decap_8
XFILLER_24_423 VPWR VGND sg13g2_decap_8
XFILLER_22_35 VPWR VGND sg13g2_decap_8
XFILLER_3_327 VPWR VGND sg13g2_decap_8
XFILLER_19_217 VPWR VGND sg13g2_decap_8
XFILLER_19_228 VPWR VGND sg13g2_decap_8
XFILLER_15_412 VPWR VGND sg13g2_decap_8
XFILLER_10_161 VPWR VGND sg13g2_decap_8
X_156_ _156_/Y _157_/B _156_/B VPWR VGND sg13g2_nand2b_1
X_225_ _225_/Y _254_/Q _253_/Q _255_/Q _256_/Q VPWR VGND sg13g2_nand4_1
XFILLER_7_699 VPWR VGND sg13g2_decap_8
XFILLER_30_459 VPWR VGND sg13g2_decap_8
XFILLER_18_294 VPWR VGND sg13g2_decap_8
XFILLER_19_4 VPWR VGND sg13g2_decap_8
XFILLER_25_209 VPWR VGND sg13g2_decap_8
XFILLER_29_559 VPWR VGND sg13g2_decap_8
XFILLER_12_437 VPWR VGND sg13g2_decap_8
XFILLER_17_35 VPWR VGND sg13g2_decap_8
XFILLER_24_220 VPWR VGND sg13g2_decap_8
XFILLER_4_614 VPWR VGND sg13g2_decap_8
XFILLER_24_297 VPWR VGND sg13g2_decap_8
XFILLER_3_157 VPWR VGND sg13g2_decap_8
XFILLER_3_135 VPWR VGND sg13g2_decap_4
XFILLER_28_581 VPWR VGND sg13g2_decap_8
XFILLER_15_231 VPWR VGND sg13g2_decap_8
XFILLER_30_256 VPWR VGND sg13g2_decap_8
X_139_ _140_/A _139_/A _139_/B VPWR VGND sg13g2_or2_1
X_208_ _208_/Y _248_/Q _208_/B VPWR VGND sg13g2_xnor2_1
XFILLER_21_234 VPWR VGND sg13g2_decap_8
XFILLER_29_378 VPWR VGND sg13g2_decap_8
XFILLER_29_301 VPWR VGND sg13g2_decap_8
XFILLER_28_56 VPWR VGND sg13g2_decap_8
XFILLER_12_234 VPWR VGND sg13g2_decap_8
XFILLER_13_713 VPWR VGND sg13g2_decap_4
XFILLER_5_49 VPWR VGND sg13g2_decap_8
XFILLER_4_433 VPWR VGND sg13g2_decap_8
XFILLER_6_709 VPWR VGND sg13g2_decap_8
XFILLER_30_46 VPWR VGND sg13g2_decap_8
XFILLER_17_315 VPWR VGND sg13g2_decap_8
XFILLER_29_175 VPWR VGND sg13g2_decap_8
XFILLER_4_241 VPWR VGND sg13g2_decap_8
XFILLER_23_329 VPWR VGND sg13g2_decap_8
XFILLER_6_70 VPWR VGND sg13g2_decap_8
XFILLER_27_668 VPWR VGND sg13g2_decap_8
XFILLER_27_613 VPWR VGND sg13g2_decap_8
XFILLER_25_35 VPWR VGND sg13g2_decap_8
XFILLER_22_362 VPWR VGND sg13g2_decap_8
XFILLER_25_79 VPWR VGND sg13g2_decap_8
XFILLER_6_528 VPWR VGND sg13g2_decap_8
XFILLER_17_112 VPWR VGND sg13g2_decap_8
XFILLER_18_602 VPWR VGND sg13g2_fill_1
XFILLER_17_189 VPWR VGND sg13g2_decap_8
XFILLER_13_362 VPWR VGND sg13g2_decap_8
XFILLER_9_333 VPWR VGND sg13g2_decap_8
XFILLER_5_561 VPWR VGND sg13g2_decap_8
XFILLER_17_690 VPWR VGND sg13g2_decap_8
XFILLER_23_126 VPWR VGND sg13g2_decap_8
XFILLER_27_410 VPWR VGND sg13g2_decap_8
XFILLER_15_627 VPWR VGND sg13g2_fill_1
X_310_ _310_/X _310_/A VPWR VGND sg13g2_buf_1
XFILLER_27_487 VPWR VGND sg13g2_decap_8
XFILLER_10_343 VPWR VGND sg13g2_decap_8
X_172_ _172_/Y _174_/A _170_/B _232_/Q VPWR VGND sg13g2_o21ai_1
X_241_ _241_/Q _251_/CLK _241_/D _145_/Y VPWR VGND sg13g2_dfrbpq_1
XFILLER_6_325 VPWR VGND sg13g2_decap_8
XFILLER_18_476 VPWR VGND sg13g2_decap_8
XFILLER_13_192 VPWR VGND sg13g2_decap_8
XFILLER_21_608 VPWR VGND sg13g2_decap_8
XFILLER_9_130 VPWR VGND sg13g2_decap_8
XFILLER_3_93 VPWR VGND sg13g2_decap_8
XFILLER_3_60 VPWR VGND sg13g2_decap_8
XFILLER_24_479 VPWR VGND sg13g2_decap_8
XFILLER_24_402 VPWR VGND sg13g2_decap_8
XFILLER_22_14 VPWR VGND sg13g2_decap_8
XFILLER_3_306 VPWR VGND sg13g2_decap_8
XFILLER_23_490 VPWR VGND sg13g2_decap_8
X_224_ _224_/Y _255_/Q _224_/B VPWR VGND sg13g2_xnor2_1
XFILLER_30_438 VPWR VGND sg13g2_decap_8
XFILLER_27_284 VPWR VGND sg13g2_decap_8
XFILLER_10_140 VPWR VGND sg13g2_decap_8
XFILLER_11_685 VPWR VGND sg13g2_decap_8
XFILLER_12_91 VPWR VGND sg13g2_decap_8
X_155_ _155_/Y _156_/B _157_/B VPWR VGND sg13g2_nand2_1
XFILLER_7_678 VPWR VGND sg13g2_decap_8
XFILLER_6_199 VPWR VGND sg13g2_decap_8
XFILLER_6_144 VPWR VGND sg13g2_fill_1
XFILLER_6_133 VPWR VGND sg13g2_decap_8
XFILLER_18_273 VPWR VGND sg13g2_decap_8
XFILLER_21_449 VPWR VGND sg13g2_decap_8
XFILLER_17_14 VPWR VGND sg13g2_decap_8
XFILLER_29_538 VPWR VGND sg13g2_decap_8
XFILLER_12_416 VPWR VGND sg13g2_decap_8
XFILLER_24_276 VPWR VGND sg13g2_decap_8
XFILLER_3_114 VPWR VGND sg13g2_decap_8
XFILLER_15_210 VPWR VGND sg13g2_decap_8
XFILLER_28_560 VPWR VGND sg13g2_decap_8
XFILLER_15_287 VPWR VGND sg13g2_decap_8
X_207_ _247_/D _206_/A _206_/B _207_/B1 _207_/B2 VPWR VGND sg13g2_a22oi_1
XFILLER_7_442 VPWR VGND sg13g2_decap_8
XFILLER_30_235 VPWR VGND sg13g2_decap_8
X_138_ _139_/B _296_/A _300_/A VPWR VGND sg13g2_nor2_1
XFILLER_7_497 VPWR VGND sg13g2_decap_8
XFILLER_7_453 VPWR VGND sg13g2_fill_2
XFILLER_3_692 VPWR VGND sg13g2_decap_8
XFILLER_21_213 VPWR VGND sg13g2_decap_8
XFILLER_22_703 VPWR VGND sg13g2_decap_8
XFILLER_9_81 VPWR VGND sg13g2_decap_8
XFILLER_29_357 VPWR VGND sg13g2_decap_8
XFILLER_28_35 VPWR VGND sg13g2_decap_8
XFILLER_12_213 VPWR VGND sg13g2_decap_8
XFILLER_9_707 VPWR VGND sg13g2_decap_8
XFILLER_9_718 VPWR VGND sg13g2_fill_1
XFILLER_25_574 VPWR VGND sg13g2_decap_8
XFILLER_5_28 VPWR VGND sg13g2_decap_8
XFILLER_4_489 VPWR VGND sg13g2_decap_8
XFILLER_4_412 VPWR VGND sg13g2_decap_8
XFILLER_16_552 VPWR VGND sg13g2_fill_2
XFILLER_22_0 VPWR VGND sg13g2_decap_8
XFILLER_10_706 VPWR VGND sg13g2_decap_8
XFILLER_30_25 VPWR VGND sg13g2_decap_8
XFILLER_29_154 VPWR VGND sg13g2_decap_8
XFILLER_13_511 VPWR VGND sg13g2_decap_4
XFILLER_13_566 VPWR VGND sg13g2_decap_8
XFILLER_13_577 VPWR VGND sg13g2_fill_2
XFILLER_9_504 VPWR VGND sg13g2_decap_8
XFILLER_4_220 VPWR VGND sg13g2_decap_8
XFILLER_23_308 VPWR VGND sg13g2_decap_8
XFILLER_27_647 VPWR VGND sg13g2_decap_8
XFILLER_25_14 VPWR VGND sg13g2_decap_8
XFILLER_22_341 VPWR VGND sg13g2_decap_8
XFILLER_6_507 VPWR VGND sg13g2_decap_8
XFILLER_9_4 VPWR VGND sg13g2_decap_8
XFILLER_18_669 VPWR VGND sg13g2_decap_8
XFILLER_13_341 VPWR VGND sg13g2_decap_8
XFILLER_15_91 VPWR VGND sg13g2_decap_8
XFILLER_17_168 VPWR VGND sg13g2_decap_8
XFILLER_9_312 VPWR VGND sg13g2_decap_8
XFILLER_9_389 VPWR VGND sg13g2_decap_8
Xclk_lane.lp.c_stop.tempo_58 clk_lane.lp.c_stop.tempo_58/L_HI VPWR VGND sg13g2_tiehi
XFILLER_5_540 VPWR VGND sg13g2_decap_8
XFILLER_23_105 VPWR VGND sg13g2_decap_8
XFILLER_11_49 VPWR VGND sg13g2_decap_8
X_240_ _240_/Q _250_/CLK _240_/D _145_/Y VPWR VGND sg13g2_dfrbpq_1
XFILLER_27_466 VPWR VGND sg13g2_decap_8
XFILLER_23_683 VPWR VGND sg13g2_decap_8
XFILLER_10_322 VPWR VGND sg13g2_decap_8
XFILLER_10_399 VPWR VGND sg13g2_decap_8
XFILLER_22_182 VPWR VGND sg13g2_decap_8
X_171_ _231_/D _171_/A _173_/B VPWR VGND sg13g2_or2_1
XFILLER_6_304 VPWR VGND sg13g2_decap_8
XFILLER_13_171 VPWR VGND sg13g2_decap_8
XFILLER_9_186 VPWR VGND sg13g2_decap_8
XFILLER_5_392 VPWR VGND sg13g2_decap_8
XFILLER_3_72 VPWR VGND sg13g2_decap_8
XFILLER_11_119 VPWR VGND sg13g2_decap_8
XFILLER_12_609 VPWR VGND sg13g2_decap_8
XFILLER_24_458 VPWR VGND sg13g2_decap_8
XFILLER_27_263 VPWR VGND sg13g2_decap_8
XFILLER_11_664 VPWR VGND sg13g2_decap_8
XFILLER_15_469 VPWR VGND sg13g2_decap_8
X_223_ _254_/D _222_/A _222_/B _223_/B1 _223_/B2 VPWR VGND sg13g2_a22oi_1
Xlane2.lp.f11.tempo_53 lane2.lp.f11.tempo/ARM VPWR VGND sg13g2_tielo
XFILLER_30_417 VPWR VGND sg13g2_decap_8
XFILLER_10_196 VPWR VGND sg13g2_decap_8
XFILLER_12_70 VPWR VGND sg13g2_decap_8
X_154_ _154_/Y _153_/B _154_/B VPWR VGND sg13g2_nand2b_1
XFILLER_7_646 VPWR VGND sg13g2_decap_8
XFILLER_6_178 VPWR VGND sg13g2_decap_8
XFILLER_6_112 VPWR VGND sg13g2_decap_8
XFILLER_18_252 VPWR VGND sg13g2_decap_8
XFILLER_21_428 VPWR VGND sg13g2_decap_8
XFILLER_21_439 VPWR VGND sg13g2_fill_1
Xlane2.lp.f11.tempo VPWR VGND _161_/Y lane2.lp.f11.tempo/ARM lane2.lp.f11.tempo_69/L_HI
+ fanout37/X _146_/B tempo_t24n
Xlane0.lp.c_stop.tempo VPWR VGND _136_/A _155_/Y lane0.lp.c_stop.tempo_61/L_HI fanout36/X
+ _303_/A tempo_t24n
XFILLER_29_517 VPWR VGND sg13g2_decap_8
XFILLER_24_255 VPWR VGND sg13g2_decap_8
XFILLER_4_649 VPWR VGND sg13g2_decap_8
XFILLER_15_266 VPWR VGND sg13g2_decap_8
XFILLER_11_483 VPWR VGND sg13g2_decap_8
X_137_ _139_/A _159_/B _160_/B VPWR VGND sg13g2_or2_1
X_206_ _208_/B _206_/A _206_/B VPWR VGND sg13g2_nand2_1
XFILLER_7_476 VPWR VGND sg13g2_decap_8
XFILLER_7_432 VPWR VGND sg13g2_fill_1
XFILLER_30_214 VPWR VGND sg13g2_decap_8
XFILLER_23_91 VPWR VGND sg13g2_decap_8
XFILLER_3_671 VPWR VGND sg13g2_decap_8
XFILLER_19_561 VPWR VGND sg13g2_fill_2
XFILLER_24_4 VPWR VGND sg13g2_decap_8
XFILLER_21_269 VPWR VGND sg13g2_decap_8
XFILLER_9_60 VPWR VGND sg13g2_decap_8
XFILLER_29_336 VPWR VGND sg13g2_decap_8
XFILLER_28_14 VPWR VGND sg13g2_decap_8
XFILLER_13_704 VPWR VGND sg13g2_decap_4
XFILLER_12_269 VPWR VGND sg13g2_decap_8
XFILLER_4_468 VPWR VGND sg13g2_decap_8
XFILLER_0_696 VPWR VGND sg13g2_decap_8
XFILLER_18_91 VPWR VGND sg13g2_decap_8
XFILLER_11_280 VPWR VGND sg13g2_decap_8
XFILLER_7_284 VPWR VGND sg13g2_fill_2
XFILLER_3_490 VPWR VGND sg13g2_decap_8
XFILLER_15_0 VPWR VGND sg13g2_decap_8
XFILLER_19_391 VPWR VGND sg13g2_decap_8
XFILLER_29_133 VPWR VGND sg13g2_decap_8
XFILLER_25_383 VPWR VGND sg13g2_decap_8
XFILLER_4_287 VPWR VGND sg13g2_decap_8
XFILLER_4_276 VPWR VGND sg13g2_fill_1
Xhold90 _219_/A _291_/A VPWR VGND sg13g2_dlygate4sd3_1
XFILLER_16_361 VPWR VGND sg13g2_decap_8
XFILLER_27_626 VPWR VGND sg13g2_decap_8
XFILLER_22_320 VPWR VGND sg13g2_decap_8
XFILLER_10_504 VPWR VGND sg13g2_decap_8
XFILLER_10_548 VPWR VGND sg13g2_decap_8
XFILLER_22_397 VPWR VGND sg13g2_decap_8
XFILLER_17_147 VPWR VGND sg13g2_decap_8
XFILLER_18_648 VPWR VGND sg13g2_decap_8
XFILLER_13_320 VPWR VGND sg13g2_decap_8
XFILLER_13_397 VPWR VGND sg13g2_decap_8
XFILLER_15_70 VPWR VGND sg13g2_decap_8
XFILLER_9_368 VPWR VGND sg13g2_decap_8
XFILLER_24_629 VPWR VGND sg13g2_decap_8
XFILLER_11_28 VPWR VGND sg13g2_decap_8
XFILLER_27_445 VPWR VGND sg13g2_decap_8
XFILLER_10_301 VPWR VGND sg13g2_decap_8
XFILLER_22_161 VPWR VGND sg13g2_decap_8
X_170_ _173_/B _174_/A _170_/B VPWR VGND sg13g2_nor2_1
XFILLER_23_662 VPWR VGND sg13g2_decap_8
XFILLER_10_378 VPWR VGND sg13g2_decap_8
XFILLER_18_412 VPWR VGND sg13g2_decap_8
XFILLER_13_150 VPWR VGND sg13g2_decap_8
X_299_ _299_/X _299_/A VPWR VGND sg13g2_buf_1
XFILLER_9_165 VPWR VGND sg13g2_decap_8
XFILLER_5_371 VPWR VGND sg13g2_decap_8
XFILLER_24_437 VPWR VGND sg13g2_decap_8
XFILLER_22_49 VPWR VGND sg13g2_decap_8
XFILLER_15_426 VPWR VGND sg13g2_decap_8
XFILLER_28_721 VPWR VGND sg13g2_fill_2
XFILLER_27_242 VPWR VGND sg13g2_decap_8
XFILLER_10_175 VPWR VGND sg13g2_decap_8
XFILLER_11_643 VPWR VGND sg13g2_decap_8
X_153_ _153_/Y _154_/B _153_/B VPWR VGND sg13g2_nand2b_1
X_222_ _224_/B _222_/A _222_/B VPWR VGND sg13g2_nand2_1
XFILLER_7_625 VPWR VGND sg13g2_decap_8
XFILLER_6_157 VPWR VGND sg13g2_decap_8
XFILLER_18_231 VPWR VGND sg13g2_decap_8
XFILLER_21_407 VPWR VGND sg13g2_decap_8
Xlane0.lp.f10.tempo_46 lane0.lp.f10.tempo/ARM VPWR VGND sg13g2_tielo
XFILLER_17_49 VPWR VGND sg13g2_decap_8
XFILLER_25_713 VPWR VGND sg13g2_decap_4
XFILLER_24_234 VPWR VGND sg13g2_decap_8
XFILLER_4_628 VPWR VGND sg13g2_decap_8
XFILLER_15_245 VPWR VGND sg13g2_decap_8
XFILLER_16_713 VPWR VGND sg13g2_decap_8
XFILLER_28_595 VPWR VGND sg13g2_decap_8
XFILLER_11_462 VPWR VGND sg13g2_decap_8
X_136_ _136_/X _136_/A _136_/B VPWR VGND sg13g2_or2_1
X_205_ _246_/D _246_/Q _205_/B VPWR VGND sg13g2_xnor2_1
XFILLER_7_411 VPWR VGND sg13g2_decap_8
XFILLER_23_70 VPWR VGND sg13g2_decap_8
XFILLER_3_650 VPWR VGND sg13g2_decap_8
XFILLER_21_248 VPWR VGND sg13g2_decap_8
XFILLER_29_315 VPWR VGND sg13g2_decap_8
XFILLER_12_248 VPWR VGND sg13g2_decap_8
XFILLER_4_447 VPWR VGND sg13g2_decap_8
XFILLER_18_70 VPWR VGND sg13g2_decap_8
Xlane2.lp.f10.tempo VPWR VGND _163_/Y lane2.lp.f10.tempo/ARM lane2.lp.f10.tempo_68/L_HI
+ fanout37/X _146_/A tempo_t24n
XFILLER_28_392 VPWR VGND sg13g2_decap_8
X_119_ _119_/Y _244_/Q VPWR VGND sg13g2_inv_1
XFILLER_7_296 VPWR VGND sg13g2_fill_2
XFILLER_7_263 VPWR VGND sg13g2_decap_8
XFILLER_22_502 VPWR VGND sg13g2_decap_8
XFILLER_22_568 VPWR VGND sg13g2_fill_2
XFILLER_17_329 VPWR VGND sg13g2_decap_8
XFILLER_29_189 VPWR VGND sg13g2_decap_8
XFILLER_29_112 VPWR VGND sg13g2_decap_8
XFILLER_25_362 VPWR VGND sg13g2_decap_8
XFILLER_5_712 VPWR VGND sg13g2_decap_8
XFILLER_4_255 VPWR VGND sg13g2_decap_8
XFILLER_16_340 VPWR VGND sg13g2_decap_8
XFILLER_16_384 VPWR VGND sg13g2_decap_8
Xhold80 hold80/X _122_/Y VPWR VGND sg13g2_dlygate4sd3_1
XFILLER_29_91 VPWR VGND sg13g2_decap_8
XFILLER_12_590 VPWR VGND sg13g2_fill_2
XFILLER_6_84 VPWR VGND sg13g2_decap_8
XFILLER_22_376 VPWR VGND sg13g2_decap_8
Xclk_lane.lp.f11.tempo_60 clk_lane.lp.f11.tempo_60/L_HI VPWR VGND sg13g2_tiehi
XFILLER_25_49 VPWR VGND sg13g2_decap_8
XFILLER_17_126 VPWR VGND sg13g2_decap_8
XFILLER_13_376 VPWR VGND sg13g2_decap_8
XFILLER_9_347 VPWR VGND sg13g2_decap_8
XFILLER_25_192 VPWR VGND sg13g2_decap_8
XFILLER_5_575 VPWR VGND sg13g2_decap_8
XFILLER_24_608 VPWR VGND sg13g2_decap_8
XFILLER_27_424 VPWR VGND sg13g2_decap_8
XFILLER_10_357 VPWR VGND sg13g2_decap_8
XFILLER_22_140 VPWR VGND sg13g2_decap_8
XFILLER_23_641 VPWR VGND sg13g2_decap_8
XFILLER_6_339 VPWR VGND sg13g2_decap_8
X_298_ _298_/X _298_/A VPWR VGND sg13g2_buf_1
XFILLER_9_144 VPWR VGND sg13g2_decap_8
XFILLER_5_350 VPWR VGND sg13g2_decap_8
XFILLER_24_416 VPWR VGND sg13g2_decap_8
XFILLER_17_490 VPWR VGND sg13g2_decap_8
XFILLER_22_28 VPWR VGND sg13g2_decap_8
XFILLER_28_700 VPWR VGND sg13g2_decap_8
XFILLER_15_405 VPWR VGND sg13g2_decap_8
XFILLER_27_298 VPWR VGND sg13g2_decap_8
XFILLER_27_221 VPWR VGND sg13g2_decap_8
XFILLER_10_154 VPWR VGND sg13g2_decap_8
XFILLER_11_622 VPWR VGND sg13g2_decap_8
XFILLER_11_699 VPWR VGND sg13g2_decap_8
X_152_ _152_/Y _153_/B _154_/B VPWR VGND sg13g2_nand2_1
X_221_ _253_/D _253_/Q _221_/B VPWR VGND sg13g2_xnor2_1
XFILLER_5_0 VPWR VGND sg13g2_decap_8
XFILLER_18_210 VPWR VGND sg13g2_decap_8
XFILLER_19_700 VPWR VGND sg13g2_decap_4
XFILLER_18_287 VPWR VGND sg13g2_decap_8
Xdelaybuf_1_rx_clk delaybuf_2_rx_clk/A delaybuf_1_rx_clk/A VPWR VGND sg13g2_buf_8
XFILLER_6_681 VPWR VGND sg13g2_decap_8
XFILLER_17_28 VPWR VGND sg13g2_decap_8
XFILLER_24_213 VPWR VGND sg13g2_decap_8
XFILLER_3_139 VPWR VGND sg13g2_fill_2
XFILLER_3_128 VPWR VGND sg13g2_decap_8
XFILLER_28_574 VPWR VGND sg13g2_decap_8
XFILLER_11_441 VPWR VGND sg13g2_decap_8
XFILLER_15_224 VPWR VGND sg13g2_decap_8
X_204_ _204_/Y _206_/A _202_/B _246_/Q VPWR VGND sg13g2_o21ai_1
XFILLER_30_249 VPWR VGND sg13g2_decap_8
X_135_ _135_/Y _135_/A VPWR VGND sg13g2_inv_1
XFILLER_0_53 VPWR VGND sg13g2_decap_4
XFILLER_22_717 VPWR VGND sg13g2_decap_4
XFILLER_21_227 VPWR VGND sg13g2_decap_8
XFILLER_9_95 VPWR VGND sg13g2_decap_8
XFILLER_28_49 VPWR VGND sg13g2_decap_8
XFILLER_12_227 VPWR VGND sg13g2_decap_8
XFILLER_13_717 VPWR VGND sg13g2_fill_2
XFILLER_4_426 VPWR VGND sg13g2_decap_8
XFILLER_16_566 VPWR VGND sg13g2_fill_2
XFILLER_28_371 VPWR VGND sg13g2_decap_8
X_118_ _118_/Y _243_/Q VPWR VGND sg13g2_inv_1
XFILLER_7_242 VPWR VGND sg13g2_decap_8
XFILLER_30_39 VPWR VGND sg13g2_decap_8
XFILLER_17_308 VPWR VGND sg13g2_decap_8
XFILLER_29_168 VPWR VGND sg13g2_decap_8
XFILLER_25_341 VPWR VGND sg13g2_decap_8
XFILLER_4_234 VPWR VGND sg13g2_decap_8
XFILLER_29_70 VPWR VGND sg13g2_decap_8
XFILLER_6_63 VPWR VGND sg13g2_decap_8
XFILLER_27_606 VPWR VGND sg13g2_decap_8
XFILLER_22_355 VPWR VGND sg13g2_decap_8
XFILLER_25_28 VPWR VGND sg13g2_decap_8
Xclkbuf_2_2__f_rx_clk_regs _258_/CLK clkbuf_0_rx_clk_regs/X VPWR VGND sg13g2_buf_16
XFILLER_17_105 VPWR VGND sg13g2_decap_8
XFILLER_25_171 VPWR VGND sg13g2_decap_8
XFILLER_13_355 VPWR VGND sg13g2_decap_8
XFILLER_9_326 VPWR VGND sg13g2_decap_8
XFILLER_5_532 VPWR VGND sg13g2_decap_4
XFILLER_5_554 VPWR VGND sg13g2_decap_8
XFILLER_16_193 VPWR VGND sg13g2_decap_8
XFILLER_17_683 VPWR VGND sg13g2_decap_8
XFILLER_23_119 VPWR VGND sg13g2_decap_8
XFILLER_23_620 VPWR VGND sg13g2_decap_8
XFILLER_27_403 VPWR VGND sg13g2_decap_8
XFILLER_10_336 VPWR VGND sg13g2_decap_8
XFILLER_22_196 VPWR VGND sg13g2_decap_8
XFILLER_6_318 VPWR VGND sg13g2_decap_8
XFILLER_23_697 VPWR VGND sg13g2_decap_8
XFILLER_7_4 VPWR VGND sg13g2_decap_8
XFILLER_18_469 VPWR VGND sg13g2_decap_8
XFILLER_13_185 VPWR VGND sg13g2_decap_8
XFILLER_9_123 VPWR VGND sg13g2_decap_8
X_297_ _297_/X _297_/A VPWR VGND sg13g2_buf_1
XFILLER_3_86 VPWR VGND sg13g2_decap_8
XFILLER_3_53 VPWR VGND sg13g2_decap_8
XFILLER_27_200 VPWR VGND sg13g2_decap_8
XFILLER_23_483 VPWR VGND sg13g2_decap_8
X_220_ _220_/Y _222_/A _218_/B _253_/Q VPWR VGND sg13g2_o21ai_1
XFILLER_27_277 VPWR VGND sg13g2_decap_8
XFILLER_10_133 VPWR VGND sg13g2_decap_8
XFILLER_11_678 VPWR VGND sg13g2_decap_8
XFILLER_12_84 VPWR VGND sg13g2_decap_8
X_151_ _151_/X _151_/A _151_/B VPWR VGND sg13g2_or2_1
XFILLER_6_126 VPWR VGND sg13g2_decap_8
XFILLER_18_266 VPWR VGND sg13g2_decap_8
XFILLER_6_660 VPWR VGND sg13g2_decap_8
XFILLER_12_409 VPWR VGND sg13g2_decap_8
XFILLER_24_269 VPWR VGND sg13g2_decap_8
XFILLER_3_107 VPWR VGND sg13g2_decap_8
XFILLER_15_203 VPWR VGND sg13g2_decap_8
XFILLER_28_553 VPWR VGND sg13g2_decap_8
XFILLER_11_420 VPWR VGND sg13g2_decap_8
XFILLER_23_280 VPWR VGND sg13g2_decap_8
X_203_ _245_/D _203_/A _205_/B VPWR VGND sg13g2_or2_1
XFILLER_30_228 VPWR VGND sg13g2_decap_8
XFILLER_11_497 VPWR VGND sg13g2_decap_8
X_134_ _135_/A _134_/A _134_/B VPWR VGND sg13g2_or2_1
XFILLER_3_685 VPWR VGND sg13g2_decap_8
XFILLER_0_32 VPWR VGND sg13g2_decap_8
XFILLER_21_206 VPWR VGND sg13g2_decap_8
XFILLER_9_74 VPWR VGND sg13g2_decap_8
XFILLER_28_28 VPWR VGND sg13g2_decap_8
XFILLER_12_206 VPWR VGND sg13g2_decap_8
XFILLER_25_567 VPWR VGND sg13g2_decap_8
XFILLER_4_405 VPWR VGND sg13g2_decap_8
XFILLER_28_350 VPWR VGND sg13g2_decap_8
XFILLER_11_294 VPWR VGND sg13g2_decap_8
X_117_ _117_/Y _240_/Q VPWR VGND sg13g2_inv_1
XFILLER_30_592 VPWR VGND sg13g2_decap_8
XFILLER_30_18 VPWR VGND sg13g2_decap_8
XFILLER_13_504 VPWR VGND sg13g2_decap_8
XFILLER_13_515 VPWR VGND sg13g2_fill_2
XFILLER_13_526 VPWR VGND sg13g2_decap_4
Xlane3.lp.c_stop.tempo_70 lane3.lp.c_stop.tempo_70/L_HI VPWR VGND sg13g2_tiehi
XFILLER_29_147 VPWR VGND sg13g2_decap_8
XFILLER_25_320 VPWR VGND sg13g2_decap_8
XFILLER_13_559 VPWR VGND sg13g2_decap_8
XFILLER_25_397 VPWR VGND sg13g2_decap_8
XFILLER_4_213 VPWR VGND sg13g2_decap_8
Xhold93 _241_/D _192_/Y VPWR VGND sg13g2_dlygate4sd3_1
XFILLER_29_692 VPWR VGND sg13g2_decap_8
XFILLER_12_592 VPWR VGND sg13g2_fill_1
XFILLER_6_42 VPWR VGND sg13g2_decap_8
XFILLER_22_334 VPWR VGND sg13g2_decap_8
XFILLER_13_301 VPWR VGND sg13g2_fill_1
XFILLER_13_334 VPWR VGND sg13g2_decap_8
XFILLER_15_84 VPWR VGND sg13g2_decap_8
XFILLER_9_305 VPWR VGND sg13g2_decap_8
XFILLER_25_150 VPWR VGND sg13g2_decap_8
XFILLER_5_511 VPWR VGND sg13g2_decap_8
XFILLER_17_662 VPWR VGND sg13g2_decap_8
XFILLER_16_172 VPWR VGND sg13g2_decap_8
XFILLER_27_459 VPWR VGND sg13g2_decap_8
XFILLER_23_676 VPWR VGND sg13g2_decap_8
XFILLER_10_315 VPWR VGND sg13g2_decap_8
XFILLER_22_175 VPWR VGND sg13g2_decap_8
XFILLER_18_426 VPWR VGND sg13g2_decap_8
XFILLER_13_164 VPWR VGND sg13g2_decap_8
X_296_ _296_/X _296_/A VPWR VGND sg13g2_buf_1
Xlane3.lp.f11.tempo_72 lane3.lp.f11.tempo_72/L_HI VPWR VGND sg13g2_tiehi
XFILLER_9_102 VPWR VGND sg13g2_decap_8
XFILLER_9_179 VPWR VGND sg13g2_decap_8
XFILLER_5_385 VPWR VGND sg13g2_decap_8
XFILLER_3_32 VPWR VGND sg13g2_decap_8
XFILLER_27_256 VPWR VGND sg13g2_decap_8
XFILLER_10_112 VPWR VGND sg13g2_decap_8
XFILLER_11_657 VPWR VGND sg13g2_decap_8
XFILLER_23_462 VPWR VGND sg13g2_decap_8
X_150_ _150_/Y _150_/A VPWR VGND sg13g2_inv_1
XFILLER_10_189 VPWR VGND sg13g2_decap_8
XFILLER_12_63 VPWR VGND sg13g2_decap_8
XFILLER_7_639 VPWR VGND sg13g2_decap_8
XFILLER_6_105 VPWR VGND sg13g2_decap_8
XFILLER_18_245 VPWR VGND sg13g2_decap_8
XFILLER_5_182 VPWR VGND sg13g2_decap_8
XFILLER_24_248 VPWR VGND sg13g2_decap_8
XFILLER_15_259 VPWR VGND sg13g2_decap_8
XFILLER_28_532 VPWR VGND sg13g2_decap_8
XFILLER_11_476 VPWR VGND sg13g2_decap_8
X_133_ _134_/B _295_/A _299_/A VPWR VGND sg13g2_nor2_1
X_202_ _205_/B _206_/A _202_/B VPWR VGND sg13g2_nor2_1
XFILLER_7_425 VPWR VGND sg13g2_decap_8
XFILLER_30_207 VPWR VGND sg13g2_decap_8
XFILLER_23_84 VPWR VGND sg13g2_decap_8
XFILLER_7_469 VPWR VGND sg13g2_decap_8
XFILLER_3_664 VPWR VGND sg13g2_decap_8
XFILLER_0_11 VPWR VGND sg13g2_decap_8
XFILLER_17_7 VPWR VGND sg13g2_decap_8
XFILLER_9_53 VPWR VGND sg13g2_decap_8
XFILLER_13_708 VPWR VGND sg13g2_fill_1
XFILLER_29_329 VPWR VGND sg13g2_decap_8
XFILLER_0_689 VPWR VGND sg13g2_decap_8
XFILLER_18_84 VPWR VGND sg13g2_decap_8
XFILLER_11_273 VPWR VGND sg13g2_decap_8
X_116_ _116_/Y _237_/Q VPWR VGND sg13g2_inv_1
XFILLER_7_277 VPWR VGND sg13g2_decap_8
XFILLER_7_222 VPWR VGND sg13g2_fill_2
XFILLER_7_211 VPWR VGND sg13g2_decap_8
XFILLER_3_483 VPWR VGND sg13g2_decap_8
XFILLER_19_384 VPWR VGND sg13g2_decap_8
XFILLER_30_571 VPWR VGND sg13g2_decap_8
XFILLER_29_126 VPWR VGND sg13g2_decap_8
XFILLER_25_376 VPWR VGND sg13g2_decap_8
XFILLER_5_726 VPWR VGND sg13g2_fill_1
XFILLER_4_269 VPWR VGND sg13g2_decap_8
Xhold83 hold83/X _119_/Y VPWR VGND sg13g2_dlygate4sd3_1
XFILLER_29_671 VPWR VGND sg13g2_decap_8
XFILLER_16_354 VPWR VGND sg13g2_decap_8
XFILLER_16_398 VPWR VGND sg13g2_decap_8
XFILLER_6_98 VPWR VGND sg13g2_decap_8
XFILLER_6_21 VPWR VGND sg13g2_decap_8
XFILLER_19_192 VPWR VGND sg13g2_decap_8
XFILLER_22_313 VPWR VGND sg13g2_decap_8
XFILLER_13_313 VPWR VGND sg13g2_decap_8
XFILLER_15_63 VPWR VGND sg13g2_decap_8
XFILLER_16_151 VPWR VGND sg13g2_decap_8
XFILLER_17_641 VPWR VGND sg13g2_decap_8
XFILLER_27_438 VPWR VGND sg13g2_decap_8
XFILLER_22_154 VPWR VGND sg13g2_decap_8
XFILLER_23_655 VPWR VGND sg13g2_decap_8
XFILLER_18_405 VPWR VGND sg13g2_decap_8
XFILLER_18_449 VPWR VGND sg13g2_fill_1
XFILLER_13_132 VPWR VGND sg13g2_decap_8
X_295_ _295_/X _295_/A VPWR VGND sg13g2_buf_1
XFILLER_9_158 VPWR VGND sg13g2_decap_8
XFILLER_5_364 VPWR VGND sg13g2_decap_8
XFILLER_3_11 VPWR VGND sg13g2_decap_8
Xlane1.lp.f10.tempo_65 lane1.lp.f10.tempo_65/L_HI VPWR VGND sg13g2_tiehi
XFILLER_15_419 VPWR VGND sg13g2_decap_8
XFILLER_28_714 VPWR VGND sg13g2_decap_8
XFILLER_27_235 VPWR VGND sg13g2_decap_8
XFILLER_10_168 VPWR VGND sg13g2_decap_8
XFILLER_11_636 VPWR VGND sg13g2_decap_8
XFILLER_23_441 VPWR VGND sg13g2_decap_8
Xlane2.lp.f11.tempo_69 lane2.lp.f11.tempo_69/L_HI VPWR VGND sg13g2_tiehi
XFILLER_7_618 VPWR VGND sg13g2_decap_8
XFILLER_12_42 VPWR VGND sg13g2_decap_8
XFILLER_18_224 VPWR VGND sg13g2_decap_8
XFILLER_6_695 VPWR VGND sg13g2_decap_8
XFILLER_5_161 VPWR VGND sg13g2_decap_8
XFILLER_25_717 VPWR VGND sg13g2_fill_2
XFILLER_25_706 VPWR VGND sg13g2_decap_8
XFILLER_24_227 VPWR VGND sg13g2_decap_8
XFILLER_28_511 VPWR VGND sg13g2_decap_8
XFILLER_15_238 VPWR VGND sg13g2_decap_8
XFILLER_16_706 VPWR VGND sg13g2_decap_8
XFILLER_28_588 VPWR VGND sg13g2_decap_8
XFILLER_11_455 VPWR VGND sg13g2_decap_8
XFILLER_23_63 VPWR VGND sg13g2_decap_8
X_132_ _134_/A _156_/B _157_/B VPWR VGND sg13g2_or2_1
X_201_ _202_/B _246_/Q _247_/Q _248_/Q VPWR VGND sg13g2_a21oi_1
XFILLER_7_404 VPWR VGND sg13g2_decap_8
XFILLER_3_643 VPWR VGND sg13g2_decap_8
XFILLER_9_32 VPWR VGND sg13g2_decap_8
XFILLER_29_308 VPWR VGND sg13g2_decap_8
XFILLER_21_720 VPWR VGND sg13g2_fill_2
XFILLER_18_63 VPWR VGND sg13g2_decap_8
XFILLER_16_536 VPWR VGND sg13g2_fill_2
XFILLER_28_385 VPWR VGND sg13g2_decap_8
XFILLER_11_252 VPWR VGND sg13g2_decap_8
X_115_ _115_/Y _236_/Q VPWR VGND sg13g2_inv_1
XFILLER_7_256 VPWR VGND sg13g2_decap_8
XFILLER_3_462 VPWR VGND sg13g2_decap_8
XFILLER_3_440 VPWR VGND sg13g2_decap_8
XFILLER_19_341 VPWR VGND sg13g2_decap_8
XFILLER_30_550 VPWR VGND sg13g2_decap_8
XFILLER_29_105 VPWR VGND sg13g2_decap_8
XFILLER_25_355 VPWR VGND sg13g2_decap_8
XFILLER_21_572 VPWR VGND sg13g2_decap_4
XFILLER_21_594 VPWR VGND sg13g2_decap_8
XFILLER_5_705 VPWR VGND sg13g2_decap_8
XFILLER_4_248 VPWR VGND sg13g2_decap_8
XFILLER_16_333 VPWR VGND sg13g2_decap_8
Xhold95 hold95/X _117_/Y VPWR VGND sg13g2_dlygate4sd3_1
XFILLER_29_84 VPWR VGND sg13g2_decap_8
XFILLER_29_650 VPWR VGND sg13g2_decap_8
XFILLER_28_182 VPWR VGND sg13g2_decap_8
XFILLER_12_583 VPWR VGND sg13g2_decap_8
XFILLER_6_77 VPWR VGND sg13g2_decap_8
XFILLER_3_270 VPWR VGND sg13g2_decap_8
Xclk_lane.arm.u_xor clk_lane.arm.u_xor/X clk_lane.arm.u_xor/A clk_lane.arm.u_xor/B
+ VPWR VGND sg13g2_xor2_1
XFILLER_19_171 VPWR VGND sg13g2_decap_8
XFILLER_22_369 VPWR VGND sg13g2_decap_8
XFILLER_17_119 VPWR VGND sg13g2_decap_8
XFILLER_13_369 VPWR VGND sg13g2_decap_8
XFILLER_15_42 VPWR VGND sg13g2_decap_8
XFILLER_25_185 VPWR VGND sg13g2_decap_8
Xoutput30 stop[3] _306_/X VPWR VGND sg13g2_buf_1
XFILLER_5_568 VPWR VGND sg13g2_decap_8
XFILLER_16_130 VPWR VGND sg13g2_decap_8
XFILLER_17_697 VPWR VGND sg13g2_decap_8
.ends
