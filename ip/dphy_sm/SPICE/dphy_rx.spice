* NGSPICE file created from dphy_rx.ext - technology: ihp-sg13g2

* Black-box entry subcircuit for sg13g2_decap_8 abstract view
.subckt sg13g2_decap_8 VDD VSS
.ends

* Black-box entry subcircuit for sg13g2_fill_1 abstract view
.subckt sg13g2_fill_1 VDD VSS
.ends

* Black-box entry subcircuit for sg13g2_or2_1 abstract view
.subckt sg13g2_or2_1 X A B VDD VSS
.ends

* Black-box entry subcircuit for sg13g2_dfrbpq_1 abstract view
.subckt sg13g2_dfrbpq_1 Q CLK D RESET_B VDD VSS
.ends

* Black-box entry subcircuit for tempo_t24n abstract view
.subckt tempo_t24n VDD VSS RESET ARM INGRESS PG PROGRESS
.ends

* Black-box entry subcircuit for sg13g2_nand2b_1 abstract view
.subckt sg13g2_nand2b_1 Y A_N B VDD VSS
.ends

* Black-box entry subcircuit for sg13g2_tielo abstract view
.subckt sg13g2_tielo L_LO VDD VSS
.ends

* Black-box entry subcircuit for sg13g2_dlygate4sd3_1 abstract view
.subckt sg13g2_dlygate4sd3_1 X A VDD VSS
.ends

* Black-box entry subcircuit for sg13g2_buf_1 abstract view
.subckt sg13g2_buf_1 X A VDD VSS
.ends

* Black-box entry subcircuit for sg13g2_inv_1 abstract view
.subckt sg13g2_inv_1 Y A VDD VSS
.ends

* Black-box entry subcircuit for sg13g2_fill_2 abstract view
.subckt sg13g2_fill_2 VDD VSS
.ends

* Black-box entry subcircuit for sg13g2_tiehi abstract view
.subckt sg13g2_tiehi L_HI VDD VSS
.ends

* Black-box entry subcircuit for sg13g2_a21o_1 abstract view
.subckt sg13g2_a21o_1 X A1 A2 B1 VDD VSS
.ends

* Black-box entry subcircuit for sg13g2_buf_8 abstract view
.subckt sg13g2_buf_8 X A VDD VSS
.ends

* Black-box entry subcircuit for sg13g2_decap_4 abstract view
.subckt sg13g2_decap_4 VDD VSS
.ends

* Black-box entry subcircuit for sg13g2_xnor2_1 abstract view
.subckt sg13g2_xnor2_1 Y A B VDD VSS
.ends

* Black-box entry subcircuit for sg13g2_inv_2 abstract view
.subckt sg13g2_inv_2 Y A VDD VSS
.ends

* Black-box entry subcircuit for tempo_t110n abstract view
.subckt tempo_t110n VDD VSS RESET ARM INGRESS PG PROGRESS
.ends

* Black-box entry subcircuit for sg13g2_buf_16 abstract view
.subckt sg13g2_buf_16 X A VDD VSS
.ends

* Black-box entry subcircuit for tempo_t40n abstract view
.subckt tempo_t40n VDD VSS RESET ARM INGRESS PG PROGRESS
.ends

* Black-box entry subcircuit for sg13g2_nand2_1 abstract view
.subckt sg13g2_nand2_1 Y A B VDD VSS
.ends

* Black-box entry subcircuit for sg13g2_nor2_1 abstract view
.subckt sg13g2_nor2_1 Y A B VDD VSS
.ends

* Black-box entry subcircuit for sg13g2_dlhrq_1 abstract view
.subckt sg13g2_dlhrq_1 Q D GATE RESET_B VDD VSS
.ends

* Black-box entry subcircuit for tempo_t180n abstract view
.subckt tempo_t180n VDD VSS RESET ARM INGRESS PG PROGRESS
.ends

* Black-box entry subcircuit for sg13g2_buf_4 abstract view
.subckt sg13g2_buf_4 X A VDD VSS
.ends

* Black-box entry subcircuit for sg13g2_and2_1 abstract view
.subckt sg13g2_and2_1 X A B VDD VSS
.ends

* Black-box entry subcircuit for sg13g2_xor2_1 abstract view
.subckt sg13g2_xor2_1 X A B VDD VSS
.ends

.subckt dphy_rx PG VGND VPWR clk_lp_n clk_lp_p clk_miss clk_rx_en clk_stop clk_term_en
+ hs_rx_en[0] hs_rx_en[1] hs_rx_en[2] hs_rx_en[3] hspr[0] hspr[1] hspr[2] hspr[3]
+ hsreq[0] hsreq[1] hsreq[2] hsreq[3] lp_n[0] lp_n[1] lp_n[2] lp_n[3] lp_p[0] lp_p[1]
+ lp_p[2] lp_p[3] rx_clk stop[0] stop[1] stop[2] stop[3] term_en[0] term_en[1] term_en[2]
+ term_en[3]
XFILLER_27_417 VPWR VGND sg13g2_decap_8
XFILLER_22_133 VPWR VGND sg13g2_decap_8
XFILLER_23_667 VPWR VGND sg13g2_decap_8
XFILLER_13_100 VPWR VGND sg13g2_decap_8
XFILLER_13_199 VPWR VGND sg13g2_decap_8
XFILLER_9_137 VPWR VGND sg13g2_decap_8
XFILLER_5_343 VPWR VGND sg13g2_decap_8
XFILLER_3_67 VPWR VGND sg13g2_fill_1
XFILLER_9_682 VPWR VGND sg13g2_fill_1
XFILLER_27_214 VPWR VGND sg13g2_decap_8
XFILLER_23_420 VPWR VGND sg13g2_decap_8
XFILLER_10_147 VPWR VGND sg13g2_decap_8
XFILLER_11_615 VPWR VGND sg13g2_decap_8
XFILLER_12_21 VPWR VGND sg13g2_decap_8
XFILLER_23_497 VPWR VGND sg13g2_decap_8
XFILLER_12_98 VPWR VGND sg13g2_decap_8
XFILLER_18_269 VPWR VGND sg13g2_decap_8
XFILLER_6_652 VPWR VGND sg13g2_decap_8
XFILLER_5_140 VPWR VGND sg13g2_decap_8
XFILLER_17_280 VPWR VGND sg13g2_decap_8
XFILLER_24_206 VPWR VGND sg13g2_decap_8
XFILLER_28_567 VPWR VGND sg13g2_decap_8
XFILLER_11_412 VPWR VGND sg13g2_decap_8
XFILLER_15_217 VPWR VGND sg13g2_decap_8
XFILLER_16_718 VPWR VGND sg13g2_decap_8
XFILLER_11_489 VPWR VGND sg13g2_decap_8
X_062_ _065_/A _089_/B _090_/B VPWR VGND sg13g2_or2_1
X_131_ _131_/Q _138_/CLK _131_/D _075_/Y VPWR VGND sg13g2_dfrbpq_1
XFILLER_7_438 VPWR VGND sg13g2_fill_1
XFILLER_23_42 VPWR VGND sg13g2_decap_8
XFILLER_23_294 VPWR VGND sg13g2_decap_8
XFILLER_3_677 VPWR VGND sg13g2_decap_8
XFILLER_0_46 VPWR VGND sg13g2_decap_8
XFILLER_19_589 VPWR VGND sg13g2_decap_8
XFILLER_9_11 VPWR VGND sg13g2_decap_8
XFILLER_9_88 VPWR VGND sg13g2_decap_8
Xlane2.lp.c_hsprp.tempo VPWR VGND _082_/X _081_/A _185_/A fanout39/X _181_/A tempo_t24n
XFILLER_6_471 VPWR VGND sg13g2_decap_8
XFILLER_29_0 VPWR VGND sg13g2_decap_8
XFILLER_25_504 VPWR VGND sg13g2_decap_8
XFILLER_18_42 VPWR VGND sg13g2_decap_8
XFILLER_28_364 VPWR VGND sg13g2_decap_8
XFILLER_11_231 VPWR VGND sg13g2_decap_8
X_114_ _116_/B _115_/B _115_/A VPWR VGND sg13g2_nand2b_1
XFILLER_7_235 VPWR VGND sg13g2_decap_8
XFILLER_22_7 VPWR VGND sg13g2_decap_8
XFILLER_19_364 VPWR VGND sg13g2_decap_8
XFILLER_15_592 VPWR VGND sg13g2_decap_8
XFILLER_6_290 VPWR VGND sg13g2_decap_8
Xlane1.t_settle.tempo_52 lane1.t_settle.tempo/ARM VPWR VGND sg13g2_tielo
XFILLER_25_356 VPWR VGND sg13g2_decap_8
XFILLER_21_595 VPWR VGND sg13g2_decap_8
XFILLER_4_249 VPWR VGND sg13g2_decap_8
XFILLER_29_63 VPWR VGND sg13g2_decap_8
XFILLER_16_312 VPWR VGND sg13g2_decap_8
Xhold85 _105_/A _124_/Q VPWR VGND sg13g2_dlygate4sd3_1
XFILLER_29_651 VPWR VGND sg13g2_decap_8
XFILLER_28_161 VPWR VGND sg13g2_decap_8
XFILLER_12_540 VPWR VGND sg13g2_decap_8
XFILLER_6_56 VPWR VGND sg13g2_decap_8
XFILLER_19_150 VPWR VGND sg13g2_decap_8
XFILLER_22_315 VPWR VGND sg13g2_decap_8
XFILLER_15_21 VPWR VGND sg13g2_decap_8
XFILLER_25_164 VPWR VGND sg13g2_decap_8
XFILLER_13_348 VPWR VGND sg13g2_decap_8
XFILLER_15_98 VPWR VGND sg13g2_decap_8
XFILLER_21_392 VPWR VGND sg13g2_decap_8
XFILLER_9_319 VPWR VGND sg13g2_decap_8
Xoutput31 term_en[0] _191_/X VPWR VGND sg13g2_buf_1
Xoutput20 hspr[1] _180_/X VPWR VGND sg13g2_buf_1
XFILLER_5_547 VPWR VGND sg13g2_decap_8
XFILLER_16_186 VPWR VGND sg13g2_decap_8
XFILLER_17_643 VPWR VGND sg13g2_decap_8
XFILLER_11_0 VPWR VGND sg13g2_decap_8
XFILLER_10_329 VPWR VGND sg13g2_decap_8
XFILLER_22_112 VPWR VGND sg13g2_decap_8
XFILLER_22_189 VPWR VGND sg13g2_decap_8
XFILLER_23_646 VPWR VGND sg13g2_decap_8
XFILLER_9_116 VPWR VGND sg13g2_decap_8
XFILLER_13_178 VPWR VGND sg13g2_decap_8
XFILLER_5_322 VPWR VGND sg13g2_decap_8
XFILLER_5_399 VPWR VGND sg13g2_decap_8
XFILLER_3_79 VPWR VGND sg13g2_decap_8
XFILLER_3_46 VPWR VGND sg13g2_decap_8
XFILLER_17_495 VPWR VGND sg13g2_decap_8
Xlane1.lp.c_stop.tempo VPWR VGND _077_/A _094_/Y lane1.lp.c_stop.tempo_68/L_HI fanout36/X
+ _188_/A tempo_t24n
XFILLER_9_694 VPWR VGND sg13g2_decap_8
XFILLER_10_126 VPWR VGND sg13g2_decap_8
XFILLER_12_77 VPWR VGND sg13g2_decap_8
XFILLER_6_119 VPWR VGND sg13g2_decap_8
XFILLER_23_476 VPWR VGND sg13g2_decap_8
XFILLER_18_248 VPWR VGND sg13g2_decap_8
XFILLER_10_693 VPWR VGND sg13g2_decap_8
XFILLER_6_631 VPWR VGND sg13g2_decap_8
XFILLER_5_196 VPWR VGND sg13g2_decap_8
XFILLER_25_708 VPWR VGND sg13g2_decap_8
XFILLER_28_546 VPWR VGND sg13g2_decap_8
X_130_ _130_/Q _130_/CLK _130_/D _080_/Y VPWR VGND sg13g2_dfrbpq_1
XFILLER_23_273 VPWR VGND sg13g2_decap_8
XFILLER_23_21 VPWR VGND sg13g2_decap_8
XFILLER_11_468 VPWR VGND sg13g2_decap_8
X_061_ _061_/Y _066_/B VPWR VGND sg13g2_inv_1
XFILLER_23_98 VPWR VGND sg13g2_decap_8
XFILLER_3_656 VPWR VGND sg13g2_decap_8
XFILLER_0_25 VPWR VGND sg13g2_decap_8
XFILLER_19_568 VPWR VGND sg13g2_decap_8
XFILLER_9_67 VPWR VGND sg13g2_decap_8
XFILLER_30_711 VPWR VGND sg13g2_decap_8
XFILLER_10_490 VPWR VGND sg13g2_decap_8
XFILLER_6_450 VPWR VGND sg13g2_decap_8
XFILLER_25_516 VPWR VGND sg13g2_fill_2
XFILLER_21_700 VPWR VGND sg13g2_fill_2
XFILLER_21_722 VPWR VGND sg13g2_fill_1
XFILLER_18_21 VPWR VGND sg13g2_decap_8
XFILLER_18_98 VPWR VGND sg13g2_decap_8
XFILLER_28_343 VPWR VGND sg13g2_decap_8
XFILLER_11_210 VPWR VGND sg13g2_decap_8
XFILLER_11_287 VPWR VGND sg13g2_decap_8
XFILLER_12_722 VPWR VGND sg13g2_fill_1
X_113_ _131_/D _115_/B _113_/B VPWR VGND sg13g2_or2_1
XFILLER_3_497 VPWR VGND sg13g2_decap_8
XFILLER_3_431 VPWR VGND sg13g2_fill_2
XFILLER_3_420 VPWR VGND sg13g2_decap_8
XFILLER_15_7 VPWR VGND sg13g2_decap_8
XFILLER_19_343 VPWR VGND sg13g2_decap_8
Xlane3.lp.f11.tempo VPWR VGND _100_/Y lane3.lp.f11.tempo/ARM lane3.lp.f11.tempo_76/L_HI
+ fanout40/X _087_/B tempo_t24n
XFILLER_15_571 VPWR VGND sg13g2_decap_8
XFILLER_30_585 VPWR VGND sg13g2_decap_8
Xlane3.lp.c_stop.tempo_74 lane3.lp.c_stop.tempo_74/L_HI VPWR VGND sg13g2_tiehi
XFILLER_25_335 VPWR VGND sg13g2_decap_8
XFILLER_21_574 VPWR VGND sg13g2_decap_8
XFILLER_4_228 VPWR VGND sg13g2_decap_8
XFILLER_4_217 VPWR VGND sg13g2_fill_1
XFILLER_4_206 VPWR VGND sg13g2_decap_8
Xhold97 _113_/B _131_/Q VPWR VGND sg13g2_dlygate4sd3_1
XFILLER_29_630 VPWR VGND sg13g2_decap_8
XFILLER_29_42 VPWR VGND sg13g2_decap_8
XFILLER_28_140 VPWR VGND sg13g2_decap_8
XFILLER_24_390 VPWR VGND sg13g2_decap_8
XFILLER_12_596 VPWR VGND sg13g2_decap_8
XFILLER_6_35 VPWR VGND sg13g2_decap_8
XFILLER_13_4 VPWR VGND sg13g2_decap_8
Xclk_lane.lp.f11.tempo_44 clk_lane.lp.f11.tempo/ARM VPWR VGND sg13g2_tielo
XFILLER_30_382 VPWR VGND sg13g2_decap_8
XFILLER_13_327 VPWR VGND sg13g2_decap_8
XFILLER_25_132 VPWR VGND sg13g2_decap_8
XFILLER_15_77 VPWR VGND sg13g2_decap_8
XFILLER_21_371 VPWR VGND sg13g2_decap_8
XFILLER_5_504 VPWR VGND sg13g2_decap_8
Xoutput32 term_en[1] _192_/X VPWR VGND sg13g2_buf_1
Xoutput21 hspr[2] _181_/X VPWR VGND sg13g2_buf_1
XFILLER_17_622 VPWR VGND sg13g2_decap_8
XFILLER_16_165 VPWR VGND sg13g2_decap_8
XFILLER_17_699 VPWR VGND sg13g2_decap_8
Xlane2.lp.f10.tempo_72 lane2.lp.f10.tempo_72/L_HI VPWR VGND sg13g2_tiehi
XFILLER_23_625 VPWR VGND sg13g2_decap_8
XFILLER_10_308 VPWR VGND sg13g2_decap_8
XFILLER_22_168 VPWR VGND sg13g2_decap_8
Xclk_lane.arm.u_arm_61 clk_lane.arm.u_arm/D VPWR VGND sg13g2_tiehi
XFILLER_18_419 VPWR VGND sg13g2_decap_8
XFILLER_13_135 VPWR VGND sg13g2_fill_1
XFILLER_13_157 VPWR VGND sg13g2_decap_8
Xlane3.lp.f11.tempo_76 lane3.lp.f11.tempo_76/L_HI VPWR VGND sg13g2_tiehi
XFILLER_5_378 VPWR VGND sg13g2_decap_8
XFILLER_5_301 VPWR VGND sg13g2_decap_8
XFILLER_3_25 VPWR VGND sg13g2_decap_8
XFILLER_17_474 VPWR VGND sg13g2_decap_8
XFILLER_9_673 VPWR VGND sg13g2_decap_8
XFILLER_27_249 VPWR VGND sg13g2_decap_8
XFILLER_10_105 VPWR VGND sg13g2_decap_8
XFILLER_23_444 VPWR VGND sg13g2_fill_1
XFILLER_12_56 VPWR VGND sg13g2_decap_8
XFILLER_18_227 VPWR VGND sg13g2_decap_8
XFILLER_19_717 VPWR VGND sg13g2_fill_2
XFILLER_10_672 VPWR VGND sg13g2_decap_8
XFILLER_6_610 VPWR VGND sg13g2_decap_8
XFILLER_6_687 VPWR VGND sg13g2_decap_8
XFILLER_5_175 VPWR VGND sg13g2_decap_8
XFILLER_9_481 VPWR VGND sg13g2_decap_8
XFILLER_28_525 VPWR VGND sg13g2_decap_8
XFILLER_24_720 VPWR VGND sg13g2_decap_8
XFILLER_7_418 VPWR VGND sg13g2_decap_8
XFILLER_23_77 VPWR VGND sg13g2_decap_8
XFILLER_23_252 VPWR VGND sg13g2_decap_8
XFILLER_3_635 VPWR VGND sg13g2_decap_8
XFILLER_19_525 VPWR VGND sg13g2_fill_2
XFILLER_19_547 VPWR VGND sg13g2_decap_8
XFILLER_9_46 VPWR VGND sg13g2_decap_8
X_189_ _189_/X _189_/A VPWR VGND sg13g2_buf_1
XFILLER_18_580 VPWR VGND sg13g2_decap_8
XFILLER_28_322 VPWR VGND sg13g2_decap_8
XFILLER_12_701 VPWR VGND sg13g2_decap_8
XFILLER_18_77 VPWR VGND sg13g2_decap_8
XFILLER_28_399 VPWR VGND sg13g2_decap_8
XFILLER_11_266 VPWR VGND sg13g2_decap_8
X_112_ _130_/D _110_/A _111_/A _110_/B VPWR VGND sg13g2_a21o_1
XFILLER_24_594 VPWR VGND sg13g2_decap_8
XFILLER_1_0 VPWR VGND sg13g2_decap_8
XFILLER_3_476 VPWR VGND sg13g2_decap_8
XFILLER_19_322 VPWR VGND sg13g2_decap_8
XFILLER_19_399 VPWR VGND sg13g2_decap_8
XFILLER_15_550 VPWR VGND sg13g2_decap_8
XFILLER_30_564 VPWR VGND sg13g2_decap_8
XFILLER_29_119 VPWR VGND sg13g2_decap_8
Xdelaybuf_2_rx_clk clkbuf_0_rx_clk/A delaybuf_2_rx_clk/A VPWR VGND sg13g2_buf_8
XFILLER_25_314 VPWR VGND sg13g2_decap_8
XFILLER_21_553 VPWR VGND sg13g2_decap_8
Xhold87 _110_/A _128_/Q VPWR VGND sg13g2_dlygate4sd3_1
Xhold98 _120_/B _138_/Q VPWR VGND sg13g2_dlygate4sd3_1
XFILLER_29_98 VPWR VGND sg13g2_decap_8
XFILLER_29_686 VPWR VGND sg13g2_decap_8
XFILLER_29_21 VPWR VGND sg13g2_decap_8
XFILLER_16_347 VPWR VGND sg13g2_decap_8
XFILLER_16_358 VPWR VGND sg13g2_fill_1
XFILLER_28_196 VPWR VGND sg13g2_decap_8
XFILLER_12_575 VPWR VGND sg13g2_decap_8
XFILLER_6_14 VPWR VGND sg13g2_decap_8
XFILLER_19_185 VPWR VGND sg13g2_decap_8
XFILLER_15_391 VPWR VGND sg13g2_decap_8
XFILLER_30_361 VPWR VGND sg13g2_decap_8
XFILLER_13_306 VPWR VGND sg13g2_decap_8
XFILLER_15_56 VPWR VGND sg13g2_decap_8
Xlane3.lp.f10.tempo VPWR VGND _102_/Y lane3.lp.f10.tempo/ARM lane3.lp.f10.tempo_75/L_HI
+ fanout40/X _087_/A tempo_t24n
XFILLER_25_100 VPWR VGND sg13g2_decap_8
XFILLER_21_350 VPWR VGND sg13g2_decap_8
Xoutput33 term_en[2] _193_/X VPWR VGND sg13g2_buf_1
Xoutput22 hspr[3] _182_/X VPWR VGND sg13g2_buf_1
Xoutput11 clk_miss output11/A VPWR VGND sg13g2_buf_1
XFILLER_16_144 VPWR VGND sg13g2_decap_8
XFILLER_17_601 VPWR VGND sg13g2_decap_8
XFILLER_17_678 VPWR VGND sg13g2_decap_8
XFILLER_29_483 VPWR VGND sg13g2_decap_8
XFILLER_12_350 VPWR VGND sg13g2_decap_8
XFILLER_4_582 VPWR VGND sg13g2_decap_8
XFILLER_22_147 VPWR VGND sg13g2_decap_8
XFILLER_23_604 VPWR VGND sg13g2_decap_8
XFILLER_13_114 VPWR VGND sg13g2_decap_8
XFILLER_22_692 VPWR VGND sg13g2_decap_8
XFILLER_5_357 VPWR VGND sg13g2_decap_8
Xlane1.lp.f10.tempo_69 lane1.lp.f10.tempo_69/L_HI VPWR VGND sg13g2_tiehi
XFILLER_29_280 VPWR VGND sg13g2_decap_8
XFILLER_13_692 VPWR VGND sg13g2_decap_8
XFILLER_9_652 VPWR VGND sg13g2_decap_8
XFILLER_28_718 VPWR VGND sg13g2_decap_4
XFILLER_27_228 VPWR VGND sg13g2_decap_8
XFILLER_11_629 VPWR VGND sg13g2_decap_8
XFILLER_23_434 VPWR VGND sg13g2_fill_2
XFILLER_12_35 VPWR VGND sg13g2_decap_8
XFILLER_5_7 VPWR VGND sg13g2_decap_8
XFILLER_18_206 VPWR VGND sg13g2_decap_8
XFILLER_10_651 VPWR VGND sg13g2_decap_8
XFILLER_6_666 VPWR VGND sg13g2_decap_8
XFILLER_5_154 VPWR VGND sg13g2_decap_8
XFILLER_17_294 VPWR VGND sg13g2_decap_8
XFILLER_9_460 VPWR VGND sg13g2_decap_8
XFILLER_4_91 VPWR VGND sg13g2_decap_8
XFILLER_28_504 VPWR VGND sg13g2_decap_8
XFILLER_23_231 VPWR VGND sg13g2_decap_8
XFILLER_11_426 VPWR VGND sg13g2_decap_8
XFILLER_23_56 VPWR VGND sg13g2_decap_8
XFILLER_3_614 VPWR VGND sg13g2_decap_8
XFILLER_3_4 VPWR VGND sg13g2_decap_8
XFILLER_19_504 VPWR VGND sg13g2_decap_8
XFILLER_9_25 VPWR VGND sg13g2_decap_8
XFILLER_27_592 VPWR VGND sg13g2_decap_8
X_188_ _188_/X _188_/A VPWR VGND sg13g2_buf_1
XFILLER_6_485 VPWR VGND sg13g2_decap_8
XFILLER_21_713 VPWR VGND sg13g2_decap_8
XFILLER_18_56 VPWR VGND sg13g2_decap_8
XFILLER_28_301 VPWR VGND sg13g2_decap_8
XFILLER_28_378 VPWR VGND sg13g2_decap_8
XFILLER_24_573 VPWR VGND sg13g2_decap_8
XFILLER_11_245 VPWR VGND sg13g2_decap_8
X_111_ _129_/D _111_/A _111_/B VPWR VGND sg13g2_xnor2_1
XFILLER_7_249 VPWR VGND sg13g2_decap_8
XFILLER_7_216 VPWR VGND sg13g2_decap_8
XFILLER_3_444 VPWR VGND sg13g2_fill_1
XFILLER_19_301 VPWR VGND sg13g2_decap_8
XFILLER_19_378 VPWR VGND sg13g2_decap_8
XFILLER_30_543 VPWR VGND sg13g2_decap_8
XFILLER_21_532 VPWR VGND sg13g2_decap_8
XFILLER_5_709 VPWR VGND sg13g2_decap_8
XFILLER_16_326 VPWR VGND sg13g2_decap_8
Xhold77 _116_/A _133_/Q VPWR VGND sg13g2_dlygate4sd3_1
XFILLER_29_77 VPWR VGND sg13g2_decap_8
XFILLER_29_665 VPWR VGND sg13g2_decap_8
XFILLER_28_175 VPWR VGND sg13g2_decap_8
XFILLER_12_554 VPWR VGND sg13g2_decap_8
XFILLER_3_263 VPWR VGND sg13g2_decap_8
Xlane2.lp.c_stop.tempo_71 lane2.lp.c_stop.tempo_71/L_HI VPWR VGND sg13g2_tiehi
XFILLER_19_164 VPWR VGND sg13g2_decap_8
XFILLER_22_329 VPWR VGND sg13g2_decap_8
XFILLER_30_340 VPWR VGND sg13g2_decap_8
XFILLER_15_35 VPWR VGND sg13g2_decap_8
XFILLER_25_178 VPWR VGND sg13g2_decap_8
XFILLER_25_145 VPWR VGND sg13g2_fill_1
Xoutput34 term_en[3] _194_/X VPWR VGND sg13g2_buf_1
Xoutput23 hsreq[0] _183_/X VPWR VGND sg13g2_buf_1
Xoutput12 clk_rx_en _066_/B VPWR VGND sg13g2_buf_1
XFILLER_16_123 VPWR VGND sg13g2_decap_8
XFILLER_17_657 VPWR VGND sg13g2_decap_8
XFILLER_29_462 VPWR VGND sg13g2_decap_8
XFILLER_12_384 VPWR VGND sg13g2_decap_8
XFILLER_4_561 VPWR VGND sg13g2_decap_8
XFILLER_16_690 VPWR VGND sg13g2_decap_8
XFILLER_22_126 VPWR VGND sg13g2_decap_8
XFILLER_22_671 VPWR VGND sg13g2_decap_8
XFILLER_5_336 VPWR VGND sg13g2_decap_8
XFILLER_13_671 VPWR VGND sg13g2_decap_8
XFILLER_9_631 VPWR VGND sg13g2_decap_8
XFILLER_27_207 VPWR VGND sg13g2_decap_8
XFILLER_23_413 VPWR VGND sg13g2_decap_8
XFILLER_11_608 VPWR VGND sg13g2_decap_8
XFILLER_12_14 VPWR VGND sg13g2_decap_8
XFILLER_19_708 VPWR VGND sg13g2_fill_1
XFILLER_10_630 VPWR VGND sg13g2_decap_8
XFILLER_22_490 VPWR VGND sg13g2_decap_8
XFILLER_6_645 VPWR VGND sg13g2_decap_8
XFILLER_5_133 VPWR VGND sg13g2_decap_8
XFILLER_17_273 VPWR VGND sg13g2_decap_8
XFILLER_13_490 VPWR VGND sg13g2_decap_8
XFILLER_4_70 VPWR VGND sg13g2_decap_8
XFILLER_11_405 VPWR VGND sg13g2_decap_8
XFILLER_23_210 VPWR VGND sg13g2_decap_8
XFILLER_23_35 VPWR VGND sg13g2_decap_8
XFILLER_23_287 VPWR VGND sg13g2_decap_8
XFILLER_0_39 VPWR VGND sg13g2_decap_8
XFILLER_27_571 VPWR VGND sg13g2_decap_8
X_187_ _187_/X _187_/A VPWR VGND sg13g2_buf_1
XFILLER_6_464 VPWR VGND sg13g2_decap_8
XFILLER_9_291 VPWR VGND sg13g2_decap_8
XFILLER_18_35 VPWR VGND sg13g2_decap_8
XFILLER_28_357 VPWR VGND sg13g2_decap_8
XFILLER_11_224 VPWR VGND sg13g2_decap_8
X_110_ _128_/D _110_/A _110_/B VPWR VGND sg13g2_xnor2_1
XFILLER_24_552 VPWR VGND sg13g2_decap_8
Xclkload0 clkload0/Y clkload0/A VPWR VGND sg13g2_inv_2
XFILLER_7_228 VPWR VGND sg13g2_decap_8
XFILLER_7_206 VPWR VGND sg13g2_decap_4
XFILLER_19_357 VPWR VGND sg13g2_decap_8
XFILLER_15_585 VPWR VGND sg13g2_decap_8
XFILLER_30_599 VPWR VGND sg13g2_decap_8
XFILLER_30_522 VPWR VGND sg13g2_decap_8
XFILLER_6_283 VPWR VGND sg13g2_decap_8
XFILLER_21_511 VPWR VGND sg13g2_decap_8
XFILLER_25_349 VPWR VGND sg13g2_decap_8
XFILLER_21_588 VPWR VGND sg13g2_decap_8
XFILLER_29_56 VPWR VGND sg13g2_decap_8
XFILLER_16_305 VPWR VGND sg13g2_decap_8
Xhold89 _103_/B _123_/Q VPWR VGND sg13g2_dlygate4sd3_1
XFILLER_29_644 VPWR VGND sg13g2_decap_8
XFILLER_28_154 VPWR VGND sg13g2_decap_8
XFILLER_10_91 VPWR VGND sg13g2_decap_8
XFILLER_6_49 VPWR VGND sg13g2_decap_8
XFILLER_3_242 VPWR VGND sg13g2_decap_8
XFILLER_19_121 VPWR VGND sg13g2_decap_8
XFILLER_3_297 VPWR VGND sg13g2_fill_1
XFILLER_22_308 VPWR VGND sg13g2_decap_8
XFILLER_30_396 VPWR VGND sg13g2_decap_8
XFILLER_15_14 VPWR VGND sg13g2_decap_8
XFILLER_25_157 VPWR VGND sg13g2_decap_8
XFILLER_21_385 VPWR VGND sg13g2_decap_8
XFILLER_1_713 VPWR VGND sg13g2_decap_4
Xoutput24 hsreq[1] _184_/X VPWR VGND sg13g2_buf_1
Xoutput13 clk_stop output13/A VPWR VGND sg13g2_buf_1
XFILLER_29_441 VPWR VGND sg13g2_decap_8
XFILLER_16_102 VPWR VGND sg13g2_decap_8
XFILLER_16_179 VPWR VGND sg13g2_decap_8
XFILLER_17_636 VPWR VGND sg13g2_decap_8
XFILLER_25_680 VPWR VGND sg13g2_decap_8
XFILLER_4_540 VPWR VGND sg13g2_decap_8
XFILLER_22_105 VPWR VGND sg13g2_decap_8
XFILLER_23_639 VPWR VGND sg13g2_decap_8
XFILLER_30_193 VPWR VGND sg13g2_decap_8
XFILLER_21_182 VPWR VGND sg13g2_decap_8
XFILLER_22_650 VPWR VGND sg13g2_decap_8
XFILLER_9_109 VPWR VGND sg13g2_decap_8
XFILLER_5_315 VPWR VGND sg13g2_decap_8
XFILLER_3_39 VPWR VGND sg13g2_decap_8
XFILLER_13_650 VPWR VGND sg13g2_decap_8
XFILLER_17_488 VPWR VGND sg13g2_decap_8
XFILLER_9_610 VPWR VGND sg13g2_decap_8
XFILLER_12_182 VPWR VGND sg13g2_decap_8
XFILLER_9_687 VPWR VGND sg13g2_decap_8
XFILLER_10_119 VPWR VGND sg13g2_decap_8
XFILLER_23_469 VPWR VGND sg13g2_decap_8
XFILLER_10_686 VPWR VGND sg13g2_decap_8
Xlane2.lp.c_hsreq.tempo VPWR VGND _082_/X _098_/Y _189_/A fanout37/X _185_/A tempo_t24n
Xlane1.t_settle.tempo VPWR VGND _076_/X lane1.t_settle.tempo/ARM _131_/Q fanout39/X
+ _176_/A tempo_t110n
XFILLER_6_624 VPWR VGND sg13g2_decap_8
XFILLER_5_189 VPWR VGND sg13g2_decap_8
XFILLER_5_112 VPWR VGND sg13g2_decap_8
XFILLER_17_252 VPWR VGND sg13g2_decap_8
XFILLER_18_720 VPWR VGND sg13g2_decap_8
XFILLER_9_495 VPWR VGND sg13g2_decap_8
XFILLER_28_539 VPWR VGND sg13g2_decap_8
XFILLER_23_14 VPWR VGND sg13g2_decap_8
XFILLER_23_266 VPWR VGND sg13g2_decap_8
XFILLER_3_649 VPWR VGND sg13g2_decap_8
XFILLER_0_18 VPWR VGND sg13g2_decap_8
XFILLER_27_550 VPWR VGND sg13g2_decap_8
XFILLER_30_704 VPWR VGND sg13g2_decap_8
XFILLER_10_483 VPWR VGND sg13g2_decap_8
X_186_ _186_/X _186_/A VPWR VGND sg13g2_buf_1
XFILLER_6_443 VPWR VGND sg13g2_decap_8
XFILLER_18_594 VPWR VGND sg13g2_decap_8
XFILLER_9_270 VPWR VGND sg13g2_decap_8
XFILLER_16_509 VPWR VGND sg13g2_fill_2
XFILLER_18_14 VPWR VGND sg13g2_decap_8
XFILLER_28_336 VPWR VGND sg13g2_decap_8
XFILLER_11_203 VPWR VGND sg13g2_decap_8
XFILLER_12_715 VPWR VGND sg13g2_decap_8
XFILLER_3_413 VPWR VGND sg13g2_decap_8
XFILLER_19_336 VPWR VGND sg13g2_decap_8
Xclk_lane.arm.u_dly clk_lane.arm.u_xor/B clkload0/A VPWR VGND sg13g2_dlygate4sd3_1
Xlane0.c_term.tempo VPWR VGND _071_/X lane0.c_term.tempo/ARM _070_/Y fanout38/X _191_/A
+ tempo_t24n
XFILLER_15_564 VPWR VGND sg13g2_decap_8
XFILLER_30_501 VPWR VGND sg13g2_decap_8
XFILLER_10_280 VPWR VGND sg13g2_decap_8
XFILLER_6_262 VPWR VGND sg13g2_decap_8
XFILLER_30_578 VPWR VGND sg13g2_decap_8
XFILLER_25_328 VPWR VGND sg13g2_decap_8
XFILLER_18_391 VPWR VGND sg13g2_decap_8
XFILLER_21_567 VPWR VGND sg13g2_decap_8
Xhold79 _121_/A _137_/Q VPWR VGND sg13g2_dlygate4sd3_1
XFILLER_29_623 VPWR VGND sg13g2_decap_8
XFILLER_29_35 VPWR VGND sg13g2_decap_8
XFILLER_28_133 VPWR VGND sg13g2_decap_8
XFILLER_12_589 VPWR VGND sg13g2_decap_8
XFILLER_6_28 VPWR VGND sg13g2_decap_8
XFILLER_24_383 VPWR VGND sg13g2_decap_8
XFILLER_10_70 VPWR VGND sg13g2_decap_8
XFILLER_19_100 VPWR VGND sg13g2_decap_8
XFILLER_19_199 VPWR VGND sg13g2_decap_8
XFILLER_15_350 VPWR VGND sg13g2_decap_8
XFILLER_7_582 VPWR VGND sg13g2_decap_8
XFILLER_30_375 VPWR VGND sg13g2_decap_8
XFILLER_25_125 VPWR VGND sg13g2_decap_8
XFILLER_25_114 VPWR VGND sg13g2_decap_8
XFILLER_21_364 VPWR VGND sg13g2_decap_8
Xoutput25 hsreq[2] _185_/X VPWR VGND sg13g2_buf_1
Xoutput14 clk_term_en output14/A VPWR VGND sg13g2_buf_1
XFILLER_17_615 VPWR VGND sg13g2_decap_8
XFILLER_29_497 VPWR VGND sg13g2_decap_8
XFILLER_29_420 VPWR VGND sg13g2_decap_8
XFILLER_16_158 VPWR VGND sg13g2_decap_8
XFILLER_21_91 VPWR VGND sg13g2_decap_8
XFILLER_4_596 VPWR VGND sg13g2_decap_8
Xlane2.lp.f10.tempo_54 lane2.lp.f10.tempo/ARM VPWR VGND sg13g2_tielo
XFILLER_23_618 VPWR VGND sg13g2_decap_8
XFILLER_30_172 VPWR VGND sg13g2_decap_8
XFILLER_7_60 VPWR VGND sg13g2_decap_4
XFILLER_7_93 VPWR VGND sg13g2_decap_8
XFILLER_7_390 VPWR VGND sg13g2_decap_8
XFILLER_13_128 VPWR VGND sg13g2_decap_8
XFILLER_21_161 VPWR VGND sg13g2_decap_8
XFILLER_3_18 VPWR VGND sg13g2_decap_8
XFILLER_17_412 VPWR VGND sg13g2_decap_8
XFILLER_17_467 VPWR VGND sg13g2_decap_8
XFILLER_29_294 VPWR VGND sg13g2_decap_8
XFILLER_12_161 VPWR VGND sg13g2_decap_8
XFILLER_9_666 VPWR VGND sg13g2_decap_8
XFILLER_4_382 VPWR VGND sg13g2_decap_8
XFILLER_12_49 VPWR VGND sg13g2_decap_8
XFILLER_27_721 VPWR VGND sg13g2_fill_2
XFILLER_6_603 VPWR VGND sg13g2_decap_8
XFILLER_10_665 VPWR VGND sg13g2_decap_8
XFILLER_5_168 VPWR VGND sg13g2_decap_8
XFILLER_17_231 VPWR VGND sg13g2_decap_8
XFILLER_9_474 VPWR VGND sg13g2_decap_8
XFILLER_28_518 VPWR VGND sg13g2_decap_8
XFILLER_24_713 VPWR VGND sg13g2_decap_8
XFILLER_23_245 VPWR VGND sg13g2_decap_8
XFILLER_3_628 VPWR VGND sg13g2_decap_8
XFILLER_15_702 VPWR VGND sg13g2_decap_8
Xclkbuf_2_1__f_rx_clk_regs _138_/CLK clkbuf_0_rx_clk_regs/X VPWR VGND sg13g2_buf_16
XFILLER_10_462 VPWR VGND sg13g2_decap_8
XFILLER_9_39 VPWR VGND sg13g2_decap_8
X_185_ _185_/X _185_/A VPWR VGND sg13g2_buf_1
XFILLER_6_422 VPWR VGND sg13g2_decap_8
XFILLER_6_499 VPWR VGND sg13g2_decap_8
XFILLER_18_573 VPWR VGND sg13g2_decap_8
XFILLER_28_315 VPWR VGND sg13g2_decap_8
XFILLER_11_259 VPWR VGND sg13g2_decap_8
XFILLER_24_587 VPWR VGND sg13g2_decap_8
Xlane0.c_term.tempo_45 lane0.c_term.tempo/ARM VPWR VGND sg13g2_tielo
XFILLER_3_469 VPWR VGND sg13g2_decap_8
XFILLER_19_315 VPWR VGND sg13g2_decap_8
XFILLER_15_543 VPWR VGND sg13g2_decap_8
XFILLER_7_720 VPWR VGND sg13g2_fill_2
XFILLER_6_241 VPWR VGND sg13g2_decap_8
XFILLER_30_557 VPWR VGND sg13g2_decap_8
X_099_ _099_/Y _098_/B _099_/B VPWR VGND sg13g2_nand2b_1
XFILLER_25_307 VPWR VGND sg13g2_decap_8
XFILLER_21_546 VPWR VGND sg13g2_decap_8
XFILLER_29_679 VPWR VGND sg13g2_decap_8
XFILLER_29_602 VPWR VGND sg13g2_decap_8
XFILLER_29_14 VPWR VGND sg13g2_decap_8
XFILLER_28_112 VPWR VGND sg13g2_decap_8
XFILLER_28_189 VPWR VGND sg13g2_decap_8
XFILLER_24_362 VPWR VGND sg13g2_decap_8
XFILLER_12_568 VPWR VGND sg13g2_decap_8
XFILLER_4_712 VPWR VGND sg13g2_decap_8
XFILLER_3_211 VPWR VGND sg13g2_decap_8
XFILLER_3_222 VPWR VGND sg13g2_fill_2
XFILLER_19_145 VPWR VGND sg13g2_fill_1
XFILLER_19_178 VPWR VGND sg13g2_decap_8
XFILLER_15_384 VPWR VGND sg13g2_decap_8
XFILLER_30_354 VPWR VGND sg13g2_decap_8
XFILLER_7_561 VPWR VGND sg13g2_decap_8
XFILLER_25_0 VPWR VGND sg13g2_decap_8
XFILLER_15_49 VPWR VGND sg13g2_decap_8
XFILLER_21_343 VPWR VGND sg13g2_decap_8
Xoutput26 hsreq[3] _186_/X VPWR VGND sg13g2_buf_1
Xoutput15 hs_rx_en[0] _175_/X VPWR VGND sg13g2_buf_1
XFILLER_16_137 VPWR VGND sg13g2_decap_8
XFILLER_29_476 VPWR VGND sg13g2_decap_8
XFILLER_12_343 VPWR VGND sg13g2_decap_8
Xclk_lane.c_term.tempo VPWR VGND _065_/X clk_lane.c_term.tempo/ARM _064_/Y fanout38/X
+ output14/A tempo_t24n
XFILLER_24_192 VPWR VGND sg13g2_decap_8
XFILLER_12_398 VPWR VGND sg13g2_decap_8
XFILLER_21_70 VPWR VGND sg13g2_decap_8
XFILLER_4_575 VPWR VGND sg13g2_decap_8
XFILLER_7_72 VPWR VGND sg13g2_decap_8
XFILLER_30_151 VPWR VGND sg13g2_decap_8
XFILLER_13_107 VPWR VGND sg13g2_decap_8
XFILLER_21_140 VPWR VGND sg13g2_decap_8
XFILLER_22_685 VPWR VGND sg13g2_decap_8
Xlane3.lp.f11.tempo_59 lane3.lp.f11.tempo/ARM VPWR VGND sg13g2_tielo
XFILLER_29_273 VPWR VGND sg13g2_decap_8
XFILLER_12_140 VPWR VGND sg13g2_decap_8
XFILLER_13_685 VPWR VGND sg13g2_decap_8
XFILLER_16_81 VPWR VGND sg13g2_decap_8
XFILLER_9_645 VPWR VGND sg13g2_decap_8
XFILLER_25_490 VPWR VGND sg13g2_decap_8
XFILLER_4_361 VPWR VGND sg13g2_decap_8
XFILLER_23_427 VPWR VGND sg13g2_decap_8
XFILLER_12_28 VPWR VGND sg13g2_decap_8
Xhold100 _105_/B _126_/Q VPWR VGND sg13g2_dlygate4sd3_1
XFILLER_27_700 VPWR VGND sg13g2_decap_8
XFILLER_10_644 VPWR VGND sg13g2_decap_8
XFILLER_6_659 VPWR VGND sg13g2_decap_8
XFILLER_5_147 VPWR VGND sg13g2_decap_8
XFILLER_17_210 VPWR VGND sg13g2_decap_8
XFILLER_17_287 VPWR VGND sg13g2_decap_8
XFILLER_9_431 VPWR VGND sg13g2_fill_2
XFILLER_5_681 VPWR VGND sg13g2_decap_8
XFILLER_4_84 VPWR VGND sg13g2_decap_8
XFILLER_11_419 VPWR VGND sg13g2_decap_8
XFILLER_23_49 VPWR VGND sg13g2_decap_8
XFILLER_23_224 VPWR VGND sg13g2_decap_8
XFILLER_9_18 VPWR VGND sg13g2_decap_8
XFILLER_27_585 VPWR VGND sg13g2_decap_8
XFILLER_13_93 VPWR VGND sg13g2_decap_8
X_184_ _184_/X _184_/A VPWR VGND sg13g2_buf_1
XFILLER_6_478 VPWR VGND sg13g2_decap_8
XFILLER_6_401 VPWR VGND sg13g2_decap_8
Xlane0.lp.c_hsprp.tempo VPWR VGND _072_/X _071_/A _183_/A fanout38/X _179_/A tempo_t24n
XFILLER_29_7 VPWR VGND sg13g2_decap_8
XFILLER_18_552 VPWR VGND sg13g2_decap_8
XFILLER_21_706 VPWR VGND sg13g2_decap_8
XFILLER_18_49 VPWR VGND sg13g2_decap_8
XFILLER_24_566 VPWR VGND sg13g2_decap_8
XFILLER_11_238 VPWR VGND sg13g2_decap_8
XFILLER_3_437 VPWR VGND sg13g2_decap_8
XFILLER_15_599 VPWR VGND sg13g2_decap_8
XFILLER_30_536 VPWR VGND sg13g2_decap_8
XFILLER_27_382 VPWR VGND sg13g2_decap_8
XFILLER_24_81 VPWR VGND sg13g2_decap_8
X_098_ _098_/Y _099_/B _098_/B VPWR VGND sg13g2_nand2b_1
XFILLER_6_297 VPWR VGND sg13g2_decap_8
XFILLER_6_220 VPWR VGND sg13g2_decap_8
XFILLER_27_4 VPWR VGND sg13g2_decap_8
XFILLER_21_525 VPWR VGND sg13g2_decap_8
XFILLER_16_319 VPWR VGND sg13g2_decap_8
XFILLER_29_658 VPWR VGND sg13g2_decap_8
XFILLER_28_168 VPWR VGND sg13g2_decap_8
XFILLER_12_547 VPWR VGND sg13g2_decap_8
XFILLER_24_341 VPWR VGND sg13g2_decap_8
XFILLER_3_256 VPWR VGND sg13g2_decap_8
XFILLER_19_135 VPWR VGND sg13g2_decap_4
XFILLER_19_157 VPWR VGND sg13g2_decap_8
XFILLER_7_540 VPWR VGND sg13g2_decap_8
XFILLER_30_333 VPWR VGND sg13g2_decap_8
XFILLER_18_0 VPWR VGND sg13g2_decap_8
XFILLER_15_28 VPWR VGND sg13g2_decap_8
XFILLER_19_680 VPWR VGND sg13g2_decap_8
XFILLER_21_322 VPWR VGND sg13g2_decap_8
XFILLER_21_399 VPWR VGND sg13g2_decap_8
Xoutput27 stop[0] _187_/X VPWR VGND sg13g2_buf_1
Xoutput16 hs_rx_en[1] _176_/X VPWR VGND sg13g2_buf_1
XFILLER_16_116 VPWR VGND sg13g2_decap_8
XFILLER_29_455 VPWR VGND sg13g2_decap_8
XFILLER_12_322 VPWR VGND sg13g2_decap_8
XFILLER_25_694 VPWR VGND sg13g2_decap_8
XFILLER_24_171 VPWR VGND sg13g2_decap_8
XFILLER_4_554 VPWR VGND sg13g2_decap_8
XFILLER_11_7 VPWR VGND sg13g2_decap_8
XFILLER_15_182 VPWR VGND sg13g2_decap_8
XFILLER_16_683 VPWR VGND sg13g2_decap_8
XFILLER_22_119 VPWR VGND sg13g2_decap_8
Xclk_lane.lp.c_hsprp.tempo VPWR VGND _067_/X _065_/A _063_/B fanout38/X _063_/A tempo_t24n
Xlane2.lp.c_stop.tempo VPWR VGND _082_/A _097_/Y lane2.lp.c_stop.tempo_71/L_HI fanout37/X
+ _189_/A tempo_t24n
XFILLER_30_130 VPWR VGND sg13g2_decap_8
XFILLER_21_196 VPWR VGND sg13g2_decap_8
XFILLER_22_664 VPWR VGND sg13g2_decap_8
XFILLER_5_329 VPWR VGND sg13g2_decap_8
XFILLER_29_252 VPWR VGND sg13g2_decap_8
XFILLER_16_60 VPWR VGND sg13g2_decap_8
XFILLER_12_196 VPWR VGND sg13g2_decap_8
XFILLER_13_664 VPWR VGND sg13g2_decap_8
XFILLER_9_624 VPWR VGND sg13g2_decap_8
XFILLER_4_340 VPWR VGND sg13g2_decap_8
XFILLER_23_406 VPWR VGND sg13g2_decap_8
Xhold101 _120_/A _136_/Q VPWR VGND sg13g2_dlygate4sd3_1
Xclk_lane.c_miss.tempo VPWR VGND _061_/Y clk_lane.arm.u_xor/X _066_/X fanout38/X output11/A
+ tempo_t40n
XFILLER_10_623 VPWR VGND sg13g2_decap_8
XFILLER_22_483 VPWR VGND sg13g2_decap_8
XFILLER_6_638 VPWR VGND sg13g2_decap_8
XFILLER_5_126 VPWR VGND sg13g2_decap_8
XFILLER_27_81 VPWR VGND sg13g2_decap_8
XFILLER_13_483 VPWR VGND sg13g2_decap_8
XFILLER_17_266 VPWR VGND sg13g2_decap_8
XFILLER_9_410 VPWR VGND sg13g2_decap_8
XFILLER_5_660 VPWR VGND sg13g2_decap_8
XFILLER_4_63 VPWR VGND sg13g2_decap_8
XFILLER_4_192 VPWR VGND sg13g2_decap_8
XFILLER_23_203 VPWR VGND sg13g2_decap_8
XFILLER_23_28 VPWR VGND sg13g2_decap_8
Xfanout40 fanout40/X PG VPWR VGND sg13g2_buf_1
XFILLER_30_718 VPWR VGND sg13g2_fill_1
XFILLER_27_564 VPWR VGND sg13g2_decap_8
XFILLER_10_497 VPWR VGND sg13g2_decap_8
XFILLER_13_72 VPWR VGND sg13g2_decap_8
XFILLER_22_280 VPWR VGND sg13g2_decap_8
X_183_ _183_/X _183_/A VPWR VGND sg13g2_buf_1
XFILLER_6_457 VPWR VGND sg13g2_decap_8
XFILLER_13_291 VPWR VGND sg13g2_decap_4
XFILLER_9_284 VPWR VGND sg13g2_decap_8
XFILLER_5_490 VPWR VGND sg13g2_decap_8
XFILLER_18_28 VPWR VGND sg13g2_decap_8
XFILLER_11_217 VPWR VGND sg13g2_decap_8
XFILLER_24_545 VPWR VGND sg13g2_decap_8
XFILLER_3_427 VPWR VGND sg13g2_decap_4
XFILLER_27_361 VPWR VGND sg13g2_decap_8
XFILLER_15_578 VPWR VGND sg13g2_decap_8
XFILLER_7_722 VPWR VGND sg13g2_fill_1
XFILLER_30_515 VPWR VGND sg13g2_decap_8
XFILLER_24_60 VPWR VGND sg13g2_decap_8
XFILLER_10_294 VPWR VGND sg13g2_decap_8
X_097_ _097_/Y _098_/B _099_/B VPWR VGND sg13g2_nand2_1
XFILLER_6_276 VPWR VGND sg13g2_decap_8
XFILLER_1_42 VPWR VGND sg13g2_decap_8
XFILLER_21_504 VPWR VGND sg13g2_decap_8
XFILLER_29_49 VPWR VGND sg13g2_decap_8
XFILLER_29_637 VPWR VGND sg13g2_decap_8
XFILLER_28_147 VPWR VGND sg13g2_decap_8
XFILLER_24_320 VPWR VGND sg13g2_decap_8
XFILLER_12_504 VPWR VGND sg13g2_decap_8
XFILLER_24_397 VPWR VGND sg13g2_decap_8
XFILLER_3_235 VPWR VGND sg13g2_decap_8
XFILLER_10_84 VPWR VGND sg13g2_decap_8
XFILLER_19_114 VPWR VGND sg13g2_decap_8
XFILLER_19_93 VPWR VGND sg13g2_decap_8
XFILLER_30_312 VPWR VGND sg13g2_decap_8
XFILLER_30_389 VPWR VGND sg13g2_decap_8
XFILLER_7_596 VPWR VGND sg13g2_decap_8
XFILLER_25_139 VPWR VGND sg13g2_fill_2
XFILLER_21_301 VPWR VGND sg13g2_decap_8
XFILLER_21_378 VPWR VGND sg13g2_decap_8
XFILLER_1_706 VPWR VGND sg13g2_decap_8
XFILLER_1_717 VPWR VGND sg13g2_fill_2
Xoutput28 stop[1] _188_/X VPWR VGND sg13g2_buf_1
Xoutput17 hs_rx_en[2] _177_/X VPWR VGND sg13g2_buf_1
XFILLER_29_434 VPWR VGND sg13g2_decap_8
XFILLER_12_301 VPWR VGND sg13g2_decap_8
XFILLER_17_629 VPWR VGND sg13g2_decap_8
XFILLER_25_673 VPWR VGND sg13g2_decap_8
XFILLER_24_150 VPWR VGND sg13g2_decap_8
XFILLER_15_161 VPWR VGND sg13g2_decap_8
XFILLER_16_662 VPWR VGND sg13g2_decap_8
XFILLER_30_186 VPWR VGND sg13g2_decap_8
XFILLER_21_175 VPWR VGND sg13g2_decap_8
XFILLER_22_643 VPWR VGND sg13g2_decap_8
XFILLER_5_308 VPWR VGND sg13g2_decap_8
XFILLER_17_426 VPWR VGND sg13g2_decap_8
XFILLER_29_231 VPWR VGND sg13g2_decap_8
XFILLER_13_610 VPWR VGND sg13g2_fill_2
XFILLER_13_643 VPWR VGND sg13g2_decap_8
XFILLER_9_603 VPWR VGND sg13g2_decap_8
XFILLER_12_175 VPWR VGND sg13g2_decap_8
XFILLER_4_396 VPWR VGND sg13g2_decap_8
XFILLER_16_481 VPWR VGND sg13g2_decap_8
Xhold102 _115_/A _132_/Q VPWR VGND sg13g2_dlygate4sd3_1
XFILLER_22_462 VPWR VGND sg13g2_decap_8
XFILLER_10_679 VPWR VGND sg13g2_decap_8
XFILLER_6_617 VPWR VGND sg13g2_decap_8
XFILLER_5_105 VPWR VGND sg13g2_decap_8
XFILLER_17_245 VPWR VGND sg13g2_decap_8
XFILLER_18_713 VPWR VGND sg13g2_decap_8
XFILLER_27_60 VPWR VGND sg13g2_decap_8
XFILLER_13_451 VPWR VGND sg13g2_fill_2
XFILLER_13_462 VPWR VGND sg13g2_decap_8
XFILLER_9_488 VPWR VGND sg13g2_decap_8
XFILLER_4_42 VPWR VGND sg13g2_decap_8
XFILLER_4_171 VPWR VGND sg13g2_decap_8
XFILLER_23_259 VPWR VGND sg13g2_decap_8
XFILLER_15_716 VPWR VGND sg13g2_decap_8
XFILLER_27_543 VPWR VGND sg13g2_decap_8
X_182_ _182_/X _182_/A VPWR VGND sg13g2_buf_1
XFILLER_10_476 VPWR VGND sg13g2_decap_8
XFILLER_6_436 VPWR VGND sg13g2_decap_8
XFILLER_18_587 VPWR VGND sg13g2_decap_8
XFILLER_13_270 VPWR VGND sg13g2_decap_8
XFILLER_9_263 VPWR VGND sg13g2_decap_8
XFILLER_28_329 VPWR VGND sg13g2_decap_8
XFILLER_12_708 VPWR VGND sg13g2_decap_8
XFILLER_3_406 VPWR VGND sg13g2_decap_8
XFILLER_19_329 VPWR VGND sg13g2_decap_8
XFILLER_1_7 VPWR VGND sg13g2_decap_8
Xclk_lane.lp.f10.tempo_63 clk_lane.lp.f10.tempo_63/L_HI VPWR VGND sg13g2_tiehi
XFILLER_15_557 VPWR VGND sg13g2_decap_8
XFILLER_27_340 VPWR VGND sg13g2_decap_8
XFILLER_10_273 VPWR VGND sg13g2_decap_8
XFILLER_23_590 VPWR VGND sg13g2_decap_8
X_096_ _096_/Y _095_/B _096_/B VPWR VGND sg13g2_nand2b_1
XFILLER_6_255 VPWR VGND sg13g2_decap_8
XFILLER_1_21 VPWR VGND sg13g2_decap_8
XFILLER_18_384 VPWR VGND sg13g2_decap_8
XFILLER_29_616 VPWR VGND sg13g2_decap_8
XFILLER_29_28 VPWR VGND sg13g2_decap_8
XFILLER_28_126 VPWR VGND sg13g2_decap_8
XFILLER_24_376 VPWR VGND sg13g2_decap_8
XFILLER_10_63 VPWR VGND sg13g2_decap_8
XFILLER_4_726 VPWR VGND sg13g2_fill_1
XFILLER_19_72 VPWR VGND sg13g2_decap_8
XFILLER_15_343 VPWR VGND sg13g2_decap_8
XFILLER_15_398 VPWR VGND sg13g2_decap_8
XFILLER_28_693 VPWR VGND sg13g2_decap_8
XFILLER_11_582 VPWR VGND sg13g2_decap_8
XFILLER_7_575 VPWR VGND sg13g2_decap_8
XFILLER_30_368 VPWR VGND sg13g2_decap_8
X_079_ _081_/B _181_/A _185_/A VPWR VGND sg13g2_nor2_1
XFILLER_18_192 VPWR VGND sg13g2_decap_8
XFILLER_25_107 VPWR VGND sg13g2_decap_8
XFILLER_21_357 VPWR VGND sg13g2_decap_8
Xoutput29 stop[2] _189_/X VPWR VGND sg13g2_buf_1
Xoutput18 hs_rx_en[3] _178_/X VPWR VGND sg13g2_buf_1
XFILLER_17_608 VPWR VGND sg13g2_decap_8
XFILLER_29_413 VPWR VGND sg13g2_decap_8
XFILLER_25_652 VPWR VGND sg13g2_decap_8
XFILLER_21_84 VPWR VGND sg13g2_decap_8
XFILLER_4_589 VPWR VGND sg13g2_decap_8
XFILLER_16_641 VPWR VGND sg13g2_decap_8
XFILLER_28_490 VPWR VGND sg13g2_decap_8
XFILLER_15_140 VPWR VGND sg13g2_decap_8
XFILLER_30_165 VPWR VGND sg13g2_decap_8
XFILLER_7_53 VPWR VGND sg13g2_decap_8
XFILLER_7_86 VPWR VGND sg13g2_decap_8
XFILLER_7_383 VPWR VGND sg13g2_decap_8
XFILLER_23_0 VPWR VGND sg13g2_decap_8
XFILLER_19_490 VPWR VGND sg13g2_decap_8
XFILLER_22_622 VPWR VGND sg13g2_decap_8
XFILLER_21_154 VPWR VGND sg13g2_decap_8
XFILLER_22_699 VPWR VGND sg13g2_decap_8
XFILLER_17_405 VPWR VGND sg13g2_decap_8
XFILLER_29_287 VPWR VGND sg13g2_decap_8
XFILLER_29_210 VPWR VGND sg13g2_decap_8
XFILLER_12_154 VPWR VGND sg13g2_decap_8
XFILLER_13_622 VPWR VGND sg13g2_decap_8
XFILLER_13_699 VPWR VGND sg13g2_decap_8
XFILLER_16_95 VPWR VGND sg13g2_decap_8
XFILLER_9_659 VPWR VGND sg13g2_decap_8
XFILLER_4_375 VPWR VGND sg13g2_decap_8
XFILLER_16_460 VPWR VGND sg13g2_decap_8
Xhold103 _110_/B _130_/Q VPWR VGND sg13g2_dlygate4sd3_1
XFILLER_27_714 VPWR VGND sg13g2_decap_8
XFILLER_22_441 VPWR VGND sg13g2_decap_4
XFILLER_10_658 VPWR VGND sg13g2_decap_8
XFILLER_17_224 VPWR VGND sg13g2_decap_8
XFILLER_9_467 VPWR VGND sg13g2_decap_8
XFILLER_5_695 VPWR VGND sg13g2_decap_8
XFILLER_4_21 VPWR VGND sg13g2_decap_8
XFILLER_4_150 VPWR VGND sg13g2_decap_8
XFILLER_4_98 VPWR VGND sg13g2_decap_8
XFILLER_24_706 VPWR VGND sg13g2_decap_8
XFILLER_23_238 VPWR VGND sg13g2_decap_8
Xclk_lane.arm.u_arm _066_/A clk_lane.arm.u_arm/D clk_lane.arm.u_xor/X _066_/B VPWR
+ VGND sg13g2_dlhrq_1
XFILLER_27_599 VPWR VGND sg13g2_decap_8
XFILLER_27_522 VPWR VGND sg13g2_decap_8
XFILLER_10_433 VPWR VGND sg13g2_fill_2
X_181_ _181_/X _181_/A VPWR VGND sg13g2_buf_1
XFILLER_6_415 VPWR VGND sg13g2_decap_8
XFILLER_18_566 VPWR VGND sg13g2_decap_8
XFILLER_9_242 VPWR VGND sg13g2_decap_8
XFILLER_28_308 VPWR VGND sg13g2_decap_8
XFILLER_19_308 VPWR VGND sg13g2_decap_8
XFILLER_15_536 VPWR VGND sg13g2_decap_8
XFILLER_27_396 VPWR VGND sg13g2_decap_8
XFILLER_10_252 VPWR VGND sg13g2_decap_8
XFILLER_11_720 VPWR VGND sg13g2_decap_8
XFILLER_7_713 VPWR VGND sg13g2_decap_8
X_095_ _095_/Y _096_/B _095_/B VPWR VGND sg13g2_nand2b_1
XFILLER_6_234 VPWR VGND sg13g2_decap_8
XFILLER_24_95 VPWR VGND sg13g2_decap_8
XFILLER_21_539 VPWR VGND sg13g2_decap_8
XFILLER_28_105 VPWR VGND sg13g2_decap_8
XFILLER_24_355 VPWR VGND sg13g2_decap_8
XFILLER_4_705 VPWR VGND sg13g2_decap_8
XFILLER_10_42 VPWR VGND sg13g2_decap_8
XFILLER_28_672 VPWR VGND sg13g2_decap_8
XFILLER_15_322 VPWR VGND sg13g2_decap_8
XFILLER_30_347 VPWR VGND sg13g2_decap_8
XFILLER_27_193 VPWR VGND sg13g2_decap_8
XFILLER_11_561 VPWR VGND sg13g2_decap_8
XFILLER_11_594 VPWR VGND sg13g2_decap_8
XFILLER_7_532 VPWR VGND sg13g2_decap_4
XFILLER_7_554 VPWR VGND sg13g2_decap_8
X_078_ _081_/A _098_/B _099_/B VPWR VGND sg13g2_or2_1
XFILLER_18_171 VPWR VGND sg13g2_decap_8
XFILLER_19_694 VPWR VGND sg13g2_fill_2
XFILLER_21_336 VPWR VGND sg13g2_decap_8
Xoutput19 hspr[0] _179_/X VPWR VGND sg13g2_buf_1
XFILLER_29_469 VPWR VGND sg13g2_decap_8
XFILLER_12_336 VPWR VGND sg13g2_decap_8
XFILLER_25_631 VPWR VGND sg13g2_decap_8
XFILLER_24_185 VPWR VGND sg13g2_decap_8
XFILLER_24_130 VPWR VGND sg13g2_decap_8
XFILLER_21_63 VPWR VGND sg13g2_decap_8
XFILLER_4_568 VPWR VGND sg13g2_decap_8
XFILLER_4_502 VPWR VGND sg13g2_decap_8
XFILLER_16_620 VPWR VGND sg13g2_decap_8
XFILLER_11_391 VPWR VGND sg13g2_decap_8
XFILLER_15_196 VPWR VGND sg13g2_decap_8
XFILLER_16_697 VPWR VGND sg13g2_decap_8
XFILLER_7_32 VPWR VGND sg13g2_decap_8
XFILLER_30_144 VPWR VGND sg13g2_decap_8
XFILLER_7_362 VPWR VGND sg13g2_decap_8
XFILLER_21_133 VPWR VGND sg13g2_decap_8
XFILLER_22_601 VPWR VGND sg13g2_decap_8
XFILLER_22_678 VPWR VGND sg13g2_decap_8
Xclkbuf_1_1__f_rx_clk clk_lane.arm.u_xor/A clkbuf_0_rx_clk/X VPWR VGND sg13g2_buf_16
XFILLER_29_266 VPWR VGND sg13g2_decap_8
XFILLER_12_133 VPWR VGND sg13g2_decap_8
XFILLER_13_612 VPWR VGND sg13g2_fill_1
XFILLER_13_678 VPWR VGND sg13g2_decap_8
XFILLER_16_74 VPWR VGND sg13g2_decap_8
XFILLER_9_638 VPWR VGND sg13g2_decap_8
XFILLER_25_483 VPWR VGND sg13g2_decap_8
XFILLER_4_354 VPWR VGND sg13g2_decap_8
XFILLER_7_192 VPWR VGND sg13g2_decap_8
XFILLER_10_637 VPWR VGND sg13g2_decap_8
XFILLER_22_420 VPWR VGND sg13g2_decap_8
XFILLER_22_497 VPWR VGND sg13g2_decap_8
XFILLER_17_203 VPWR VGND sg13g2_decap_8
XFILLER_27_95 VPWR VGND sg13g2_decap_8
XFILLER_25_291 VPWR VGND sg13g2_decap_4
XFILLER_13_497 VPWR VGND sg13g2_decap_8
XFILLER_9_424 VPWR VGND sg13g2_decap_8
XFILLER_5_674 VPWR VGND sg13g2_decap_8
XFILLER_4_77 VPWR VGND sg13g2_decap_8
XFILLER_4_140 VPWR VGND sg13g2_decap_4
XFILLER_16_291 VPWR VGND sg13g2_decap_8
XFILLER_23_217 VPWR VGND sg13g2_decap_8
XFILLER_27_501 VPWR VGND sg13g2_decap_8
XFILLER_27_578 VPWR VGND sg13g2_decap_8
XFILLER_10_412 VPWR VGND sg13g2_decap_8
XFILLER_13_53 VPWR VGND sg13g2_decap_8
XFILLER_13_86 VPWR VGND sg13g2_decap_8
XFILLER_22_294 VPWR VGND sg13g2_decap_8
X_180_ _180_/X _180_/A VPWR VGND sg13g2_buf_1
XFILLER_18_545 VPWR VGND sg13g2_decap_8
XFILLER_9_221 VPWR VGND sg13g2_decap_8
XFILLER_9_298 VPWR VGND sg13g2_decap_8
XFILLER_24_559 VPWR VGND sg13g2_decap_8
XFILLER_24_504 VPWR VGND sg13g2_decap_8
Xclk_lane.lp.f10.tempo_43 clk_lane.lp.f10.tempo/ARM VPWR VGND sg13g2_tielo
XFILLER_15_504 VPWR VGND sg13g2_decap_8
XFILLER_30_529 VPWR VGND sg13g2_decap_8
XFILLER_27_375 VPWR VGND sg13g2_decap_8
XFILLER_24_74 VPWR VGND sg13g2_decap_8
XFILLER_10_231 VPWR VGND sg13g2_decap_8
X_094_ _094_/Y _095_/B _096_/B VPWR VGND sg13g2_nand2_1
XFILLER_6_213 VPWR VGND sg13g2_decap_8
XFILLER_18_353 VPWR VGND sg13g2_decap_4
XFILLER_21_518 VPWR VGND sg13g2_decap_8
XFILLER_12_529 VPWR VGND sg13g2_fill_2
XFILLER_24_334 VPWR VGND sg13g2_decap_8
XFILLER_10_21 VPWR VGND sg13g2_decap_8
XFILLER_10_98 VPWR VGND sg13g2_decap_8
XFILLER_3_249 VPWR VGND sg13g2_decap_8
XFILLER_15_301 VPWR VGND sg13g2_decap_8
XFILLER_19_128 VPWR VGND sg13g2_decap_8
XFILLER_19_139 VPWR VGND sg13g2_fill_2
XFILLER_28_651 VPWR VGND sg13g2_decap_8
XFILLER_27_172 VPWR VGND sg13g2_decap_8
XFILLER_11_540 VPWR VGND sg13g2_decap_8
XFILLER_7_511 VPWR VGND sg13g2_decap_8
XFILLER_30_326 VPWR VGND sg13g2_decap_8
X_077_ _077_/X _077_/A _077_/B VPWR VGND sg13g2_or2_1
Xlane3.lp.f10.tempo_75 lane3.lp.f10.tempo_75/L_HI VPWR VGND sg13g2_tiehi
XFILLER_18_150 VPWR VGND sg13g2_decap_8
XFILLER_19_673 VPWR VGND sg13g2_decap_8
XFILLER_21_315 VPWR VGND sg13g2_decap_8
XFILLER_16_109 VPWR VGND sg13g2_decap_8
XFILLER_29_448 VPWR VGND sg13g2_decap_8
XFILLER_25_610 VPWR VGND sg13g2_decap_8
XFILLER_12_315 VPWR VGND sg13g2_decap_8
XFILLER_25_687 VPWR VGND sg13g2_decap_8
XFILLER_24_164 VPWR VGND sg13g2_decap_8
XFILLER_21_42 VPWR VGND sg13g2_decap_8
XFILLER_4_547 VPWR VGND sg13g2_decap_8
XFILLER_15_175 VPWR VGND sg13g2_decap_8
XFILLER_16_676 VPWR VGND sg13g2_decap_8
XFILLER_7_341 VPWR VGND sg13g2_decap_8
XFILLER_7_11 VPWR VGND sg13g2_decap_8
XFILLER_30_123 VPWR VGND sg13g2_decap_8
X_129_ _129_/Q _129_/CLK _129_/D _080_/Y VPWR VGND sg13g2_dfrbpq_1
XFILLER_21_112 VPWR VGND sg13g2_decap_8
XFILLER_22_657 VPWR VGND sg13g2_decap_8
XFILLER_21_189 VPWR VGND sg13g2_decap_8
XFILLER_30_690 VPWR VGND sg13g2_decap_8
XFILLER_29_245 VPWR VGND sg13g2_decap_8
XFILLER_16_53 VPWR VGND sg13g2_decap_8
XFILLER_25_462 VPWR VGND sg13g2_decap_8
XFILLER_12_112 VPWR VGND sg13g2_decap_8
XFILLER_12_189 VPWR VGND sg13g2_decap_8
XFILLER_13_657 VPWR VGND sg13g2_decap_8
XFILLER_9_617 VPWR VGND sg13g2_decap_8
XFILLER_4_333 VPWR VGND sg13g2_decap_8
XFILLER_16_495 VPWR VGND sg13g2_decap_8
XFILLER_7_171 VPWR VGND sg13g2_decap_8
XFILLER_10_616 VPWR VGND sg13g2_decap_8
XFILLER_22_476 VPWR VGND sg13g2_decap_8
XFILLER_5_119 VPWR VGND sg13g2_decap_8
Xlane0.lp.c_hsreq.tempo VPWR VGND _072_/X _092_/Y _187_/A fanout36/X _183_/A tempo_t24n
XFILLER_13_432 VPWR VGND sg13g2_fill_1
XFILLER_13_476 VPWR VGND sg13g2_decap_8
XFILLER_17_259 VPWR VGND sg13g2_decap_8
XFILLER_9_403 VPWR VGND sg13g2_decap_8
XFILLER_27_74 VPWR VGND sg13g2_decap_8
XFILLER_25_270 VPWR VGND sg13g2_decap_8
XFILLER_5_653 VPWR VGND sg13g2_decap_8
XFILLER_4_56 VPWR VGND sg13g2_decap_8
XFILLER_4_185 VPWR VGND sg13g2_decap_8
XFILLER_16_270 VPWR VGND sg13g2_decap_8
XFILLER_27_557 VPWR VGND sg13g2_decap_8
XFILLER_13_32 VPWR VGND sg13g2_decap_8
XFILLER_22_273 VPWR VGND sg13g2_decap_8
XFILLER_13_284 VPWR VGND sg13g2_decap_8
XFILLER_13_295 VPWR VGND sg13g2_fill_1
XFILLER_9_200 VPWR VGND sg13g2_decap_8
XFILLER_9_277 VPWR VGND sg13g2_decap_8
XFILLER_5_483 VPWR VGND sg13g2_decap_8
XFILLER_24_538 VPWR VGND sg13g2_decap_8
XFILLER_27_354 VPWR VGND sg13g2_decap_8
XFILLER_10_210 VPWR VGND sg13g2_decap_8
XFILLER_30_508 VPWR VGND sg13g2_decap_8
XFILLER_24_53 VPWR VGND sg13g2_decap_8
XFILLER_10_287 VPWR VGND sg13g2_decap_8
X_093_ _093_/Y _092_/B _093_/B VPWR VGND sg13g2_nand2b_1
XFILLER_6_269 VPWR VGND sg13g2_decap_8
XFILLER_6_0 VPWR VGND sg13g2_decap_8
XFILLER_1_35 VPWR VGND sg13g2_decap_8
XFILLER_18_332 VPWR VGND sg13g2_decap_8
XFILLER_18_398 VPWR VGND sg13g2_decap_8
XFILLER_5_280 VPWR VGND sg13g2_decap_8
Xinput1 _089_/B clk_lp_n VPWR VGND sg13g2_buf_1
XFILLER_24_313 VPWR VGND sg13g2_decap_8
XFILLER_3_228 VPWR VGND sg13g2_decap_8
XFILLER_10_77 VPWR VGND sg13g2_decap_8
XFILLER_19_107 VPWR VGND sg13g2_decap_8
XFILLER_19_53 VPWR VGND sg13g2_decap_8
XFILLER_15_357 VPWR VGND sg13g2_fill_2
XFILLER_19_86 VPWR VGND sg13g2_decap_8
XFILLER_28_630 VPWR VGND sg13g2_decap_8
XFILLER_27_151 VPWR VGND sg13g2_decap_8
Xclk_lane.lp.c_hsreq.tempo VPWR VGND _067_/X _089_/Y output13/A fanout35/X _063_/B
+ tempo_t24n
XFILLER_30_305 VPWR VGND sg13g2_decap_8
XFILLER_7_589 VPWR VGND sg13g2_decap_8
X_076_ _076_/X _076_/A _076_/B VPWR VGND sg13g2_or2_1
XFILLER_18_140 VPWR VGND sg13g2_decap_4
XFILLER_19_652 VPWR VGND sg13g2_decap_8
XFILLER_19_696 VPWR VGND sg13g2_fill_1
Xclk_lane.c_settle.tempo_41 clk_lane.c_settle.tempo/ARM VPWR VGND sg13g2_tielo
XFILLER_29_427 VPWR VGND sg13g2_decap_8
XFILLER_25_666 VPWR VGND sg13g2_decap_8
XFILLER_21_21 VPWR VGND sg13g2_decap_8
Xlane1.c_term.tempo VPWR VGND _076_/X lane1.c_term.tempo/ARM _075_/Y fanout38/X _192_/A
+ tempo_t24n
XFILLER_0_710 VPWR VGND sg13g2_decap_8
XFILLER_0_721 VPWR VGND sg13g2_fill_2
XFILLER_21_98 VPWR VGND sg13g2_decap_8
XFILLER_15_154 VPWR VGND sg13g2_decap_8
XFILLER_16_655 VPWR VGND sg13g2_decap_8
XFILLER_30_102 VPWR VGND sg13g2_decap_8
X_128_ _128_/Q _129_/CLK _128_/D _080_/Y VPWR VGND sg13g2_dfrbpq_1
XFILLER_7_397 VPWR VGND sg13g2_decap_8
XFILLER_7_320 VPWR VGND sg13g2_decap_8
XFILLER_30_179 VPWR VGND sg13g2_decap_8
XFILLER_30_4 VPWR VGND sg13g2_decap_8
XFILLER_21_168 VPWR VGND sg13g2_decap_8
XFILLER_22_636 VPWR VGND sg13g2_decap_8
XFILLER_17_419 VPWR VGND sg13g2_decap_8
XFILLER_29_224 VPWR VGND sg13g2_decap_8
XFILLER_13_603 VPWR VGND sg13g2_decap_8
XFILLER_13_636 VPWR VGND sg13g2_decap_8
XFILLER_16_32 VPWR VGND sg13g2_decap_8
XFILLER_12_168 VPWR VGND sg13g2_decap_8
XFILLER_4_312 VPWR VGND sg13g2_decap_8
XFILLER_4_389 VPWR VGND sg13g2_decap_8
XFILLER_12_680 VPWR VGND sg13g2_decap_8
XFILLER_16_474 VPWR VGND sg13g2_decap_8
XFILLER_7_150 VPWR VGND sg13g2_decap_8
XFILLER_21_0 VPWR VGND sg13g2_decap_8
XFILLER_17_238 VPWR VGND sg13g2_decap_8
XFILLER_18_706 VPWR VGND sg13g2_decap_8
XFILLER_27_53 VPWR VGND sg13g2_decap_8
XFILLER_13_411 VPWR VGND sg13g2_decap_8
XFILLER_5_632 VPWR VGND sg13g2_decap_8
XFILLER_4_164 VPWR VGND sg13g2_decap_8
XFILLER_4_35 VPWR VGND sg13g2_decap_8
Xclkbuf_0_rx_clk clkbuf_0_rx_clk/X clkbuf_0_rx_clk/A VPWR VGND sg13g2_buf_16
XFILLER_15_709 VPWR VGND sg13g2_decap_8
XFILLER_27_536 VPWR VGND sg13g2_decap_8
XFILLER_13_11 VPWR VGND sg13g2_decap_8
XFILLER_22_252 VPWR VGND sg13g2_decap_8
XFILLER_10_469 VPWR VGND sg13g2_decap_8
XFILLER_6_429 VPWR VGND sg13g2_decap_8
XFILLER_13_263 VPWR VGND sg13g2_decap_8
XFILLER_9_256 VPWR VGND sg13g2_decap_8
XFILLER_5_462 VPWR VGND sg13g2_decap_8
XFILLER_17_580 VPWR VGND sg13g2_decap_8
Xclk_lane.lp.c_stop.tempo VPWR VGND _067_/A _088_/Y clk_lane.lp.c_stop.tempo_62/L_HI
+ fanout35/X output13/A tempo_t24n
XFILLER_27_333 VPWR VGND sg13g2_decap_8
XFILLER_10_266 VPWR VGND sg13g2_decap_8
XFILLER_24_32 VPWR VGND sg13g2_decap_8
XFILLER_23_583 VPWR VGND sg13g2_decap_8
X_092_ _092_/Y _093_/B _092_/B VPWR VGND sg13g2_nand2b_1
XFILLER_6_248 VPWR VGND sg13g2_decap_8
XFILLER_18_311 VPWR VGND sg13g2_decap_8
XFILLER_1_14 VPWR VGND sg13g2_decap_8
XFILLER_29_609 VPWR VGND sg13g2_decap_8
Xinput2 _090_/B clk_lp_p VPWR VGND sg13g2_buf_1
XFILLER_28_119 VPWR VGND sg13g2_decap_8
XFILLER_24_369 VPWR VGND sg13g2_decap_8
XFILLER_10_56 VPWR VGND sg13g2_decap_8
XFILLER_4_719 VPWR VGND sg13g2_decap_8
XFILLER_3_218 VPWR VGND sg13g2_decap_4
XFILLER_19_32 VPWR VGND sg13g2_decap_8
XFILLER_15_336 VPWR VGND sg13g2_decap_8
XFILLER_28_686 VPWR VGND sg13g2_decap_8
XFILLER_27_130 VPWR VGND sg13g2_decap_8
XFILLER_11_575 VPWR VGND sg13g2_decap_8
XFILLER_7_568 VPWR VGND sg13g2_decap_8
X_075_ _075_/Y _076_/A _076_/B VPWR VGND sg13g2_nor2_1
XFILLER_25_7 VPWR VGND sg13g2_decap_8
XFILLER_18_185 VPWR VGND sg13g2_decap_8
XFILLER_19_631 VPWR VGND sg13g2_decap_8
XFILLER_29_406 VPWR VGND sg13g2_decap_8
XFILLER_25_645 VPWR VGND sg13g2_decap_8
XFILLER_24_144 VPWR VGND sg13g2_fill_1
XFILLER_4_516 VPWR VGND sg13g2_decap_8
XFILLER_24_199 VPWR VGND sg13g2_decap_8
XFILLER_21_77 VPWR VGND sg13g2_decap_8
XFILLER_16_634 VPWR VGND sg13g2_decap_8
XFILLER_28_483 VPWR VGND sg13g2_decap_8
XFILLER_11_350 VPWR VGND sg13g2_decap_8
XFILLER_15_133 VPWR VGND sg13g2_decap_8
XFILLER_30_158 VPWR VGND sg13g2_decap_8
XFILLER_7_79 VPWR VGND sg13g2_decap_8
X_127_ _127_/Q _130_/CLK _127_/D _080_/Y VPWR VGND sg13g2_dfrbpq_1
XFILLER_7_46 VPWR VGND sg13g2_decap_8
XFILLER_7_376 VPWR VGND sg13g2_decap_8
XFILLER_3_582 VPWR VGND sg13g2_decap_8
XFILLER_19_483 VPWR VGND sg13g2_decap_8
XFILLER_22_615 VPWR VGND sg13g2_decap_8
XFILLER_21_147 VPWR VGND sg13g2_decap_8
XFILLER_16_11 VPWR VGND sg13g2_decap_8
XFILLER_29_203 VPWR VGND sg13g2_decap_8
XFILLER_12_147 VPWR VGND sg13g2_decap_8
XFILLER_16_88 VPWR VGND sg13g2_decap_8
XFILLER_25_497 VPWR VGND sg13g2_decap_8
XFILLER_21_681 VPWR VGND sg13g2_fill_1
XFILLER_4_368 VPWR VGND sg13g2_decap_8
XFILLER_28_280 VPWR VGND sg13g2_decap_8
XFILLER_27_707 VPWR VGND sg13g2_decap_8
XFILLER_22_434 VPWR VGND sg13g2_decap_8
XFILLER_22_456 VPWR VGND sg13g2_fill_1
XFILLER_17_217 VPWR VGND sg13g2_decap_8
XFILLER_27_32 VPWR VGND sg13g2_decap_8
XFILLER_5_688 VPWR VGND sg13g2_decap_8
XFILLER_4_14 VPWR VGND sg13g2_decap_8
XFILLER_27_515 VPWR VGND sg13g2_decap_8
XFILLER_10_426 VPWR VGND sg13g2_decap_8
XFILLER_22_231 VPWR VGND sg13g2_decap_8
Xfanout35 fanout35/X fanout37/X VPWR VGND sg13g2_buf_1
XFILLER_6_408 VPWR VGND sg13g2_decap_8
XFILLER_18_504 VPWR VGND sg13g2_decap_8
XFILLER_13_242 VPWR VGND sg13g2_decap_8
XFILLER_18_559 VPWR VGND sg13g2_decap_8
XFILLER_9_235 VPWR VGND sg13g2_decap_8
XFILLER_5_441 VPWR VGND sg13g2_decap_8
XFILLER_27_389 VPWR VGND sg13g2_decap_8
XFILLER_27_312 VPWR VGND sg13g2_decap_8
XFILLER_24_11 VPWR VGND sg13g2_decap_8
XFILLER_10_245 VPWR VGND sg13g2_decap_8
XFILLER_11_713 VPWR VGND sg13g2_decap_8
XFILLER_7_706 VPWR VGND sg13g2_decap_8
X_091_ _091_/Y _092_/B _093_/B VPWR VGND sg13g2_nand2_1
XFILLER_6_227 VPWR VGND sg13g2_decap_8
XFILLER_24_88 VPWR VGND sg13g2_decap_8
XFILLER_23_562 VPWR VGND sg13g2_decap_8
Xinput3 _092_/B lp_n[0] VPWR VGND sg13g2_buf_1
XFILLER_24_348 VPWR VGND sg13g2_decap_8
XFILLER_10_35 VPWR VGND sg13g2_decap_8
XFILLER_19_11 VPWR VGND sg13g2_decap_8
XFILLER_28_665 VPWR VGND sg13g2_decap_8
XFILLER_11_510 VPWR VGND sg13g2_fill_1
XFILLER_15_315 VPWR VGND sg13g2_decap_8
XFILLER_27_186 VPWR VGND sg13g2_decap_8
XFILLER_23_392 VPWR VGND sg13g2_decap_8
XFILLER_11_554 VPWR VGND sg13g2_decap_8
XFILLER_7_525 VPWR VGND sg13g2_decap_8
XFILLER_7_547 VPWR VGND sg13g2_decap_8
X_074_ _076_/B _180_/A _184_/A VPWR VGND sg13g2_nor2_1
Xlane0.t_settle.tempo VPWR VGND _071_/X lane0.t_settle.tempo/ARM _135_/Q fanout39/X
+ _175_/A tempo_t110n
XFILLER_18_164 VPWR VGND sg13g2_decap_8
XFILLER_18_7 VPWR VGND sg13g2_decap_8
XFILLER_19_610 VPWR VGND sg13g2_decap_8
XFILLER_19_687 VPWR VGND sg13g2_decap_8
Xlane3.lp.c_stop.tempo VPWR VGND _087_/A _100_/Y lane3.lp.c_stop.tempo_74/L_HI fanout37/X
+ _190_/A tempo_t24n
XFILLER_21_329 VPWR VGND sg13g2_decap_8
XFILLER_12_329 VPWR VGND sg13g2_decap_8
XFILLER_25_624 VPWR VGND sg13g2_decap_8
XFILLER_24_178 VPWR VGND sg13g2_decap_8
XFILLER_24_123 VPWR VGND sg13g2_decap_8
XFILLER_21_56 VPWR VGND sg13g2_decap_8
Xlane3.lp.c_hsprp.tempo VPWR VGND _087_/X _086_/A _186_/A fanout39/X _182_/A tempo_t24n
XFILLER_15_112 VPWR VGND sg13g2_decap_8
XFILLER_16_613 VPWR VGND sg13g2_decap_8
XFILLER_28_462 VPWR VGND sg13g2_decap_8
XFILLER_11_384 VPWR VGND sg13g2_decap_8
XFILLER_15_189 VPWR VGND sg13g2_decap_8
XFILLER_7_25 VPWR VGND sg13g2_decap_8
XFILLER_30_137 VPWR VGND sg13g2_decap_8
X_126_ _126_/Q _130_/CLK _126_/D _085_/Y VPWR VGND sg13g2_dfrbpq_1
XFILLER_7_355 VPWR VGND sg13g2_decap_8
XFILLER_3_561 VPWR VGND sg13g2_decap_8
XFILLER_16_4 VPWR VGND sg13g2_decap_8
XFILLER_19_462 VPWR VGND sg13g2_decap_8
XFILLER_21_126 VPWR VGND sg13g2_decap_8
XFILLER_29_259 VPWR VGND sg13g2_decap_8
XFILLER_12_126 VPWR VGND sg13g2_decap_8
XFILLER_16_67 VPWR VGND sg13g2_decap_8
XFILLER_25_476 VPWR VGND sg13g2_decap_8
XFILLER_21_693 VPWR VGND sg13g2_decap_8
XFILLER_4_347 VPWR VGND sg13g2_decap_8
X_109_ _111_/B _110_/B _110_/A VPWR VGND sg13g2_nand2b_1
XFILLER_7_185 VPWR VGND sg13g2_decap_8
XFILLER_19_270 VPWR VGND sg13g2_decap_8
XFILLER_22_413 VPWR VGND sg13g2_decap_8
XFILLER_27_11 VPWR VGND sg13g2_decap_8
XFILLER_27_88 VPWR VGND sg13g2_decap_8
XFILLER_25_284 VPWR VGND sg13g2_decap_8
XFILLER_21_490 VPWR VGND sg13g2_decap_8
XFILLER_9_417 VPWR VGND sg13g2_decap_8
XFILLER_5_667 VPWR VGND sg13g2_decap_8
XFILLER_4_199 VPWR VGND sg13g2_decap_8
XFILLER_4_144 VPWR VGND sg13g2_fill_1
XFILLER_4_133 VPWR VGND sg13g2_decap_8
XFILLER_16_284 VPWR VGND sg13g2_decap_8
XFILLER_12_490 VPWR VGND sg13g2_decap_8
XFILLER_22_210 VPWR VGND sg13g2_decap_8
XFILLER_10_405 VPWR VGND sg13g2_decap_8
XFILLER_13_46 VPWR VGND sg13g2_decap_8
XFILLER_13_79 VPWR VGND sg13g2_decap_8
XFILLER_22_287 VPWR VGND sg13g2_decap_8
Xfanout36 fanout36/X fanout37/X VPWR VGND sg13g2_buf_1
XFILLER_18_538 VPWR VGND sg13g2_decap_8
XFILLER_9_214 VPWR VGND sg13g2_decap_8
XFILLER_5_420 VPWR VGND sg13g2_decap_8
XFILLER_1_692 VPWR VGND sg13g2_decap_8
XFILLER_5_497 VPWR VGND sg13g2_decap_8
XFILLER_5_91 VPWR VGND sg13g2_decap_8
XFILLER_27_368 VPWR VGND sg13g2_decap_8
XFILLER_24_67 VPWR VGND sg13g2_decap_8
XFILLER_23_541 VPWR VGND sg13g2_decap_8
XFILLER_10_224 VPWR VGND sg13g2_decap_8
X_090_ _090_/Y _089_/B _090_/B VPWR VGND sg13g2_nand2b_1
Xlane0.lp.f11.tempo VPWR VGND _091_/Y lane0.lp.f11.tempo/ARM lane0.lp.f11.tempo_67/L_HI
+ fanout35/X _072_/B tempo_t24n
XFILLER_6_206 VPWR VGND sg13g2_decap_8
XFILLER_18_346 VPWR VGND sg13g2_decap_8
XFILLER_18_357 VPWR VGND sg13g2_fill_2
XFILLER_5_294 VPWR VGND sg13g2_decap_8
Xinput4 _095_/B lp_n[1] VPWR VGND sg13g2_buf_1
XFILLER_24_327 VPWR VGND sg13g2_decap_8
XFILLER_10_14 VPWR VGND sg13g2_decap_8
XFILLER_28_644 VPWR VGND sg13g2_decap_8
XFILLER_27_165 VPWR VGND sg13g2_decap_8
XFILLER_7_504 VPWR VGND sg13g2_decap_8
XFILLER_30_319 VPWR VGND sg13g2_decap_8
XFILLER_23_371 VPWR VGND sg13g2_decap_8
X_073_ _076_/A _095_/B _096_/B VPWR VGND sg13g2_or2_1
XFILLER_4_0 VPWR VGND sg13g2_decap_8
XFILLER_19_666 VPWR VGND sg13g2_decap_8
XFILLER_21_308 VPWR VGND sg13g2_decap_8
XFILLER_25_603 VPWR VGND sg13g2_decap_8
XFILLER_24_102 VPWR VGND sg13g2_decap_8
XFILLER_12_308 VPWR VGND sg13g2_decap_8
XFILLER_24_157 VPWR VGND sg13g2_decap_8
XFILLER_21_35 VPWR VGND sg13g2_decap_8
XFILLER_15_168 VPWR VGND sg13g2_decap_8
XFILLER_16_669 VPWR VGND sg13g2_decap_8
Xclkbuf_2_0__f_rx_clk_regs _136_/CLK clkbuf_0_rx_clk_regs/X VPWR VGND sg13g2_buf_16
XFILLER_28_441 VPWR VGND sg13g2_decap_8
X_125_ _125_/Q _129_/CLK _125_/D _085_/Y VPWR VGND sg13g2_dfrbpq_1
XFILLER_7_334 VPWR VGND sg13g2_decap_8
XFILLER_7_301 VPWR VGND sg13g2_fill_1
XFILLER_30_116 VPWR VGND sg13g2_decap_8
XFILLER_3_540 VPWR VGND sg13g2_decap_8
XFILLER_21_105 VPWR VGND sg13g2_decap_8
XFILLER_30_683 VPWR VGND sg13g2_decap_8
XFILLER_13_617 VPWR VGND sg13g2_fill_1
XFILLER_16_46 VPWR VGND sg13g2_decap_8
XFILLER_29_238 VPWR VGND sg13g2_decap_8
XFILLER_25_433 VPWR VGND sg13g2_fill_2
XFILLER_12_105 VPWR VGND sg13g2_decap_8
XFILLER_21_672 VPWR VGND sg13g2_decap_8
XFILLER_4_326 VPWR VGND sg13g2_decap_8
XFILLER_16_488 VPWR VGND sg13g2_decap_8
XFILLER_11_182 VPWR VGND sg13g2_decap_8
XFILLER_12_694 VPWR VGND sg13g2_decap_8
X_108_ _127_/D _110_/B _108_/B VPWR VGND sg13g2_or2_1
XFILLER_7_164 VPWR VGND sg13g2_decap_8
XFILLER_3_392 VPWR VGND sg13g2_decap_8
XFILLER_22_469 VPWR VGND sg13g2_decap_8
XFILLER_30_480 VPWR VGND sg13g2_decap_8
XFILLER_13_425 VPWR VGND sg13g2_decap_8
XFILLER_27_67 VPWR VGND sg13g2_decap_8
XFILLER_25_263 VPWR VGND sg13g2_decap_8
XFILLER_13_469 VPWR VGND sg13g2_decap_8
XFILLER_5_646 VPWR VGND sg13g2_decap_8
XFILLER_4_112 VPWR VGND sg13g2_decap_8
XFILLER_4_49 VPWR VGND sg13g2_decap_8
XFILLER_4_178 VPWR VGND sg13g2_decap_8
XFILLER_17_720 VPWR VGND sg13g2_fill_2
XFILLER_16_263 VPWR VGND sg13g2_decap_8
Xfanout37 fanout37/X fanout40/X VPWR VGND sg13g2_buf_1
XFILLER_23_723 VPWR VGND sg13g2_decap_4
XFILLER_13_25 VPWR VGND sg13g2_decap_8
XFILLER_22_266 VPWR VGND sg13g2_decap_8
XFILLER_13_211 VPWR VGND sg13g2_decap_8
XFILLER_13_222 VPWR VGND sg13g2_fill_2
XFILLER_13_277 VPWR VGND sg13g2_decap_8
XFILLER_5_476 VPWR VGND sg13g2_decap_8
XFILLER_17_594 VPWR VGND sg13g2_decap_8
XFILLER_5_70 VPWR VGND sg13g2_decap_8
XFILLER_27_347 VPWR VGND sg13g2_decap_8
XFILLER_10_203 VPWR VGND sg13g2_decap_8
XFILLER_24_46 VPWR VGND sg13g2_decap_8
XFILLER_23_597 VPWR VGND sg13g2_decap_8
XFILLER_23_520 VPWR VGND sg13g2_decap_8
XFILLER_1_28 VPWR VGND sg13g2_decap_8
XFILLER_18_325 VPWR VGND sg13g2_decap_8
XFILLER_5_273 VPWR VGND sg13g2_decap_8
Xinput5 _098_/B lp_n[2] VPWR VGND sg13g2_buf_1
XFILLER_17_391 VPWR VGND sg13g2_decap_8
XFILLER_24_306 VPWR VGND sg13g2_decap_8
XFILLER_19_46 VPWR VGND sg13g2_decap_8
XFILLER_19_79 VPWR VGND sg13g2_decap_8
XFILLER_28_623 VPWR VGND sg13g2_decap_8
XFILLER_27_144 VPWR VGND sg13g2_decap_8
XFILLER_23_350 VPWR VGND sg13g2_decap_8
X_072_ _072_/X _072_/A _072_/B VPWR VGND sg13g2_or2_1
XFILLER_18_133 VPWR VGND sg13g2_decap_8
XFILLER_19_645 VPWR VGND sg13g2_decap_8
Xlane3.lp.f10.tempo_58 lane3.lp.f10.tempo/ARM VPWR VGND sg13g2_tielo
XFILLER_18_144 VPWR VGND sg13g2_fill_1
XFILLER_18_199 VPWR VGND sg13g2_decap_8
Xlane1.lp.c_stop.tempo_68 lane1.lp.c_stop.tempo_68/L_HI VPWR VGND sg13g2_tiehi
XFILLER_6_582 VPWR VGND sg13g2_decap_8
Xlane0.lp.f10.tempo VPWR VGND _093_/Y lane0.lp.f10.tempo/ARM lane0.lp.f10.tempo_66/L_HI
+ fanout35/X _072_/A tempo_t24n
XFILLER_25_659 VPWR VGND sg13g2_decap_8
XFILLER_0_703 VPWR VGND sg13g2_decap_8
XFILLER_21_14 VPWR VGND sg13g2_decap_8
Xclk_lane.lp.f11.tempo VPWR VGND _088_/Y clk_lane.lp.f11.tempo/ARM clk_lane.lp.f11.tempo_64/L_HI
+ fanout35/X _067_/B tempo_t24n
XFILLER_28_420 VPWR VGND sg13g2_decap_8
XFILLER_15_147 VPWR VGND sg13g2_decap_8
XFILLER_16_648 VPWR VGND sg13g2_decap_8
XFILLER_28_497 VPWR VGND sg13g2_decap_8
X_124_ _124_/Q _129_/CLK _124_/D _085_/Y VPWR VGND sg13g2_dfrbpq_1
XFILLER_7_313 VPWR VGND sg13g2_decap_8
XFILLER_24_692 VPWR VGND sg13g2_decap_8
XFILLER_11_91 VPWR VGND sg13g2_decap_8
XFILLER_23_7 VPWR VGND sg13g2_decap_8
XFILLER_19_420 VPWR VGND sg13g2_decap_8
XFILLER_19_497 VPWR VGND sg13g2_decap_8
XFILLER_15_692 VPWR VGND sg13g2_decap_4
XFILLER_22_629 VPWR VGND sg13g2_decap_8
XFILLER_30_662 VPWR VGND sg13g2_decap_8
XFILLER_29_217 VPWR VGND sg13g2_decap_8
XFILLER_13_629 VPWR VGND sg13g2_decap_8
XFILLER_16_25 VPWR VGND sg13g2_decap_8
XFILLER_25_412 VPWR VGND sg13g2_decap_8
XFILLER_21_651 VPWR VGND sg13g2_decap_8
XFILLER_4_305 VPWR VGND sg13g2_decap_8
XFILLER_16_412 VPWR VGND sg13g2_decap_8
XFILLER_12_673 VPWR VGND sg13g2_decap_8
XFILLER_16_467 VPWR VGND sg13g2_decap_8
XFILLER_28_294 VPWR VGND sg13g2_decap_8
XFILLER_11_161 VPWR VGND sg13g2_decap_8
X_107_ _126_/D _105_/A _106_/A _105_/B VPWR VGND sg13g2_a21o_1
XFILLER_7_132 VPWR VGND sg13g2_decap_8
XFILLER_3_371 VPWR VGND sg13g2_decap_8
XFILLER_19_294 VPWR VGND sg13g2_decap_8
XFILLER_27_46 VPWR VGND sg13g2_decap_8
XFILLER_13_404 VPWR VGND sg13g2_decap_8
Xlane2.c_term.tempo_53 lane2.c_term.tempo/ARM VPWR VGND sg13g2_tielo
XFILLER_25_242 VPWR VGND sg13g2_decap_8
XFILLER_5_625 VPWR VGND sg13g2_decap_8
XFILLER_4_157 VPWR VGND sg13g2_decap_8
XFILLER_4_28 VPWR VGND sg13g2_decap_8
XFILLER_16_242 VPWR VGND sg13g2_decap_8
XFILLER_29_581 VPWR VGND sg13g2_decap_8
XFILLER_4_691 VPWR VGND sg13g2_decap_8
XFILLER_12_0 VPWR VGND sg13g2_decap_8
XFILLER_27_529 VPWR VGND sg13g2_decap_8
XFILLER_22_245 VPWR VGND sg13g2_decap_8
Xfanout38 fanout38/X fanout39/X VPWR VGND sg13g2_buf_1
XFILLER_23_702 VPWR VGND sg13g2_decap_8
Xlane1.c_term.tempo_49 lane1.c_term.tempo/ARM VPWR VGND sg13g2_tielo
XFILLER_13_256 VPWR VGND sg13g2_decap_8
XFILLER_9_249 VPWR VGND sg13g2_decap_8
XFILLER_5_455 VPWR VGND sg13g2_decap_8
XFILLER_17_573 VPWR VGND sg13g2_decap_8
XFILLER_27_326 VPWR VGND sg13g2_decap_8
XFILLER_10_259 VPWR VGND sg13g2_decap_8
XFILLER_24_25 VPWR VGND sg13g2_decap_8
XFILLER_23_576 VPWR VGND sg13g2_decap_8
XFILLER_18_304 VPWR VGND sg13g2_decap_8
XFILLER_5_252 VPWR VGND sg13g2_decap_8
Xinput6 _101_/B lp_n[3] VPWR VGND sg13g2_buf_1
XFILLER_10_49 VPWR VGND sg13g2_decap_8
XFILLER_19_25 VPWR VGND sg13g2_decap_8
XFILLER_28_602 VPWR VGND sg13g2_decap_8
XFILLER_15_329 VPWR VGND sg13g2_decap_8
XFILLER_28_679 VPWR VGND sg13g2_decap_8
XFILLER_27_123 VPWR VGND sg13g2_decap_8
XFILLER_11_568 VPWR VGND sg13g2_decap_8
X_071_ _071_/X _071_/A _071_/B VPWR VGND sg13g2_or2_1
XFILLER_3_712 VPWR VGND sg13g2_decap_8
XFILLER_18_112 VPWR VGND sg13g2_decap_8
XFILLER_19_624 VPWR VGND sg13g2_decap_8
XFILLER_18_178 VPWR VGND sg13g2_decap_8
XFILLER_6_561 VPWR VGND sg13g2_decap_8
XFILLER_25_638 VPWR VGND sg13g2_decap_8
XFILLER_24_137 VPWR VGND sg13g2_decap_8
XFILLER_4_509 VPWR VGND sg13g2_decap_8
XFILLER_28_476 VPWR VGND sg13g2_decap_8
XFILLER_15_126 VPWR VGND sg13g2_decap_8
XFILLER_16_627 VPWR VGND sg13g2_decap_8
XFILLER_24_671 VPWR VGND sg13g2_decap_8
XFILLER_11_343 VPWR VGND sg13g2_decap_8
XFILLER_11_398 VPWR VGND sg13g2_decap_8
X_123_ _123_/Q _130_/CLK _123_/D _085_/Y VPWR VGND sg13g2_dfrbpq_1
XFILLER_7_39 VPWR VGND sg13g2_decap_8
XFILLER_7_369 VPWR VGND sg13g2_decap_8
XFILLER_11_70 VPWR VGND sg13g2_decap_8
XFILLER_3_575 VPWR VGND sg13g2_decap_8
XFILLER_19_476 VPWR VGND sg13g2_decap_8
XFILLER_22_608 VPWR VGND sg13g2_decap_8
XFILLER_15_671 VPWR VGND sg13g2_decap_8
XFILLER_30_641 VPWR VGND sg13g2_decap_8
XFILLER_6_380 VPWR VGND sg13g2_decap_8
XFILLER_21_630 VPWR VGND sg13g2_decap_8
XFILLER_25_457 VPWR VGND sg13g2_fill_1
XFILLER_28_273 VPWR VGND sg13g2_decap_8
XFILLER_11_140 VPWR VGND sg13g2_decap_8
XFILLER_12_652 VPWR VGND sg13g2_decap_8
XFILLER_7_100 VPWR VGND sg13g2_decap_8
XFILLER_24_490 VPWR VGND sg13g2_decap_8
XFILLER_22_91 VPWR VGND sg13g2_decap_8
X_106_ _125_/D _106_/A _106_/B VPWR VGND sg13g2_xnor2_1
XFILLER_7_199 VPWR VGND sg13g2_decap_8
XFILLER_15_490 VPWR VGND sg13g2_decap_8
XFILLER_22_427 VPWR VGND sg13g2_decap_8
Xclk_lane.lp.f10.tempo VPWR VGND _090_/Y clk_lane.lp.f10.tempo/ARM clk_lane.lp.f10.tempo_63/L_HI
+ fanout35/X _067_/A tempo_t24n
XFILLER_27_25 VPWR VGND sg13g2_decap_8
XFILLER_16_221 VPWR VGND sg13g2_decap_8
XFILLER_16_298 VPWR VGND sg13g2_decap_8
XFILLER_17_722 VPWR VGND sg13g2_fill_1
XFILLER_17_91 VPWR VGND sg13g2_decap_8
XFILLER_29_560 VPWR VGND sg13g2_decap_8
Xlane1.lp.f11.tempo_70 lane1.lp.f11.tempo_70/L_HI VPWR VGND sg13g2_tiehi
XFILLER_4_670 VPWR VGND sg13g2_decap_8
XFILLER_27_508 VPWR VGND sg13g2_decap_8
XFILLER_10_419 VPWR VGND sg13g2_decap_8
XFILLER_22_224 VPWR VGND sg13g2_decap_8
Xfanout39 fanout39/X fanout40/X VPWR VGND sg13g2_buf_1
Xlane2.t_settle.tempo_56 lane2.t_settle.tempo/ARM VPWR VGND sg13g2_tielo
XFILLER_13_235 VPWR VGND sg13g2_decap_8
XFILLER_9_228 VPWR VGND sg13g2_decap_8
XFILLER_5_434 VPWR VGND sg13g2_decap_8
XFILLER_17_552 VPWR VGND sg13g2_decap_8
XFILLER_27_305 VPWR VGND sg13g2_decap_8
XFILLER_10_238 VPWR VGND sg13g2_decap_8
XFILLER_11_706 VPWR VGND sg13g2_decap_8
XFILLER_23_555 VPWR VGND sg13g2_decap_8
XFILLER_5_231 VPWR VGND sg13g2_decap_8
Xinput7 _093_/B lp_p[0] VPWR VGND sg13g2_buf_1
XFILLER_10_28 VPWR VGND sg13g2_decap_8
XFILLER_28_658 VPWR VGND sg13g2_decap_8
XFILLER_27_102 VPWR VGND sg13g2_decap_8
XFILLER_11_503 VPWR VGND sg13g2_decap_8
XFILLER_15_308 VPWR VGND sg13g2_decap_8
XFILLER_27_179 VPWR VGND sg13g2_decap_8
XFILLER_11_547 VPWR VGND sg13g2_decap_8
XFILLER_7_518 VPWR VGND sg13g2_decap_8
X_070_ _070_/Y _071_/A _071_/B VPWR VGND sg13g2_nor2_1
XFILLER_23_385 VPWR VGND sg13g2_decap_8
XFILLER_18_157 VPWR VGND sg13g2_decap_8
XFILLER_19_603 VPWR VGND sg13g2_decap_8
XFILLER_10_580 VPWR VGND sg13g2_decap_8
XFILLER_6_540 VPWR VGND sg13g2_decap_8
XFILLER_25_617 VPWR VGND sg13g2_decap_8
XFILLER_24_116 VPWR VGND sg13g2_decap_8
XFILLER_21_49 VPWR VGND sg13g2_decap_8
XFILLER_15_105 VPWR VGND sg13g2_decap_8
XFILLER_16_606 VPWR VGND sg13g2_decap_8
XFILLER_28_455 VPWR VGND sg13g2_fill_2
XFILLER_11_322 VPWR VGND sg13g2_decap_8
XFILLER_23_182 VPWR VGND sg13g2_decap_8
XFILLER_7_18 VPWR VGND sg13g2_decap_8
XFILLER_24_650 VPWR VGND sg13g2_decap_8
X_122_ _138_/D _120_/A _121_/A _120_/B VPWR VGND sg13g2_a21o_1
Xlane0.lp.c_stop.tempo_65 lane0.lp.c_stop.tempo_65/L_HI VPWR VGND sg13g2_tiehi
XFILLER_7_348 VPWR VGND sg13g2_decap_8
XFILLER_3_554 VPWR VGND sg13g2_decap_8
XFILLER_15_650 VPWR VGND sg13g2_decap_8
XFILLER_21_119 VPWR VGND sg13g2_decap_8
Xinput10 _102_/B lp_p[3] VPWR VGND sg13g2_buf_1
XFILLER_30_697 VPWR VGND sg13g2_decap_8
XFILLER_30_620 VPWR VGND sg13g2_decap_8
XFILLER_12_119 VPWR VGND sg13g2_decap_8
XFILLER_25_469 VPWR VGND sg13g2_decap_8
XFILLER_21_686 VPWR VGND sg13g2_decap_8
XFILLER_28_252 VPWR VGND sg13g2_decap_8
XFILLER_11_196 VPWR VGND sg13g2_decap_8
XFILLER_12_631 VPWR VGND sg13g2_decap_8
XFILLER_22_70 VPWR VGND sg13g2_decap_8
X_105_ _124_/D _105_/A _105_/B VPWR VGND sg13g2_xnor2_1
XFILLER_7_145 VPWR VGND sg13g2_fill_1
XFILLER_7_178 VPWR VGND sg13g2_decap_8
XFILLER_3_362 VPWR VGND sg13g2_fill_1
XFILLER_19_263 VPWR VGND sg13g2_decap_8
XFILLER_22_406 VPWR VGND sg13g2_decap_8
XFILLER_30_494 VPWR VGND sg13g2_decap_8
XFILLER_25_222 VPWR VGND sg13g2_fill_2
XFILLER_25_211 VPWR VGND sg13g2_decap_8
XFILLER_21_483 VPWR VGND sg13g2_decap_8
XFILLER_25_277 VPWR VGND sg13g2_decap_8
XFILLER_4_126 VPWR VGND sg13g2_decap_8
XFILLER_16_200 VPWR VGND sg13g2_decap_8
XFILLER_16_277 VPWR VGND sg13g2_decap_8
XFILLER_17_70 VPWR VGND sg13g2_decap_8
XFILLER_12_483 VPWR VGND sg13g2_decap_8
XFILLER_3_192 VPWR VGND sg13g2_decap_8
XFILLER_13_39 VPWR VGND sg13g2_decap_8
XFILLER_22_203 VPWR VGND sg13g2_decap_8
XFILLER_30_291 VPWR VGND sg13g2_decap_8
XFILLER_9_207 VPWR VGND sg13g2_decap_8
XFILLER_21_280 VPWR VGND sg13g2_decap_8
XFILLER_5_413 VPWR VGND sg13g2_decap_8
XFILLER_1_685 VPWR VGND sg13g2_decap_8
Xlane0.lp.f11.tempo_67 lane0.lp.f11.tempo_67/L_HI VPWR VGND sg13g2_tiehi
XFILLER_28_91 VPWR VGND sg13g2_decap_8
XFILLER_12_280 VPWR VGND sg13g2_decap_8
XFILLER_5_84 VPWR VGND sg13g2_decap_8
XFILLER_23_534 VPWR VGND sg13g2_decap_8
XFILLER_10_217 VPWR VGND sg13g2_decap_8
XFILLER_6_7 VPWR VGND sg13g2_decap_8
XFILLER_18_339 VPWR VGND sg13g2_decap_8
XFILLER_6_722 VPWR VGND sg13g2_fill_1
XFILLER_5_287 VPWR VGND sg13g2_decap_8
XFILLER_5_210 VPWR VGND sg13g2_decap_8
XFILLER_30_81 VPWR VGND sg13g2_decap_8
Xinput8 _096_/B lp_p[1] VPWR VGND sg13g2_buf_1
XFILLER_17_350 VPWR VGND sg13g2_decap_8
XFILLER_9_582 VPWR VGND sg13g2_decap_8
Xlane3.lp.c_hsreq.tempo VPWR VGND _087_/X _101_/Y _190_/A fanout37/X _186_/A tempo_t24n
XFILLER_28_637 VPWR VGND sg13g2_decap_8
XFILLER_27_158 VPWR VGND sg13g2_decap_8
XFILLER_23_364 VPWR VGND sg13g2_decap_8
XFILLER_19_659 VPWR VGND sg13g2_decap_8
Xclkbuf_1_0__f_rx_clk clkload0/A clkbuf_0_rx_clk/X VPWR VGND sg13g2_buf_16
XFILLER_6_596 VPWR VGND sg13g2_decap_8
XFILLER_18_692 VPWR VGND sg13g2_decap_8
XFILLER_21_28 VPWR VGND sg13g2_decap_8
XFILLER_0_717 VPWR VGND sg13g2_decap_4
XFILLER_28_434 VPWR VGND sg13g2_decap_8
XFILLER_11_301 VPWR VGND sg13g2_decap_8
XFILLER_23_161 VPWR VGND sg13g2_decap_8
X_121_ _137_/D _121_/A _121_/B VPWR VGND sg13g2_xnor2_1
XFILLER_7_327 VPWR VGND sg13g2_decap_8
XFILLER_30_109 VPWR VGND sg13g2_decap_8
XFILLER_3_522 VPWR VGND sg13g2_fill_2
XFILLER_3_511 VPWR VGND sg13g2_decap_8
XFILLER_19_434 VPWR VGND sg13g2_decap_4
XFILLER_30_676 VPWR VGND sg13g2_decap_8
XFILLER_28_0 VPWR VGND sg13g2_decap_8
XFILLER_16_39 VPWR VGND sg13g2_decap_8
XFILLER_25_426 VPWR VGND sg13g2_decap_8
XFILLER_21_665 VPWR VGND sg13g2_decap_8
XFILLER_4_319 VPWR VGND sg13g2_decap_8
XFILLER_29_721 VPWR VGND sg13g2_decap_4
XFILLER_28_231 VPWR VGND sg13g2_decap_8
XFILLER_12_610 VPWR VGND sg13g2_decap_8
XFILLER_16_426 VPWR VGND sg13g2_decap_8
XFILLER_11_175 VPWR VGND sg13g2_decap_8
XFILLER_12_687 VPWR VGND sg13g2_decap_8
X_104_ _106_/B _105_/B _105_/A VPWR VGND sg13g2_nand2b_1
XFILLER_7_157 VPWR VGND sg13g2_decap_8
XFILLER_3_385 VPWR VGND sg13g2_decap_8
XFILLER_3_341 VPWR VGND sg13g2_decap_8
XFILLER_19_242 VPWR VGND sg13g2_decap_8
XFILLER_21_7 VPWR VGND sg13g2_decap_8
XFILLER_30_473 VPWR VGND sg13g2_decap_8
Xlane2.c_term.tempo VPWR VGND _081_/X lane2.c_term.tempo/ARM _080_/Y fanout39/X _193_/A
+ tempo_t24n
XFILLER_13_418 VPWR VGND sg13g2_decap_8
XFILLER_25_256 VPWR VGND sg13g2_decap_8
XFILLER_21_462 VPWR VGND sg13g2_decap_8
XFILLER_5_639 VPWR VGND sg13g2_decap_8
XFILLER_4_105 VPWR VGND sg13g2_decap_8
XFILLER_17_713 VPWR VGND sg13g2_decap_8
XFILLER_29_595 VPWR VGND sg13g2_decap_8
XFILLER_12_462 VPWR VGND sg13g2_decap_8
XFILLER_16_256 VPWR VGND sg13g2_decap_8
Xclkbuf_regs_0_rx_clk clkbuf_regs_0_rx_clk/X rx_clk VPWR VGND sg13g2_buf_16
XFILLER_3_171 VPWR VGND sg13g2_decap_8
XFILLER_23_716 VPWR VGND sg13g2_decap_8
XFILLER_13_18 VPWR VGND sg13g2_decap_8
XFILLER_22_259 VPWR VGND sg13g2_decap_8
XFILLER_30_270 VPWR VGND sg13g2_decap_8
XFILLER_5_469 VPWR VGND sg13g2_decap_8
XFILLER_17_587 VPWR VGND sg13g2_decap_8
XFILLER_29_392 VPWR VGND sg13g2_decap_8
XFILLER_28_70 VPWR VGND sg13g2_decap_8
XFILLER_5_63 VPWR VGND sg13g2_decap_8
XFILLER_10_0 VPWR VGND sg13g2_decap_8
XFILLER_24_39 VPWR VGND sg13g2_decap_8
XFILLER_18_318 VPWR VGND sg13g2_decap_8
XFILLER_6_701 VPWR VGND sg13g2_decap_8
XFILLER_5_266 VPWR VGND sg13g2_decap_8
XFILLER_30_60 VPWR VGND sg13g2_decap_8
Xinput9 _099_/B lp_p[2] VPWR VGND sg13g2_buf_1
XFILLER_17_384 VPWR VGND sg13g2_decap_8
XFILLER_9_561 VPWR VGND sg13g2_decap_8
XFILLER_19_39 VPWR VGND sg13g2_decap_8
XFILLER_28_616 VPWR VGND sg13g2_decap_8
XFILLER_27_137 VPWR VGND sg13g2_decap_8
XFILLER_23_343 VPWR VGND sg13g2_decap_8
XFILLER_19_638 VPWR VGND sg13g2_decap_8
XFILLER_18_126 VPWR VGND sg13g2_decap_8
XFILLER_27_693 VPWR VGND sg13g2_decap_8
XFILLER_25_93 VPWR VGND sg13g2_decap_8
XFILLER_6_575 VPWR VGND sg13g2_decap_8
XFILLER_18_671 VPWR VGND sg13g2_decap_8
XFILLER_28_413 VPWR VGND sg13g2_decap_8
XFILLER_23_140 VPWR VGND sg13g2_decap_8
XFILLER_28_457 VPWR VGND sg13g2_fill_1
X_120_ _136_/D _120_/A _120_/B VPWR VGND sg13g2_xnor2_1
XFILLER_7_306 VPWR VGND sg13g2_decap_8
XFILLER_24_685 VPWR VGND sg13g2_decap_8
XFILLER_11_84 VPWR VGND sg13g2_decap_8
XFILLER_19_413 VPWR VGND sg13g2_decap_8
XFILLER_15_685 VPWR VGND sg13g2_decap_8
XFILLER_15_696 VPWR VGND sg13g2_fill_2
XFILLER_30_655 VPWR VGND sg13g2_decap_8
XFILLER_6_394 VPWR VGND sg13g2_decap_8
XFILLER_16_18 VPWR VGND sg13g2_decap_8
XFILLER_18_490 VPWR VGND sg13g2_decap_8
XFILLER_25_405 VPWR VGND sg13g2_decap_8
XFILLER_21_644 VPWR VGND sg13g2_decap_8
XFILLER_16_405 VPWR VGND sg13g2_decap_8
XFILLER_29_700 VPWR VGND sg13g2_decap_8
XFILLER_28_210 VPWR VGND sg13g2_decap_8
XFILLER_28_287 VPWR VGND sg13g2_decap_8
XFILLER_11_154 VPWR VGND sg13g2_decap_8
XFILLER_12_666 VPWR VGND sg13g2_decap_8
X_103_ _123_/D _105_/B _103_/B VPWR VGND sg13g2_or2_1
XFILLER_7_125 VPWR VGND sg13g2_decap_8
XFILLER_7_114 VPWR VGND sg13g2_decap_8
XFILLER_3_320 VPWR VGND sg13g2_decap_8
XFILLER_19_221 VPWR VGND sg13g2_fill_2
XFILLER_19_287 VPWR VGND sg13g2_decap_8
XFILLER_30_452 VPWR VGND sg13g2_decap_8
XFILLER_7_681 VPWR VGND sg13g2_decap_8
XFILLER_7_692 VPWR VGND sg13g2_decap_8
XFILLER_27_39 VPWR VGND sg13g2_decap_8
XFILLER_25_235 VPWR VGND sg13g2_decap_8
XFILLER_5_618 VPWR VGND sg13g2_decap_8
XFILLER_16_235 VPWR VGND sg13g2_decap_8
XFILLER_29_574 VPWR VGND sg13g2_decap_8
XFILLER_24_290 VPWR VGND sg13g2_decap_8
Xlane1.lp.f11.tempo_51 lane1.lp.f11.tempo/ARM VPWR VGND sg13g2_tielo
XFILLER_4_684 VPWR VGND sg13g2_decap_8
XFILLER_3_150 VPWR VGND sg13g2_decap_8
XFILLER_22_238 VPWR VGND sg13g2_decap_8
XFILLER_13_249 VPWR VGND sg13g2_decap_8
XFILLER_5_448 VPWR VGND sg13g2_decap_8
Xlane0.lp.f11.tempo_47 lane0.lp.f11.tempo/ARM VPWR VGND sg13g2_tielo
XFILLER_17_566 VPWR VGND sg13g2_decap_8
XFILLER_29_371 VPWR VGND sg13g2_decap_8
XFILLER_5_42 VPWR VGND sg13g2_decap_8
XFILLER_4_481 VPWR VGND sg13g2_decap_8
XFILLER_27_319 VPWR VGND sg13g2_decap_8
XFILLER_24_18 VPWR VGND sg13g2_decap_8
XFILLER_23_569 VPWR VGND sg13g2_decap_8
XFILLER_22_580 VPWR VGND sg13g2_decap_8
XFILLER_5_245 VPWR VGND sg13g2_decap_8
XFILLER_9_540 VPWR VGND sg13g2_decap_8
XFILLER_19_18 VPWR VGND sg13g2_decap_8
XFILLER_27_116 VPWR VGND sg13g2_decap_8
XFILLER_23_322 VPWR VGND sg13g2_decap_8
XFILLER_11_528 VPWR VGND sg13g2_decap_4
XFILLER_23_399 VPWR VGND sg13g2_decap_8
XFILLER_3_705 VPWR VGND sg13g2_decap_8
XFILLER_18_105 VPWR VGND sg13g2_decap_8
XFILLER_19_617 VPWR VGND sg13g2_decap_8
XFILLER_25_72 VPWR VGND sg13g2_decap_8
XFILLER_6_554 VPWR VGND sg13g2_decap_8
XFILLER_17_182 VPWR VGND sg13g2_decap_8
XFILLER_18_650 VPWR VGND sg13g2_decap_8
XFILLER_15_119 VPWR VGND sg13g2_decap_8
Xlane1.lp.c_hsprp.tempo VPWR VGND _077_/X _076_/A _184_/A fanout38/X _180_/A tempo_t24n
XFILLER_28_469 VPWR VGND sg13g2_decap_8
XFILLER_24_664 VPWR VGND sg13g2_decap_8
XFILLER_11_336 VPWR VGND sg13g2_decap_8
XFILLER_23_196 VPWR VGND sg13g2_decap_8
XFILLER_11_63 VPWR VGND sg13g2_decap_8
XFILLER_3_568 VPWR VGND sg13g2_decap_8
XFILLER_15_620 VPWR VGND sg13g2_decap_8
XFILLER_19_469 VPWR VGND sg13g2_decap_8
XFILLER_27_480 VPWR VGND sg13g2_decap_8
XFILLER_15_631 VPWR VGND sg13g2_fill_1
XFILLER_15_664 VPWR VGND sg13g2_decap_8
Xclkbuf_0_rx_clk_regs clkbuf_0_rx_clk_regs/X clkbuf_regs_0_rx_clk/X VPWR VGND sg13g2_buf_16
XFILLER_30_634 VPWR VGND sg13g2_decap_8
XFILLER_10_391 VPWR VGND sg13g2_decap_8
X_179_ _179_/X _179_/A VPWR VGND sg13g2_buf_1
XFILLER_6_373 VPWR VGND sg13g2_decap_8
XFILLER_21_623 VPWR VGND sg13g2_decap_8
Xlane3.t_settle.tempo VPWR VGND _086_/X lane3.t_settle.tempo/ARM _123_/Q fanout40/X
+ _178_/A tempo_t110n
XFILLER_28_266 VPWR VGND sg13g2_decap_8
XFILLER_11_133 VPWR VGND sg13g2_decap_8
XFILLER_12_645 VPWR VGND sg13g2_decap_8
XFILLER_24_483 VPWR VGND sg13g2_decap_8
XFILLER_22_84 VPWR VGND sg13g2_decap_8
X_102_ _102_/Y _101_/B _102_/B VPWR VGND sg13g2_nand2b_1
XFILLER_15_483 VPWR VGND sg13g2_decap_8
XFILLER_7_660 VPWR VGND sg13g2_decap_8
XFILLER_30_431 VPWR VGND sg13g2_decap_8
XFILLER_6_192 VPWR VGND sg13g2_decap_8
XFILLER_27_18 VPWR VGND sg13g2_decap_8
XFILLER_21_420 VPWR VGND sg13g2_decap_8
XFILLER_21_497 VPWR VGND sg13g2_decap_8
XFILLER_16_214 VPWR VGND sg13g2_decap_8
XFILLER_17_84 VPWR VGND sg13g2_decap_8
XFILLER_29_553 VPWR VGND sg13g2_decap_8
XFILLER_12_442 VPWR VGND sg13g2_decap_8
XFILLER_12_497 VPWR VGND sg13g2_decap_8
XFILLER_4_663 VPWR VGND sg13g2_decap_8
XFILLER_15_280 VPWR VGND sg13g2_decap_8
XFILLER_22_217 VPWR VGND sg13g2_decap_8
XFILLER_7_490 VPWR VGND sg13g2_decap_8
XFILLER_13_228 VPWR VGND sg13g2_decap_8
XFILLER_21_294 VPWR VGND sg13g2_decap_8
XFILLER_5_427 VPWR VGND sg13g2_decap_8
XFILLER_1_699 VPWR VGND sg13g2_decap_8
XFILLER_29_350 VPWR VGND sg13g2_decap_8
XFILLER_17_545 VPWR VGND sg13g2_decap_8
XFILLER_12_294 VPWR VGND sg13g2_decap_8
XFILLER_5_21 VPWR VGND sg13g2_decap_8
XFILLER_5_98 VPWR VGND sg13g2_decap_8
XFILLER_4_460 VPWR VGND sg13g2_decap_8
XFILLER_23_504 VPWR VGND sg13g2_decap_8
XFILLER_23_548 VPWR VGND sg13g2_decap_8
XFILLER_10_721 VPWR VGND sg13g2_decap_4
XFILLER_5_224 VPWR VGND sg13g2_decap_8
XFILLER_30_95 VPWR VGND sg13g2_decap_8
XFILLER_9_530 VPWR VGND sg13g2_fill_1
XFILLER_9_596 VPWR VGND sg13g2_decap_8
XFILLER_23_301 VPWR VGND sg13g2_decap_8
XFILLER_23_378 VPWR VGND sg13g2_decap_8
XFILLER_4_7 VPWR VGND sg13g2_decap_8
XFILLER_27_662 VPWR VGND sg13g2_decap_8
XFILLER_10_573 VPWR VGND sg13g2_decap_8
XFILLER_17_161 VPWR VGND sg13g2_decap_8
Xclk_lane.c_term.tempo_42 clk_lane.c_term.tempo/ARM VPWR VGND sg13g2_tielo
XFILLER_24_109 VPWR VGND sg13g2_decap_8
XFILLER_9_382 VPWR VGND sg13g2_decap_8
Xclk_lane.lp.c_stop.tempo_62 clk_lane.lp.c_stop.tempo_62/L_HI VPWR VGND sg13g2_tiehi
Xlane1.lp.f11.tempo VPWR VGND _094_/Y lane1.lp.f11.tempo/ARM lane1.lp.f11.tempo_70/L_HI
+ fanout35/X _077_/B tempo_t24n
XFILLER_28_448 VPWR VGND sg13g2_decap_8
XFILLER_11_315 VPWR VGND sg13g2_decap_8
XFILLER_23_175 VPWR VGND sg13g2_decap_8
XFILLER_24_643 VPWR VGND sg13g2_decap_8
XFILLER_11_42 VPWR VGND sg13g2_decap_8
XFILLER_3_547 VPWR VGND sg13g2_decap_8
XFILLER_15_643 VPWR VGND sg13g2_decap_8
XFILLER_30_613 VPWR VGND sg13g2_decap_8
X_178_ _178_/X _178_/A VPWR VGND sg13g2_buf_1
XFILLER_21_602 VPWR VGND sg13g2_decap_8
XFILLER_21_679 VPWR VGND sg13g2_fill_2
XFILLER_28_245 VPWR VGND sg13g2_decap_8
XFILLER_11_112 VPWR VGND sg13g2_decap_8
XFILLER_11_189 VPWR VGND sg13g2_decap_8
XFILLER_12_624 VPWR VGND sg13g2_decap_8
X_101_ _101_/Y _102_/B _101_/B VPWR VGND sg13g2_nand2b_1
XFILLER_24_462 VPWR VGND sg13g2_decap_8
XFILLER_22_63 VPWR VGND sg13g2_decap_8
XFILLER_3_355 VPWR VGND sg13g2_decap_8
XFILLER_19_223 VPWR VGND sg13g2_fill_1
XFILLER_19_256 VPWR VGND sg13g2_decap_8
XFILLER_3_399 VPWR VGND sg13g2_decap_8
XFILLER_15_462 VPWR VGND sg13g2_decap_8
XFILLER_30_410 VPWR VGND sg13g2_decap_8
XFILLER_6_171 VPWR VGND sg13g2_decap_8
XFILLER_30_487 VPWR VGND sg13g2_decap_8
XFILLER_25_204 VPWR VGND sg13g2_decap_8
XFILLER_21_476 VPWR VGND sg13g2_decap_8
XFILLER_4_119 VPWR VGND sg13g2_decap_8
Xclkbuf_2_3__f_rx_clk_regs _130_/CLK clkbuf_0_rx_clk_regs/X VPWR VGND sg13g2_buf_16
XFILLER_29_532 VPWR VGND sg13g2_decap_8
XFILLER_17_63 VPWR VGND sg13g2_decap_8
XFILLER_12_476 VPWR VGND sg13g2_decap_8
XFILLER_4_642 VPWR VGND sg13g2_decap_8
XFILLER_3_185 VPWR VGND sg13g2_decap_8
XFILLER_30_284 VPWR VGND sg13g2_decap_8
XFILLER_13_218 VPWR VGND sg13g2_decap_4
XFILLER_21_273 VPWR VGND sg13g2_decap_8
XFILLER_5_406 VPWR VGND sg13g2_decap_8
XFILLER_17_502 VPWR VGND sg13g2_decap_8
XFILLER_28_84 VPWR VGND sg13g2_decap_8
XFILLER_9_701 VPWR VGND sg13g2_decap_8
XFILLER_12_273 VPWR VGND sg13g2_decap_8
XFILLER_5_77 VPWR VGND sg13g2_decap_8
XFILLER_23_527 VPWR VGND sg13g2_decap_8
XFILLER_10_700 VPWR VGND sg13g2_decap_8
XFILLER_6_715 VPWR VGND sg13g2_decap_8
XFILLER_5_203 VPWR VGND sg13g2_decap_8
XFILLER_30_74 VPWR VGND sg13g2_decap_8
XFILLER_17_343 VPWR VGND sg13g2_decap_8
XFILLER_17_398 VPWR VGND sg13g2_decap_8
XFILLER_13_582 VPWR VGND sg13g2_decap_8
XFILLER_9_520 VPWR VGND sg13g2_fill_1
XFILLER_9_575 VPWR VGND sg13g2_decap_8
XFILLER_4_291 VPWR VGND sg13g2_decap_8
XFILLER_23_357 VPWR VGND sg13g2_decap_8
XFILLER_27_641 VPWR VGND sg13g2_decap_8
XFILLER_10_552 VPWR VGND sg13g2_decap_8
XFILLER_25_63 VPWR VGND sg13g2_fill_1
X_194_ _194_/X _194_/A VPWR VGND sg13g2_buf_1
XFILLER_6_589 VPWR VGND sg13g2_decap_8
XFILLER_17_140 VPWR VGND sg13g2_decap_8
XFILLER_18_685 VPWR VGND sg13g2_decap_8
XFILLER_13_390 VPWR VGND sg13g2_decap_8
XFILLER_9_361 VPWR VGND sg13g2_decap_8
XFILLER_28_427 VPWR VGND sg13g2_decap_8
XFILLER_23_154 VPWR VGND sg13g2_decap_8
XFILLER_24_699 VPWR VGND sg13g2_decap_8
XFILLER_24_622 VPWR VGND sg13g2_decap_8
XFILLER_11_21 VPWR VGND sg13g2_decap_8
XFILLER_11_98 VPWR VGND sg13g2_decap_8
XFILLER_3_504 VPWR VGND sg13g2_decap_8
XFILLER_19_427 VPWR VGND sg13g2_decap_8
X_177_ _177_/X _177_/A VPWR VGND sg13g2_buf_1
XFILLER_6_353 VPWR VGND sg13g2_fill_2
XFILLER_30_669 VPWR VGND sg13g2_decap_8
XFILLER_25_419 VPWR VGND sg13g2_decap_8
XFILLER_21_658 VPWR VGND sg13g2_decap_8
XFILLER_29_725 VPWR VGND sg13g2_fill_2
XFILLER_29_714 VPWR VGND sg13g2_decap_8
XFILLER_12_603 VPWR VGND sg13g2_decap_8
XFILLER_16_419 VPWR VGND sg13g2_decap_8
XFILLER_28_224 VPWR VGND sg13g2_decap_8
XFILLER_11_168 VPWR VGND sg13g2_decap_8
XFILLER_22_42 VPWR VGND sg13g2_decap_8
X_100_ _100_/Y _101_/B _102_/B VPWR VGND sg13g2_nand2_1
XFILLER_7_139 VPWR VGND sg13g2_fill_2
XFILLER_3_378 VPWR VGND sg13g2_decap_8
XFILLER_3_334 VPWR VGND sg13g2_decap_8
XFILLER_19_235 VPWR VGND sg13g2_decap_8
XFILLER_15_441 VPWR VGND sg13g2_fill_2
Xlane1.lp.f10.tempo VPWR VGND _096_/Y lane1.lp.f10.tempo/ARM lane1.lp.f10.tempo_69/L_HI
+ fanout35/X _077_/A tempo_t24n
XFILLER_6_150 VPWR VGND sg13g2_decap_8
XFILLER_30_466 VPWR VGND sg13g2_decap_8
XFILLER_18_290 VPWR VGND sg13g2_decap_8
XFILLER_25_249 VPWR VGND sg13g2_decap_8
XFILLER_17_706 VPWR VGND sg13g2_decap_8
XFILLER_29_588 VPWR VGND sg13g2_decap_8
XFILLER_29_511 VPWR VGND sg13g2_decap_8
XFILLER_16_249 VPWR VGND sg13g2_decap_8
XFILLER_17_42 VPWR VGND sg13g2_decap_8
XFILLER_4_621 VPWR VGND sg13g2_decap_8
XFILLER_4_698 VPWR VGND sg13g2_decap_8
XFILLER_3_164 VPWR VGND sg13g2_decap_8
XFILLER_12_7 VPWR VGND sg13g2_decap_8
XFILLER_23_709 VPWR VGND sg13g2_decap_8
XFILLER_30_263 VPWR VGND sg13g2_decap_8
XFILLER_22_720 VPWR VGND sg13g2_fill_2
XFILLER_21_252 VPWR VGND sg13g2_decap_8
XFILLER_29_385 VPWR VGND sg13g2_decap_8
XFILLER_28_63 VPWR VGND sg13g2_decap_8
XFILLER_12_252 VPWR VGND sg13g2_decap_8
XFILLER_5_56 VPWR VGND sg13g2_decap_8
XFILLER_4_495 VPWR VGND sg13g2_decap_8
XFILLER_22_594 VPWR VGND sg13g2_decap_8
XFILLER_5_259 VPWR VGND sg13g2_decap_8
XFILLER_30_53 VPWR VGND sg13g2_decap_8
XFILLER_17_322 VPWR VGND sg13g2_decap_8
Xclk_lane.c_settle.tempo VPWR VGND _065_/X clk_lane.c_settle.tempo/ARM _064_/Y fanout38/X
+ _066_/B tempo_t180n
XFILLER_29_182 VPWR VGND sg13g2_decap_8
XFILLER_13_561 VPWR VGND sg13g2_decap_8
XFILLER_9_554 VPWR VGND sg13g2_decap_8
XFILLER_4_270 VPWR VGND sg13g2_decap_8
XFILLER_28_609 VPWR VGND sg13g2_decap_8
XFILLER_23_336 VPWR VGND sg13g2_decap_8
XFILLER_18_119 VPWR VGND sg13g2_decap_8
XFILLER_27_686 VPWR VGND sg13g2_decap_8
XFILLER_27_620 VPWR VGND sg13g2_decap_8
XFILLER_25_42 VPWR VGND sg13g2_decap_8
X_193_ _193_/X _193_/A VPWR VGND sg13g2_buf_1
XFILLER_6_513 VPWR VGND sg13g2_fill_2
XFILLER_25_86 VPWR VGND sg13g2_decap_8
XFILLER_6_568 VPWR VGND sg13g2_decap_8
XFILLER_17_196 VPWR VGND sg13g2_decap_8
XFILLER_18_664 VPWR VGND sg13g2_decap_8
XFILLER_9_340 VPWR VGND sg13g2_decap_8
XFILLER_28_406 VPWR VGND sg13g2_decap_8
XFILLER_24_601 VPWR VGND sg13g2_decap_8
XFILLER_23_133 VPWR VGND sg13g2_decap_8
XFILLER_24_678 VPWR VGND sg13g2_decap_8
XFILLER_11_77 VPWR VGND sg13g2_decap_8
XFILLER_19_406 VPWR VGND sg13g2_decap_8
XFILLER_15_678 VPWR VGND sg13g2_decap_8
XFILLER_27_494 VPWR VGND sg13g2_decap_8
XFILLER_10_350 VPWR VGND sg13g2_decap_8
X_176_ _176_/X _176_/A VPWR VGND sg13g2_buf_1
XFILLER_6_387 VPWR VGND sg13g2_decap_8
XFILLER_6_332 VPWR VGND sg13g2_decap_8
XFILLER_30_648 VPWR VGND sg13g2_decap_8
XFILLER_18_483 VPWR VGND sg13g2_decap_8
XFILLER_21_637 VPWR VGND sg13g2_decap_8
XFILLER_28_203 VPWR VGND sg13g2_decap_8
XFILLER_24_497 VPWR VGND sg13g2_decap_8
XFILLER_11_147 VPWR VGND sg13g2_decap_8
XFILLER_12_659 VPWR VGND sg13g2_decap_8
XFILLER_22_21 VPWR VGND sg13g2_decap_8
XFILLER_22_98 VPWR VGND sg13g2_decap_8
Xlane3.t_settle.tempo_60 lane3.t_settle.tempo/ARM VPWR VGND sg13g2_tielo
XFILLER_7_107 VPWR VGND sg13g2_decap_8
XFILLER_3_313 VPWR VGND sg13g2_decap_8
XFILLER_19_214 VPWR VGND sg13g2_decap_8
XFILLER_15_453 VPWR VGND sg13g2_decap_4
XFILLER_15_497 VPWR VGND sg13g2_decap_8
XFILLER_30_445 VPWR VGND sg13g2_decap_8
XFILLER_27_291 VPWR VGND sg13g2_decap_8
XFILLER_11_692 VPWR VGND sg13g2_decap_8
XFILLER_7_674 VPWR VGND sg13g2_decap_8
XFILLER_6_140 VPWR VGND sg13g2_decap_4
XFILLER_25_228 VPWR VGND sg13g2_decap_8
XFILLER_21_434 VPWR VGND sg13g2_fill_1
XFILLER_16_228 VPWR VGND sg13g2_decap_8
XFILLER_17_21 VPWR VGND sg13g2_decap_8
XFILLER_29_567 VPWR VGND sg13g2_decap_8
XFILLER_12_412 VPWR VGND sg13g2_decap_8
XFILLER_17_98 VPWR VGND sg13g2_decap_8
XFILLER_24_283 VPWR VGND sg13g2_decap_8
XFILLER_4_677 VPWR VGND sg13g2_decap_8
XFILLER_3_121 VPWR VGND sg13g2_decap_8
XFILLER_15_294 VPWR VGND sg13g2_decap_8
XFILLER_30_242 VPWR VGND sg13g2_decap_8
XFILLER_21_231 VPWR VGND sg13g2_decap_8
XFILLER_17_559 VPWR VGND sg13g2_decap_8
XFILLER_29_364 VPWR VGND sg13g2_decap_8
XFILLER_28_42 VPWR VGND sg13g2_decap_8
XFILLER_12_231 VPWR VGND sg13g2_decap_8
XFILLER_5_35 VPWR VGND sg13g2_decap_8
XFILLER_4_474 VPWR VGND sg13g2_decap_8
XFILLER_16_592 VPWR VGND sg13g2_decap_8
XFILLER_22_573 VPWR VGND sg13g2_decap_8
XFILLER_5_238 VPWR VGND sg13g2_decap_8
XFILLER_30_32 VPWR VGND sg13g2_decap_8
XFILLER_17_301 VPWR VGND sg13g2_decap_8
XFILLER_29_161 VPWR VGND sg13g2_decap_8
XFILLER_13_540 VPWR VGND sg13g2_decap_8
XFILLER_27_109 VPWR VGND sg13g2_decap_8
XFILLER_23_315 VPWR VGND sg13g2_decap_8
Xdelaybuf_0_rx_clk delaybuf_1_rx_clk/A rx_clk VPWR VGND sg13g2_buf_8
XFILLER_27_676 VPWR VGND sg13g2_fill_2
XFILLER_25_21 VPWR VGND sg13g2_decap_8
XFILLER_10_587 VPWR VGND sg13g2_fill_2
XFILLER_22_392 VPWR VGND sg13g2_decap_8
X_192_ _192_/X _192_/A VPWR VGND sg13g2_buf_1
XFILLER_6_547 VPWR VGND sg13g2_decap_8
XFILLER_18_643 VPWR VGND sg13g2_decap_8
XFILLER_17_175 VPWR VGND sg13g2_decap_8
XFILLER_9_396 VPWR VGND sg13g2_decap_8
XFILLER_23_112 VPWR VGND sg13g2_decap_8
XFILLER_24_657 VPWR VGND sg13g2_decap_8
XFILLER_11_329 VPWR VGND sg13g2_decap_8
XFILLER_23_189 VPWR VGND sg13g2_decap_8
XFILLER_11_56 VPWR VGND sg13g2_decap_8
XFILLER_15_613 VPWR VGND sg13g2_decap_8
XFILLER_15_657 VPWR VGND sg13g2_decap_8
XFILLER_30_627 VPWR VGND sg13g2_decap_8
XFILLER_27_473 VPWR VGND sg13g2_decap_8
XFILLER_10_384 VPWR VGND sg13g2_decap_8
X_175_ _175_/X _175_/A VPWR VGND sg13g2_buf_1
XFILLER_6_366 VPWR VGND sg13g2_decap_8
XFILLER_6_311 VPWR VGND sg13g2_decap_8
XFILLER_18_462 VPWR VGND sg13g2_decap_8
XFILLER_21_616 VPWR VGND sg13g2_decap_8
XFILLER_9_193 VPWR VGND sg13g2_decap_8
XFILLER_28_259 VPWR VGND sg13g2_decap_8
XFILLER_11_126 VPWR VGND sg13g2_decap_8
XFILLER_12_638 VPWR VGND sg13g2_decap_8
XFILLER_24_476 VPWR VGND sg13g2_decap_8
XFILLER_24_432 VPWR VGND sg13g2_fill_2
XFILLER_22_77 VPWR VGND sg13g2_decap_8
XFILLER_0_4 VPWR VGND sg13g2_decap_8
XFILLER_15_443 VPWR VGND sg13g2_fill_1
XFILLER_27_270 VPWR VGND sg13g2_decap_8
XFILLER_11_671 VPWR VGND sg13g2_decap_8
XFILLER_15_476 VPWR VGND sg13g2_decap_8
XFILLER_30_424 VPWR VGND sg13g2_decap_8
XFILLER_7_653 VPWR VGND sg13g2_decap_8
X_089_ _089_/Y _090_/B _089_/B VPWR VGND sg13g2_nand2b_1
XFILLER_6_185 VPWR VGND sg13g2_decap_8
XFILLER_21_413 VPWR VGND sg13g2_decap_8
XFILLER_25_218 VPWR VGND sg13g2_decap_4
XFILLER_16_207 VPWR VGND sg13g2_decap_8
XFILLER_17_77 VPWR VGND sg13g2_decap_8
XFILLER_29_546 VPWR VGND sg13g2_decap_8
XFILLER_24_262 VPWR VGND sg13g2_decap_8
XFILLER_4_656 VPWR VGND sg13g2_decap_8
XFILLER_3_100 VPWR VGND sg13g2_decap_8
XFILLER_3_199 VPWR VGND sg13g2_decap_8
XFILLER_15_273 VPWR VGND sg13g2_decap_8
XFILLER_30_221 VPWR VGND sg13g2_decap_8
XFILLER_7_483 VPWR VGND sg13g2_decap_8
XFILLER_30_298 VPWR VGND sg13g2_decap_8
XFILLER_21_210 VPWR VGND sg13g2_decap_8
XFILLER_21_287 VPWR VGND sg13g2_decap_8
XFILLER_22_722 VPWR VGND sg13g2_fill_1
XFILLER_29_343 VPWR VGND sg13g2_decap_8
XFILLER_28_21 VPWR VGND sg13g2_decap_8
XFILLER_12_210 VPWR VGND sg13g2_decap_8
XFILLER_17_538 VPWR VGND sg13g2_decap_8
XFILLER_28_98 VPWR VGND sg13g2_decap_8
XFILLER_25_582 VPWR VGND sg13g2_decap_8
XFILLER_12_287 VPWR VGND sg13g2_decap_8
XFILLER_9_715 VPWR VGND sg13g2_decap_4
XFILLER_5_14 VPWR VGND sg13g2_decap_8
XFILLER_4_431 VPWR VGND sg13g2_decap_8
XFILLER_16_571 VPWR VGND sg13g2_decap_8
XFILLER_10_714 VPWR VGND sg13g2_decap_8
XFILLER_10_725 VPWR VGND sg13g2_fill_2
XFILLER_22_552 VPWR VGND sg13g2_decap_8
XFILLER_5_217 VPWR VGND sg13g2_decap_8
XFILLER_30_11 VPWR VGND sg13g2_decap_8
XFILLER_30_88 VPWR VGND sg13g2_decap_8
XFILLER_29_140 VPWR VGND sg13g2_decap_8
XFILLER_17_357 VPWR VGND sg13g2_fill_2
XFILLER_13_596 VPWR VGND sg13g2_decap_8
XFILLER_9_589 VPWR VGND sg13g2_decap_8
Xlane1.lp.c_hsreq.tempo VPWR VGND _077_/X _095_/Y _188_/A fanout36/X _184_/A tempo_t24n
XFILLER_22_371 VPWR VGND sg13g2_decap_8
XFILLER_27_655 VPWR VGND sg13g2_decap_8
XFILLER_10_566 VPWR VGND sg13g2_decap_8
X_191_ _191_/X _191_/A VPWR VGND sg13g2_buf_1
XFILLER_17_154 VPWR VGND sg13g2_decap_8
XFILLER_18_622 VPWR VGND sg13g2_decap_8
XFILLER_18_699 VPWR VGND sg13g2_decap_8
XFILLER_9_375 VPWR VGND sg13g2_decap_8
XFILLER_11_308 VPWR VGND sg13g2_decap_8
XFILLER_23_168 VPWR VGND sg13g2_decap_8
XFILLER_24_636 VPWR VGND sg13g2_decap_8
XFILLER_11_35 VPWR VGND sg13g2_decap_8
XFILLER_3_518 VPWR VGND sg13g2_decap_4
XFILLER_15_636 VPWR VGND sg13g2_decap_8
XFILLER_27_452 VPWR VGND sg13g2_decap_8
XFILLER_30_606 VPWR VGND sg13g2_decap_8
XFILLER_28_7 VPWR VGND sg13g2_decap_8
XFILLER_9_172 VPWR VGND sg13g2_decap_8
XFILLER_28_238 VPWR VGND sg13g2_decap_8
XFILLER_24_411 VPWR VGND sg13g2_decap_8
XFILLER_11_105 VPWR VGND sg13g2_decap_8
XFILLER_12_617 VPWR VGND sg13g2_decap_8
XFILLER_22_56 VPWR VGND sg13g2_decap_8
XFILLER_3_348 VPWR VGND sg13g2_decap_8
XFILLER_19_249 VPWR VGND sg13g2_decap_8
XFILLER_30_403 VPWR VGND sg13g2_decap_8
XFILLER_10_182 VPWR VGND sg13g2_decap_8
XFILLER_11_650 VPWR VGND sg13g2_decap_8
XFILLER_7_632 VPWR VGND sg13g2_decap_8
X_088_ _088_/Y _089_/B _090_/B VPWR VGND sg13g2_nand2_1
XFILLER_6_164 VPWR VGND sg13g2_decap_8
XFILLER_21_469 VPWR VGND sg13g2_decap_8
XFILLER_29_525 VPWR VGND sg13g2_decap_8
XFILLER_17_56 VPWR VGND sg13g2_decap_8
XFILLER_24_241 VPWR VGND sg13g2_decap_8
XFILLER_12_469 VPWR VGND sg13g2_decap_8
XFILLER_4_635 VPWR VGND sg13g2_decap_8
XFILLER_3_178 VPWR VGND sg13g2_decap_8
XFILLER_3_145 VPWR VGND sg13g2_fill_1
XFILLER_15_252 VPWR VGND sg13g2_decap_8
XFILLER_30_200 VPWR VGND sg13g2_decap_8
XFILLER_7_462 VPWR VGND sg13g2_decap_8
XFILLER_30_277 VPWR VGND sg13g2_decap_8
XFILLER_17_0 VPWR VGND sg13g2_decap_8
XFILLER_21_266 VPWR VGND sg13g2_decap_8
XFILLER_29_322 VPWR VGND sg13g2_decap_8
XFILLER_28_77 VPWR VGND sg13g2_decap_8
XFILLER_29_399 VPWR VGND sg13g2_decap_8
XFILLER_25_561 VPWR VGND sg13g2_decap_8
XFILLER_12_266 VPWR VGND sg13g2_decap_8
XFILLER_4_410 VPWR VGND sg13g2_decap_8
XFILLER_0_682 VPWR VGND sg13g2_decap_8
XFILLER_10_7 VPWR VGND sg13g2_decap_8
XFILLER_16_550 VPWR VGND sg13g2_decap_8
Xlane3.c_term.tempo VPWR VGND _086_/X lane3.c_term.tempo/ARM _085_/Y fanout39/X _194_/A
+ tempo_t24n
XFILLER_7_270 VPWR VGND sg13g2_decap_8
XFILLER_6_708 VPWR VGND sg13g2_decap_8
XFILLER_30_67 VPWR VGND sg13g2_decap_8
XFILLER_17_336 VPWR VGND sg13g2_decap_8
XFILLER_29_196 VPWR VGND sg13g2_decap_8
XFILLER_13_575 VPWR VGND sg13g2_decap_8
XFILLER_9_502 VPWR VGND sg13g2_decap_8
XFILLER_9_568 VPWR VGND sg13g2_decap_8
XFILLER_25_391 VPWR VGND sg13g2_decap_8
XFILLER_4_284 VPWR VGND sg13g2_decap_8
XFILLER_16_391 VPWR VGND sg13g2_decap_8
XFILLER_6_91 VPWR VGND sg13g2_decap_8
XFILLER_27_634 VPWR VGND sg13g2_decap_8
XFILLER_22_350 VPWR VGND sg13g2_decap_8
X_190_ _190_/X _190_/A VPWR VGND sg13g2_buf_1
XFILLER_25_56 VPWR VGND sg13g2_decap_8
XFILLER_10_545 VPWR VGND sg13g2_decap_8
XFILLER_18_601 VPWR VGND sg13g2_decap_8
XFILLER_17_133 VPWR VGND sg13g2_decap_8
XFILLER_18_678 VPWR VGND sg13g2_decap_8
XFILLER_13_383 VPWR VGND sg13g2_decap_8
XFILLER_9_354 VPWR VGND sg13g2_decap_8
XFILLER_5_582 VPWR VGND sg13g2_decap_8
XFILLER_23_147 VPWR VGND sg13g2_decap_8
XFILLER_24_615 VPWR VGND sg13g2_decap_8
XFILLER_11_14 VPWR VGND sg13g2_decap_8
XFILLER_27_431 VPWR VGND sg13g2_decap_8
XFILLER_23_681 VPWR VGND sg13g2_decap_8
XFILLER_6_346 VPWR VGND sg13g2_decap_8
XFILLER_18_497 VPWR VGND sg13g2_decap_8
XFILLER_9_151 VPWR VGND sg13g2_decap_8
XFILLER_29_707 VPWR VGND sg13g2_decap_8
Xlane3.c_term.tempo_57 lane3.c_term.tempo/ARM VPWR VGND sg13g2_tielo
XFILLER_28_217 VPWR VGND sg13g2_decap_8
XFILLER_24_434 VPWR VGND sg13g2_fill_1
XFILLER_22_35 VPWR VGND sg13g2_decap_8
XFILLER_3_327 VPWR VGND sg13g2_decap_8
XFILLER_19_206 VPWR VGND sg13g2_fill_2
XFILLER_19_228 VPWR VGND sg13g2_decap_8
XFILLER_15_412 VPWR VGND sg13g2_decap_8
XFILLER_10_161 VPWR VGND sg13g2_decap_8
XFILLER_7_699 VPWR VGND sg13g2_decap_8
X_087_ _087_/X _087_/A _087_/B VPWR VGND sg13g2_or2_1
Xlane2.lp.f11.tempo_73 lane2.lp.f11.tempo_73/L_HI VPWR VGND sg13g2_tiehi
XFILLER_30_459 VPWR VGND sg13g2_decap_8
XFILLER_18_283 VPWR VGND sg13g2_decap_8
XFILLER_19_4 VPWR VGND sg13g2_decap_8
XFILLER_29_504 VPWR VGND sg13g2_decap_8
XFILLER_12_426 VPWR VGND sg13g2_decap_8
XFILLER_17_35 VPWR VGND sg13g2_decap_8
XFILLER_24_220 VPWR VGND sg13g2_decap_8
XFILLER_4_614 VPWR VGND sg13g2_decap_8
XFILLER_4_603 VPWR VGND sg13g2_fill_2
XFILLER_24_297 VPWR VGND sg13g2_decap_4
XFILLER_3_157 VPWR VGND sg13g2_decap_8
XFILLER_3_135 VPWR VGND sg13g2_decap_4
XFILLER_28_581 VPWR VGND sg13g2_decap_8
XFILLER_15_231 VPWR VGND sg13g2_decap_8
XFILLER_30_256 VPWR VGND sg13g2_decap_8
XFILLER_3_691 VPWR VGND sg13g2_decap_8
XFILLER_22_713 VPWR VGND sg13g2_decap_8
XFILLER_21_245 VPWR VGND sg13g2_decap_8
XFILLER_29_378 VPWR VGND sg13g2_decap_8
XFILLER_29_301 VPWR VGND sg13g2_decap_8
XFILLER_28_56 VPWR VGND sg13g2_decap_8
XFILLER_12_245 VPWR VGND sg13g2_decap_8
XFILLER_13_713 VPWR VGND sg13g2_decap_4
XFILLER_25_540 VPWR VGND sg13g2_decap_8
XFILLER_5_49 VPWR VGND sg13g2_decap_8
XFILLER_4_488 VPWR VGND sg13g2_decap_8
XFILLER_22_587 VPWR VGND sg13g2_decap_8
XFILLER_30_46 VPWR VGND sg13g2_decap_8
XFILLER_17_315 VPWR VGND sg13g2_decap_8
XFILLER_29_175 VPWR VGND sg13g2_decap_8
XFILLER_25_370 VPWR VGND sg13g2_decap_8
XFILLER_13_554 VPWR VGND sg13g2_decap_8
XFILLER_9_547 VPWR VGND sg13g2_decap_8
XFILLER_4_263 VPWR VGND sg13g2_decap_8
XFILLER_23_329 VPWR VGND sg13g2_decap_8
XFILLER_6_70 VPWR VGND sg13g2_decap_8
XFILLER_27_613 VPWR VGND sg13g2_decap_8
XFILLER_25_35 VPWR VGND sg13g2_decap_8
XFILLER_6_506 VPWR VGND sg13g2_decap_8
XFILLER_25_79 VPWR VGND sg13g2_decap_8
XFILLER_17_112 VPWR VGND sg13g2_decap_8
XFILLER_17_189 VPWR VGND sg13g2_decap_8
XFILLER_18_657 VPWR VGND sg13g2_decap_8
XFILLER_13_362 VPWR VGND sg13g2_decap_8
XFILLER_9_333 VPWR VGND sg13g2_decap_8
XFILLER_5_561 VPWR VGND sg13g2_decap_8
XFILLER_23_126 VPWR VGND sg13g2_decap_8
XFILLER_27_410 VPWR VGND sg13g2_decap_8
XFILLER_15_627 VPWR VGND sg13g2_decap_4
XFILLER_27_487 VPWR VGND sg13g2_decap_8
XFILLER_23_660 VPWR VGND sg13g2_decap_8
XFILLER_10_343 VPWR VGND sg13g2_decap_8
XFILLER_10_398 VPWR VGND sg13g2_decap_8
XFILLER_6_325 VPWR VGND sg13g2_decap_8
XFILLER_18_476 VPWR VGND sg13g2_decap_8
XFILLER_13_192 VPWR VGND sg13g2_decap_8
XFILLER_9_130 VPWR VGND sg13g2_decap_8
XFILLER_3_93 VPWR VGND sg13g2_decap_8
XFILLER_3_60 VPWR VGND sg13g2_decap_8
XFILLER_22_14 VPWR VGND sg13g2_decap_8
XFILLER_3_306 VPWR VGND sg13g2_decap_8
XFILLER_15_457 VPWR VGND sg13g2_fill_1
XFILLER_30_438 VPWR VGND sg13g2_decap_8
XFILLER_27_284 VPWR VGND sg13g2_decap_8
XFILLER_23_490 VPWR VGND sg13g2_decap_8
XFILLER_10_140 VPWR VGND sg13g2_decap_8
XFILLER_11_685 VPWR VGND sg13g2_decap_8
XFILLER_12_91 VPWR VGND sg13g2_decap_8
XFILLER_7_667 VPWR VGND sg13g2_decap_8
X_086_ _086_/X _086_/A _086_/B VPWR VGND sg13g2_or2_1
XFILLER_6_199 VPWR VGND sg13g2_decap_8
XFILLER_6_144 VPWR VGND sg13g2_fill_1
XFILLER_6_133 VPWR VGND sg13g2_decap_8
XFILLER_18_262 VPWR VGND sg13g2_decap_8
XFILLER_21_427 VPWR VGND sg13g2_decap_8
Xlane0.lp.f10.tempo_66 lane0.lp.f10.tempo_66/L_HI VPWR VGND sg13g2_tiehi
XFILLER_17_14 VPWR VGND sg13g2_decap_8
XFILLER_12_405 VPWR VGND sg13g2_decap_8
XFILLER_12_449 VPWR VGND sg13g2_decap_4
XFILLER_24_276 VPWR VGND sg13g2_decap_8
XFILLER_3_114 VPWR VGND sg13g2_decap_8
XFILLER_15_210 VPWR VGND sg13g2_decap_8
XFILLER_16_711 VPWR VGND sg13g2_decap_8
XFILLER_28_560 VPWR VGND sg13g2_decap_8
XFILLER_11_482 VPWR VGND sg13g2_decap_8
XFILLER_15_287 VPWR VGND sg13g2_decap_8
XFILLER_30_235 VPWR VGND sg13g2_decap_8
XFILLER_7_497 VPWR VGND sg13g2_decap_8
X_069_ _071_/B _179_/A _183_/A VPWR VGND sg13g2_nor2_1
X_138_ _138_/Q _138_/CLK _138_/D _070_/Y VPWR VGND sg13g2_dfrbpq_1
XFILLER_3_670 VPWR VGND sg13g2_decap_8
XFILLER_19_582 VPWR VGND sg13g2_decap_8
XFILLER_21_224 VPWR VGND sg13g2_decap_8
XFILLER_9_81 VPWR VGND sg13g2_decap_8
XFILLER_29_357 VPWR VGND sg13g2_decap_8
XFILLER_28_35 VPWR VGND sg13g2_decap_8
XFILLER_12_224 VPWR VGND sg13g2_decap_8
XFILLER_25_596 VPWR VGND sg13g2_decap_8
XFILLER_5_28 VPWR VGND sg13g2_decap_8
XFILLER_4_467 VPWR VGND sg13g2_decap_8
XFILLER_4_445 VPWR VGND sg13g2_decap_4
XFILLER_16_585 VPWR VGND sg13g2_decap_8
XFILLER_22_0 VPWR VGND sg13g2_decap_8
XFILLER_7_294 VPWR VGND sg13g2_decap_8
XFILLER_22_566 VPWR VGND sg13g2_decap_8
XFILLER_30_25 VPWR VGND sg13g2_decap_8
XFILLER_29_154 VPWR VGND sg13g2_decap_8
XFILLER_13_511 VPWR VGND sg13g2_fill_2
XFILLER_4_242 VPWR VGND sg13g2_decap_8
XFILLER_23_308 VPWR VGND sg13g2_decap_8
XFILLER_27_669 VPWR VGND sg13g2_decap_8
XFILLER_25_14 VPWR VGND sg13g2_decap_8
XFILLER_22_385 VPWR VGND sg13g2_decap_8
XFILLER_9_4 VPWR VGND sg13g2_decap_8
XFILLER_18_636 VPWR VGND sg13g2_decap_8
XFILLER_13_341 VPWR VGND sg13g2_decap_8
XFILLER_15_91 VPWR VGND sg13g2_decap_8
XFILLER_17_168 VPWR VGND sg13g2_decap_8
XFILLER_9_312 VPWR VGND sg13g2_decap_8
XFILLER_9_389 VPWR VGND sg13g2_decap_8
XFILLER_5_540 VPWR VGND sg13g2_decap_8
Xlane0.t_settle.tempo_48 lane0.t_settle.tempo/ARM VPWR VGND sg13g2_tielo
XFILLER_23_105 VPWR VGND sg13g2_decap_8
XFILLER_11_49 VPWR VGND sg13g2_decap_8
XFILLER_15_606 VPWR VGND sg13g2_decap_8
XFILLER_27_466 VPWR VGND sg13g2_decap_8
XFILLER_10_322 VPWR VGND sg13g2_decap_8
XFILLER_22_182 VPWR VGND sg13g2_decap_8
XFILLER_6_359 VPWR VGND sg13g2_decap_8
XFILLER_6_304 VPWR VGND sg13g2_decap_8
XFILLER_18_433 VPWR VGND sg13g2_fill_2
XFILLER_13_171 VPWR VGND sg13g2_decap_8
XFILLER_21_609 VPWR VGND sg13g2_decap_8
XFILLER_9_186 VPWR VGND sg13g2_decap_8
XFILLER_5_392 VPWR VGND sg13g2_decap_8
XFILLER_3_72 VPWR VGND sg13g2_decap_8
XFILLER_11_119 VPWR VGND sg13g2_decap_8
XFILLER_24_469 VPWR VGND sg13g2_decap_8
XFILLER_24_425 VPWR VGND sg13g2_decap_8
XFILLER_19_208 VPWR VGND sg13g2_fill_1
XFILLER_27_263 VPWR VGND sg13g2_decap_8
XFILLER_11_664 VPWR VGND sg13g2_decap_8
XFILLER_15_469 VPWR VGND sg13g2_decap_8
XFILLER_30_417 VPWR VGND sg13g2_decap_8
XFILLER_10_196 VPWR VGND sg13g2_decap_8
XFILLER_12_70 VPWR VGND sg13g2_decap_8
XFILLER_7_646 VPWR VGND sg13g2_decap_8
X_085_ _085_/Y _086_/A _086_/B VPWR VGND sg13g2_nor2_1
XFILLER_6_178 VPWR VGND sg13g2_decap_8
XFILLER_6_112 VPWR VGND sg13g2_decap_8
XFILLER_18_241 VPWR VGND sg13g2_decap_8
XFILLER_21_406 VPWR VGND sg13g2_decap_8
Xlane2.lp.f11.tempo VPWR VGND _097_/Y lane2.lp.f11.tempo/ARM lane2.lp.f11.tempo_73/L_HI
+ fanout37/X _082_/B tempo_t24n
Xlane0.lp.c_stop.tempo VPWR VGND _072_/A _091_/Y lane0.lp.c_stop.tempo_65/L_HI fanout36/X
+ _187_/A tempo_t24n
XFILLER_29_539 VPWR VGND sg13g2_decap_8
XFILLER_25_701 VPWR VGND sg13g2_decap_8
XFILLER_24_255 VPWR VGND sg13g2_decap_8
XFILLER_4_649 VPWR VGND sg13g2_decap_8
XFILLER_15_266 VPWR VGND sg13g2_decap_8
XFILLER_11_461 VPWR VGND sg13g2_decap_8
XFILLER_7_476 VPWR VGND sg13g2_decap_8
X_137_ _137_/Q _138_/CLK _137_/D _070_/Y VPWR VGND sg13g2_dfrbpq_1
XFILLER_7_454 VPWR VGND sg13g2_decap_4
XFILLER_7_432 VPWR VGND sg13g2_fill_1
XFILLER_30_214 VPWR VGND sg13g2_decap_8
XFILLER_23_91 VPWR VGND sg13g2_decap_8
X_068_ _071_/A _092_/B _093_/B VPWR VGND sg13g2_or2_1
XFILLER_19_561 VPWR VGND sg13g2_decap_8
XFILLER_24_4 VPWR VGND sg13g2_decap_8
XFILLER_21_203 VPWR VGND sg13g2_decap_8
XFILLER_9_60 VPWR VGND sg13g2_decap_8
XFILLER_29_336 VPWR VGND sg13g2_decap_8
XFILLER_28_14 VPWR VGND sg13g2_decap_8
XFILLER_12_203 VPWR VGND sg13g2_decap_8
XFILLER_17_509 VPWR VGND sg13g2_fill_2
XFILLER_25_575 VPWR VGND sg13g2_decap_8
XFILLER_9_708 VPWR VGND sg13g2_decap_8
XFILLER_4_424 VPWR VGND sg13g2_decap_8
XFILLER_0_696 VPWR VGND sg13g2_decap_8
XFILLER_16_564 VPWR VGND sg13g2_decap_8
XFILLER_18_91 VPWR VGND sg13g2_decap_8
XFILLER_11_280 VPWR VGND sg13g2_decap_8
XFILLER_3_490 VPWR VGND sg13g2_decap_8
XFILLER_15_0 VPWR VGND sg13g2_decap_8
XFILLER_10_707 VPWR VGND sg13g2_decap_8
XFILLER_22_545 VPWR VGND sg13g2_decap_8
XFILLER_29_133 VPWR VGND sg13g2_decap_8
XFILLER_13_589 VPWR VGND sg13g2_decap_8
XFILLER_4_298 VPWR VGND sg13g2_decap_8
XFILLER_27_648 VPWR VGND sg13g2_decap_8
XFILLER_10_504 VPWR VGND sg13g2_decap_8
XFILLER_10_559 VPWR VGND sg13g2_decap_8
XFILLER_22_364 VPWR VGND sg13g2_decap_8
XFILLER_17_147 VPWR VGND sg13g2_decap_8
XFILLER_18_615 VPWR VGND sg13g2_decap_8
XFILLER_13_320 VPWR VGND sg13g2_decap_8
XFILLER_13_397 VPWR VGND sg13g2_decap_8
XFILLER_15_70 VPWR VGND sg13g2_decap_8
XFILLER_9_368 VPWR VGND sg13g2_decap_8
XFILLER_5_596 VPWR VGND sg13g2_decap_8
XFILLER_17_692 VPWR VGND sg13g2_decap_8
XFILLER_24_629 VPWR VGND sg13g2_decap_8
XFILLER_11_28 VPWR VGND sg13g2_decap_8
XFILLER_27_445 VPWR VGND sg13g2_decap_8
XFILLER_10_301 VPWR VGND sg13g2_decap_8
XFILLER_22_161 VPWR VGND sg13g2_decap_8
XFILLER_23_695 VPWR VGND sg13g2_decap_8
XFILLER_18_412 VPWR VGND sg13g2_decap_8
XFILLER_13_150 VPWR VGND sg13g2_decap_8
XFILLER_9_165 VPWR VGND sg13g2_decap_8
XFILLER_5_371 VPWR VGND sg13g2_decap_8
Xlane1.lp.f10.tempo_50 lane1.lp.f10.tempo/ARM VPWR VGND sg13g2_tielo
XFILLER_24_404 VPWR VGND sg13g2_decap_8
XFILLER_22_49 VPWR VGND sg13g2_decap_8
XFILLER_15_426 VPWR VGND sg13g2_decap_8
XFILLER_27_242 VPWR VGND sg13g2_decap_8
XFILLER_10_175 VPWR VGND sg13g2_decap_8
XFILLER_11_643 VPWR VGND sg13g2_decap_8
XFILLER_7_603 VPWR VGND sg13g2_decap_8
XFILLER_7_625 VPWR VGND sg13g2_decap_8
X_084_ _086_/B _182_/A _186_/A VPWR VGND sg13g2_nor2_1
XFILLER_6_157 VPWR VGND sg13g2_decap_8
XFILLER_18_220 VPWR VGND sg13g2_decap_8
XFILLER_18_297 VPWR VGND sg13g2_decap_8
Xlane0.lp.f10.tempo_46 lane0.lp.f10.tempo/ARM VPWR VGND sg13g2_tielo
XFILLER_6_680 VPWR VGND sg13g2_decap_8
XFILLER_29_518 VPWR VGND sg13g2_decap_8
XFILLER_17_49 VPWR VGND sg13g2_decap_8
XFILLER_24_234 VPWR VGND sg13g2_decap_8
XFILLER_4_628 VPWR VGND sg13g2_decap_8
XFILLER_15_245 VPWR VGND sg13g2_decap_8
XFILLER_28_595 VPWR VGND sg13g2_decap_8
X_136_ _136_/Q _136_/CLK _136_/D _070_/Y VPWR VGND sg13g2_dfrbpq_1
XFILLER_7_411 VPWR VGND sg13g2_decap_8
XFILLER_23_70 VPWR VGND sg13g2_decap_8
X_067_ _067_/X _067_/A _067_/B VPWR VGND sg13g2_or2_1
XFILLER_19_540 VPWR VGND sg13g2_decap_8
XFILLER_21_259 VPWR VGND sg13g2_decap_8
XFILLER_29_315 VPWR VGND sg13g2_decap_8
XFILLER_25_554 VPWR VGND sg13g2_decap_8
XFILLER_12_259 VPWR VGND sg13g2_decap_8
XFILLER_4_403 VPWR VGND sg13g2_decap_8
XFILLER_16_543 VPWR VGND sg13g2_decap_8
XFILLER_18_70 VPWR VGND sg13g2_decap_8
Xlane2.lp.f10.tempo VPWR VGND _099_/Y lane2.lp.f10.tempo/ARM lane2.lp.f10.tempo_72/L_HI
+ fanout37/X _082_/A tempo_t24n
XFILLER_28_392 VPWR VGND sg13g2_decap_8
X_119_ _121_/B _120_/B _120_/A VPWR VGND sg13g2_nand2b_1
XFILLER_7_263 VPWR VGND sg13g2_decap_8
XFILLER_19_392 VPWR VGND sg13g2_decap_8
XFILLER_17_329 VPWR VGND sg13g2_decap_8
XFILLER_29_189 VPWR VGND sg13g2_decap_8
XFILLER_29_112 VPWR VGND sg13g2_decap_8
XFILLER_13_568 VPWR VGND sg13g2_decap_8
Xlane2.t_settle.tempo VPWR VGND _081_/X lane2.t_settle.tempo/ARM _127_/Q fanout39/X
+ _177_/A tempo_t110n
XFILLER_25_384 VPWR VGND sg13g2_decap_8
XFILLER_5_723 VPWR VGND sg13g2_decap_4
XFILLER_4_277 VPWR VGND sg13g2_decap_8
XFILLER_16_340 VPWR VGND sg13g2_decap_8
XFILLER_16_384 VPWR VGND sg13g2_decap_8
Xhold91 _108_/B _127_/Q VPWR VGND sg13g2_dlygate4sd3_1
XFILLER_29_91 VPWR VGND sg13g2_decap_8
XFILLER_6_84 VPWR VGND sg13g2_decap_8
XFILLER_27_627 VPWR VGND sg13g2_decap_8
XFILLER_22_343 VPWR VGND sg13g2_decap_8
XFILLER_25_49 VPWR VGND sg13g2_decap_8
XFILLER_10_538 VPWR VGND sg13g2_decap_8
XFILLER_17_126 VPWR VGND sg13g2_decap_8
XFILLER_13_376 VPWR VGND sg13g2_decap_8
XFILLER_9_347 VPWR VGND sg13g2_decap_8
XFILLER_25_192 VPWR VGND sg13g2_decap_8
XFILLER_5_575 VPWR VGND sg13g2_decap_8
XFILLER_17_671 VPWR VGND sg13g2_decap_8
XFILLER_24_608 VPWR VGND sg13g2_decap_8
XFILLER_27_424 VPWR VGND sg13g2_decap_8
XFILLER_22_140 VPWR VGND sg13g2_decap_8
XFILLER_23_674 VPWR VGND sg13g2_decap_8
XFILLER_6_339 VPWR VGND sg13g2_decap_8
XFILLER_18_435 VPWR VGND sg13g2_fill_1
XFILLER_9_144 VPWR VGND sg13g2_decap_8
XFILLER_5_350 VPWR VGND sg13g2_decap_8
XFILLER_22_28 VPWR VGND sg13g2_decap_8
XFILLER_28_722 VPWR VGND sg13g2_fill_1
XFILLER_28_711 VPWR VGND sg13g2_decap_8
XFILLER_28_700 VPWR VGND sg13g2_decap_8
XFILLER_15_405 VPWR VGND sg13g2_decap_8
XFILLER_27_298 VPWR VGND sg13g2_decap_8
XFILLER_27_221 VPWR VGND sg13g2_decap_8
XFILLER_10_154 VPWR VGND sg13g2_decap_8
XFILLER_11_622 VPWR VGND sg13g2_decap_8
XFILLER_11_699 VPWR VGND sg13g2_decap_8
X_083_ _086_/A _101_/B _102_/B VPWR VGND sg13g2_or2_1
Xlane2.lp.f11.tempo_55 lane2.lp.f11.tempo/ARM VPWR VGND sg13g2_tielo
XFILLER_5_0 VPWR VGND sg13g2_decap_8
XFILLER_18_276 VPWR VGND sg13g2_decap_8
Xdelaybuf_1_rx_clk delaybuf_2_rx_clk/A delaybuf_1_rx_clk/A VPWR VGND sg13g2_buf_4
XFILLER_12_419 VPWR VGND sg13g2_decap_8
XFILLER_17_28 VPWR VGND sg13g2_decap_8
XFILLER_24_213 VPWR VGND sg13g2_decap_8
XFILLER_3_139 VPWR VGND sg13g2_fill_2
XFILLER_3_128 VPWR VGND sg13g2_decap_8
XFILLER_16_725 VPWR VGND sg13g2_fill_2
XFILLER_28_574 VPWR VGND sg13g2_decap_8
XFILLER_15_224 VPWR VGND sg13g2_decap_8
XFILLER_30_249 VPWR VGND sg13g2_decap_8
XFILLER_11_496 VPWR VGND sg13g2_decap_8
X_066_ _066_/X _066_/A _066_/B VPWR VGND sg13g2_and2_1
X_135_ _135_/Q _138_/CLK _135_/D _070_/Y VPWR VGND sg13g2_dfrbpq_1
XFILLER_3_684 VPWR VGND sg13g2_decap_8
XFILLER_0_53 VPWR VGND sg13g2_decap_4
XFILLER_19_596 VPWR VGND sg13g2_decap_8
XFILLER_22_706 VPWR VGND sg13g2_decap_8
XFILLER_21_238 VPWR VGND sg13g2_decap_8
XFILLER_9_95 VPWR VGND sg13g2_decap_8
XFILLER_28_49 VPWR VGND sg13g2_decap_8
XFILLER_12_238 VPWR VGND sg13g2_decap_8
XFILLER_13_706 VPWR VGND sg13g2_decap_8
XFILLER_13_717 VPWR VGND sg13g2_fill_2
XFILLER_25_522 VPWR VGND sg13g2_decap_4
XFILLER_28_371 VPWR VGND sg13g2_decap_8
XFILLER_16_599 VPWR VGND sg13g2_decap_8
X_118_ _135_/D _120_/B _118_/B VPWR VGND sg13g2_or2_1
XFILLER_7_242 VPWR VGND sg13g2_decap_8
XFILLER_19_371 VPWR VGND sg13g2_decap_8
XFILLER_30_39 VPWR VGND sg13g2_decap_8
XFILLER_17_308 VPWR VGND sg13g2_decap_8
XFILLER_29_168 VPWR VGND sg13g2_decap_8
XFILLER_13_547 VPWR VGND sg13g2_decap_8
XFILLER_9_518 VPWR VGND sg13g2_fill_2
XFILLER_25_363 VPWR VGND sg13g2_decap_8
XFILLER_5_702 VPWR VGND sg13g2_decap_8
XFILLER_4_256 VPWR VGND sg13g2_decap_8
Xhold81 _106_/A _125_/Q VPWR VGND sg13g2_dlygate4sd3_1
XFILLER_29_70 VPWR VGND sg13g2_decap_8
XFILLER_6_63 VPWR VGND sg13g2_decap_8
XFILLER_27_606 VPWR VGND sg13g2_decap_8
XFILLER_22_322 VPWR VGND sg13g2_decap_8
XFILLER_22_399 VPWR VGND sg13g2_decap_8
XFILLER_25_28 VPWR VGND sg13g2_decap_8
Xclkbuf_2_2__f_rx_clk_regs _129_/CLK clkbuf_0_rx_clk_regs/X VPWR VGND sg13g2_buf_16
XFILLER_17_105 VPWR VGND sg13g2_decap_8
XFILLER_25_171 VPWR VGND sg13g2_decap_8
XFILLER_13_355 VPWR VGND sg13g2_decap_8
XFILLER_9_326 VPWR VGND sg13g2_decap_8
XFILLER_5_554 VPWR VGND sg13g2_decap_8
XFILLER_17_650 VPWR VGND sg13g2_decap_8
XFILLER_16_193 VPWR VGND sg13g2_decap_8
XFILLER_23_119 VPWR VGND sg13g2_decap_8
XFILLER_27_403 VPWR VGND sg13g2_decap_8
XFILLER_10_336 VPWR VGND sg13g2_decap_8
XFILLER_22_196 VPWR VGND sg13g2_decap_8
XFILLER_6_318 VPWR VGND sg13g2_decap_8
XFILLER_23_653 VPWR VGND sg13g2_decap_8
XFILLER_7_4 VPWR VGND sg13g2_decap_8
XFILLER_18_469 VPWR VGND sg13g2_decap_8
XFILLER_13_141 VPWR VGND sg13g2_fill_1
XFILLER_13_185 VPWR VGND sg13g2_decap_8
XFILLER_9_123 VPWR VGND sg13g2_decap_8
XFILLER_3_86 VPWR VGND sg13g2_decap_8
XFILLER_3_53 VPWR VGND sg13g2_decap_8
XFILLER_27_200 VPWR VGND sg13g2_decap_8
XFILLER_11_601 VPWR VGND sg13g2_decap_8
XFILLER_27_277 VPWR VGND sg13g2_decap_8
XFILLER_23_483 VPWR VGND sg13g2_decap_8
XFILLER_10_133 VPWR VGND sg13g2_decap_8
XFILLER_11_678 VPWR VGND sg13g2_decap_8
XFILLER_12_84 VPWR VGND sg13g2_decap_8
X_082_ _082_/X _082_/A _082_/B VPWR VGND sg13g2_or2_1
XFILLER_6_126 VPWR VGND sg13g2_decap_8
XFILLER_18_255 VPWR VGND sg13g2_decap_8
XFILLER_19_701 VPWR VGND sg13g2_decap_8
XFILLER_25_715 VPWR VGND sg13g2_decap_4
XFILLER_24_269 VPWR VGND sg13g2_decap_8
XFILLER_3_107 VPWR VGND sg13g2_decap_8
XFILLER_15_203 VPWR VGND sg13g2_decap_8
XFILLER_16_704 VPWR VGND sg13g2_decap_8
XFILLER_28_553 VPWR VGND sg13g2_decap_8
XFILLER_11_475 VPWR VGND sg13g2_decap_8
XFILLER_30_228 VPWR VGND sg13g2_decap_8
XFILLER_23_280 VPWR VGND sg13g2_decap_8
X_065_ _065_/X _065_/A _065_/B VPWR VGND sg13g2_or2_1
X_134_ _134_/Q _136_/CLK _134_/D _075_/Y VPWR VGND sg13g2_dfrbpq_1
XFILLER_3_663 VPWR VGND sg13g2_decap_8
XFILLER_0_32 VPWR VGND sg13g2_decap_8
XFILLER_19_575 VPWR VGND sg13g2_decap_8
XFILLER_21_217 VPWR VGND sg13g2_decap_8
XFILLER_9_74 VPWR VGND sg13g2_decap_8
XFILLER_28_28 VPWR VGND sg13g2_decap_8
XFILLER_12_217 VPWR VGND sg13g2_decap_8
XFILLER_25_589 VPWR VGND sg13g2_decap_8
XFILLER_4_449 VPWR VGND sg13g2_fill_2
XFILLER_4_438 VPWR VGND sg13g2_decap_8
XFILLER_16_578 VPWR VGND sg13g2_decap_8
XFILLER_28_350 VPWR VGND sg13g2_decap_8
XFILLER_11_294 VPWR VGND sg13g2_decap_8
X_117_ _134_/D _115_/A _116_/A _115_/B VPWR VGND sg13g2_a21o_1
XFILLER_7_210 VPWR VGND sg13g2_fill_1
XFILLER_7_287 VPWR VGND sg13g2_decap_8
XFILLER_19_350 VPWR VGND sg13g2_decap_8
XFILLER_22_504 VPWR VGND sg13g2_decap_8
XFILLER_22_559 VPWR VGND sg13g2_decap_8
XFILLER_30_592 VPWR VGND sg13g2_decap_8
XFILLER_30_18 VPWR VGND sg13g2_decap_8
XFILLER_13_504 VPWR VGND sg13g2_decap_8
XFILLER_29_147 VPWR VGND sg13g2_decap_8
XFILLER_25_342 VPWR VGND sg13g2_decap_8
XFILLER_21_581 VPWR VGND sg13g2_decap_8
XFILLER_4_235 VPWR VGND sg13g2_decap_8
XFILLER_4_213 VPWR VGND sg13g2_decap_4
Xhold93 _118_/B _135_/Q VPWR VGND sg13g2_dlygate4sd3_1
XFILLER_6_42 VPWR VGND sg13g2_decap_8
XFILLER_3_290 VPWR VGND sg13g2_decap_8
XFILLER_22_301 VPWR VGND sg13g2_decap_8
XFILLER_22_378 VPWR VGND sg13g2_decap_8
XFILLER_18_629 VPWR VGND sg13g2_decap_8
XFILLER_13_334 VPWR VGND sg13g2_decap_8
XFILLER_15_84 VPWR VGND sg13g2_decap_8
XFILLER_9_305 VPWR VGND sg13g2_decap_8
XFILLER_25_150 VPWR VGND sg13g2_decap_8
XFILLER_16_172 VPWR VGND sg13g2_decap_8
XFILLER_27_459 VPWR VGND sg13g2_decap_8
XFILLER_23_632 VPWR VGND sg13g2_decap_8
XFILLER_10_315 VPWR VGND sg13g2_decap_8
XFILLER_22_175 VPWR VGND sg13g2_decap_8
XFILLER_18_426 VPWR VGND sg13g2_decap_8
XFILLER_13_164 VPWR VGND sg13g2_decap_8
XFILLER_9_102 VPWR VGND sg13g2_decap_8
XFILLER_9_179 VPWR VGND sg13g2_decap_8
XFILLER_5_385 VPWR VGND sg13g2_decap_8
XFILLER_3_32 VPWR VGND sg13g2_decap_8
XFILLER_17_481 VPWR VGND sg13g2_decap_8
XFILLER_24_418 VPWR VGND sg13g2_decap_8
XFILLER_9_680 VPWR VGND sg13g2_fill_2
XFILLER_27_256 VPWR VGND sg13g2_decap_8
XFILLER_10_112 VPWR VGND sg13g2_decap_8
XFILLER_11_657 VPWR VGND sg13g2_decap_8
XFILLER_23_462 VPWR VGND sg13g2_decap_8
XFILLER_10_189 VPWR VGND sg13g2_decap_8
XFILLER_12_63 VPWR VGND sg13g2_decap_8
XFILLER_7_639 VPWR VGND sg13g2_decap_8
X_081_ _081_/X _081_/A _081_/B VPWR VGND sg13g2_or2_1
XFILLER_6_105 VPWR VGND sg13g2_decap_8
XFILLER_19_713 VPWR VGND sg13g2_decap_4
XFILLER_18_234 VPWR VGND sg13g2_decap_8
XFILLER_6_694 VPWR VGND sg13g2_decap_8
XFILLER_5_182 VPWR VGND sg13g2_decap_8
XFILLER_24_248 VPWR VGND sg13g2_decap_8
XFILLER_15_259 VPWR VGND sg13g2_decap_8
XFILLER_28_532 VPWR VGND sg13g2_decap_8
X_133_ _133_/Q _136_/CLK _133_/D _075_/Y VPWR VGND sg13g2_dfrbpq_1
XFILLER_7_447 VPWR VGND sg13g2_decap_8
XFILLER_7_425 VPWR VGND sg13g2_decap_8
XFILLER_30_207 VPWR VGND sg13g2_decap_8
XFILLER_23_84 VPWR VGND sg13g2_decap_8
XFILLER_7_469 VPWR VGND sg13g2_decap_8
X_064_ _064_/Y _065_/A _065_/B VPWR VGND sg13g2_nor2_1
XFILLER_3_642 VPWR VGND sg13g2_decap_8
XFILLER_0_11 VPWR VGND sg13g2_decap_8
XFILLER_17_7 VPWR VGND sg13g2_decap_8
XFILLER_19_554 VPWR VGND sg13g2_decap_8
XFILLER_9_53 VPWR VGND sg13g2_decap_8
XFILLER_29_329 VPWR VGND sg13g2_decap_8
XFILLER_25_568 VPWR VGND sg13g2_decap_8
XFILLER_25_535 VPWR VGND sg13g2_fill_1
XFILLER_4_417 VPWR VGND sg13g2_decap_8
XFILLER_0_689 VPWR VGND sg13g2_decap_8
XFILLER_16_502 VPWR VGND sg13g2_decap_8
XFILLER_16_557 VPWR VGND sg13g2_decap_8
XFILLER_18_84 VPWR VGND sg13g2_decap_8
XFILLER_11_273 VPWR VGND sg13g2_decap_8
X_116_ _133_/D _116_/A _116_/B VPWR VGND sg13g2_xnor2_1
XFILLER_3_483 VPWR VGND sg13g2_decap_8
XFILLER_22_538 VPWR VGND sg13g2_decap_8
XFILLER_30_571 VPWR VGND sg13g2_decap_8
XFILLER_29_126 VPWR VGND sg13g2_decap_8
XFILLER_25_398 VPWR VGND sg13g2_decap_8
XFILLER_25_321 VPWR VGND sg13g2_decap_8
XFILLER_21_560 VPWR VGND sg13g2_decap_8
XFILLER_9_509 VPWR VGND sg13g2_fill_2
Xhold83 _111_/A _129_/Q VPWR VGND sg13g2_dlygate4sd3_1
XFILLER_29_693 VPWR VGND sg13g2_decap_8
XFILLER_12_582 VPWR VGND sg13g2_decap_8
XFILLER_16_354 VPWR VGND sg13g2_decap_4
XFILLER_16_398 VPWR VGND sg13g2_decap_8
XFILLER_6_98 VPWR VGND sg13g2_decap_8
XFILLER_6_21 VPWR VGND sg13g2_decap_8
XFILLER_19_192 VPWR VGND sg13g2_decap_8
XFILLER_22_357 VPWR VGND sg13g2_decap_8
XFILLER_18_608 VPWR VGND sg13g2_decap_8
XFILLER_13_313 VPWR VGND sg13g2_decap_8
XFILLER_15_63 VPWR VGND sg13g2_decap_8
XFILLER_5_589 VPWR VGND sg13g2_decap_8
XFILLER_16_151 VPWR VGND sg13g2_decap_8
XFILLER_17_685 VPWR VGND sg13g2_decap_8
XFILLER_29_490 VPWR VGND sg13g2_decap_8
XFILLER_27_438 VPWR VGND sg13g2_decap_8
XFILLER_22_154 VPWR VGND sg13g2_decap_8
XFILLER_23_688 VPWR VGND sg13g2_decap_8
XFILLER_23_611 VPWR VGND sg13g2_decap_8
XFILLER_18_405 VPWR VGND sg13g2_decap_8
XFILLER_13_121 VPWR VGND sg13g2_decap_8
XFILLER_9_158 VPWR VGND sg13g2_decap_8
XFILLER_5_364 VPWR VGND sg13g2_decap_8
XFILLER_3_11 VPWR VGND sg13g2_decap_8
XFILLER_17_460 VPWR VGND sg13g2_decap_8
XFILLER_15_419 VPWR VGND sg13g2_decap_8
XFILLER_27_235 VPWR VGND sg13g2_decap_8
XFILLER_10_168 VPWR VGND sg13g2_decap_8
XFILLER_11_636 VPWR VGND sg13g2_decap_8
XFILLER_7_618 VPWR VGND sg13g2_decap_8
X_080_ _080_/Y _081_/A _081_/B VPWR VGND sg13g2_nor2_1
XFILLER_12_42 VPWR VGND sg13g2_decap_8
XFILLER_18_213 VPWR VGND sg13g2_decap_8
XFILLER_6_673 VPWR VGND sg13g2_decap_8
XFILLER_5_161 VPWR VGND sg13g2_decap_8
XFILLER_24_227 VPWR VGND sg13g2_decap_8
XFILLER_28_511 VPWR VGND sg13g2_decap_8
XFILLER_15_238 VPWR VGND sg13g2_decap_8
XFILLER_28_588 VPWR VGND sg13g2_decap_8
X_063_ _065_/B _063_/A _063_/B VPWR VGND sg13g2_nor2_1
X_132_ _132_/Q _136_/CLK _132_/D _075_/Y VPWR VGND sg13g2_dfrbpq_1
XFILLER_7_404 VPWR VGND sg13g2_decap_8
XFILLER_23_63 VPWR VGND sg13g2_decap_8
XFILLER_3_698 VPWR VGND sg13g2_decap_8
XFILLER_3_621 VPWR VGND sg13g2_decap_8
XFILLER_9_32 VPWR VGND sg13g2_decap_8
XFILLER_6_492 VPWR VGND sg13g2_decap_8
XFILLER_29_308 VPWR VGND sg13g2_decap_8
XFILLER_25_547 VPWR VGND sg13g2_decap_8
XFILLER_21_720 VPWR VGND sg13g2_fill_2
XFILLER_18_63 VPWR VGND sg13g2_decap_8
XFILLER_16_536 VPWR VGND sg13g2_decap_8
XFILLER_28_385 VPWR VGND sg13g2_decap_8
XFILLER_24_580 VPWR VGND sg13g2_decap_8
XFILLER_11_252 VPWR VGND sg13g2_decap_8
X_115_ _132_/D _115_/A _115_/B VPWR VGND sg13g2_xnor2_1
XFILLER_7_256 VPWR VGND sg13g2_decap_8
XFILLER_7_223 VPWR VGND sg13g2_fill_1
XFILLER_3_462 VPWR VGND sg13g2_decap_8
XFILLER_19_385 VPWR VGND sg13g2_decap_8
XFILLER_30_550 VPWR VGND sg13g2_decap_8
XFILLER_29_105 VPWR VGND sg13g2_decap_8
XFILLER_25_300 VPWR VGND sg13g2_decap_8
XFILLER_25_377 VPWR VGND sg13g2_decap_8
XFILLER_5_716 VPWR VGND sg13g2_decap_8
XFILLER_16_333 VPWR VGND sg13g2_decap_8
Xhold95 _115_/B _134_/Q VPWR VGND sg13g2_dlygate4sd3_1
XFILLER_29_84 VPWR VGND sg13g2_decap_8
XFILLER_29_672 VPWR VGND sg13g2_decap_8
XFILLER_28_182 VPWR VGND sg13g2_decap_8
XFILLER_12_561 VPWR VGND sg13g2_decap_8
XFILLER_6_77 VPWR VGND sg13g2_decap_8
XFILLER_3_270 VPWR VGND sg13g2_decap_8
Xclk_lane.arm.u_xor clk_lane.arm.u_xor/X clk_lane.arm.u_xor/A clk_lane.arm.u_xor/B
+ VPWR VGND sg13g2_xor2_1
XFILLER_19_171 VPWR VGND sg13g2_decap_8
XFILLER_22_336 VPWR VGND sg13g2_decap_8
Xclk_lane.lp.f11.tempo_64 clk_lane.lp.f11.tempo_64/L_HI VPWR VGND sg13g2_tiehi
XFILLER_17_119 VPWR VGND sg13g2_decap_8
XFILLER_13_369 VPWR VGND sg13g2_decap_8
XFILLER_15_42 VPWR VGND sg13g2_decap_8
XFILLER_25_185 VPWR VGND sg13g2_decap_8
Xoutput30 stop[3] _190_/X VPWR VGND sg13g2_buf_1
XFILLER_5_568 VPWR VGND sg13g2_decap_8
XFILLER_16_130 VPWR VGND sg13g2_decap_8
XFILLER_17_664 VPWR VGND sg13g2_decap_8
XFILLER_12_391 VPWR VGND sg13g2_decap_8
.ends
