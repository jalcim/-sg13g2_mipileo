* NGSPICE file created from dphy_tx.ext - technology: ihp-sg13g2

* Black-box entry subcircuit for sg13g2_decap_8 abstract view
.subckt sg13g2_decap_8 VDD VSS
.ends

* Black-box entry subcircuit for sg13g2_fill_2 abstract view
.subckt sg13g2_fill_2 VDD VSS
.ends

* Black-box entry subcircuit for sg13g2_nand2b_1 abstract view
.subckt sg13g2_nand2b_1 Y A_N B VDD VSS
.ends

* Black-box entry subcircuit for sg13g2_inv_1 abstract view
.subckt sg13g2_inv_1 Y A VDD VSS
.ends

* Black-box entry subcircuit for sg13g2_fill_1 abstract view
.subckt sg13g2_fill_1 VDD VSS
.ends

* Black-box entry subcircuit for sg13g2_buf_8 abstract view
.subckt sg13g2_buf_8 X A VDD VSS
.ends

* Black-box entry subcircuit for sg13g2_tielo abstract view
.subckt sg13g2_tielo L_LO VDD VSS
.ends

* Black-box entry subcircuit for sg13g2_dfrbpq_1 abstract view
.subckt sg13g2_dfrbpq_1 Q CLK D RESET_B VDD VSS
.ends

* Black-box entry subcircuit for tempo_t80n abstract view
.subckt tempo_t80n VDD VSS RESET ARM INGRESS PG PROGRESS
.ends

* Black-box entry subcircuit for sg13g2_dlygate4sd3_1 abstract view
.subckt sg13g2_dlygate4sd3_1 X A VDD VSS
.ends

* Black-box entry subcircuit for sg13g2_buf_1 abstract view
.subckt sg13g2_buf_1 X A VDD VSS
.ends

* Black-box entry subcircuit for sg13g2_buf_16 abstract view
.subckt sg13g2_buf_16 X A VDD VSS
.ends

* Black-box entry subcircuit for sg13g2_xnor2_1 abstract view
.subckt sg13g2_xnor2_1 Y A B VDD VSS
.ends

* Black-box entry subcircuit for tempo_t60n abstract view
.subckt tempo_t60n VDD VSS RESET ARM INGRESS PG PROGRESS
.ends

* Black-box entry subcircuit for sg13g2_nand3b_1 abstract view
.subckt sg13g2_nand3b_1 Y A_N B C VDD VSS
.ends

* Black-box entry subcircuit for sg13g2_decap_4 abstract view
.subckt sg13g2_decap_4 VDD VSS
.ends

* Black-box entry subcircuit for sg13g2_a22oi_1 abstract view
.subckt sg13g2_a22oi_1 Y A1 A2 B1 B2 VDD VSS
.ends

* Black-box entry subcircuit for sg13g2_o21ai_1 abstract view
.subckt sg13g2_o21ai_1 Y A1 A2 B1 VDD VSS
.ends

* Black-box entry subcircuit for tempo_t150n abstract view
.subckt tempo_t150n VDD VSS RESET ARM INGRESS PG PROGRESS
.ends

* Black-box entry subcircuit for sg13g2_a21o_1 abstract view
.subckt sg13g2_a21o_1 X A1 A2 B1 VDD VSS
.ends

* Black-box entry subcircuit for sg13g2_nand2_1 abstract view
.subckt sg13g2_nand2_1 Y A B VDD VSS
.ends

* Black-box entry subcircuit for sg13g2_nor3_1 abstract view
.subckt sg13g2_nor3_1 Y A B C VDD VSS
.ends

* Black-box entry subcircuit for sg13g2_or4_1 abstract view
.subckt sg13g2_or4_1 X A B C D VDD VSS
.ends

* Black-box entry subcircuit for sg13g2_or2_1 abstract view
.subckt sg13g2_or2_1 X A B VDD VSS
.ends

* Black-box entry subcircuit for tempo_t350n abstract view
.subckt tempo_t350n VDD VSS RESET ARM INGRESS PG PROGRESS
.ends

.subckt dphy_tx PG VGND VPWR clk clk_hs_oe clk_lp_n clk_lp_p clk_ready clk_request
+ clk_run hs_oe[0] hs_oe[1] hs_oe[2] hs_oe[3] hs_sync[0] hs_sync[1] hs_sync[2] hs_sync[3]
+ hs_trail[0] hs_trail[1] hs_trail[2] hs_trail[3] lp_n[0] lp_n[1] lp_n[2] lp_n[3]
+ lp_p[0] lp_p[1] lp_p[2] lp_p[3] rst tx_ready_hs[0] tx_ready_hs[1] tx_ready_hs[2]
+ tx_ready_hs[3] tx_request_hs[0] tx_request_hs[1] tx_request_hs[2] tx_request_hs[3]
XFILLER_10_306 VPWR VGND sg13g2_decap_8
XFILLER_22_199 VPWR VGND sg13g2_fill_2
XFILLER_22_100 VPWR VGND sg13g2_decap_8
XFILLER_13_100 VPWR VGND sg13g2_decap_8
X_501_ _501_/Y _503_/B _650_/Q VPWR VGND sg13g2_nand2b_1
X_432_ _432_/Y _778_/A VPWR VGND sg13g2_inv_1
XFILLER_13_199 VPWR VGND sg13g2_fill_2
XFILLER_9_148 VPWR VGND sg13g2_decap_8
XFILLER_5_398 VPWR VGND sg13g2_decap_8
XFILLER_5_332 VPWR VGND sg13g2_decap_8
XFILLER_1_560 VPWR VGND sg13g2_fill_2
XFILLER_27_269 VPWR VGND sg13g2_decap_8
XFILLER_23_431 VPWR VGND sg13g2_fill_2
XFILLER_6_107 VPWR VGND sg13g2_decap_8
X_415_ _415_/Y _688_/Q VPWR VGND sg13g2_inv_1
XFILLER_17_280 VPWR VGND sg13g2_fill_1
Xclkbuf_4_12_0_clk clkbuf_4_12_0_clk/X clkbuf_0_clk/X VPWR VGND sg13g2_buf_8
Xlane2.t_exit.tempo_68 lane2.t_exit.tempo/ARM VPWR VGND sg13g2_tielo
XFILLER_28_501 VPWR VGND sg13g2_decap_8
XFILLER_7_405 VPWR VGND sg13g2_decap_8
XFILLER_23_86 VPWR VGND sg13g2_decap_8
XFILLER_23_42 VPWR VGND sg13g2_fill_2
XFILLER_0_46 VPWR VGND sg13g2_decap_8
XFILLER_29_0 VPWR VGND sg13g2_decap_8
XFILLER_4_419 VPWR VGND sg13g2_decap_8
X_680_ _681_/D _685_/CLK _680_/D _776_/A VPWR VGND sg13g2_dfrbpq_1
XFILLER_28_320 VPWR VGND sg13g2_decap_8
XFILLER_18_86 VPWR VGND sg13g2_decap_8
XFILLER_11_242 VPWR VGND sg13g2_decap_8
XFILLER_24_570 VPWR VGND sg13g2_fill_1
XFILLER_7_235 VPWR VGND sg13g2_decap_8
XFILLER_22_7 VPWR VGND sg13g2_decap_8
XFILLER_19_320 VPWR VGND sg13g2_decap_8
XFILLER_25_334 VPWR VGND sg13g2_decap_8
XFILLER_4_249 VPWR VGND sg13g2_decap_8
XFILLER_4_205 VPWR VGND sg13g2_fill_1
X_732_ _732_/Q _732_/CLK _732_/D _495_/D VPWR VGND sg13g2_dfrbpq_1
Xlane3.t_lpx.tempo VPWR VGND _516_/B lane3.t_lpx.tempo/ARM _650_/Q fanout50/X _503_/B
+ tempo_t80n
XFILLER_29_63 VPWR VGND sg13g2_decap_8
XFILLER_16_334 VPWR VGND sg13g2_decap_8
X_594_ _594_/Y _611_/A VPWR VGND sg13g2_inv_1
X_663_ _663_/Q _713_/CLK _663_/D _669_/Q VPWR VGND sg13g2_dfrbpq_1
Xhold96 _637_/D _636_/Q VPWR VGND sg13g2_dlygate4sd3_1
Xhold85 _640_/D _639_/Q VPWR VGND sg13g2_dlygate4sd3_1
XFILLER_28_161 VPWR VGND sg13g2_decap_8
XFILLER_12_562 VPWR VGND sg13g2_fill_1
Xclk_lane.t_lpx.tempo_53 clk_lane.t_lpx.tempo/ARM VPWR VGND sg13g2_tielo
Xlane1.t_lpx.tempo_64 lane1.t_lpx.tempo/ARM VPWR VGND sg13g2_tielo
XFILLER_19_150 VPWR VGND sg13g2_decap_8
XFILLER_22_348 VPWR VGND sg13g2_decap_8
XFILLER_13_304 VPWR VGND sg13g2_decap_8
XFILLER_25_164 VPWR VGND sg13g2_decap_8
Xoutput7 clk_hs_oe _530_/Y VPWR VGND sg13g2_buf_1
Xoutput31 lp_p[3] _790_/X VPWR VGND sg13g2_buf_1
Xoutput20 hs_trail[0] _779_/X VPWR VGND sg13g2_buf_1
XFILLER_5_569 VPWR VGND sg13g2_fill_2
X_715_ _715_/Q _721_/CLK _715_/D _529_/A VPWR VGND sg13g2_dfrbpq_1
XFILLER_16_164 VPWR VGND sg13g2_decap_8
X_577_ _735_/D _735_/Q _577_/B VPWR VGND sg13g2_nand2b_1
X_646_ _794_/A _648_/CLK _646_/D _594_/Y VPWR VGND sg13g2_dfrbpq_1
XFILLER_29_492 VPWR VGND sg13g2_decap_8
Xclkbuf_5_17__f_clk _744_/CLK clkbuf_4_8_0_clk/X VPWR VGND sg13g2_buf_16
Xclk_lane.t_exit.tempo_52 clk_lane.t_exit.tempo/ARM VPWR VGND sg13g2_tielo
XFILLER_22_178 VPWR VGND sg13g2_decap_8
X_500_ _652_/D _654_/D _654_/Q VPWR VGND sg13g2_xnor2_1
Xlane0.t_zero.tempo_62 lane0.t_zero.tempo/ARM VPWR VGND sg13g2_tielo
X_431_ _431_/Y _648_/Q VPWR VGND sg13g2_inv_1
XFILLER_13_178 VPWR VGND sg13g2_decap_8
XFILLER_5_311 VPWR VGND sg13g2_decap_8
XFILLER_3_79 VPWR VGND sg13g2_decap_8
X_629_ _629_/Y _630_/A VPWR VGND sg13g2_inv_1
XFILLER_27_248 VPWR VGND sg13g2_decap_8
XFILLER_23_410 VPWR VGND sg13g2_decap_8
Xlane3.t_exit.tempo_73 lane3.t_exit.tempo/ARM VPWR VGND sg13g2_tielo
X_414_ _414_/Y _689_/Q VPWR VGND sg13g2_inv_1
XFILLER_5_185 VPWR VGND sg13g2_decap_8
XFILLER_11_424 VPWR VGND sg13g2_decap_8
XFILLER_23_21 VPWR VGND sg13g2_decap_8
XFILLER_0_25 VPWR VGND sg13g2_decap_8
XFILLER_6_483 VPWR VGND sg13g2_decap_8
XFILLER_25_538 VPWR VGND sg13g2_decap_8
Xlane2.t_lpx.tempo VPWR VGND _494_/B lane2.t_lpx.tempo/ARM _670_/Q fanout50/X _481_/B
+ tempo_t80n
XFILLER_11_210 VPWR VGND sg13g2_fill_1
XFILLER_3_497 VPWR VGND sg13g2_decap_8
Xclkbuf_4_11_0_clk clkbuf_4_11_0_clk/X clkbuf_0_clk/X VPWR VGND sg13g2_buf_8
XFILLER_19_398 VPWR VGND sg13g2_decap_8
Xlane2.t_trail.tempo_71 lane2.t_trail.tempo/ARM VPWR VGND sg13g2_tielo
XFILLER_25_313 VPWR VGND sg13g2_decap_8
XFILLER_4_228 VPWR VGND sg13g2_decap_8
X_662_ _662_/Q _670_/CLK _662_/D _669_/Q VPWR VGND sg13g2_dfrbpq_1
X_731_ _731_/Q _731_/CLK _731_/D _668_/Q VPWR VGND sg13g2_dfrbpq_1
Xhold97 _660_/D _659_/Q VPWR VGND sg13g2_dlygate4sd3_1
Xhold86 _696_/D _695_/Q VPWR VGND sg13g2_dlygate4sd3_1
XFILLER_29_42 VPWR VGND sg13g2_decap_8
XFILLER_28_140 VPWR VGND sg13g2_decap_8
XFILLER_16_313 VPWR VGND sg13g2_decap_8
XFILLER_16_379 VPWR VGND sg13g2_fill_2
X_593_ _593_/Y _603_/A VPWR VGND sg13g2_inv_1
XFILLER_6_79 VPWR VGND sg13g2_decap_8
XFILLER_30_382 VPWR VGND sg13g2_decap_8
XFILLER_22_327 VPWR VGND sg13g2_decap_8
XFILLER_5_504 VPWR VGND sg13g2_decap_8
Xoutput8 clk_lp_n _528_/Y VPWR VGND sg13g2_buf_1
Xoutput32 tx_ready_hs[0] _791_/X VPWR VGND sg13g2_buf_1
Xoutput21 hs_trail[1] _780_/X VPWR VGND sg13g2_buf_1
Xoutput10 clk_ready _722_/Q VPWR VGND sg13g2_buf_1
X_645_ _782_/A _729_/CLK _645_/D _593_/Y VPWR VGND sg13g2_dfrbpq_1
X_714_ _715_/D _721_/CLK _714_/D _529_/A VPWR VGND sg13g2_dfrbpq_1
XFILLER_29_471 VPWR VGND sg13g2_decap_8
Xlane0.t_prep.tempo VPWR VGND _444_/Y lane0.t_prep.tempo/ARM _742_/Q fanout48/X _549_/B
+ tempo_t60n
X_576_ _577_/B _674_/D _674_/Q _672_/Q VPWR VGND sg13g2_nand3b_1
XFILLER_22_157 VPWR VGND sg13g2_decap_8
Xclkbuf_5_23__f_clk _718_/CLK clkbuf_4_11_0_clk/X VPWR VGND sg13g2_buf_16
XFILLER_18_419 VPWR VGND sg13g2_decap_8
XFILLER_13_146 VPWR VGND sg13g2_fill_1
XFILLER_13_157 VPWR VGND sg13g2_decap_8
X_430_ _430_/Y _649_/Q VPWR VGND sg13g2_inv_1
XFILLER_3_25 VPWR VGND sg13g2_decap_4
XFILLER_1_562 VPWR VGND sg13g2_fill_1
XFILLER_17_430 VPWR VGND sg13g2_fill_2
X_628_ _628_/Y _630_/A VPWR VGND sg13g2_inv_1
X_559_ _651_/D _427_/Y _428_/Y _644_/Q _559_/B2 VPWR VGND sg13g2_a22oi_1
XFILLER_27_227 VPWR VGND sg13g2_decap_8
XFILLER_10_105 VPWR VGND sg13g2_decap_8
X_413_ _472_/B _690_/Q VPWR VGND sg13g2_inv_1
XFILLER_18_249 VPWR VGND sg13g2_decap_8
XFILLER_5_164 VPWR VGND sg13g2_decap_8
Xlane1.t_lpx.tempo VPWR VGND _472_/B lane1.t_lpx.tempo/ARM _690_/Q fanout48/X _459_/B
+ tempo_t80n
XFILLER_9_481 VPWR VGND sg13g2_fill_1
XFILLER_28_536 VPWR VGND sg13g2_decap_8
XFILLER_11_403 VPWR VGND sg13g2_decap_8
XFILLER_23_44 VPWR VGND sg13g2_fill_1
XFILLER_23_263 VPWR VGND sg13g2_decap_8
XFILLER_9_79 VPWR VGND sg13g2_decap_8
XFILLER_6_462 VPWR VGND sg13g2_decap_8
XFILLER_25_517 VPWR VGND sg13g2_decap_8
XFILLER_3_476 VPWR VGND sg13g2_decap_8
XFILLER_1_0 VPWR VGND sg13g2_decap_8
XFILLER_19_355 VPWR VGND sg13g2_fill_2
XFILLER_6_270 VPWR VGND sg13g2_decap_8
XFILLER_29_119 VPWR VGND sg13g2_decap_4
Xclkbuf_5_4__f_clk _738_/CLK clkbuf_4_2_0_clk/X VPWR VGND sg13g2_buf_16
X_592_ _744_/D _541_/X _591_/Y _446_/Y VPWR VGND sg13g2_o21ai_1
X_661_ _661_/Q _661_/CLK _661_/D _777_/A VPWR VGND sg13g2_dfrbpq_1
X_730_ _730_/Q _730_/CLK _730_/D _649_/Q VPWR VGND sg13g2_dfrbpq_1
Xhold98 _698_/D _697_/Q VPWR VGND sg13g2_dlygate4sd3_1
Xhold87 _703_/D _702_/Q VPWR VGND sg13g2_dlygate4sd3_1
XFILLER_29_98 VPWR VGND sg13g2_decap_8
XFILLER_29_21 VPWR VGND sg13g2_decap_8
XFILLER_12_542 VPWR VGND sg13g2_decap_4
XFILLER_28_196 VPWR VGND sg13g2_fill_2
XFILLER_24_391 VPWR VGND sg13g2_decap_8
XFILLER_22_306 VPWR VGND sg13g2_decap_8
XFILLER_19_185 VPWR VGND sg13g2_decap_8
XFILLER_15_391 VPWR VGND sg13g2_decap_8
XFILLER_13_339 VPWR VGND sg13g2_decap_8
XFILLER_25_199 VPWR VGND sg13g2_decap_8
XFILLER_25_100 VPWR VGND sg13g2_decap_8
Xclkbuf_4_10_0_clk clkbuf_4_10_0_clk/X clkbuf_0_clk/X VPWR VGND sg13g2_buf_8
Xoutput9 clk_lp_p _527_/Y VPWR VGND sg13g2_buf_1
Xoutput33 tx_ready_hs[1] _792_/X VPWR VGND sg13g2_buf_1
Xoutput22 hs_trail[2] _781_/X VPWR VGND sg13g2_buf_1
Xoutput11 clk_run _529_/X VPWR VGND sg13g2_buf_1
XFILLER_16_100 VPWR VGND sg13g2_decap_8
X_644_ _644_/Q _729_/CLK _644_/D _445_/Y VPWR VGND sg13g2_dfrbpq_1
X_713_ _713_/Q _713_/CLK _713_/D _723_/Q VPWR VGND sg13g2_dfrbpq_1
X_575_ _734_/D _734_/Q _575_/B VPWR VGND sg13g2_nand2b_1
XFILLER_29_450 VPWR VGND sg13g2_decap_8
XFILLER_12_372 VPWR VGND sg13g2_fill_2
XFILLER_27_409 VPWR VGND sg13g2_decap_8
XFILLER_22_114 VPWR VGND sg13g2_decap_8
XFILLER_13_114 VPWR VGND sg13g2_decap_8
XFILLER_9_107 VPWR VGND sg13g2_decap_8
XFILLER_5_346 VPWR VGND sg13g2_decap_8
XFILLER_1_552 VPWR VGND sg13g2_fill_2
X_627_ _627_/Y _630_/A VPWR VGND sg13g2_inv_1
X_558_ _671_/D _419_/Y _420_/Y _664_/Q _558_/B2 VPWR VGND sg13g2_a22oi_1
Xlane0.t_lpx.tempo VPWR VGND _450_/B lane0.t_lpx.tempo/ARM _710_/Q fanout48/X _547_/B
+ tempo_t80n
X_489_ _489_/Y _419_/A _793_/A VPWR VGND sg13g2_nand2b_1
XFILLER_12_79 VPWR VGND sg13g2_decap_8
XFILLER_5_7 VPWR VGND sg13g2_decap_4
X_412_ _412_/Y _691_/Q VPWR VGND sg13g2_inv_1
XFILLER_18_228 VPWR VGND sg13g2_decap_8
XFILLER_5_121 VPWR VGND sg13g2_fill_2
Xclk_lane.t_prep.tempo VPWR VGND _442_/Y clk_lane.t_prep.tempo/ARM _724_/Q fanout48/X
+ _535_/B tempo_t60n
XFILLER_28_515 VPWR VGND sg13g2_decap_8
XFILLER_7_419 VPWR VGND sg13g2_decap_8
XFILLER_23_242 VPWR VGND sg13g2_decap_8
XFILLER_3_4 VPWR VGND sg13g2_decap_8
XFILLER_9_25 VPWR VGND sg13g2_fill_1
XFILLER_28_334 VPWR VGND sg13g2_decap_8
XFILLER_28_389 VPWR VGND sg13g2_decap_8
XFILLER_11_256 VPWR VGND sg13g2_decap_8
XFILLER_7_249 VPWR VGND sg13g2_decap_8
XFILLER_19_334 VPWR VGND sg13g2_decap_8
XFILLER_30_543 VPWR VGND sg13g2_decap_8
XFILLER_25_348 VPWR VGND sg13g2_decap_8
XFILLER_16_348 VPWR VGND sg13g2_decap_8
X_591_ _591_/Y _715_/Q _715_/D _717_/Q VPWR VGND sg13g2_nand3b_1
X_660_ _661_/D _728_/CLK _660_/D _777_/A VPWR VGND sg13g2_dfrbpq_1
Xhold99 _653_/D _652_/Q VPWR VGND sg13g2_dlygate4sd3_1
Xhold88 _676_/D _675_/Q VPWR VGND sg13g2_dlygate4sd3_1
XFILLER_29_77 VPWR VGND sg13g2_decap_8
XFILLER_28_175 VPWR VGND sg13g2_decap_8
XFILLER_3_263 VPWR VGND sg13g2_decap_8
X_789_ _789_/X _789_/A VPWR VGND sg13g2_buf_1
XFILLER_19_164 VPWR VGND sg13g2_decap_8
XFILLER_13_318 VPWR VGND sg13g2_decap_8
XFILLER_15_79 VPWR VGND sg13g2_decap_8
XFILLER_25_178 VPWR VGND sg13g2_decap_8
Xoutput34 tx_ready_hs[2] _793_/X VPWR VGND sg13g2_buf_1
Xoutput23 hs_trail[3] _782_/X VPWR VGND sg13g2_buf_1
Xoutput12 hs_oe[0] _771_/X VPWR VGND sg13g2_buf_1
XFILLER_21_384 VPWR VGND sg13g2_decap_8
X_712_ _712_/Q _738_/CLK _712_/D _723_/Q VPWR VGND sg13g2_dfrbpq_1
XFILLER_29_440 VPWR VGND sg13g2_decap_4
XFILLER_16_178 VPWR VGND sg13g2_decap_8
X_643_ _643_/Q _647_/CLK _643_/D _649_/Q VPWR VGND sg13g2_dfrbpq_1
X_574_ _733_/D _733_/Q _574_/B VPWR VGND sg13g2_nand2b_1
XFILLER_12_384 VPWR VGND sg13g2_decap_8
XFILLER_21_192 VPWR VGND sg13g2_decap_8
XFILLER_5_325 VPWR VGND sg13g2_decap_8
XFILLER_17_432 VPWR VGND sg13g2_fill_1
X_626_ _626_/Y _631_/A VPWR VGND sg13g2_inv_1
X_557_ _691_/D _411_/Y _412_/Y _684_/Q _557_/B2 VPWR VGND sg13g2_a22oi_1
X_488_ _666_/D _488_/A VPWR VGND sg13g2_inv_1
XFILLER_12_192 VPWR VGND sg13g2_decap_8
XFILLER_4_391 VPWR VGND sg13g2_decap_8
XFILLER_27_207 VPWR VGND sg13g2_decap_4
XFILLER_23_424 VPWR VGND sg13g2_decap_8
X_411_ _411_/Y _411_/A VPWR VGND sg13g2_inv_1
XFILLER_5_100 VPWR VGND sg13g2_decap_8
XFILLER_5_199 VPWR VGND sg13g2_fill_2
XFILLER_17_262 VPWR VGND sg13g2_decap_8
X_609_ _609_/Y _631_/A VPWR VGND sg13g2_inv_1
XFILLER_23_79 VPWR VGND sg13g2_decap_8
XFILLER_23_35 VPWR VGND sg13g2_decap_8
XFILLER_0_39 VPWR VGND sg13g2_decap_8
XFILLER_10_482 VPWR VGND sg13g2_decap_4
XFILLER_10_493 VPWR VGND sg13g2_fill_1
XFILLER_6_497 VPWR VGND sg13g2_decap_8
XFILLER_28_313 VPWR VGND sg13g2_decap_8
XFILLER_18_79 VPWR VGND sg13g2_decap_8
XFILLER_11_235 VPWR VGND sg13g2_decap_8
XFILLER_24_552 VPWR VGND sg13g2_decap_8
Xclkload0 clkload0/Y _735_/CLK VPWR VGND sg13g2_inv_1
XFILLER_7_228 VPWR VGND sg13g2_decap_8
XFILLER_3_412 VPWR VGND sg13g2_decap_8
Xclkbuf_5_29__f_clk _675_/CLK clkbuf_4_14_0_clk/X VPWR VGND sg13g2_buf_16
XFILLER_19_313 VPWR VGND sg13g2_decap_8
XFILLER_30_522 VPWR VGND sg13g2_decap_8
XFILLER_25_327 VPWR VGND sg13g2_decap_8
XFILLER_21_522 VPWR VGND sg13g2_fill_2
XFILLER_29_56 VPWR VGND sg13g2_decap_8
XFILLER_16_327 VPWR VGND sg13g2_decap_8
X_590_ _743_/D _743_/Q _590_/B VPWR VGND sg13g2_nand2b_1
Xhold78 _697_/D _696_/Q VPWR VGND sg13g2_dlygate4sd3_1
Xhold89 _673_/D _672_/Q VPWR VGND sg13g2_dlygate4sd3_1
XFILLER_28_198 VPWR VGND sg13g2_fill_1
XFILLER_28_154 VPWR VGND sg13g2_decap_8
XFILLER_10_91 VPWR VGND sg13g2_decap_8
XFILLER_3_242 VPWR VGND sg13g2_decap_8
X_788_ _788_/X _788_/A VPWR VGND sg13g2_buf_1
XFILLER_19_121 VPWR VGND sg13g2_fill_2
XFILLER_30_396 VPWR VGND sg13g2_decap_8
Xclkbuf_5_12__f_clk _731_/CLK clkbuf_4_6_0_clk/X VPWR VGND sg13g2_buf_16
XFILLER_25_157 VPWR VGND sg13g2_decap_8
Xoutput35 tx_ready_hs[3] _794_/X VPWR VGND sg13g2_buf_1
Xoutput24 lp_n[0] _783_/X VPWR VGND sg13g2_buf_1
Xoutput13 hs_oe[1] _772_/X VPWR VGND sg13g2_buf_1
X_642_ _642_/Q _730_/CLK _642_/D _649_/Q VPWR VGND sg13g2_dfrbpq_1
X_711_ _711_/Q _744_/CLK _711_/D _623_/Y VPWR VGND sg13g2_dfrbpq_1
XFILLER_16_124 VPWR VGND sg13g2_fill_1
XFILLER_16_157 VPWR VGND sg13g2_decap_8
X_573_ _574_/B _659_/Q _661_/D _661_/Q VPWR VGND sg13g2_nand3b_1
XFILLER_29_485 VPWR VGND sg13g2_decap_8
XFILLER_24_190 VPWR VGND sg13g2_decap_8
XFILLER_12_341 VPWR VGND sg13g2_decap_8
XFILLER_15_190 VPWR VGND sg13g2_decap_8
XFILLER_30_193 VPWR VGND sg13g2_decap_4
XFILLER_5_304 VPWR VGND sg13g2_decap_8
XFILLER_21_171 VPWR VGND sg13g2_decap_8
XFILLER_1_554 VPWR VGND sg13g2_fill_1
X_625_ _625_/Y _631_/A VPWR VGND sg13g2_inv_1
XFILLER_12_171 VPWR VGND sg13g2_decap_8
X_556_ _705_/D _410_/Y _447_/B _555_/Y VPWR VGND sg13g2_o21ai_1
X_487_ _488_/A _777_/A _733_/Q _793_/A _419_/A VPWR VGND sg13g2_a22oi_1
XFILLER_23_403 VPWR VGND sg13g2_decap_8
XFILLER_10_119 VPWR VGND sg13g2_decap_4
X_410_ _410_/Y _451_/D VPWR VGND sg13g2_inv_1
XFILLER_5_178 VPWR VGND sg13g2_decap_8
XFILLER_17_241 VPWR VGND sg13g2_decap_8
X_608_ _608_/Y _631_/A VPWR VGND sg13g2_inv_1
X_539_ _539_/Y _441_/A _722_/Q VPWR VGND sg13g2_nand2b_1
XFILLER_4_93 VPWR VGND sg13g2_decap_8
XFILLER_11_417 VPWR VGND sg13g2_decap_8
XFILLER_23_14 VPWR VGND sg13g2_decap_8
Xlane2.t_zero.tempo VPWR VGND _423_/Y lane2.t_zero.tempo/ARM _731_/Q fanout50/X _485_/B
+ tempo_t150n
XFILLER_0_18 VPWR VGND sg13g2_decap_8
XFILLER_6_476 VPWR VGND sg13g2_decap_8
XFILLER_9_270 VPWR VGND sg13g2_decap_8
Xclkload1 clkload1/Y _708_/CLK VPWR VGND sg13g2_inv_1
XFILLER_24_531 VPWR VGND sg13g2_decap_8
XFILLER_30_501 VPWR VGND sg13g2_decap_8
XFILLER_25_306 VPWR VGND sg13g2_decap_8
XFILLER_21_501 VPWR VGND sg13g2_decap_8
XFILLER_18_391 VPWR VGND sg13g2_decap_8
Xhold79 _656_/D _655_/Q VPWR VGND sg13g2_dlygate4sd3_1
XFILLER_29_35 VPWR VGND sg13g2_decap_8
XFILLER_16_306 VPWR VGND sg13g2_decap_8
XFILLER_28_133 VPWR VGND sg13g2_decap_8
XFILLER_10_70 VPWR VGND sg13g2_decap_8
X_787_ _787_/X _787_/A VPWR VGND sg13g2_buf_1
XFILLER_19_100 VPWR VGND sg13g2_decap_8
XFILLER_30_353 VPWR VGND sg13g2_fill_2
XFILLER_25_114 VPWR VGND sg13g2_decap_8
XFILLER_21_375 VPWR VGND sg13g2_fill_2
XFILLER_21_353 VPWR VGND sg13g2_fill_2
XFILLER_21_342 VPWR VGND sg13g2_decap_8
Xoutput25 lp_n[1] _784_/X VPWR VGND sg13g2_buf_1
Xoutput14 hs_oe[2] _773_/X VPWR VGND sg13g2_buf_1
XFILLER_16_114 VPWR VGND sg13g2_decap_8
X_641_ _641_/Q _733_/CLK _641_/D _778_/A VPWR VGND sg13g2_dfrbpq_1
X_710_ _710_/Q _743_/CLK _710_/D _622_/Y VPWR VGND sg13g2_dfrbpq_1
X_572_ _732_/D _657_/D _571_/Y _732_/Q VPWR VGND sg13g2_a21o_1
XFILLER_29_464 VPWR VGND sg13g2_decap_8
XFILLER_12_320 VPWR VGND sg13g2_decap_8
XFILLER_30_172 VPWR VGND sg13g2_decap_8
XFILLER_22_139 VPWR VGND sg13g2_fill_2
XFILLER_7_93 VPWR VGND sg13g2_decap_8
XFILLER_21_150 VPWR VGND sg13g2_decap_8
XFILLER_3_29 VPWR VGND sg13g2_fill_2
XFILLER_3_18 VPWR VGND sg13g2_decap_8
XFILLER_17_423 VPWR VGND sg13g2_decap_8
X_624_ _624_/Y _631_/A VPWR VGND sg13g2_inv_1
X_555_ _555_/Y _443_/A _791_/A VPWR VGND sg13g2_nand2b_1
XFILLER_29_294 VPWR VGND sg13g2_fill_2
XFILLER_29_261 VPWR VGND sg13g2_decap_8
XFILLER_12_150 VPWR VGND sg13g2_decap_8
X_486_ _667_/D _424_/Y _733_/Q _485_/Y VPWR VGND sg13g2_o21ai_1
XFILLER_5_157 VPWR VGND sg13g2_decap_8
X_607_ _607_/Y _607_/A VPWR VGND sg13g2_inv_1
X_538_ _722_/D _538_/A VPWR VGND sg13g2_inv_1
X_469_ _469_/Y _473_/D _469_/B VPWR VGND sg13g2_nand2_1
XFILLER_4_72 VPWR VGND sg13g2_decap_8
XFILLER_28_529 VPWR VGND sg13g2_decap_8
XFILLER_23_256 VPWR VGND sg13g2_decap_8
XFILLER_27_562 VPWR VGND sg13g2_decap_4
XFILLER_6_433 VPWR VGND sg13g2_fill_2
XFILLER_28_348 VPWR VGND sg13g2_decap_8
XFILLER_24_510 VPWR VGND sg13g2_decap_8
Xclkload2 clkload2/Y _741_/CLK VPWR VGND sg13g2_inv_1
XFILLER_3_469 VPWR VGND sg13g2_decap_8
XFILLER_19_348 VPWR VGND sg13g2_decap_8
XFILLER_27_381 VPWR VGND sg13g2_decap_8
XFILLER_10_270 VPWR VGND sg13g2_decap_8
XFILLER_6_263 VPWR VGND sg13g2_decap_8
XFILLER_30_557 VPWR VGND sg13g2_decap_4
XFILLER_29_14 VPWR VGND sg13g2_decap_8
XFILLER_28_112 VPWR VGND sg13g2_decap_8
XFILLER_12_535 VPWR VGND sg13g2_decap_8
XFILLER_12_546 VPWR VGND sg13g2_fill_2
XFILLER_28_189 VPWR VGND sg13g2_decap_8
XFILLER_24_384 VPWR VGND sg13g2_decap_8
XFILLER_3_277 VPWR VGND sg13g2_fill_2
X_786_ _786_/X _786_/A VPWR VGND sg13g2_buf_1
XFILLER_19_178 VPWR VGND sg13g2_decap_8
XFILLER_15_384 VPWR VGND sg13g2_decap_8
XFILLER_30_332 VPWR VGND sg13g2_decap_8
XFILLER_25_0 VPWR VGND sg13g2_decap_8
XFILLER_21_321 VPWR VGND sg13g2_decap_8
XFILLER_21_398 VPWR VGND sg13g2_decap_8
Xoutput26 lp_n[2] _785_/X VPWR VGND sg13g2_buf_1
Xoutput15 hs_oe[3] _774_/X VPWR VGND sg13g2_buf_1
X_640_ _640_/Q _648_/CLK _640_/D _778_/A VPWR VGND sg13g2_dfrbpq_1
X_571_ _571_/Y _658_/D _658_/Q _655_/Q VPWR VGND sg13g2_nor3_1
XFILLER_12_398 VPWR VGND sg13g2_decap_8
XFILLER_4_520 VPWR VGND sg13g2_decap_8
XFILLER_22_107 VPWR VGND sg13g2_decap_8
XFILLER_7_72 VPWR VGND sg13g2_decap_8
XFILLER_30_151 VPWR VGND sg13g2_decap_8
XFILLER_7_391 VPWR VGND sg13g2_decap_8
XFILLER_13_107 VPWR VGND sg13g2_decap_8
XFILLER_5_339 VPWR VGND sg13g2_decap_8
XFILLER_1_545 VPWR VGND sg13g2_decap_8
XFILLER_17_402 VPWR VGND sg13g2_decap_8
X_623_ _623_/Y _631_/A VPWR VGND sg13g2_inv_1
X_554_ _706_/D _554_/A VPWR VGND sg13g2_inv_1
X_485_ _485_/Y _668_/Q _485_/B VPWR VGND sg13g2_nand2_1
XFILLER_29_240 VPWR VGND sg13g2_decap_8
Xhold100 _641_/D _640_/Q VPWR VGND sg13g2_dlygate4sd3_1
XFILLER_5_114 VPWR VGND sg13g2_decap_8
XFILLER_17_221 VPWR VGND sg13g2_fill_2
XFILLER_17_276 VPWR VGND sg13g2_fill_1
X_606_ _606_/Y _611_/A VPWR VGND sg13g2_inv_1
X_537_ _538_/A _722_/Q _441_/A _537_/B1 _723_/Q VPWR VGND sg13g2_a22oi_1
X_468_ _685_/D _417_/Y _469_/B _467_/Y VPWR VGND sg13g2_o21ai_1
XFILLER_4_191 VPWR VGND sg13g2_decap_8
Xlane1.t_prep.tempo_65 lane1.t_prep.tempo/ARM VPWR VGND sg13g2_tielo
XFILLER_28_508 VPWR VGND sg13g2_decap_8
Xclkbuf_5_18__f_clk _699_/CLK clkbuf_4_9_0_clk/X VPWR VGND sg13g2_buf_16
XFILLER_23_235 VPWR VGND sg13g2_decap_8
XFILLER_27_541 VPWR VGND sg13g2_decap_8
XFILLER_13_93 VPWR VGND sg13g2_decap_8
Xfanout50 fanout50/X fanout51/X VPWR VGND sg13g2_buf_1
XFILLER_6_412 VPWR VGND sg13g2_decap_8
XFILLER_29_7 VPWR VGND sg13g2_decap_8
XFILLER_28_327 VPWR VGND sg13g2_decap_8
XFILLER_24_566 VPWR VGND sg13g2_decap_4
XFILLER_11_249 VPWR VGND sg13g2_decap_8
Xclkload3 clkload3/Y _734_/CLK VPWR VGND sg13g2_inv_1
XFILLER_3_426 VPWR VGND sg13g2_decap_8
XFILLER_19_327 VPWR VGND sg13g2_decap_8
XFILLER_30_536 VPWR VGND sg13g2_decap_8
XFILLER_6_242 VPWR VGND sg13g2_decap_8
XFILLER_6_220 VPWR VGND sg13g2_fill_1
XFILLER_27_4 VPWR VGND sg13g2_decap_8
Xclk_lane.t_post.tempo VPWR VGND _435_/Y clk_lane.t_post.tempo/ARM _744_/Q fanout49/X
+ _523_/A tempo_t80n
XFILLER_28_168 VPWR VGND sg13g2_decap_8
XFILLER_24_341 VPWR VGND sg13g2_decap_8
XFILLER_3_256 VPWR VGND sg13g2_decap_8
X_785_ _785_/X _785_/A VPWR VGND sg13g2_buf_1
XFILLER_19_157 VPWR VGND sg13g2_decap_8
XFILLER_30_311 VPWR VGND sg13g2_decap_8
XFILLER_21_300 VPWR VGND sg13g2_decap_8
Xoutput27 lp_n[3] _786_/X VPWR VGND sg13g2_buf_1
Xoutput16 hs_sync[0] _775_/X VPWR VGND sg13g2_buf_1
X_570_ _731_/D _731_/Q _570_/B VPWR VGND sg13g2_nand2b_1
XFILLER_29_499 VPWR VGND sg13g2_decap_8
XFILLER_29_444 VPWR VGND sg13g2_fill_2
XFILLER_29_433 VPWR VGND sg13g2_decap_8
XFILLER_21_93 VPWR VGND sg13g2_decap_8
X_699_ _699_/Q _699_/CLK _699_/D _775_/A VPWR VGND sg13g2_dfrbpq_1
Xclkbuf_0_clk clkbuf_0_clk/X clk VPWR VGND sg13g2_buf_16
XFILLER_30_130 VPWR VGND sg13g2_decap_8
XFILLER_21_185 VPWR VGND sg13g2_decap_8
Xclk_lane.t_post.tempo_54 clk_lane.t_post.tempo/ARM VPWR VGND sg13g2_tielo
XFILLER_5_318 VPWR VGND sg13g2_decap_8
X_622_ _622_/Y _630_/A VPWR VGND sg13g2_inv_1
XFILLER_16_93 VPWR VGND sg13g2_decap_8
X_553_ _554_/A _791_/A _443_/A _741_/Q _775_/A VPWR VGND sg13g2_a22oi_1
X_484_ _668_/D _423_/Y _485_/B _483_/Y VPWR VGND sg13g2_o21ai_1
XFILLER_29_296 VPWR VGND sg13g2_fill_1
XFILLER_12_185 VPWR VGND sg13g2_decap_8
XFILLER_4_384 VPWR VGND sg13g2_decap_8
XFILLER_23_417 VPWR VGND sg13g2_decap_8
Xhold101 _683_/D _682_/Q VPWR VGND sg13g2_dlygate4sd3_1
Xlane2.t_prep.tempo_70 lane2.t_prep.tempo/ARM VPWR VGND sg13g2_tielo
XFILLER_17_255 VPWR VGND sg13g2_decap_8
X_605_ _605_/Y _611_/A VPWR VGND sg13g2_inv_1
XFILLER_27_81 VPWR VGND sg13g2_decap_8
X_536_ _723_/D _530_/B _537_/B1 _535_/Y VPWR VGND sg13g2_o21ai_1
X_467_ _467_/Y _411_/A _792_/A VPWR VGND sg13g2_nand2b_1
XFILLER_9_465 VPWR VGND sg13g2_decap_4
XFILLER_4_170 VPWR VGND sg13g2_decap_8
XFILLER_23_214 VPWR VGND sg13g2_fill_2
XFILLER_23_28 VPWR VGND sg13g2_decap_8
Xfanout40 _517_/D _782_/A VPWR VGND sg13g2_buf_1
Xfanout51 fanout51/X PG VPWR VGND sg13g2_buf_1
XFILLER_10_475 VPWR VGND sg13g2_decap_8
XFILLER_10_486 VPWR VGND sg13g2_fill_1
XFILLER_13_72 VPWR VGND sg13g2_decap_8
Xclkbuf_5_24__f_clk _729_/CLK clkbuf_4_12_0_clk/X VPWR VGND sg13g2_buf_16
Xclkload10 clkload10/Y _718_/CLK VPWR VGND sg13g2_inv_1
X_519_ _642_/D _642_/Q _643_/Q VPWR VGND sg13g2_xnor2_1
XFILLER_5_490 VPWR VGND sg13g2_decap_8
XFILLER_28_306 VPWR VGND sg13g2_decap_8
XFILLER_11_206 VPWR VGND sg13g2_decap_4
XFILLER_11_228 VPWR VGND sg13g2_decap_8
XFILLER_24_545 VPWR VGND sg13g2_decap_8
Xclkload4 clkload4/Y _647_/CLK VPWR VGND sg13g2_inv_1
XFILLER_3_405 VPWR VGND sg13g2_decap_8
XFILLER_19_306 VPWR VGND sg13g2_decap_8
XFILLER_30_515 VPWR VGND sg13g2_decap_8
XFILLER_24_93 VPWR VGND sg13g2_decap_8
XFILLER_1_42 VPWR VGND sg13g2_decap_8
XFILLER_21_515 VPWR VGND sg13g2_decap_8
XFILLER_29_49 VPWR VGND sg13g2_decap_8
XFILLER_28_147 VPWR VGND sg13g2_decap_8
XFILLER_24_320 VPWR VGND sg13g2_decap_8
XFILLER_3_235 VPWR VGND sg13g2_decap_8
XFILLER_3_213 VPWR VGND sg13g2_decap_4
XFILLER_10_84 VPWR VGND sg13g2_decap_8
X_784_ _784_/X _784_/A VPWR VGND sg13g2_buf_1
XFILLER_19_114 VPWR VGND sg13g2_decap_8
XFILLER_15_353 VPWR VGND sg13g2_decap_4
XFILLER_19_93 VPWR VGND sg13g2_decap_8
XFILLER_30_389 VPWR VGND sg13g2_decap_8
Xoutput28 lp_p[0] _787_/X VPWR VGND sg13g2_buf_1
Xoutput17 hs_sync[1] _776_/X VPWR VGND sg13g2_buf_1
XFILLER_29_412 VPWR VGND sg13g2_decap_8
XFILLER_29_478 VPWR VGND sg13g2_decap_8
XFILLER_12_334 VPWR VGND sg13g2_decap_8
XFILLER_24_183 VPWR VGND sg13g2_decap_8
XFILLER_21_72 VPWR VGND sg13g2_decap_8
XFILLER_15_183 VPWR VGND sg13g2_decap_8
X_698_ _698_/Q _699_/CLK _698_/D _451_/D VPWR VGND sg13g2_dfrbpq_1
XFILLER_30_197 VPWR VGND sg13g2_fill_2
XFILLER_30_186 VPWR VGND sg13g2_decap_8
XFILLER_21_164 VPWR VGND sg13g2_decap_8
X_621_ _621_/Y _630_/A VPWR VGND sg13g2_inv_1
Xclkbuf_5_5__f_clk _708_/CLK clkbuf_4_2_0_clk/X VPWR VGND sg13g2_buf_16
XFILLER_29_275 VPWR VGND sg13g2_fill_2
XFILLER_16_72 VPWR VGND sg13g2_decap_8
X_552_ _707_/D _408_/Y _741_/Q _551_/Y VPWR VGND sg13g2_o21ai_1
X_483_ _483_/Y _669_/Q _483_/B VPWR VGND sg13g2_nand2_1
XFILLER_12_164 VPWR VGND sg13g2_decap_8
XFILLER_4_341 VPWR VGND sg13g2_decap_8
Xhold102 _713_/D _712_/Q VPWR VGND sg13g2_dlygate4sd3_1
Xlane1.t_prep.tempo VPWR VGND _414_/Y lane1.t_prep.tempo/ARM _738_/Q fanout48/X _461_/B
+ tempo_t60n
XFILLER_17_223 VPWR VGND sg13g2_fill_1
XFILLER_17_234 VPWR VGND sg13g2_decap_8
X_604_ _604_/Y _611_/A VPWR VGND sg13g2_inv_1
X_535_ _535_/Y _724_/Q _535_/B VPWR VGND sg13g2_nand2_1
XFILLER_27_60 VPWR VGND sg13g2_decap_8
X_466_ _686_/D _466_/A VPWR VGND sg13g2_inv_1
XFILLER_9_422 VPWR VGND sg13g2_decap_8
XFILLER_4_86 VPWR VGND sg13g2_decap_8
XFILLER_27_521 VPWR VGND sg13g2_fill_2
Xfanout41 _630_/A _617_/A VPWR VGND sg13g2_buf_1
XFILLER_22_270 VPWR VGND sg13g2_decap_8
XFILLER_6_469 VPWR VGND sg13g2_decap_8
X_518_ _568_/B _642_/Q _643_/Q VPWR VGND sg13g2_nand2b_1
XFILLER_13_270 VPWR VGND sg13g2_decap_8
Xclkload11 clkload11/Y _685_/CLK VPWR VGND sg13g2_inv_1
X_449_ _787_/A _704_/Q _711_/Q VPWR VGND sg13g2_nand2b_1
XFILLER_9_263 VPWR VGND sg13g2_decap_8
Xclkload5 clkload5/Y _737_/CLK VPWR VGND sg13g2_inv_1
XFILLER_24_524 VPWR VGND sg13g2_decap_8
Xclkbuf_5_30__f_clk _661_/CLK clkbuf_4_15_0_clk/X VPWR VGND sg13g2_buf_16
XFILLER_1_7 VPWR VGND sg13g2_decap_8
XFILLER_27_395 VPWR VGND sg13g2_decap_8
XFILLER_27_373 VPWR VGND sg13g2_fill_2
XFILLER_24_72 VPWR VGND sg13g2_decap_8
Xlane0.t_trail.tempo_61 lane0.t_trail.tempo/ARM VPWR VGND sg13g2_tielo
XFILLER_6_277 VPWR VGND sg13g2_fill_2
XFILLER_1_21 VPWR VGND sg13g2_decap_8
XFILLER_18_384 VPWR VGND sg13g2_decap_8
XFILLER_29_28 VPWR VGND sg13g2_decap_8
XFILLER_28_126 VPWR VGND sg13g2_decap_8
XFILLER_24_398 VPWR VGND sg13g2_decap_8
X_783_ _783_/X _783_/A VPWR VGND sg13g2_buf_1
XFILLER_19_72 VPWR VGND sg13g2_decap_8
XFILLER_15_332 VPWR VGND sg13g2_decap_8
XFILLER_15_398 VPWR VGND sg13g2_decap_8
XFILLER_30_346 VPWR VGND sg13g2_decap_8
XFILLER_25_107 VPWR VGND sg13g2_decap_8
XFILLER_18_192 VPWR VGND sg13g2_decap_4
XFILLER_21_335 VPWR VGND sg13g2_decap_8
Xoutput29 lp_p[1] _788_/X VPWR VGND sg13g2_buf_1
Xoutput18 hs_sync[2] _777_/X VPWR VGND sg13g2_buf_1
XFILLER_29_457 VPWR VGND sg13g2_decap_8
XFILLER_12_313 VPWR VGND sg13g2_decap_8
XFILLER_16_107 VPWR VGND sg13g2_decap_8
XFILLER_24_162 VPWR VGND sg13g2_decap_8
XFILLER_24_140 VPWR VGND sg13g2_fill_1
XFILLER_12_379 VPWR VGND sg13g2_fill_2
XFILLER_4_534 VPWR VGND sg13g2_fill_1
X_697_ _697_/Q _718_/CLK _697_/D _451_/D VPWR VGND sg13g2_dfrbpq_1
XFILLER_15_162 VPWR VGND sg13g2_decap_8
XFILLER_30_165 VPWR VGND sg13g2_decap_8
XFILLER_7_86 VPWR VGND sg13g2_decap_8
XFILLER_23_0 VPWR VGND sg13g2_decap_8
XFILLER_21_121 VPWR VGND sg13g2_fill_2
XFILLER_17_416 VPWR VGND sg13g2_decap_8
X_620_ _620_/Y _630_/A VPWR VGND sg13g2_inv_1
X_551_ _551_/Y _708_/Q _551_/B VPWR VGND sg13g2_nand2_1
XFILLER_29_254 VPWR VGND sg13g2_decap_8
X_482_ _669_/D _422_/Y _483_/B _481_/Y VPWR VGND sg13g2_o21ai_1
XFILLER_4_320 VPWR VGND sg13g2_decap_8
XFILLER_22_496 VPWR VGND sg13g2_decap_8
X_603_ _603_/Y _603_/A VPWR VGND sg13g2_inv_1
X_534_ _724_/D _442_/Y _535_/B _533_/Y VPWR VGND sg13g2_o21ai_1
X_465_ _466_/A _776_/A _737_/Q _792_/A _411_/A VPWR VGND sg13g2_a22oi_1
XFILLER_9_401 VPWR VGND sg13g2_decap_8
XFILLER_23_249 VPWR VGND sg13g2_decap_8
XFILLER_27_566 VPWR VGND sg13g2_fill_1
XFILLER_27_555 VPWR VGND sg13g2_decap_8
XFILLER_27_500 VPWR VGND sg13g2_decap_8
Xfanout42 _619_/A _617_/A VPWR VGND sg13g2_buf_1
XFILLER_6_426 VPWR VGND sg13g2_decap_8
X_517_ _774_/A _648_/Q _778_/A _794_/A _517_/D VPWR VGND sg13g2_or4_1
X_448_ _704_/D _405_/Y _561_/A2 _447_/Y VPWR VGND sg13g2_o21ai_1
Xclkload12 clkload12/Y _728_/CLK VPWR VGND sg13g2_inv_1
XFILLER_9_242 VPWR VGND sg13g2_decap_8
XFILLER_24_503 VPWR VGND sg13g2_decap_8
Xclkload6 clkload6/Y _648_/CLK VPWR VGND sg13g2_inv_1
XFILLER_10_263 VPWR VGND sg13g2_decap_8
XFILLER_10_285 VPWR VGND sg13g2_fill_1
XFILLER_6_256 VPWR VGND sg13g2_decap_8
XFILLER_18_341 VPWR VGND sg13g2_decap_8
XFILLER_28_105 VPWR VGND sg13g2_decap_8
XFILLER_24_355 VPWR VGND sg13g2_fill_2
XFILLER_15_311 VPWR VGND sg13g2_decap_8
X_782_ _782_/X _782_/A VPWR VGND sg13g2_buf_1
XFILLER_30_325 VPWR VGND sg13g2_decap_8
XFILLER_27_193 VPWR VGND sg13g2_decap_8
XFILLER_7_565 VPWR VGND sg13g2_fill_2
XFILLER_18_171 VPWR VGND sg13g2_decap_8
XFILLER_21_314 VPWR VGND sg13g2_decap_8
Xoutput19 hs_sync[3] _778_/X VPWR VGND sg13g2_buf_1
XFILLER_4_502 VPWR VGND sg13g2_decap_8
X_696_ _696_/Q _699_/CLK _696_/D _451_/D VPWR VGND sg13g2_dfrbpq_1
XFILLER_28_480 VPWR VGND sg13g2_decap_8
XFILLER_30_144 VPWR VGND sg13g2_decap_8
XFILLER_7_384 VPWR VGND sg13g2_decap_8
XFILLER_7_362 VPWR VGND sg13g2_fill_2
XFILLER_21_100 VPWR VGND sg13g2_decap_8
XFILLER_21_199 VPWR VGND sg13g2_fill_2
XFILLER_1_538 VPWR VGND sg13g2_decap_8
X_550_ _708_/D _409_/Y _551_/B _549_/Y VPWR VGND sg13g2_o21ai_1
X_481_ _481_/Y _670_/Q _481_/B VPWR VGND sg13g2_nand2_1
XFILLER_29_233 VPWR VGND sg13g2_decap_8
XFILLER_12_100 VPWR VGND sg13g2_decap_8
XFILLER_4_398 VPWR VGND sg13g2_decap_8
X_679_ _680_/D _737_/CLK _679_/D _776_/A VPWR VGND sg13g2_dfrbpq_1
XFILLER_7_192 VPWR VGND sg13g2_decap_8
XFILLER_22_431 VPWR VGND sg13g2_fill_2
Xclkbuf_5_13__f_clk _737_/CLK clkbuf_4_6_0_clk/X VPWR VGND sg13g2_buf_16
XFILLER_5_107 VPWR VGND sg13g2_decap_8
X_602_ _602_/Y _603_/A VPWR VGND sg13g2_inv_1
XFILLER_13_431 VPWR VGND sg13g2_fill_2
XFILLER_17_269 VPWR VGND sg13g2_decap_8
X_533_ _533_/Y _725_/Q _533_/B VPWR VGND sg13g2_nand2_1
X_464_ _687_/D _416_/Y _737_/Q _463_/Y VPWR VGND sg13g2_o21ai_1
XFILLER_27_95 VPWR VGND sg13g2_decap_8
XFILLER_4_184 VPWR VGND sg13g2_decap_8
XFILLER_23_228 VPWR VGND sg13g2_decap_8
XFILLER_27_534 VPWR VGND sg13g2_decap_8
XFILLER_10_412 VPWR VGND sg13g2_decap_8
XFILLER_13_86 VPWR VGND sg13g2_decap_8
Xfanout43 _631_/A _617_/A VPWR VGND sg13g2_buf_1
XFILLER_6_405 VPWR VGND sg13g2_decap_8
X_516_ _786_/A _790_/A _516_/B VPWR VGND sg13g2_nand2b_1
X_447_ _447_/Y _451_/D _447_/B VPWR VGND sg13g2_nand2_1
Xclkload13 clkload13/Y _675_/CLK VPWR VGND sg13g2_inv_1
XFILLER_24_559 VPWR VGND sg13g2_decap_8
Xclkload7 clkload7/Y _744_/CLK VPWR VGND sg13g2_inv_1
XFILLER_3_419 VPWR VGND sg13g2_decap_8
XFILLER_27_353 VPWR VGND sg13g2_fill_2
XFILLER_30_529 VPWR VGND sg13g2_decap_8
XFILLER_27_364 VPWR VGND sg13g2_decap_4
XFILLER_23_570 VPWR VGND sg13g2_fill_1
XFILLER_10_242 VPWR VGND sg13g2_decap_8
XFILLER_6_235 VPWR VGND sg13g2_decap_8
XFILLER_18_320 VPWR VGND sg13g2_decap_8
XFILLER_24_334 VPWR VGND sg13g2_decap_8
XFILLER_24_301 VPWR VGND sg13g2_fill_1
XFILLER_10_98 VPWR VGND sg13g2_decap_8
X_781_ _781_/X _781_/A VPWR VGND sg13g2_buf_1
XFILLER_3_249 VPWR VGND sg13g2_decap_8
XFILLER_27_172 VPWR VGND sg13g2_decap_8
XFILLER_30_304 VPWR VGND sg13g2_decap_8
XFILLER_18_150 VPWR VGND sg13g2_decap_8
XFILLER_29_426 VPWR VGND sg13g2_decap_8
XFILLER_12_348 VPWR VGND sg13g2_decap_8
XFILLER_24_197 VPWR VGND sg13g2_fill_2
XFILLER_24_131 VPWR VGND sg13g2_decap_4
XFILLER_21_86 VPWR VGND sg13g2_decap_8
XFILLER_21_42 VPWR VGND sg13g2_fill_2
X_695_ _695_/Q _705_/CLK _695_/D _451_/D VPWR VGND sg13g2_dfrbpq_1
XFILLER_15_197 VPWR VGND sg13g2_fill_2
XFILLER_7_341 VPWR VGND sg13g2_decap_8
XFILLER_30_123 VPWR VGND sg13g2_decap_8
XFILLER_21_178 VPWR VGND sg13g2_decap_8
XFILLER_16_20 VPWR VGND sg13g2_fill_1
XFILLER_16_86 VPWR VGND sg13g2_decap_8
X_480_ _670_/D _419_/Y _671_/Q _479_/Y VPWR VGND sg13g2_o21ai_1
XFILLER_12_178 VPWR VGND sg13g2_decap_8
XFILLER_0_561 VPWR VGND sg13g2_decap_4
XFILLER_16_440 VPWR VGND sg13g2_fill_1
X_678_ _678_/Q _732_/CLK _678_/D _473_/D VPWR VGND sg13g2_dfrbpq_1
XFILLER_7_171 VPWR VGND sg13g2_decap_8
XFILLER_22_410 VPWR VGND sg13g2_decap_8
X_601_ _601_/Y _607_/A VPWR VGND sg13g2_inv_1
XFILLER_13_410 VPWR VGND sg13g2_decap_8
XFILLER_17_248 VPWR VGND sg13g2_decap_8
X_532_ _725_/D _726_/Q _441_/Y _531_/Y VPWR VGND sg13g2_o21ai_1
X_463_ _463_/Y _688_/Q _463_/B VPWR VGND sg13g2_nand2_1
XFILLER_27_74 VPWR VGND sg13g2_decap_8
XFILLER_25_270 VPWR VGND sg13g2_decap_8
XFILLER_4_163 VPWR VGND sg13g2_decap_8
XFILLER_16_270 VPWR VGND sg13g2_decap_8
Xfanout44 _617_/A _607_/A VPWR VGND sg13g2_buf_1
X_515_ _790_/A _644_/Q _651_/Q VPWR VGND sg13g2_nand2b_1
X_446_ _446_/Y _744_/Q VPWR VGND sg13g2_inv_1
Xclkload14 clkload14/Y _664_/CLK VPWR VGND sg13g2_inv_1
XFILLER_5_483 VPWR VGND sg13g2_decap_8
XFILLER_24_538 VPWR VGND sg13g2_decap_8
Xclkload8 clkload8/Y _705_/CLK VPWR VGND sg13g2_inv_1
XFILLER_27_332 VPWR VGND sg13g2_decap_8
XFILLER_30_508 VPWR VGND sg13g2_decap_8
XFILLER_24_86 VPWR VGND sg13g2_decap_8
XFILLER_6_0 VPWR VGND sg13g2_decap_8
XFILLER_1_35 VPWR VGND sg13g2_decap_8
XFILLER_21_508 VPWR VGND sg13g2_decap_8
XFILLER_18_398 VPWR VGND sg13g2_decap_8
X_429_ _516_/B _650_/Q VPWR VGND sg13g2_inv_1
Xlane3.t_zero.tempo VPWR VGND _431_/Y lane3.t_zero.tempo/ARM _727_/Q fanout50/X _507_/B
+ tempo_t150n
Xinput1 _441_/A clk_request VPWR VGND sg13g2_buf_1
XFILLER_24_313 VPWR VGND sg13g2_decap_8
XFILLER_3_228 VPWR VGND sg13g2_decap_8
XFILLER_3_217 VPWR VGND sg13g2_fill_2
XFILLER_3_206 VPWR VGND sg13g2_decap_8
XFILLER_10_77 VPWR VGND sg13g2_decap_8
X_780_ _780_/X _780_/A VPWR VGND sg13g2_buf_1
XFILLER_19_107 VPWR VGND sg13g2_decap_8
XFILLER_15_346 VPWR VGND sg13g2_decap_8
XFILLER_27_151 VPWR VGND sg13g2_decap_8
XFILLER_19_86 VPWR VGND sg13g2_decap_8
XFILLER_21_349 VPWR VGND sg13g2_decap_4
XFILLER_29_405 VPWR VGND sg13g2_decap_8
Xlane1.t_zero.tempo_67 lane1.t_zero.tempo/ARM VPWR VGND sg13g2_tielo
XFILLER_12_327 VPWR VGND sg13g2_decap_8
XFILLER_24_176 VPWR VGND sg13g2_decap_8
XFILLER_21_21 VPWR VGND sg13g2_decap_8
X_694_ _694_/Q _740_/CLK _694_/D _708_/Q VPWR VGND sg13g2_dfrbpq_1
XFILLER_15_176 VPWR VGND sg13g2_decap_8
Xclkbuf_5_0__f_clk _713_/CLK clkbuf_4_0_0_clk/X VPWR VGND sg13g2_buf_16
XFILLER_30_102 VPWR VGND sg13g2_decap_8
XFILLER_11_382 VPWR VGND sg13g2_decap_8
XFILLER_7_320 VPWR VGND sg13g2_decap_8
XFILLER_30_179 VPWR VGND sg13g2_decap_8
XFILLER_30_4 VPWR VGND sg13g2_decap_8
XFILLER_21_157 VPWR VGND sg13g2_decap_8
Xlane1.t_trail.tempo VPWR VGND _417_/Y lane1.t_trail.tempo/ARM _736_/Q fanout51/X
+ _469_/B tempo_t80n
XFILLER_29_268 VPWR VGND sg13g2_decap_8
XFILLER_12_146 VPWR VGND sg13g2_fill_1
XFILLER_12_157 VPWR VGND sg13g2_decap_8
XFILLER_4_334 VPWR VGND sg13g2_decap_8
XFILLER_0_540 VPWR VGND sg13g2_decap_8
X_677_ _678_/D _732_/CLK _677_/D _473_/D VPWR VGND sg13g2_dfrbpq_1
XFILLER_7_150 VPWR VGND sg13g2_decap_8
XFILLER_21_0 VPWR VGND sg13g2_decap_8
X_600_ _600_/Y _603_/A VPWR VGND sg13g2_inv_1
X_531_ _531_/Y _533_/B _725_/Q VPWR VGND sg13g2_nand2b_1
XFILLER_27_53 VPWR VGND sg13g2_decap_8
X_462_ _688_/D _415_/Y _463_/B _461_/Y VPWR VGND sg13g2_o21ai_1
XFILLER_9_415 VPWR VGND sg13g2_decap_8
XFILLER_4_79 VPWR VGND sg13g2_decap_8
X_729_ _729_/Q _729_/CLK _729_/D _778_/A VPWR VGND sg13g2_dfrbpq_1
XFILLER_27_514 VPWR VGND sg13g2_decap_8
Xfanout45 _611_/A _603_/A VPWR VGND sg13g2_buf_1
XFILLER_22_263 VPWR VGND sg13g2_decap_8
X_514_ _644_/D _434_/Y _559_/B2 _513_/Y VPWR VGND sg13g2_o21ai_1
XFILLER_18_525 VPWR VGND sg13g2_fill_1
XFILLER_13_263 VPWR VGND sg13g2_decap_8
X_445_ _445_/Y _603_/A VPWR VGND sg13g2_inv_1
XFILLER_9_256 VPWR VGND sg13g2_decap_8
XFILLER_5_462 VPWR VGND sg13g2_decap_8
XFILLER_24_517 VPWR VGND sg13g2_decap_8
Xclkload9 clkload9/Y _726_/CLK VPWR VGND sg13g2_inv_1
XFILLER_15_539 VPWR VGND sg13g2_fill_1
XFILLER_27_388 VPWR VGND sg13g2_decap_8
XFILLER_27_355 VPWR VGND sg13g2_fill_1
XFILLER_27_311 VPWR VGND sg13g2_decap_8
XFILLER_24_43 VPWR VGND sg13g2_fill_2
XFILLER_24_32 VPWR VGND sg13g2_decap_8
XFILLER_1_14 VPWR VGND sg13g2_decap_8
X_428_ _428_/Y _651_/Q VPWR VGND sg13g2_inv_1
XFILLER_5_270 VPWR VGND sg13g2_decap_8
Xinput2 input2/X rst VPWR VGND sg13g2_buf_1
XFILLER_28_119 VPWR VGND sg13g2_decap_8
Xlane0.t_exit.tempo VPWR VGND _405_/Y lane0.t_exit.tempo/ARM _704_/Q fanout49/X _561_/A2
+ tempo_t150n
Xlane2.t_zero.tempo_72 lane2.t_zero.tempo/ARM VPWR VGND sg13g2_tielo
XFILLER_15_325 VPWR VGND sg13g2_decap_8
XFILLER_27_130 VPWR VGND sg13g2_decap_8
Xclkbuf_5_19__f_clk _705_/CLK clkbuf_4_9_0_clk/X VPWR VGND sg13g2_buf_16
XFILLER_7_502 VPWR VGND sg13g2_decap_8
XFILLER_30_339 VPWR VGND sg13g2_decap_8
XFILLER_25_7 VPWR VGND sg13g2_decap_8
XFILLER_18_185 VPWR VGND sg13g2_decap_8
XFILLER_21_328 VPWR VGND sg13g2_decap_8
XFILLER_12_306 VPWR VGND sg13g2_decap_8
XFILLER_24_155 VPWR VGND sg13g2_decap_8
XFILLER_24_144 VPWR VGND sg13g2_fill_1
XFILLER_24_100 VPWR VGND sg13g2_decap_8
XFILLER_21_44 VPWR VGND sg13g2_fill_1
XFILLER_4_527 VPWR VGND sg13g2_decap_8
XFILLER_15_100 VPWR VGND sg13g2_decap_8
X_693_ _694_/D _708_/CLK _693_/D _708_/Q VPWR VGND sg13g2_dfrbpq_1
XFILLER_28_494 VPWR VGND sg13g2_decap_8
XFILLER_15_155 VPWR VGND sg13g2_decap_8
XFILLER_30_158 VPWR VGND sg13g2_decap_8
XFILLER_7_79 VPWR VGND sg13g2_decap_8
XFILLER_7_398 VPWR VGND sg13g2_decap_8
XFILLER_21_114 VPWR VGND sg13g2_decap_8
XFILLER_17_409 VPWR VGND sg13g2_decap_8
XFILLER_29_247 VPWR VGND sg13g2_decap_8
XFILLER_12_114 VPWR VGND sg13g2_decap_8
XFILLER_4_313 VPWR VGND sg13g2_decap_8
X_676_ _676_/Q _736_/CLK _676_/D _473_/D VPWR VGND sg13g2_dfrbpq_1
X_530_ _530_/Y _529_/X _530_/B _530_/C VPWR VGND sg13g2_nand3b_1
X_461_ _461_/Y _689_/Q _461_/B VPWR VGND sg13g2_nand2_1
XFILLER_27_32 VPWR VGND sg13g2_decap_8
XFILLER_4_198 VPWR VGND sg13g2_fill_1
XFILLER_4_14 VPWR VGND sg13g2_decap_4
XFILLER_16_294 VPWR VGND sg13g2_fill_2
X_659_ _659_/Q _733_/CLK _659_/D _777_/A VPWR VGND sg13g2_dfrbpq_1
X_728_ _728_/Q _728_/CLK _728_/D _517_/D VPWR VGND sg13g2_dfrbpq_1
XFILLER_27_548 VPWR VGND sg13g2_decap_8
XFILLER_10_426 VPWR VGND sg13g2_decap_8
Xfanout46 _603_/A _607_/A VPWR VGND sg13g2_buf_1
XFILLER_22_242 VPWR VGND sg13g2_decap_8
XFILLER_6_419 VPWR VGND sg13g2_decap_8
XFILLER_13_242 VPWR VGND sg13g2_decap_8
X_513_ _513_/Y _517_/D _513_/B VPWR VGND sg13g2_nand2_1
X_444_ _444_/Y _709_/Q VPWR VGND sg13g2_inv_1
XFILLER_9_235 VPWR VGND sg13g2_decap_8
XFILLER_9_224 VPWR VGND sg13g2_fill_1
XFILLER_24_11 VPWR VGND sg13g2_decap_8
XFILLER_10_256 VPWR VGND sg13g2_decap_8
XFILLER_6_249 VPWR VGND sg13g2_decap_8
XFILLER_18_334 VPWR VGND sg13g2_decap_8
X_427_ _427_/Y _427_/A VPWR VGND sg13g2_inv_1
Xinput3 _443_/A tx_request_hs[0] VPWR VGND sg13g2_buf_1
XFILLER_24_348 VPWR VGND sg13g2_decap_8
Xclk_lane.t_lpx.tempo VPWR VGND _528_/B clk_lane.t_lpx.tempo/ARM _725_/Q fanout48/X
+ _533_/B tempo_t80n
XFILLER_15_304 VPWR VGND sg13g2_decap_8
XFILLER_30_318 VPWR VGND sg13g2_decap_8
XFILLER_27_186 VPWR VGND sg13g2_decap_8
XFILLER_18_164 VPWR VGND sg13g2_decap_8
XFILLER_21_307 VPWR VGND sg13g2_decap_8
Xclkbuf_5_25__f_clk _685_/CLK clkbuf_4_12_0_clk/X VPWR VGND sg13g2_buf_16
X_692_ _692_/Q _708_/CLK _692_/D _708_/Q VPWR VGND sg13g2_dfrbpq_1
XFILLER_28_473 VPWR VGND sg13g2_decap_8
XFILLER_30_137 VPWR VGND sg13g2_decap_8
Xclk_lane.t_exit.tempo VPWR VGND _437_/Y clk_lane.t_exit.tempo/ARM _719_/Q fanout49/X
+ _560_/A2 tempo_t150n
XFILLER_29_226 VPWR VGND sg13g2_decap_8
XFILLER_4_358 VPWR VGND sg13g2_fill_1
X_744_ _744_/Q _744_/CLK _744_/D _529_/A VPWR VGND sg13g2_dfrbpq_1
X_675_ _675_/Q _675_/CLK _675_/D _473_/D VPWR VGND sg13g2_dfrbpq_1
XFILLER_28_292 VPWR VGND sg13g2_fill_1
XFILLER_28_270 VPWR VGND sg13g2_decap_8
XFILLER_11_192 VPWR VGND sg13g2_decap_8
XFILLER_7_185 VPWR VGND sg13g2_decap_8
XFILLER_3_391 VPWR VGND sg13g2_decap_8
XFILLER_19_270 VPWR VGND sg13g2_fill_2
XFILLER_22_424 VPWR VGND sg13g2_decap_8
XFILLER_27_11 VPWR VGND sg13g2_decap_8
XFILLER_13_424 VPWR VGND sg13g2_decap_8
X_460_ _689_/D _414_/Y _461_/B _459_/Y VPWR VGND sg13g2_o21ai_1
XFILLER_27_88 VPWR VGND sg13g2_decap_8
XFILLER_4_177 VPWR VGND sg13g2_decap_8
XFILLER_4_100 VPWR VGND sg13g2_decap_8
X_727_ _727_/Q _727_/CLK _727_/D _648_/Q VPWR VGND sg13g2_dfrbpq_1
X_589_ _742_/D _742_/Q _589_/B VPWR VGND sg13g2_nand2b_1
X_658_ _658_/Q _675_/CLK _658_/D _495_/D VPWR VGND sg13g2_dfrbpq_1
XFILLER_27_527 VPWR VGND sg13g2_decap_8
XFILLER_10_405 VPWR VGND sg13g2_decap_8
XFILLER_13_79 VPWR VGND sg13g2_decap_8
Xfanout36 _529_/A _721_/Q VPWR VGND sg13g2_buf_1
Xfanout47 _607_/A input2/X VPWR VGND sg13g2_buf_1
X_512_ _645_/D _433_/Y _513_/B _511_/Y VPWR VGND sg13g2_o21ai_1
X_443_ _443_/Y _443_/A VPWR VGND sg13g2_inv_1
Xclkbuf_5_6__f_clk _688_/CLK clkbuf_4_3_0_clk/X VPWR VGND sg13g2_buf_16
XFILLER_5_497 VPWR VGND sg13g2_decap_8
XFILLER_27_346 VPWR VGND sg13g2_decap_8
XFILLER_23_552 VPWR VGND sg13g2_decap_8
XFILLER_10_235 VPWR VGND sg13g2_decap_8
XFILLER_6_228 VPWR VGND sg13g2_decap_8
XFILLER_1_49 VPWR VGND sg13g2_fill_1
XFILLER_18_313 VPWR VGND sg13g2_decap_8
X_426_ _426_/Y _664_/Q VPWR VGND sg13g2_inv_1
Xinput4 _411_/A tx_request_hs[1] VPWR VGND sg13g2_buf_1
XFILLER_24_327 VPWR VGND sg13g2_decap_8
XFILLER_27_165 VPWR VGND sg13g2_decap_8
XFILLER_23_382 VPWR VGND sg13g2_decap_8
XFILLER_4_0 VPWR VGND sg13g2_decap_8
X_409_ _409_/Y _708_/Q VPWR VGND sg13g2_inv_1
XFILLER_29_419 VPWR VGND sg13g2_decap_8
XFILLER_21_79 VPWR VGND sg13g2_decap_8
XFILLER_21_35 VPWR VGND sg13g2_decap_8
X_691_ _691_/Q _699_/CLK _691_/D _615_/Y VPWR VGND sg13g2_dfrbpq_1
XFILLER_28_452 VPWR VGND sg13g2_decap_8
XFILLER_11_341 VPWR VGND sg13g2_decap_8
XFILLER_11_396 VPWR VGND sg13g2_decap_8
XFILLER_7_334 VPWR VGND sg13g2_decap_8
XFILLER_30_116 VPWR VGND sg13g2_decap_8
XFILLER_23_190 VPWR VGND sg13g2_decap_8
Xclkbuf_5_31__f_clk _664_/CLK clkbuf_4_15_0_clk/X VPWR VGND sg13g2_buf_16
XFILLER_16_13 VPWR VGND sg13g2_fill_1
XFILLER_16_79 VPWR VGND sg13g2_decap_8
XFILLER_4_348 VPWR VGND sg13g2_decap_8
XFILLER_0_554 VPWR VGND sg13g2_decap_8
XFILLER_0_565 VPWR VGND sg13g2_fill_2
X_674_ _674_/Q _688_/CLK _674_/D _688_/Q VPWR VGND sg13g2_dfrbpq_1
X_743_ _743_/Q _743_/CLK _743_/D _723_/Q VPWR VGND sg13g2_dfrbpq_1
Xclk_lane.t_trail.tempo_56 clk_lane.t_trail.tempo/ARM VPWR VGND sg13g2_tielo
XFILLER_11_171 VPWR VGND sg13g2_decap_8
XFILLER_7_164 VPWR VGND sg13g2_decap_8
XFILLER_30_480 VPWR VGND sg13g2_decap_8
XFILLER_22_403 VPWR VGND sg13g2_decap_8
XFILLER_13_403 VPWR VGND sg13g2_decap_8
XFILLER_27_67 VPWR VGND sg13g2_decap_8
XFILLER_25_263 VPWR VGND sg13g2_decap_8
XFILLER_9_429 VPWR VGND sg13g2_decap_4
XFILLER_4_156 VPWR VGND sg13g2_decap_8
X_657_ _658_/D _664_/CLK _657_/D _495_/D VPWR VGND sg13g2_dfrbpq_1
X_726_ _726_/Q _726_/CLK _726_/D _631_/Y VPWR VGND sg13g2_dfrbpq_1
Xlane0.t_lpx.tempo_59 lane0.t_lpx.tempo/ARM VPWR VGND sg13g2_tielo
XFILLER_16_263 VPWR VGND sg13g2_decap_8
X_588_ _741_/D _741_/Q _588_/B VPWR VGND sg13g2_nand2b_1
Xfanout37 _451_/D _779_/A VPWR VGND sg13g2_buf_1
Xfanout48 fanout48/X fanout49/X VPWR VGND sg13g2_buf_1
XFILLER_22_277 VPWR VGND sg13g2_fill_2
X_511_ _511_/Y _427_/A _794_/A VPWR VGND sg13g2_nand2b_1
X_442_ _442_/Y _724_/Q VPWR VGND sg13g2_inv_1
XFILLER_5_476 VPWR VGND sg13g2_decap_8
X_709_ _709_/Q _713_/CLK _709_/D _621_/Y VPWR VGND sg13g2_dfrbpq_1
XFILLER_27_325 VPWR VGND sg13g2_decap_8
Xlane2.t_prep.tempo VPWR VGND _422_/Y lane2.t_prep.tempo/ARM _734_/Q fanout50/X _483_/B
+ tempo_t60n
XFILLER_24_79 VPWR VGND sg13g2_decap_8
XFILLER_23_531 VPWR VGND sg13g2_decap_8
XFILLER_6_207 VPWR VGND sg13g2_fill_2
XFILLER_1_28 VPWR VGND sg13g2_decap_8
X_425_ _425_/Y _495_/D VPWR VGND sg13g2_inv_1
Xlane3.t_lpx.tempo_74 lane3.t_lpx.tempo/ARM VPWR VGND sg13g2_tielo
Xinput5 _419_/A tx_request_hs[2] VPWR VGND sg13g2_buf_1
XFILLER_24_306 VPWR VGND sg13g2_decap_8
XFILLER_15_339 VPWR VGND sg13g2_decap_8
XFILLER_27_144 VPWR VGND sg13g2_decap_8
XFILLER_19_79 VPWR VGND sg13g2_decap_8
XFILLER_18_100 VPWR VGND sg13g2_decap_8
X_408_ _408_/Y _775_/A VPWR VGND sg13g2_inv_1
XFILLER_6_560 VPWR VGND sg13g2_fill_1
XFILLER_24_114 VPWR VGND sg13g2_decap_8
XFILLER_24_169 VPWR VGND sg13g2_decap_8
XFILLER_21_14 VPWR VGND sg13g2_decap_8
X_690_ _690_/Q _735_/CLK _690_/D _614_/Y VPWR VGND sg13g2_dfrbpq_1
XFILLER_28_431 VPWR VGND sg13g2_decap_8
XFILLER_15_114 VPWR VGND sg13g2_decap_8
XFILLER_15_169 VPWR VGND sg13g2_decap_8
XFILLER_11_320 VPWR VGND sg13g2_decap_8
XFILLER_7_313 VPWR VGND sg13g2_decap_8
Xclkbuf_4_9_0_clk clkbuf_4_9_0_clk/X clkbuf_0_clk/X VPWR VGND sg13g2_buf_8
XFILLER_23_7 VPWR VGND sg13g2_decap_8
XFILLER_25_412 VPWR VGND sg13g2_decap_8
XFILLER_0_533 VPWR VGND sg13g2_decap_8
XFILLER_4_327 VPWR VGND sg13g2_decap_8
XFILLER_16_412 VPWR VGND sg13g2_decap_8
X_673_ _674_/D _688_/CLK _673_/D _688_/Q VPWR VGND sg13g2_dfrbpq_1
X_742_ _742_/Q _743_/CLK _742_/D _709_/Q VPWR VGND sg13g2_dfrbpq_1
XFILLER_11_150 VPWR VGND sg13g2_decap_8
XFILLER_27_46 VPWR VGND sg13g2_decap_8
XFILLER_9_408 VPWR VGND sg13g2_decap_8
XFILLER_25_242 VPWR VGND sg13g2_decap_8
XFILLER_4_124 VPWR VGND sg13g2_fill_2
XFILLER_16_242 VPWR VGND sg13g2_decap_8
X_587_ _588_/B _699_/Q _701_/D _701_/Q VPWR VGND sg13g2_nand3b_1
X_656_ _657_/D _664_/CLK _656_/D _495_/D VPWR VGND sg13g2_dfrbpq_1
X_725_ _725_/Q _725_/CLK _725_/D _630_/Y VPWR VGND sg13g2_dfrbpq_1
XFILLER_27_507 VPWR VGND sg13g2_decap_8
Xfanout38 _473_/D _780_/A VPWR VGND sg13g2_buf_1
Xfanout49 fanout49/X fanout51/X VPWR VGND sg13g2_buf_1
XFILLER_22_256 VPWR VGND sg13g2_decap_8
X_510_ _646_/D _510_/A VPWR VGND sg13g2_inv_1
X_441_ _441_/Y _441_/A VPWR VGND sg13g2_inv_1
XFILLER_13_256 VPWR VGND sg13g2_decap_8
XFILLER_9_249 VPWR VGND sg13g2_decap_8
XFILLER_5_433 VPWR VGND sg13g2_fill_2
X_639_ _639_/Q _727_/CLK _639_/D _778_/A VPWR VGND sg13g2_dfrbpq_1
X_708_ _708_/Q _708_/CLK _708_/D _620_/Y VPWR VGND sg13g2_dfrbpq_1
XFILLER_5_93 VPWR VGND sg13g2_decap_8
XFILLER_27_304 VPWR VGND sg13g2_decap_8
XFILLER_24_25 VPWR VGND sg13g2_decap_8
XFILLER_23_510 VPWR VGND sg13g2_decap_8
X_424_ _424_/Y _777_/A VPWR VGND sg13g2_inv_1
XFILLER_18_348 VPWR VGND sg13g2_decap_8
Xclkbuf_5_14__f_clk _727_/CLK clkbuf_4_7_0_clk/X VPWR VGND sg13g2_buf_16
XFILLER_5_263 VPWR VGND sg13g2_decap_8
Xinput6 _427_/A tx_request_hs[3] VPWR VGND sg13g2_buf_1
XFILLER_15_318 VPWR VGND sg13g2_decap_8
XFILLER_27_123 VPWR VGND sg13g2_decap_8
X_407_ _450_/B _710_/Q VPWR VGND sg13g2_inv_1
XFILLER_18_178 VPWR VGND sg13g2_decap_8
XFILLER_24_148 VPWR VGND sg13g2_decap_8
XFILLER_4_509 VPWR VGND sg13g2_fill_2
XFILLER_28_410 VPWR VGND sg13g2_decap_8
XFILLER_15_148 VPWR VGND sg13g2_decap_8
XFILLER_28_487 VPWR VGND sg13g2_decap_8
XFILLER_21_107 VPWR VGND sg13g2_decap_8
XFILLER_6_391 VPWR VGND sg13g2_decap_8
XFILLER_12_107 VPWR VGND sg13g2_decap_8
XFILLER_4_306 VPWR VGND sg13g2_decap_8
X_672_ _672_/Q _735_/CLK _672_/D _688_/Q VPWR VGND sg13g2_dfrbpq_1
X_741_ _741_/Q _741_/CLK _741_/D _775_/A VPWR VGND sg13g2_dfrbpq_1
XFILLER_11_140 VPWR VGND sg13g2_fill_1
XFILLER_7_100 VPWR VGND sg13g2_decap_8
XFILLER_27_25 VPWR VGND sg13g2_decap_8
XFILLER_25_221 VPWR VGND sg13g2_decap_8
Xclkbuf_4_8_0_clk clkbuf_4_8_0_clk/X clkbuf_0_clk/X VPWR VGND sg13g2_buf_8
XFILLER_4_114 VPWR VGND sg13g2_decap_8
X_724_ _724_/Q _725_/CLK _724_/D _629_/Y VPWR VGND sg13g2_dfrbpq_1
X_586_ _740_/D _696_/Q _585_/Y _740_/Q VPWR VGND sg13g2_a21o_1
X_655_ _655_/Q _675_/CLK _655_/D _495_/D VPWR VGND sg13g2_dfrbpq_1
XFILLER_12_482 VPWR VGND sg13g2_fill_1
XFILLER_10_419 VPWR VGND sg13g2_decap_8
Xfanout39 _495_/D _781_/A VPWR VGND sg13g2_buf_1
XFILLER_22_279 VPWR VGND sg13g2_fill_1
XFILLER_22_235 VPWR VGND sg13g2_decap_8
X_440_ _530_/B _723_/Q VPWR VGND sg13g2_inv_1
XFILLER_13_235 VPWR VGND sg13g2_decap_8
XFILLER_9_228 VPWR VGND sg13g2_decap_8
XFILLER_5_412 VPWR VGND sg13g2_decap_8
X_707_ _775_/A _741_/CLK _707_/D _619_/Y VPWR VGND sg13g2_dfrbpq_1
X_638_ _638_/Q _728_/CLK _638_/D _517_/D VPWR VGND sg13g2_dfrbpq_1
X_569_ _570_/B _654_/D _654_/Q _652_/Q VPWR VGND sg13g2_nand3b_1
XFILLER_5_72 VPWR VGND sg13g2_decap_8
XFILLER_10_249 VPWR VGND sg13g2_decap_8
XFILLER_6_209 VPWR VGND sg13g2_fill_1
XFILLER_23_566 VPWR VGND sg13g2_decap_4
XFILLER_18_327 VPWR VGND sg13g2_decap_8
X_423_ _423_/Y _668_/Q VPWR VGND sg13g2_inv_1
XFILLER_5_242 VPWR VGND sg13g2_decap_8
XFILLER_9_570 VPWR VGND sg13g2_fill_1
XFILLER_27_102 VPWR VGND sg13g2_decap_8
Xclkbuf_5_20__f_clk _721_/CLK clkbuf_4_10_0_clk/X VPWR VGND sg13g2_buf_16
XFILLER_27_179 VPWR VGND sg13g2_decap_8
XFILLER_11_569 VPWR VGND sg13g2_fill_2
XFILLER_23_396 VPWR VGND sg13g2_decap_8
XFILLER_18_157 VPWR VGND sg13g2_decap_8
X_406_ _406_/Y _711_/Q VPWR VGND sg13g2_inv_1
XFILLER_28_466 VPWR VGND sg13g2_decap_8
XFILLER_11_93 VPWR VGND sg13g2_decap_8
XFILLER_7_348 VPWR VGND sg13g2_decap_8
X_740_ _740_/Q _740_/CLK _740_/D _451_/D VPWR VGND sg13g2_dfrbpq_1
X_671_ _671_/Q _732_/CLK _671_/D _607_/Y VPWR VGND sg13g2_dfrbpq_1
XFILLER_28_263 VPWR VGND sg13g2_decap_8
XFILLER_11_185 VPWR VGND sg13g2_decap_8
XFILLER_7_178 VPWR VGND sg13g2_decap_8
XFILLER_3_384 VPWR VGND sg13g2_decap_8
XFILLER_19_263 VPWR VGND sg13g2_decap_8
XFILLER_22_417 VPWR VGND sg13g2_decap_8
XFILLER_30_494 VPWR VGND sg13g2_decap_8
XFILLER_13_417 VPWR VGND sg13g2_decap_8
XFILLER_25_277 VPWR VGND sg13g2_fill_2
XFILLER_21_494 VPWR VGND sg13g2_decap_8
X_654_ _654_/Q _670_/CLK _654_/D _668_/Q VPWR VGND sg13g2_dfrbpq_1
X_723_ _723_/Q _738_/CLK _723_/D _628_/Y VPWR VGND sg13g2_dfrbpq_1
X_585_ _585_/Y _697_/Q _698_/Q _695_/Q VPWR VGND sg13g2_nor3_1
XFILLER_3_192 VPWR VGND sg13g2_decap_8
Xclkbuf_5_1__f_clk _743_/CLK clkbuf_4_0_0_clk/X VPWR VGND sg13g2_buf_16
X_637_ _637_/Q _661_/CLK _637_/D _517_/D VPWR VGND sg13g2_dfrbpq_1
X_706_ _791_/A _741_/CLK _706_/D _618_/Y VPWR VGND sg13g2_dfrbpq_1
XFILLER_29_391 VPWR VGND sg13g2_decap_8
XFILLER_28_91 VPWR VGND sg13g2_decap_8
XFILLER_12_280 VPWR VGND sg13g2_fill_1
X_568_ _730_/D _730_/Q _568_/B VPWR VGND sg13g2_nand2b_1
X_499_ _655_/D _658_/D _658_/Q VPWR VGND sg13g2_xnor2_1
Xclkbuf_4_7_0_clk clkbuf_4_7_0_clk/X clkbuf_0_clk/X VPWR VGND sg13g2_buf_8
XFILLER_27_339 VPWR VGND sg13g2_decap_8
XFILLER_23_545 VPWR VGND sg13g2_decap_8
XFILLER_10_228 VPWR VGND sg13g2_decap_8
XFILLER_6_7 VPWR VGND sg13g2_fill_2
XFILLER_18_306 VPWR VGND sg13g2_decap_8
X_422_ _422_/Y _669_/Q VPWR VGND sg13g2_inv_1
XFILLER_30_81 VPWR VGND sg13g2_decap_8
XFILLER_27_158 VPWR VGND sg13g2_decap_8
XFILLER_23_353 VPWR VGND sg13g2_fill_2
XFILLER_18_114 VPWR VGND sg13g2_decap_8
XFILLER_10_570 VPWR VGND sg13g2_fill_1
X_405_ _405_/Y _704_/Q VPWR VGND sg13g2_inv_1
XFILLER_21_28 VPWR VGND sg13g2_decap_8
XFILLER_28_445 VPWR VGND sg13g2_decap_8
XFILLER_11_301 VPWR VGND sg13g2_fill_1
XFILLER_11_334 VPWR VGND sg13g2_decap_8
XFILLER_11_389 VPWR VGND sg13g2_decap_8
XFILLER_7_327 VPWR VGND sg13g2_decap_8
XFILLER_30_109 VPWR VGND sg13g2_decap_8
XFILLER_23_183 VPWR VGND sg13g2_decap_8
XFILLER_11_72 VPWR VGND sg13g2_decap_8
XFILLER_16_9 VPWR VGND sg13g2_decap_4
XFILLER_19_412 VPWR VGND sg13g2_decap_8
Xlane3.t_prep.tempo_75 lane3.t_prep.tempo/ARM VPWR VGND sg13g2_tielo
XFILLER_28_0 VPWR VGND sg13g2_decap_8
XFILLER_25_426 VPWR VGND sg13g2_decap_8
XFILLER_0_547 VPWR VGND sg13g2_decap_8
X_670_ _670_/Q _670_/CLK _670_/D _606_/Y VPWR VGND sg13g2_dfrbpq_1
XFILLER_16_426 VPWR VGND sg13g2_decap_8
XFILLER_28_242 VPWR VGND sg13g2_decap_8
XFILLER_11_164 VPWR VGND sg13g2_decap_8
XFILLER_7_157 VPWR VGND sg13g2_decap_8
XFILLER_22_93 VPWR VGND sg13g2_decap_8
XFILLER_3_341 VPWR VGND sg13g2_decap_8
XFILLER_21_7 VPWR VGND sg13g2_decap_8
XFILLER_19_242 VPWR VGND sg13g2_decap_8
XFILLER_30_473 VPWR VGND sg13g2_decap_8
XFILLER_25_256 VPWR VGND sg13g2_decap_8
XFILLER_4_149 VPWR VGND sg13g2_decap_8
X_653_ _654_/D _731_/CLK _653_/D _668_/Q VPWR VGND sg13g2_dfrbpq_1
X_722_ _722_/Q _743_/CLK _722_/D _627_/Y VPWR VGND sg13g2_dfrbpq_1
XFILLER_29_562 VPWR VGND sg13g2_decap_8
XFILLER_16_256 VPWR VGND sg13g2_decap_8
X_584_ _739_/D _739_/Q _584_/B VPWR VGND sg13g2_nand2b_1
XFILLER_17_93 VPWR VGND sg13g2_decap_8
XFILLER_3_171 VPWR VGND sg13g2_decap_8
XFILLER_5_469 VPWR VGND sg13g2_decap_8
XFILLER_21_270 VPWR VGND sg13g2_decap_8
X_636_ _636_/Q _661_/CLK _636_/D _517_/D VPWR VGND sg13g2_dfrbpq_1
X_705_ _779_/A _705_/CLK _705_/D _617_/Y VPWR VGND sg13g2_dfrbpq_1
X_567_ _729_/D _729_/Q _567_/B VPWR VGND sg13g2_nand2b_1
XFILLER_28_70 VPWR VGND sg13g2_decap_8
XFILLER_12_270 VPWR VGND sg13g2_decap_8
X_498_ _659_/D _661_/Q _661_/D VPWR VGND sg13g2_xnor2_1
XFILLER_27_318 VPWR VGND sg13g2_decap_8
XFILLER_24_39 VPWR VGND sg13g2_decap_4
XFILLER_23_524 VPWR VGND sg13g2_decap_8
X_421_ _494_/B _670_/Q VPWR VGND sg13g2_inv_1
XFILLER_30_60 VPWR VGND sg13g2_decap_8
XFILLER_17_395 VPWR VGND sg13g2_decap_8
X_619_ _619_/Y _619_/A VPWR VGND sg13g2_inv_1
XFILLER_27_137 VPWR VGND sg13g2_decap_8
XFILLER_7_509 VPWR VGND sg13g2_fill_2
XFILLER_23_332 VPWR VGND sg13g2_decap_8
Xclk_lane.t_prep.tempo_55 clk_lane.t_prep.tempo/ARM VPWR VGND sg13g2_tielo
Xclk_lane.t_trail.tempo VPWR VGND _530_/C clk_lane.t_trail.tempo/ARM _720_/Q fanout49/X
+ _525_/B tempo_t80n
Xclkbuf_4_6_0_clk clkbuf_4_6_0_clk/X clkbuf_0_clk/X VPWR VGND sg13g2_buf_8
XFILLER_25_93 VPWR VGND sg13g2_decap_8
XFILLER_24_107 VPWR VGND sg13g2_decap_8
XFILLER_17_192 VPWR VGND sg13g2_decap_8
XFILLER_9_380 VPWR VGND sg13g2_decap_8
XFILLER_28_424 VPWR VGND sg13g2_decap_8
XFILLER_15_107 VPWR VGND sg13g2_decap_8
XFILLER_11_313 VPWR VGND sg13g2_decap_8
XFILLER_7_306 VPWR VGND sg13g2_decap_8
XFILLER_23_162 VPWR VGND sg13g2_decap_8
Xlane1.t_exit.tempo VPWR VGND _418_/Y lane1.t_exit.tempo/ARM _684_/Q fanout49/X _557_/B2
+ tempo_t150n
XFILLER_16_18 VPWR VGND sg13g2_fill_2
XFILLER_25_405 VPWR VGND sg13g2_decap_8
XFILLER_0_526 VPWR VGND sg13g2_decap_8
Xlane3.t_trail.tempo_76 lane3.t_trail.tempo/ARM VPWR VGND sg13g2_tielo
XFILLER_16_405 VPWR VGND sg13g2_decap_8
XFILLER_7_114 VPWR VGND sg13g2_decap_8
XFILLER_3_320 VPWR VGND sg13g2_decap_8
XFILLER_22_72 VPWR VGND sg13g2_decap_8
XFILLER_30_452 VPWR VGND sg13g2_decap_8
XFILLER_27_39 VPWR VGND sg13g2_decap_8
XFILLER_25_235 VPWR VGND sg13g2_decap_8
XFILLER_16_235 VPWR VGND sg13g2_decap_8
XFILLER_17_72 VPWR VGND sg13g2_decap_8
X_583_ _584_/B _694_/D _694_/Q _692_/Q VPWR VGND sg13g2_nand3b_1
X_652_ _652_/Q _670_/CLK _652_/D _668_/Q VPWR VGND sg13g2_dfrbpq_1
X_721_ _721_/Q _721_/CLK _721_/D _626_/Y VPWR VGND sg13g2_dfrbpq_1
Xclkbuf_5_26__f_clk _733_/CLK clkbuf_4_13_0_clk/X VPWR VGND sg13g2_buf_16
XFILLER_29_541 VPWR VGND sg13g2_decap_8
XFILLER_3_150 VPWR VGND sg13g2_decap_8
XFILLER_12_4 VPWR VGND sg13g2_fill_1
XFILLER_22_249 VPWR VGND sg13g2_decap_8
XFILLER_13_249 VPWR VGND sg13g2_decap_8
XFILLER_5_426 VPWR VGND sg13g2_decap_8
X_704_ _704_/Q _726_/CLK _704_/D _616_/Y VPWR VGND sg13g2_dfrbpq_1
X_635_ _635_/Q _661_/CLK _635_/D _517_/D VPWR VGND sg13g2_dfrbpq_1
X_566_ _567_/B _639_/Q _640_/Q _641_/Q VPWR VGND sg13g2_nand3b_1
X_497_ _662_/D _662_/Q _663_/Q VPWR VGND sg13g2_xnor2_1
XFILLER_5_86 VPWR VGND sg13g2_decap_8
XFILLER_4_481 VPWR VGND sg13g2_decap_8
XFILLER_24_18 VPWR VGND sg13g2_decap_8
XFILLER_23_503 VPWR VGND sg13g2_decap_8
X_420_ _420_/Y _671_/Q VPWR VGND sg13g2_inv_1
XFILLER_5_256 VPWR VGND sg13g2_decap_8
XFILLER_17_341 VPWR VGND sg13g2_decap_8
X_618_ _618_/Y _630_/A VPWR VGND sg13g2_inv_1
X_549_ _549_/Y _709_/Q _549_/B VPWR VGND sg13g2_nand2_1
XFILLER_27_116 VPWR VGND sg13g2_decap_8
XFILLER_23_311 VPWR VGND sg13g2_decap_8
XFILLER_25_72 VPWR VGND sg13g2_decap_8
XFILLER_17_171 VPWR VGND sg13g2_decap_8
Xclkbuf_5_7__f_clk _741_/CLK clkbuf_4_3_0_clk/X VPWR VGND sg13g2_buf_16
XFILLER_28_403 VPWR VGND sg13g2_decap_8
XFILLER_10_380 VPWR VGND sg13g2_fill_1
XFILLER_10_391 VPWR VGND sg13g2_decap_8
XFILLER_6_384 VPWR VGND sg13g2_decap_8
Xclkbuf_4_5_0_clk clkbuf_4_5_0_clk/X clkbuf_0_clk/X VPWR VGND sg13g2_buf_8
XFILLER_11_100 VPWR VGND sg13g2_decap_8
XFILLER_3_398 VPWR VGND sg13g2_decap_8
XFILLER_30_431 VPWR VGND sg13g2_decap_8
XFILLER_6_192 VPWR VGND sg13g2_decap_8
XFILLER_27_18 VPWR VGND sg13g2_decap_8
XFILLER_25_214 VPWR VGND sg13g2_decap_8
XFILLER_4_107 VPWR VGND sg13g2_decap_8
X_720_ _720_/Q _744_/CLK _720_/D _625_/Y VPWR VGND sg13g2_dfrbpq_1
XFILLER_29_520 VPWR VGND sg13g2_decap_8
XFILLER_17_62 VPWR VGND sg13g2_fill_1
X_582_ _738_/D _738_/Q _582_/B VPWR VGND sg13g2_nand2b_1
X_651_ _651_/Q _733_/CLK _651_/D _599_/Y VPWR VGND sg13g2_dfrbpq_1
XFILLER_3_140 VPWR VGND sg13g2_fill_1
XFILLER_22_228 VPWR VGND sg13g2_decap_8
XFILLER_30_261 VPWR VGND sg13g2_decap_8
XFILLER_13_228 VPWR VGND sg13g2_decap_8
Xlane3.t_trail.tempo VPWR VGND _433_/Y lane3.t_trail.tempo/ARM _728_/Q fanout51/X
+ _513_/B tempo_t80n
XFILLER_5_405 VPWR VGND sg13g2_decap_8
X_634_ _634_/Q _647_/CLK _634_/D _648_/Q VPWR VGND sg13g2_dfrbpq_1
X_703_ _703_/Q _725_/CLK _703_/D _709_/Q VPWR VGND sg13g2_dfrbpq_1
X_565_ _728_/D _636_/Q _564_/Y _728_/Q VPWR VGND sg13g2_a21o_1
X_496_ _575_/B _662_/Q _663_/Q VPWR VGND sg13g2_nand2b_1
XFILLER_4_460 VPWR VGND sg13g2_decap_8
XFILLER_23_559 VPWR VGND sg13g2_decap_8
XFILLER_5_235 VPWR VGND sg13g2_decap_8
XFILLER_30_95 VPWR VGND sg13g2_decap_8
XFILLER_17_320 VPWR VGND sg13g2_decap_8
X_617_ _617_/Y _617_/A VPWR VGND sg13g2_inv_1
X_548_ _709_/D _444_/Y _549_/B _547_/Y VPWR VGND sg13g2_o21ai_1
X_479_ _479_/Y _481_/B _670_/Q VPWR VGND sg13g2_nand2b_1
XFILLER_23_389 VPWR VGND sg13g2_decap_8
XFILLER_4_7 VPWR VGND sg13g2_decap_8
XFILLER_17_150 VPWR VGND sg13g2_decap_8
XFILLER_28_459 VPWR VGND sg13g2_decap_8
XFILLER_11_348 VPWR VGND sg13g2_decap_8
XFILLER_23_197 VPWR VGND sg13g2_fill_2
XFILLER_11_86 VPWR VGND sg13g2_decap_8
XFILLER_19_426 VPWR VGND sg13g2_decap_8
XFILLER_6_341 VPWR VGND sg13g2_decap_8
XFILLER_9_190 VPWR VGND sg13g2_decap_8
XFILLER_28_256 VPWR VGND sg13g2_decap_8
XFILLER_28_223 VPWR VGND sg13g2_fill_2
XFILLER_11_178 VPWR VGND sg13g2_decap_8
XFILLER_19_256 VPWR VGND sg13g2_decap_8
XFILLER_30_410 VPWR VGND sg13g2_decap_8
XFILLER_6_171 VPWR VGND sg13g2_decap_8
XFILLER_30_487 VPWR VGND sg13g2_decap_8
XFILLER_21_487 VPWR VGND sg13g2_decap_8
X_650_ _650_/Q _730_/CLK _650_/D _598_/Y VPWR VGND sg13g2_dfrbpq_1
XFILLER_16_204 VPWR VGND sg13g2_fill_1
X_581_ _737_/D _737_/Q _581_/B VPWR VGND sg13g2_nand2b_1
XFILLER_3_185 VPWR VGND sg13g2_decap_8
X_779_ _779_/X _779_/A VPWR VGND sg13g2_buf_1
XFILLER_30_240 VPWR VGND sg13g2_decap_8
Xclkbuf_4_4_0_clk clkbuf_4_4_0_clk/X clkbuf_0_clk/X VPWR VGND sg13g2_buf_8
X_633_ _633_/Q _727_/CLK _633_/D _648_/Q VPWR VGND sg13g2_dfrbpq_1
X_702_ _702_/Q _713_/CLK _702_/D _709_/Q VPWR VGND sg13g2_dfrbpq_1
XFILLER_29_384 VPWR VGND sg13g2_decap_8
XFILLER_28_84 VPWR VGND sg13g2_decap_8
X_564_ _564_/Y _637_/Q _638_/Q _635_/Q VPWR VGND sg13g2_nor3_1
X_495_ _773_/A _668_/Q _777_/A _793_/A _495_/D VPWR VGND sg13g2_or4_1
XFILLER_5_11 VPWR VGND sg13g2_fill_2
XFILLER_23_538 VPWR VGND sg13g2_decap_8
Xlane0.t_exit.tempo_58 lane0.t_exit.tempo/ARM VPWR VGND sg13g2_tielo
XFILLER_30_74 VPWR VGND sg13g2_decap_8
X_616_ _616_/Y _631_/A VPWR VGND sg13g2_inv_1
X_547_ _547_/Y _710_/Q _547_/B VPWR VGND sg13g2_nand2_1
XFILLER_29_192 VPWR VGND sg13g2_decap_8
XFILLER_13_560 VPWR VGND sg13g2_fill_2
X_478_ _672_/D _674_/D _674_/Q VPWR VGND sg13g2_xnor2_1
XFILLER_23_346 VPWR VGND sg13g2_decap_8
XFILLER_18_107 VPWR VGND sg13g2_decap_8
XFILLER_25_63 VPWR VGND sg13g2_fill_2
XFILLER_9_394 VPWR VGND sg13g2_decap_8
Xlane3.t_prep.tempo VPWR VGND _430_/Y lane3.t_prep.tempo/ARM _730_/Q fanout50/X _505_/B
+ tempo_t60n
XFILLER_28_438 VPWR VGND sg13g2_decap_8
XFILLER_11_327 VPWR VGND sg13g2_decap_8
XFILLER_23_176 VPWR VGND sg13g2_decap_8
XFILLER_3_504 VPWR VGND sg13g2_decap_8
XFILLER_19_405 VPWR VGND sg13g2_decap_8
XFILLER_27_493 VPWR VGND sg13g2_decap_8
XFILLER_6_320 VPWR VGND sg13g2_decap_8
XFILLER_25_419 VPWR VGND sg13g2_decap_8
Xclkbuf_5_15__f_clk _648_/CLK clkbuf_4_7_0_clk/X VPWR VGND sg13g2_buf_16
XFILLER_16_419 VPWR VGND sg13g2_decap_8
XFILLER_28_235 VPWR VGND sg13g2_decap_8
XFILLER_11_157 VPWR VGND sg13g2_decap_8
XFILLER_3_334 VPWR VGND sg13g2_decap_8
XFILLER_22_86 VPWR VGND sg13g2_decap_8
XFILLER_19_235 VPWR VGND sg13g2_decap_8
XFILLER_6_150 VPWR VGND sg13g2_decap_8
XFILLER_30_466 VPWR VGND sg13g2_decap_8
XFILLER_25_249 VPWR VGND sg13g2_decap_8
XFILLER_19_0 VPWR VGND sg13g2_decap_4
X_580_ _581_/B _680_/D _681_/D _681_/Q VPWR VGND sg13g2_nand3b_1
XFILLER_29_555 VPWR VGND sg13g2_decap_8
XFILLER_16_249 VPWR VGND sg13g2_decap_8
XFILLER_17_86 VPWR VGND sg13g2_decap_8
XFILLER_3_164 VPWR VGND sg13g2_decap_8
X_778_ _778_/X _778_/A VPWR VGND sg13g2_buf_1
XFILLER_7_481 VPWR VGND sg13g2_decap_8
XFILLER_21_263 VPWR VGND sg13g2_decap_8
X_632_ _632_/Q _730_/CLK _632_/D _648_/Q VPWR VGND sg13g2_dfrbpq_1
X_701_ _701_/Q _736_/CLK _701_/D _775_/A VPWR VGND sg13g2_dfrbpq_1
Xlane1.t_exit.tempo_63 lane1.t_exit.tempo/ARM VPWR VGND sg13g2_tielo
X_563_ _727_/D _727_/Q _563_/B VPWR VGND sg13g2_nand2b_1
XFILLER_29_341 VPWR VGND sg13g2_decap_8
XFILLER_28_63 VPWR VGND sg13g2_decap_8
XFILLER_12_263 VPWR VGND sg13g2_decap_8
X_494_ _785_/A _789_/A _494_/B VPWR VGND sg13g2_nand2b_1
XFILLER_4_495 VPWR VGND sg13g2_decap_8
XFILLER_23_517 VPWR VGND sg13g2_decap_8
XFILLER_30_53 VPWR VGND sg13g2_decap_8
Xclkbuf_4_3_0_clk clkbuf_4_3_0_clk/X clkbuf_0_clk/X VPWR VGND sg13g2_buf_8
X_615_ _615_/Y _617_/A VPWR VGND sg13g2_inv_1
X_546_ _710_/D _711_/Q _443_/Y _545_/Y VPWR VGND sg13g2_o21ai_1
XFILLER_29_171 VPWR VGND sg13g2_decap_8
X_477_ _675_/D _678_/D _678_/Q VPWR VGND sg13g2_xnor2_1
XFILLER_4_270 VPWR VGND sg13g2_decap_8
XFILLER_23_325 VPWR VGND sg13g2_decap_8
XFILLER_25_42 VPWR VGND sg13g2_decap_8
XFILLER_25_86 VPWR VGND sg13g2_decap_8
XFILLER_17_185 VPWR VGND sg13g2_decap_8
X_529_ _529_/X _529_/A _722_/Q VPWR VGND sg13g2_or2_1
XFILLER_28_417 VPWR VGND sg13g2_decap_8
XFILLER_23_100 VPWR VGND sg13g2_decap_8
XFILLER_11_306 VPWR VGND sg13g2_decap_8
XFILLER_23_155 VPWR VGND sg13g2_decap_8
XFILLER_3_538 VPWR VGND sg13g2_fill_1
XFILLER_27_472 VPWR VGND sg13g2_decap_8
XFILLER_6_398 VPWR VGND sg13g2_decap_8
XFILLER_11_114 VPWR VGND sg13g2_decap_8
XFILLER_7_107 VPWR VGND sg13g2_decap_8
XFILLER_3_313 VPWR VGND sg13g2_decap_8
X_794_ _794_/X _794_/A VPWR VGND sg13g2_buf_1
Xclkbuf_5_21__f_clk _726_/CLK clkbuf_4_10_0_clk/X VPWR VGND sg13g2_buf_16
XFILLER_30_445 VPWR VGND sg13g2_decap_8
XFILLER_25_228 VPWR VGND sg13g2_decap_8
XFILLER_25_206 VPWR VGND sg13g2_fill_1
XFILLER_21_412 VPWR VGND sg13g2_decap_8
XFILLER_16_228 VPWR VGND sg13g2_decap_8
XFILLER_29_534 VPWR VGND sg13g2_decap_8
XFILLER_12_412 VPWR VGND sg13g2_decap_8
XFILLER_24_261 VPWR VGND sg13g2_decap_8
XFILLER_15_261 VPWR VGND sg13g2_decap_8
X_777_ _777_/X _777_/A VPWR VGND sg13g2_buf_1
XFILLER_7_460 VPWR VGND sg13g2_decap_8
XFILLER_30_275 VPWR VGND sg13g2_fill_2
XFILLER_21_242 VPWR VGND sg13g2_decap_8
XFILLER_5_419 VPWR VGND sg13g2_decap_8
X_700_ _701_/D _740_/CLK _700_/D _775_/A VPWR VGND sg13g2_dfrbpq_1
XFILLER_29_320 VPWR VGND sg13g2_decap_8
X_631_ _631_/Y _631_/A VPWR VGND sg13g2_inv_1
X_562_ _563_/B _633_/Q _634_/Q _632_/Q VPWR VGND sg13g2_nand3b_1
X_493_ _789_/A _664_/Q _671_/Q VPWR VGND sg13g2_nand2b_1
XFILLER_28_42 VPWR VGND sg13g2_decap_8
XFILLER_12_242 VPWR VGND sg13g2_decap_8
XFILLER_5_79 VPWR VGND sg13g2_decap_8
XFILLER_4_474 VPWR VGND sg13g2_decap_8
Xlane3.t_zero.tempo_77 lane3.t_zero.tempo/ARM VPWR VGND sg13g2_tielo
XFILLER_7_290 VPWR VGND sg13g2_fill_2
XFILLER_5_249 VPWR VGND sg13g2_decap_8
XFILLER_30_32 VPWR VGND sg13g2_decap_8
XFILLER_29_150 VPWR VGND sg13g2_decap_8
XFILLER_13_562 VPWR VGND sg13g2_fill_1
XFILLER_17_334 VPWR VGND sg13g2_decap_8
X_614_ _614_/Y _619_/A VPWR VGND sg13g2_inv_1
X_545_ _545_/Y _547_/B _710_/Q VPWR VGND sg13g2_nand2b_1
X_476_ _679_/D _681_/Q _681_/D VPWR VGND sg13g2_xnor2_1
XFILLER_27_109 VPWR VGND sg13g2_decap_8
XFILLER_23_304 VPWR VGND sg13g2_decap_8
Xclkbuf_5_2__f_clk _725_/CLK clkbuf_4_1_0_clk/X VPWR VGND sg13g2_buf_16
XFILLER_25_21 VPWR VGND sg13g2_decap_8
XFILLER_6_569 VPWR VGND sg13g2_fill_2
XFILLER_17_164 VPWR VGND sg13g2_decap_8
X_528_ _528_/Y _527_/Y _528_/B VPWR VGND sg13g2_nand2b_1
X_459_ _459_/Y _690_/Q _459_/B VPWR VGND sg13g2_nand2_1
Xclkbuf_4_2_0_clk clkbuf_4_2_0_clk/X clkbuf_0_clk/X VPWR VGND sg13g2_buf_8
XFILLER_27_451 VPWR VGND sg13g2_decap_8
XFILLER_10_384 VPWR VGND sg13g2_decap_8
XFILLER_6_355 VPWR VGND sg13g2_fill_2
XFILLER_24_487 VPWR VGND sg13g2_decap_8
XFILLER_0_4 VPWR VGND sg13g2_decap_8
X_793_ _793_/X _793_/A VPWR VGND sg13g2_buf_1
XFILLER_30_424 VPWR VGND sg13g2_decap_8
XFILLER_10_192 VPWR VGND sg13g2_decap_8
XFILLER_6_185 VPWR VGND sg13g2_decap_8
XFILLER_18_270 VPWR VGND sg13g2_decap_8
XFILLER_29_513 VPWR VGND sg13g2_decap_8
XFILLER_24_240 VPWR VGND sg13g2_decap_8
Xclk_lane.t_zero.tempo_57 clk_lane.t_zero.tempo/ARM VPWR VGND sg13g2_tielo
XFILLER_3_100 VPWR VGND sg13g2_decap_8
X_776_ _776_/X _776_/A VPWR VGND sg13g2_buf_1
XFILLER_3_199 VPWR VGND sg13g2_decap_8
XFILLER_15_240 VPWR VGND sg13g2_decap_8
Xlane0.t_trail.tempo VPWR VGND _410_/Y lane0.t_trail.tempo/ARM _740_/Q fanout49/X
+ _447_/B tempo_t80n
XFILLER_30_254 VPWR VGND sg13g2_decap_8
X_630_ _630_/Y _630_/A VPWR VGND sg13g2_inv_1
XFILLER_28_21 VPWR VGND sg13g2_decap_8
X_561_ _711_/D _704_/Q _561_/A2 _406_/Y _443_/Y VPWR VGND sg13g2_a22oi_1
X_492_ _664_/D _426_/Y _558_/B2 _491_/Y VPWR VGND sg13g2_o21ai_1
XFILLER_29_398 VPWR VGND sg13g2_decap_8
XFILLER_28_98 VPWR VGND sg13g2_decap_8
XFILLER_25_560 VPWR VGND sg13g2_fill_2
XFILLER_5_228 VPWR VGND sg13g2_decap_8
XFILLER_30_11 VPWR VGND sg13g2_decap_8
XFILLER_30_88 VPWR VGND sg13g2_decap_8
XFILLER_17_313 VPWR VGND sg13g2_decap_8
X_613_ _613_/Y _619_/A VPWR VGND sg13g2_inv_1
X_544_ _712_/D _713_/Q _712_/Q VPWR VGND sg13g2_xnor2_1
X_475_ _682_/D _682_/Q _683_/Q VPWR VGND sg13g2_xnor2_1
Xlane0.t_zero.tempo VPWR VGND _409_/Y lane0.t_zero.tempo/ARM _739_/Q fanout48/X _551_/B
+ tempo_t150n
XFILLER_10_544 VPWR VGND sg13g2_fill_1
XFILLER_6_504 VPWR VGND sg13g2_decap_8
XFILLER_22_382 VPWR VGND sg13g2_decap_8
X_527_ _527_/Y _719_/Q _726_/Q VPWR VGND sg13g2_nand2b_1
XFILLER_13_382 VPWR VGND sg13g2_decap_8
X_458_ _690_/D _411_/Y _691_/Q _457_/Y VPWR VGND sg13g2_o21ai_1
XFILLER_9_353 VPWR VGND sg13g2_fill_2
XFILLER_11_79 VPWR VGND sg13g2_decap_8
XFILLER_27_430 VPWR VGND sg13g2_decap_8
XFILLER_19_419 VPWR VGND sg13g2_decap_8
XFILLER_10_341 VPWR VGND sg13g2_decap_8
XFILLER_6_334 VPWR VGND sg13g2_decap_8
XFILLER_28_7 VPWR VGND sg13g2_decap_8
XFILLER_9_183 VPWR VGND sg13g2_decap_8
XFILLER_28_249 VPWR VGND sg13g2_decap_8
XFILLER_3_348 VPWR VGND sg13g2_decap_8
X_792_ _792_/X _792_/A VPWR VGND sg13g2_buf_1
XFILLER_30_403 VPWR VGND sg13g2_decap_8
XFILLER_19_249 VPWR VGND sg13g2_decap_8
XFILLER_10_171 VPWR VGND sg13g2_decap_8
XFILLER_6_164 VPWR VGND sg13g2_decap_8
Xclkbuf_4_1_0_clk clkbuf_4_1_0_clk/X clkbuf_0_clk/X VPWR VGND sg13g2_buf_8
XFILLER_17_67 VPWR VGND sg13g2_fill_2
XFILLER_29_569 VPWR VGND sg13g2_fill_2
XFILLER_3_178 VPWR VGND sg13g2_decap_8
X_775_ _775_/X _775_/A VPWR VGND sg13g2_buf_1
XFILLER_30_233 VPWR VGND sg13g2_decap_8
XFILLER_7_495 VPWR VGND sg13g2_decap_8
X_560_ _726_/D _719_/Q _560_/A2 _438_/Y _441_/Y VPWR VGND sg13g2_a22oi_1
XFILLER_29_355 VPWR VGND sg13g2_fill_2
XFILLER_28_77 VPWR VGND sg13g2_decap_8
X_491_ _491_/Y _495_/D _491_/B VPWR VGND sg13g2_nand2_1
XFILLER_12_299 VPWR VGND sg13g2_fill_2
X_689_ _689_/Q _725_/CLK _689_/D _613_/Y VPWR VGND sg13g2_dfrbpq_1
XFILLER_7_292 VPWR VGND sg13g2_fill_1
XFILLER_7_270 VPWR VGND sg13g2_decap_8
XFILLER_22_531 VPWR VGND sg13g2_decap_8
XFILLER_30_67 VPWR VGND sg13g2_decap_8
X_612_ _612_/Y _619_/A VPWR VGND sg13g2_inv_1
X_543_ _590_/B _713_/Q _712_/Q VPWR VGND sg13g2_nand2b_1
XFILLER_29_185 VPWR VGND sg13g2_decap_8
X_474_ _582_/B _682_/Q _683_/Q VPWR VGND sg13g2_nand2b_1
XFILLER_9_568 VPWR VGND sg13g2_fill_2
XFILLER_25_391 VPWR VGND sg13g2_decap_8
Xclkbuf_5_27__f_clk _728_/CLK clkbuf_4_13_0_clk/X VPWR VGND sg13g2_buf_16
XFILLER_16_391 VPWR VGND sg13g2_decap_8
XFILLER_23_339 VPWR VGND sg13g2_decap_8
XFILLER_25_56 VPWR VGND sg13g2_decap_8
XFILLER_17_100 VPWR VGND sg13g2_decap_8
X_526_ _719_/D _437_/Y _560_/A2 _525_/Y VPWR VGND sg13g2_o21ai_1
X_457_ _457_/Y _459_/B _690_/Q VPWR VGND sg13g2_nand2b_1
XFILLER_9_387 VPWR VGND sg13g2_decap_8
XFILLER_9_332 VPWR VGND sg13g2_decap_8
XFILLER_23_169 VPWR VGND sg13g2_decap_8
XFILLER_23_114 VPWR VGND sg13g2_decap_8
Xclkbuf_5_10__f_clk _730_/CLK clkbuf_4_5_0_clk/X VPWR VGND sg13g2_buf_16
XFILLER_27_486 VPWR VGND sg13g2_decap_8
XFILLER_10_320 VPWR VGND sg13g2_decap_8
XFILLER_6_313 VPWR VGND sg13g2_decap_8
Xclk_lane.t_zero.tempo VPWR VGND _530_/B clk_lane.t_zero.tempo/ARM _743_/Q fanout48/X
+ _537_/B1 tempo_t350n
X_509_ _510_/A _778_/A _729_/Q _794_/A _427_/A VPWR VGND sg13g2_a22oi_1
XFILLER_9_162 VPWR VGND sg13g2_decap_8
XFILLER_28_228 VPWR VGND sg13g2_decap_8
XFILLER_24_412 VPWR VGND sg13g2_decap_8
XFILLER_3_327 VPWR VGND sg13g2_decap_8
XFILLER_22_79 VPWR VGND sg13g2_decap_8
X_791_ _791_/X _791_/A VPWR VGND sg13g2_buf_1
XFILLER_19_228 VPWR VGND sg13g2_decap_8
XFILLER_15_412 VPWR VGND sg13g2_decap_8
XFILLER_10_150 VPWR VGND sg13g2_decap_8
XFILLER_6_121 VPWR VGND sg13g2_fill_2
XFILLER_30_459 VPWR VGND sg13g2_decap_8
XFILLER_19_4 VPWR VGND sg13g2_fill_1
XFILLER_21_426 VPWR VGND sg13g2_decap_8
XFILLER_29_548 VPWR VGND sg13g2_decap_8
XFILLER_12_426 VPWR VGND sg13g2_decap_8
XFILLER_17_79 VPWR VGND sg13g2_decap_8
XFILLER_24_275 VPWR VGND sg13g2_fill_2
Xclkbuf_5_8__f_clk _670_/CLK clkbuf_4_4_0_clk/X VPWR VGND sg13g2_buf_16
XFILLER_3_157 VPWR VGND sg13g2_decap_8
X_774_ _774_/X _774_/A VPWR VGND sg13g2_buf_1
Xlane2.t_exit.tempo VPWR VGND _426_/Y lane2.t_exit.tempo/ARM _664_/Q fanout50/X _558_/B2
+ tempo_t150n
XFILLER_15_275 VPWR VGND sg13g2_fill_2
XFILLER_7_474 VPWR VGND sg13g2_decap_8
XFILLER_21_256 VPWR VGND sg13g2_decap_8
XFILLER_29_334 VPWR VGND sg13g2_decap_8
XFILLER_29_301 VPWR VGND sg13g2_fill_2
XFILLER_28_56 VPWR VGND sg13g2_decap_8
XFILLER_12_256 VPWR VGND sg13g2_decap_8
X_490_ _665_/D _425_/Y _491_/B _489_/Y VPWR VGND sg13g2_o21ai_1
XFILLER_25_562 VPWR VGND sg13g2_fill_1
Xclkbuf_4_0_0_clk clkbuf_4_0_0_clk/X clkbuf_0_clk/X VPWR VGND sg13g2_buf_8
XFILLER_4_488 VPWR VGND sg13g2_decap_8
XFILLER_16_551 VPWR VGND sg13g2_decap_8
XFILLER_16_562 VPWR VGND sg13g2_fill_1
X_688_ _688_/Q _688_/CLK _688_/D _612_/Y VPWR VGND sg13g2_dfrbpq_1
XFILLER_7_282 VPWR VGND sg13g2_decap_4
XFILLER_22_510 VPWR VGND sg13g2_decap_8
XFILLER_30_46 VPWR VGND sg13g2_decap_8
XFILLER_17_348 VPWR VGND sg13g2_decap_8
X_611_ _611_/Y _611_/A VPWR VGND sg13g2_inv_1
X_542_ _714_/D _717_/D _718_/Q VPWR VGND sg13g2_xnor2_1
X_473_ _772_/A _688_/Q _776_/A _792_/A _473_/D VPWR VGND sg13g2_or4_1
XFILLER_29_164 VPWR VGND sg13g2_decap_8
XFILLER_13_543 VPWR VGND sg13g2_fill_1
XFILLER_4_263 VPWR VGND sg13g2_decap_8
XFILLER_23_318 VPWR VGND sg13g2_decap_8
XFILLER_25_35 VPWR VGND sg13g2_decap_8
XFILLER_25_79 VPWR VGND sg13g2_decap_8
XFILLER_17_178 VPWR VGND sg13g2_decap_8
X_525_ _525_/Y _720_/Q _525_/B VPWR VGND sg13g2_nand2_1
X_456_ _692_/D _694_/D _694_/Q VPWR VGND sg13g2_xnor2_1
XFILLER_9_311 VPWR VGND sg13g2_decap_8
XFILLER_23_148 VPWR VGND sg13g2_decap_8
XFILLER_27_465 VPWR VGND sg13g2_decap_8
XFILLER_10_398 VPWR VGND sg13g2_decap_8
XFILLER_22_192 VPWR VGND sg13g2_decap_8
XFILLER_13_192 VPWR VGND sg13g2_decap_8
X_508_ _647_/D _432_/Y _729_/Q _507_/Y VPWR VGND sg13g2_o21ai_1
X_439_ _528_/B _725_/Q VPWR VGND sg13g2_inv_1
XFILLER_5_391 VPWR VGND sg13g2_decap_8
XFILLER_3_93 VPWR VGND sg13g2_decap_8
XFILLER_28_207 VPWR VGND sg13g2_fill_1
Xlane1.t_trail.tempo_66 lane1.t_trail.tempo/ARM VPWR VGND sg13g2_tielo
XFILLER_11_107 VPWR VGND sg13g2_decap_8
XFILLER_22_14 VPWR VGND sg13g2_decap_4
XFILLER_3_306 VPWR VGND sg13g2_decap_8
X_790_ _790_/X _790_/A VPWR VGND sg13g2_buf_1
XFILLER_27_262 VPWR VGND sg13g2_decap_8
XFILLER_30_438 VPWR VGND sg13g2_decap_8
XFILLER_23_490 VPWR VGND sg13g2_fill_2
XFILLER_6_100 VPWR VGND sg13g2_decap_8
XFILLER_21_405 VPWR VGND sg13g2_decap_8
XFILLER_29_527 VPWR VGND sg13g2_decap_8
XFILLER_12_405 VPWR VGND sg13g2_decap_8
XFILLER_24_254 VPWR VGND sg13g2_decap_8
XFILLER_3_114 VPWR VGND sg13g2_decap_8
X_773_ _773_/X _773_/A VPWR VGND sg13g2_buf_1
XFILLER_28_560 VPWR VGND sg13g2_decap_8
XFILLER_15_254 VPWR VGND sg13g2_decap_8
XFILLER_30_268 VPWR VGND sg13g2_decap_8
XFILLER_21_235 VPWR VGND sg13g2_decap_8
XFILLER_29_313 VPWR VGND sg13g2_decap_8
XFILLER_28_35 VPWR VGND sg13g2_decap_8
XFILLER_25_552 VPWR VGND sg13g2_decap_4
XFILLER_12_224 VPWR VGND sg13g2_fill_1
XFILLER_12_235 VPWR VGND sg13g2_decap_8
XFILLER_4_467 VPWR VGND sg13g2_decap_8
XFILLER_4_412 VPWR VGND sg13g2_decap_8
X_687_ _776_/A _736_/CLK _687_/D _611_/Y VPWR VGND sg13g2_dfrbpq_1
XFILLER_22_0 VPWR VGND sg13g2_decap_8
XFILLER_30_25 VPWR VGND sg13g2_decap_8
X_610_ _610_/Y _619_/A VPWR VGND sg13g2_inv_1
XFILLER_17_327 VPWR VGND sg13g2_decap_8
X_541_ _541_/X _717_/D _718_/Q VPWR VGND sg13g2_or2_1
X_472_ _784_/A _788_/A _472_/B VPWR VGND sg13g2_nand2b_1
XFILLER_4_242 VPWR VGND sg13g2_decap_8
X_739_ _739_/Q _740_/CLK _739_/D _708_/Q VPWR VGND sg13g2_dfrbpq_1
XFILLER_6_93 VPWR VGND sg13g2_decap_8
XFILLER_25_14 VPWR VGND sg13g2_decap_8
XFILLER_22_396 VPWR VGND sg13g2_decap_8
XFILLER_22_341 VPWR VGND sg13g2_decap_8
XFILLER_17_124 VPWR VGND sg13g2_fill_1
XFILLER_17_157 VPWR VGND sg13g2_decap_8
X_524_ _720_/D _530_/C _525_/B _523_/Y VPWR VGND sg13g2_o21ai_1
X_455_ _695_/D _697_/Q _698_/Q VPWR VGND sg13g2_xnor2_1
XFILLER_13_396 VPWR VGND sg13g2_decap_8
XFILLER_27_444 VPWR VGND sg13g2_decap_8
XFILLER_6_348 VPWR VGND sg13g2_decap_8
XFILLER_22_171 VPWR VGND sg13g2_decap_8
XFILLER_13_171 VPWR VGND sg13g2_decap_8
X_507_ _507_/Y _648_/Q _507_/B VPWR VGND sg13g2_nand2_1
X_438_ _438_/Y _726_/Q VPWR VGND sg13g2_inv_1
XFILLER_9_197 VPWR VGND sg13g2_fill_2
XFILLER_3_72 VPWR VGND sg13g2_decap_8
XFILLER_27_241 VPWR VGND sg13g2_decap_8
XFILLER_30_417 VPWR VGND sg13g2_decap_8
XFILLER_10_185 VPWR VGND sg13g2_decap_8
XFILLER_6_178 VPWR VGND sg13g2_decap_8
XFILLER_18_263 VPWR VGND sg13g2_decap_8
XFILLER_29_506 VPWR VGND sg13g2_decap_8
XFILLER_24_299 VPWR VGND sg13g2_fill_2
XFILLER_24_233 VPWR VGND sg13g2_decap_8
X_772_ _772_/X _772_/A VPWR VGND sg13g2_buf_1
XFILLER_15_233 VPWR VGND sg13g2_decap_8
XFILLER_28_550 VPWR VGND sg13g2_decap_4
XFILLER_30_247 VPWR VGND sg13g2_decap_8
XFILLER_24_4 VPWR VGND sg13g2_decap_8
XFILLER_9_93 VPWR VGND sg13g2_decap_8
XFILLER_28_14 VPWR VGND sg13g2_decap_8
XFILLER_25_531 VPWR VGND sg13g2_decap_8
Xclkbuf_5_16__f_clk _740_/CLK clkbuf_4_8_0_clk/X VPWR VGND sg13g2_buf_16
X_686_ _792_/A _731_/CLK _686_/D _610_/Y VPWR VGND sg13g2_dfrbpq_1
XFILLER_3_490 VPWR VGND sg13g2_decap_8
XFILLER_19_391 VPWR VGND sg13g2_decap_8
XFILLER_17_306 VPWR VGND sg13g2_decap_8
X_540_ _721_/D _523_/A _435_/Y _539_/Y VPWR VGND sg13g2_o21ai_1
X_471_ _788_/A _684_/Q _691_/Q VPWR VGND sg13g2_nand2b_1
X_669_ _669_/Q _734_/CLK _669_/D _605_/Y VPWR VGND sg13g2_dfrbpq_1
X_738_ _738_/Q _738_/CLK _738_/D _689_/Q VPWR VGND sg13g2_dfrbpq_1
Xhold90 _633_/D _632_/Q VPWR VGND sg13g2_dlygate4sd3_1
XFILLER_6_72 VPWR VGND sg13g2_decap_8
XFILLER_22_320 VPWR VGND sg13g2_decap_8
XFILLER_17_114 VPWR VGND sg13g2_decap_8
X_523_ _523_/Y _523_/A _529_/A VPWR VGND sg13g2_nand2_1
XFILLER_13_353 VPWR VGND sg13g2_fill_2
X_454_ _699_/D _701_/Q _701_/D VPWR VGND sg13g2_xnor2_1
XFILLER_9_346 VPWR VGND sg13g2_decap_8
XFILLER_27_423 VPWR VGND sg13g2_decap_8
XFILLER_10_334 VPWR VGND sg13g2_decap_8
XFILLER_22_150 VPWR VGND sg13g2_decap_8
XFILLER_10_378 VPWR VGND sg13g2_fill_2
XFILLER_6_327 VPWR VGND sg13g2_decap_8
X_506_ _648_/D _431_/Y _507_/B _505_/Y VPWR VGND sg13g2_o21ai_1
XFILLER_18_412 VPWR VGND sg13g2_decap_8
XFILLER_13_150 VPWR VGND sg13g2_decap_8
X_437_ _437_/Y _719_/Q VPWR VGND sg13g2_inv_1
XFILLER_9_176 VPWR VGND sg13g2_decap_8
XFILLER_24_426 VPWR VGND sg13g2_decap_8
XFILLER_15_426 VPWR VGND sg13g2_decap_8
XFILLER_10_164 VPWR VGND sg13g2_decap_8
XFILLER_12_93 VPWR VGND sg13g2_decap_8
XFILLER_6_157 VPWR VGND sg13g2_decap_8
XFILLER_18_242 VPWR VGND sg13g2_decap_8
XFILLER_24_289 VPWR VGND sg13g2_fill_2
X_771_ _771_/X _771_/A VPWR VGND sg13g2_buf_1
XFILLER_30_226 VPWR VGND sg13g2_decap_8
XFILLER_7_488 VPWR VGND sg13g2_decap_8
XFILLER_9_72 VPWR VGND sg13g2_decap_8
XFILLER_29_348 VPWR VGND sg13g2_decap_8
Xlane0.t_prep.tempo_60 lane0.t_prep.tempo/ARM VPWR VGND sg13g2_tielo
XFILLER_25_510 VPWR VGND sg13g2_decap_8
X_685_ _780_/A _685_/CLK _685_/D _609_/Y VPWR VGND sg13g2_dfrbpq_1
XFILLER_11_270 VPWR VGND sg13g2_decap_8
XFILLER_7_263 VPWR VGND sg13g2_decap_8
Xclkbuf_5_22__f_clk _736_/CLK clkbuf_4_11_0_clk/X VPWR VGND sg13g2_buf_16
XFILLER_22_524 VPWR VGND sg13g2_decap_8
XFILLER_29_178 VPWR VGND sg13g2_decap_8
XFILLER_29_112 VPWR VGND sg13g2_decap_8
X_470_ _684_/D _418_/Y _557_/B2 _469_/Y VPWR VGND sg13g2_o21ai_1
XFILLER_25_384 VPWR VGND sg13g2_decap_8
XFILLER_16_384 VPWR VGND sg13g2_decap_8
X_599_ _599_/Y _603_/A VPWR VGND sg13g2_inv_1
X_668_ _668_/Q _731_/CLK _668_/D _604_/Y VPWR VGND sg13g2_dfrbpq_1
X_737_ _737_/Q _737_/CLK _737_/D _776_/A VPWR VGND sg13g2_dfrbpq_1
Xhold91 _677_/D _676_/Q VPWR VGND sg13g2_dlygate4sd3_1
Xhold80 _638_/D _637_/Q VPWR VGND sg13g2_dlygate4sd3_1
XFILLER_29_91 VPWR VGND sg13g2_decap_8
XFILLER_25_49 VPWR VGND sg13g2_decap_8
X_522_ _632_/D _633_/Q _634_/Q VPWR VGND sg13g2_xnor2_1
X_453_ _702_/D _702_/Q _703_/Q VPWR VGND sg13g2_xnor2_1
XFILLER_13_332 VPWR VGND sg13g2_decap_8
XFILLER_15_93 VPWR VGND sg13g2_decap_8
XFILLER_9_325 VPWR VGND sg13g2_decap_8
XFILLER_25_192 VPWR VGND sg13g2_decap_8
XFILLER_16_192 VPWR VGND sg13g2_decap_8
XFILLER_23_107 VPWR VGND sg13g2_decap_8
XFILLER_27_479 VPWR VGND sg13g2_decap_8
XFILLER_27_402 VPWR VGND sg13g2_decap_8
XFILLER_10_313 VPWR VGND sg13g2_decap_8
XFILLER_6_306 VPWR VGND sg13g2_decap_8
X_505_ _505_/Y _649_/Q _505_/B VPWR VGND sg13g2_nand2_1
X_436_ _530_/C _720_/Q VPWR VGND sg13g2_inv_1
XFILLER_9_100 VPWR VGND sg13g2_decap_8
XFILLER_9_155 VPWR VGND sg13g2_decap_8
XFILLER_24_405 VPWR VGND sg13g2_decap_8
XFILLER_15_405 VPWR VGND sg13g2_decap_8
XFILLER_27_276 VPWR VGND sg13g2_fill_1
XFILLER_12_72 VPWR VGND sg13g2_decap_8
XFILLER_6_114 VPWR VGND sg13g2_decap_8
Xlane2.t_lpx.tempo_69 lane2.t_lpx.tempo/ARM VPWR VGND sg13g2_tielo
XFILLER_5_0 VPWR VGND sg13g2_decap_8
Xclkbuf_5_3__f_clk _735_/CLK clkbuf_4_1_0_clk/X VPWR VGND sg13g2_buf_16
X_419_ _419_/Y _419_/A VPWR VGND sg13g2_inv_1
XFILLER_21_419 VPWR VGND sg13g2_decap_8
XFILLER_12_419 VPWR VGND sg13g2_decap_8
XFILLER_24_268 VPWR VGND sg13g2_decap_8
XFILLER_15_268 VPWR VGND sg13g2_decap_8
XFILLER_7_467 VPWR VGND sg13g2_decap_8
XFILLER_7_412 VPWR VGND sg13g2_decap_8
XFILLER_23_93 VPWR VGND sg13g2_decap_8
XFILLER_0_53 VPWR VGND sg13g2_decap_4
XFILLER_21_249 VPWR VGND sg13g2_decap_8
Xclkbuf_4_15_0_clk clkbuf_4_15_0_clk/X clkbuf_0_clk/X VPWR VGND sg13g2_buf_8
XFILLER_29_327 VPWR VGND sg13g2_decap_8
XFILLER_28_49 VPWR VGND sg13g2_decap_8
XFILLER_12_249 VPWR VGND sg13g2_decap_8
XFILLER_4_426 VPWR VGND sg13g2_decap_8
XFILLER_16_544 VPWR VGND sg13g2_decap_8
X_684_ _684_/Q _705_/CLK _684_/D _608_/Y VPWR VGND sg13g2_dfrbpq_1
XFILLER_28_382 VPWR VGND sg13g2_decap_8
XFILLER_18_93 VPWR VGND sg13g2_decap_8
XFILLER_7_242 VPWR VGND sg13g2_decap_8
XFILLER_22_503 VPWR VGND sg13g2_decap_8
XFILLER_30_39 VPWR VGND sg13g2_decap_8
XFILLER_29_157 VPWR VGND sg13g2_decap_8
XFILLER_25_341 VPWR VGND sg13g2_decap_8
XFILLER_13_514 VPWR VGND sg13g2_decap_4
XFILLER_4_256 VPWR VGND sg13g2_decap_8
X_736_ _736_/Q _736_/CLK _736_/D _473_/D VPWR VGND sg13g2_dfrbpq_1
Xhold92 _634_/D _633_/Q VPWR VGND sg13g2_dlygate4sd3_1
Xhold81 _693_/D _692_/Q VPWR VGND sg13g2_dlygate4sd3_1
XFILLER_29_70 VPWR VGND sg13g2_decap_8
XFILLER_16_341 VPWR VGND sg13g2_decap_8
X_598_ _598_/Y _603_/A VPWR VGND sg13g2_inv_1
X_667_ _777_/A _729_/CLK _667_/D _603_/Y VPWR VGND sg13g2_dfrbpq_1
XFILLER_25_28 VPWR VGND sg13g2_decap_8
XFILLER_13_311 VPWR VGND sg13g2_decap_8
X_521_ _635_/D _637_/Q _638_/Q VPWR VGND sg13g2_xnor2_1
X_452_ _589_/B _702_/Q _703_/Q VPWR VGND sg13g2_nand2b_1
XFILLER_25_171 VPWR VGND sg13g2_decap_8
XFILLER_15_72 VPWR VGND sg13g2_decap_8
XFILLER_9_304 VPWR VGND sg13g2_decap_8
X_719_ _719_/Q _726_/CLK _719_/D _624_/Y VPWR VGND sg13g2_dfrbpq_1
XFILLER_16_171 VPWR VGND sg13g2_decap_8
XFILLER_27_458 VPWR VGND sg13g2_decap_8
XFILLER_22_185 VPWR VGND sg13g2_decap_8
XFILLER_7_4 VPWR VGND sg13g2_decap_8
XFILLER_13_185 VPWR VGND sg13g2_decap_8
X_504_ _649_/D _430_/Y _505_/B _503_/Y VPWR VGND sg13g2_o21ai_1
X_435_ _435_/Y _529_/A VPWR VGND sg13g2_inv_1
XFILLER_5_384 VPWR VGND sg13g2_decap_8
XFILLER_3_86 VPWR VGND sg13g2_decap_8
XFILLER_27_200 VPWR VGND sg13g2_fill_1
XFILLER_27_255 VPWR VGND sg13g2_decap_8
XFILLER_19_9 VPWR VGND sg13g2_fill_1
X_418_ _418_/Y _684_/Q VPWR VGND sg13g2_inv_1
XFILLER_5_192 VPWR VGND sg13g2_decap_8
XFILLER_24_247 VPWR VGND sg13g2_decap_8
XFILLER_3_107 VPWR VGND sg13g2_decap_8
XFILLER_11_431 VPWR VGND sg13g2_fill_2
XFILLER_15_247 VPWR VGND sg13g2_decap_8
XFILLER_23_72 VPWR VGND sg13g2_decap_8
XFILLER_0_32 VPWR VGND sg13g2_decap_8
XFILLER_21_228 VPWR VGND sg13g2_decap_8
XFILLER_6_490 VPWR VGND sg13g2_decap_8
XFILLER_29_306 VPWR VGND sg13g2_decap_8
XFILLER_28_28 VPWR VGND sg13g2_decap_8
XFILLER_12_228 VPWR VGND sg13g2_decap_8
XFILLER_25_545 VPWR VGND sg13g2_decap_8
XFILLER_4_405 VPWR VGND sg13g2_decap_8
X_683_ _683_/Q _738_/CLK _683_/D _689_/Q VPWR VGND sg13g2_dfrbpq_1
XFILLER_18_72 VPWR VGND sg13g2_decap_8
XFILLER_30_18 VPWR VGND sg13g2_decap_8
XFILLER_25_320 VPWR VGND sg13g2_decap_8
XFILLER_4_235 VPWR VGND sg13g2_decap_8
X_735_ _735_/Q _735_/CLK _735_/D _688_/Q VPWR VGND sg13g2_dfrbpq_1
Xhold93 _716_/D _715_/Q VPWR VGND sg13g2_dlygate4sd3_1
Xhold82 _663_/D _662_/Q VPWR VGND sg13g2_dlygate4sd3_1
XFILLER_16_320 VPWR VGND sg13g2_decap_8
X_597_ _597_/Y _611_/A VPWR VGND sg13g2_inv_1
X_666_ _793_/A _727_/CLK _666_/D _602_/Y VPWR VGND sg13g2_dfrbpq_1
Xclkbuf_4_14_0_clk clkbuf_4_14_0_clk/X clkbuf_0_clk/X VPWR VGND sg13g2_buf_8
XFILLER_6_86 VPWR VGND sg13g2_decap_8
XFILLER_22_389 VPWR VGND sg13g2_decap_8
XFILLER_22_334 VPWR VGND sg13g2_decap_8
X_520_ _639_/D _641_/Q _640_/Q VPWR VGND sg13g2_xnor2_1
X_451_ _771_/A _775_/A _708_/Q _791_/A _451_/D VPWR VGND sg13g2_or4_1
XFILLER_25_150 VPWR VGND sg13g2_decap_8
XFILLER_13_389 VPWR VGND sg13g2_decap_8
XFILLER_16_150 VPWR VGND sg13g2_decap_8
X_649_ _649_/Q _734_/CLK _649_/D _597_/Y VPWR VGND sg13g2_dfrbpq_1
X_718_ _718_/Q _718_/CLK _718_/D _721_/Q VPWR VGND sg13g2_dfrbpq_1
XFILLER_27_437 VPWR VGND sg13g2_decap_8
XFILLER_10_348 VPWR VGND sg13g2_decap_8
XFILLER_22_164 VPWR VGND sg13g2_decap_8
X_503_ _503_/Y _650_/Q _503_/B VPWR VGND sg13g2_nand2_1
XFILLER_18_426 VPWR VGND sg13g2_decap_8
XFILLER_13_164 VPWR VGND sg13g2_decap_8
Xlane1.t_zero.tempo VPWR VGND _415_/Y lane1.t_zero.tempo/ARM _735_/Q fanout49/X _463_/B
+ tempo_t150n
X_434_ _434_/Y _644_/Q VPWR VGND sg13g2_inv_1
Xclkbuf_5_28__f_clk _732_/CLK clkbuf_4_14_0_clk/X VPWR VGND sg13g2_buf_16
XFILLER_27_234 VPWR VGND sg13g2_decap_8
XFILLER_10_112 VPWR VGND sg13g2_decap_8
XFILLER_10_178 VPWR VGND sg13g2_decap_8
XFILLER_18_256 VPWR VGND sg13g2_decap_8
X_417_ _417_/Y _473_/D VPWR VGND sg13g2_inv_1
XFILLER_5_171 VPWR VGND sg13g2_decap_8
XFILLER_24_226 VPWR VGND sg13g2_decap_8
XFILLER_15_226 VPWR VGND sg13g2_decap_8
XFILLER_28_554 VPWR VGND sg13g2_fill_2
XFILLER_28_543 VPWR VGND sg13g2_decap_8
XFILLER_11_410 VPWR VGND sg13g2_decap_8
XFILLER_23_270 VPWR VGND sg13g2_decap_8
XFILLER_0_11 VPWR VGND sg13g2_decap_8
Xclkbuf_5_11__f_clk _647_/CLK clkbuf_4_5_0_clk/X VPWR VGND sg13g2_buf_16
XFILLER_9_86 VPWR VGND sg13g2_decap_8
XFILLER_25_524 VPWR VGND sg13g2_decap_8
X_682_ _682_/Q _688_/CLK _682_/D _689_/Q VPWR VGND sg13g2_dfrbpq_1
XFILLER_3_483 VPWR VGND sg13g2_decap_8
XFILLER_19_384 VPWR VGND sg13g2_decap_8
XFILLER_22_538 VPWR VGND sg13g2_fill_2
XFILLER_13_549 VPWR VGND sg13g2_decap_8
XFILLER_25_398 VPWR VGND sg13g2_decap_8
XFILLER_21_560 VPWR VGND sg13g2_decap_8
X_665_ _781_/A _685_/CLK _665_/D _601_/Y VPWR VGND sg13g2_dfrbpq_1
X_734_ _734_/Q _734_/CLK _734_/D _669_/Q VPWR VGND sg13g2_dfrbpq_1
Xhold94 _718_/D _717_/Q VPWR VGND sg13g2_dlygate4sd3_1
Xhold83 _636_/D _635_/Q VPWR VGND sg13g2_dlygate4sd3_1
XFILLER_12_560 VPWR VGND sg13g2_fill_2
XFILLER_16_398 VPWR VGND sg13g2_decap_8
X_596_ _596_/Y _611_/A VPWR VGND sg13g2_inv_1
Xclkbuf_5_9__f_clk _734_/CLK clkbuf_4_4_0_clk/X VPWR VGND sg13g2_buf_16
XFILLER_22_313 VPWR VGND sg13g2_decap_8
XFILLER_19_192 VPWR VGND sg13g2_decap_8
XFILLER_17_107 VPWR VGND sg13g2_decap_8
XFILLER_13_346 VPWR VGND sg13g2_decap_8
XFILLER_15_52 VPWR VGND sg13g2_fill_2
X_450_ _783_/A _787_/A _450_/B VPWR VGND sg13g2_nand2b_1
XFILLER_9_339 VPWR VGND sg13g2_decap_8
X_648_ _648_/Q _648_/CLK _648_/D _596_/Y VPWR VGND sg13g2_dfrbpq_1
X_717_ _717_/Q _721_/CLK _717_/D _529_/A VPWR VGND sg13g2_dfrbpq_1
X_579_ _736_/D _676_/Q _578_/Y _736_/Q VPWR VGND sg13g2_a21o_1
XFILLER_27_416 VPWR VGND sg13g2_decap_8
XFILLER_10_327 VPWR VGND sg13g2_decap_8
Xclkbuf_4_13_0_clk clkbuf_4_13_0_clk/X clkbuf_0_clk/X VPWR VGND sg13g2_buf_8
X_502_ _650_/D _427_/Y _651_/Q _501_/Y VPWR VGND sg13g2_o21ai_1
X_433_ _433_/Y _517_/D VPWR VGND sg13g2_inv_1
XFILLER_18_405 VPWR VGND sg13g2_decap_8
XFILLER_9_169 VPWR VGND sg13g2_decap_8
XFILLER_9_114 VPWR VGND sg13g2_decap_8
XFILLER_5_353 VPWR VGND sg13g2_decap_4
XFILLER_3_11 VPWR VGND sg13g2_decap_8
XFILLER_3_66 VPWR VGND sg13g2_fill_1
XFILLER_24_419 VPWR VGND sg13g2_decap_8
XFILLER_15_419 VPWR VGND sg13g2_decap_8
XFILLER_10_157 VPWR VGND sg13g2_decap_8
XFILLER_23_496 VPWR VGND sg13g2_decap_8
XFILLER_12_86 VPWR VGND sg13g2_decap_8
X_416_ _416_/Y _776_/A VPWR VGND sg13g2_inv_1
XFILLER_18_235 VPWR VGND sg13g2_decap_8
XFILLER_5_150 VPWR VGND sg13g2_decap_8
XFILLER_28_522 VPWR VGND sg13g2_decap_8
XFILLER_7_426 VPWR VGND sg13g2_decap_8
XFILLER_19_544 VPWR VGND sg13g2_fill_2
X_681_ _681_/Q _737_/CLK _681_/D _776_/A VPWR VGND sg13g2_dfrbpq_1
XFILLER_28_341 VPWR VGND sg13g2_decap_8
XFILLER_16_536 VPWR VGND sg13g2_decap_4
XFILLER_16_558 VPWR VGND sg13g2_decap_4
XFILLER_28_396 VPWR VGND sg13g2_decap_8
XFILLER_11_263 VPWR VGND sg13g2_decap_8
XFILLER_7_256 VPWR VGND sg13g2_decap_8
XFILLER_7_212 VPWR VGND sg13g2_fill_1
XFILLER_3_462 VPWR VGND sg13g2_decap_8
XFILLER_22_517 VPWR VGND sg13g2_decap_8
XFILLER_19_341 VPWR VGND sg13g2_decap_8
XFILLER_30_561 VPWR VGND sg13g2_fill_2
XFILLER_30_550 VPWR VGND sg13g2_decap_8
XFILLER_29_105 VPWR VGND sg13g2_decap_8
Xlane3.t_exit.tempo VPWR VGND _434_/Y lane3.t_exit.tempo/ARM _644_/Q fanout51/X _559_/B2
+ tempo_t150n
X_595_ _595_/Y _611_/A VPWR VGND sg13g2_inv_1
X_664_ _664_/Q _664_/CLK _664_/D _600_/Y VPWR VGND sg13g2_dfrbpq_1
X_733_ _733_/Q _733_/CLK _733_/D _777_/A VPWR VGND sg13g2_dfrbpq_1
Xhold95 _643_/D _642_/Q VPWR VGND sg13g2_dlygate4sd3_1
Xhold84 _700_/D _699_/Q VPWR VGND sg13g2_dlygate4sd3_1
XFILLER_29_84 VPWR VGND sg13g2_decap_8
XFILLER_28_182 VPWR VGND sg13g2_decap_8
Xlane2.t_trail.tempo VPWR VGND _425_/Y lane2.t_trail.tempo/ARM _732_/Q fanout50/X
+ _491_/B tempo_t80n
XFILLER_3_270 VPWR VGND sg13g2_decap_8
XFILLER_19_171 VPWR VGND sg13g2_decap_8
XFILLER_13_325 VPWR VGND sg13g2_decap_8
XFILLER_15_86 VPWR VGND sg13g2_decap_8
XFILLER_9_318 VPWR VGND sg13g2_decap_8
XFILLER_25_185 VPWR VGND sg13g2_decap_8
XFILLER_21_391 VPWR VGND sg13g2_decap_8
Xoutput30 lp_p[2] _789_/X VPWR VGND sg13g2_buf_1
X_716_ _717_/D _718_/CLK _716_/D _529_/A VPWR VGND sg13g2_dfrbpq_1
XFILLER_16_185 VPWR VGND sg13g2_decap_8
X_578_ _578_/Y _678_/D _678_/Q _675_/Q VPWR VGND sg13g2_nor3_1
X_647_ _778_/A _647_/CLK _647_/D _595_/Y VPWR VGND sg13g2_dfrbpq_1
XFILLER_12_391 VPWR VGND sg13g2_decap_8
.ends
