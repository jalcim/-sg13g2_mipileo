* NGSPICE file created from dphy_tx.ext - technology: ihp-sg13g2

* Black-box entry subcircuit for sg13g2_decap_8 abstract view
.subckt sg13g2_decap_8 VDD VSS
.ends

* Black-box entry subcircuit for sg13g2_dlygate4sd3_1 abstract view
.subckt sg13g2_dlygate4sd3_1 X A VDD VSS
.ends

* Black-box entry subcircuit for sg13g2_fill_2 abstract view
.subckt sg13g2_fill_2 VDD VSS
.ends

* Black-box entry subcircuit for sg13g2_dfrbpq_1 abstract view
.subckt sg13g2_dfrbpq_1 Q CLK D RESET_B VDD VSS
.ends

* Black-box entry subcircuit for sg13g2_nand4_1 abstract view
.subckt sg13g2_nand4_1 Y A B C D VDD VSS
.ends

* Black-box entry subcircuit for sg13g2_buf_8 abstract view
.subckt sg13g2_buf_8 X A VDD VSS
.ends

* Black-box entry subcircuit for sg13g2_and2_1 abstract view
.subckt sg13g2_and2_1 X A B VDD VSS
.ends

* Black-box entry subcircuit for sg13g2_decap_4 abstract view
.subckt sg13g2_decap_4 VDD VSS
.ends

* Black-box entry subcircuit for sg13g2_fill_1 abstract view
.subckt sg13g2_fill_1 VDD VSS
.ends

* Black-box entry subcircuit for sg13g2_a21o_1 abstract view
.subckt sg13g2_a21o_1 X A1 A2 B1 VDD VSS
.ends

* Black-box entry subcircuit for sg13g2_nor3_1 abstract view
.subckt sg13g2_nor3_1 Y A B C VDD VSS
.ends

* Black-box entry subcircuit for sg13g2_nor4_1 abstract view
.subckt sg13g2_nor4_1 Y A B C D VDD VSS
.ends

* Black-box entry subcircuit for sg13g2_buf_1 abstract view
.subckt sg13g2_buf_1 X A VDD VSS
.ends

* Black-box entry subcircuit for sg13g2_dfrbpq_2 abstract view
.subckt sg13g2_dfrbpq_2 Q CLK D RESET_B VDD VSS
.ends

* Black-box entry subcircuit for sg13g2_inv_4 abstract view
.subckt sg13g2_inv_4 Y A VDD VSS
.ends

* Black-box entry subcircuit for sg13g2_nand2_1 abstract view
.subckt sg13g2_nand2_1 Y A B VDD VSS
.ends

* Black-box entry subcircuit for sg13g2_o21ai_1 abstract view
.subckt sg13g2_o21ai_1 Y A1 A2 B1 VDD VSS
.ends

* Black-box entry subcircuit for sg13g2_inv_1 abstract view
.subckt sg13g2_inv_1 Y A VDD VSS
.ends

* Black-box entry subcircuit for tempo_t80n abstract view
.subckt tempo_t80n VDD VSS RESET ARM INGRESS PG PROGRESS
.ends

* Black-box entry subcircuit for sg13g2_tielo abstract view
.subckt sg13g2_tielo L_LO VDD VSS
.ends

* Black-box entry subcircuit for sg13g2_xnor2_1 abstract view
.subckt sg13g2_xnor2_1 Y A B VDD VSS
.ends

* Black-box entry subcircuit for sg13g2_xor2_1 abstract view
.subckt sg13g2_xor2_1 X A B VDD VSS
.ends

* Black-box entry subcircuit for sg13g2_and2_2 abstract view
.subckt sg13g2_and2_2 X A B VDD VSS
.ends

* Black-box entry subcircuit for sg13g2_or4_1 abstract view
.subckt sg13g2_or4_1 X A B C D VDD VSS
.ends

* Black-box entry subcircuit for tempo_t60n abstract view
.subckt tempo_t60n VDD VSS RESET ARM INGRESS PG PROGRESS
.ends

* Black-box entry subcircuit for sg13g2_nand3_1 abstract view
.subckt sg13g2_nand3_1 Y A B C VDD VSS
.ends

* Black-box entry subcircuit for sg13g2_nor2_1 abstract view
.subckt sg13g2_nor2_1 Y A B VDD VSS
.ends

* Black-box entry subcircuit for sg13g2_a21oi_1 abstract view
.subckt sg13g2_a21oi_1 Y A1 A2 B1 VDD VSS
.ends

* Black-box entry subcircuit for sg13g2_and4_1 abstract view
.subckt sg13g2_and4_1 X A B C D VDD VSS
.ends

* Black-box entry subcircuit for sg13g2_nor2_2 abstract view
.subckt sg13g2_nor2_2 Y A B VDD VSS
.ends

* Black-box entry subcircuit for sg13g2_nand2b_1 abstract view
.subckt sg13g2_nand2b_1 Y A_N B VDD VSS
.ends

* Black-box entry subcircuit for sg13g2_nor2b_1 abstract view
.subckt sg13g2_nor2b_1 Y A B_N VDD VSS
.ends

* Black-box entry subcircuit for sg13g2_nor3_2 abstract view
.subckt sg13g2_nor3_2 Y A B C VDD VSS
.ends

* Black-box entry subcircuit for sg13g2_a221oi_1 abstract view
.subckt sg13g2_a221oi_1 Y A1 A2 B1 B2 C1 VDD VSS
.ends

* Black-box entry subcircuit for sg13g2_or3_1 abstract view
.subckt sg13g2_or3_1 X A B C VDD VSS
.ends

* Black-box entry subcircuit for tempo_t150n abstract view
.subckt tempo_t150n VDD VSS RESET ARM INGRESS PG PROGRESS
.ends

* Black-box entry subcircuit for sg13g2_inv_8 abstract view
.subckt sg13g2_inv_8 Y A VDD VSS
.ends

* Black-box entry subcircuit for sg13g2_inv_2 abstract view
.subckt sg13g2_inv_2 Y A VDD VSS
.ends

* Black-box entry subcircuit for sg13g2_or2_1 abstract view
.subckt sg13g2_or2_1 X A B VDD VSS
.ends

* Black-box entry subcircuit for sg13g2_buf_16 abstract view
.subckt sg13g2_buf_16 X A VDD VSS
.ends

* Black-box entry subcircuit for sg13g2_nor2b_2 abstract view
.subckt sg13g2_nor2b_2 Y A B_N VDD VSS
.ends

* Black-box entry subcircuit for sg13g2_nand2b_2 abstract view
.subckt sg13g2_nand2b_2 Y A_N B VDD VSS
.ends

* Black-box entry subcircuit for sg13g2_buf_2 abstract view
.subckt sg13g2_buf_2 X A VDD VSS
.ends

* Black-box entry subcircuit for sg13g2_nand2_2 abstract view
.subckt sg13g2_nand2_2 Y A B VDD VSS
.ends

* Black-box entry subcircuit for sg13g2_a22oi_1 abstract view
.subckt sg13g2_a22oi_1 Y A1 A2 B1 B2 VDD VSS
.ends

* Black-box entry subcircuit for sg13g2_inv_16 abstract view
.subckt sg13g2_inv_16 Y A VDD VSS
.ends

* Black-box entry subcircuit for sg13g2_a21oi_2 abstract view
.subckt sg13g2_a21oi_2 Y A1 A2 B1 VDD VSS
.ends

* Black-box entry subcircuit for sg13g2_nor4_2 abstract view
.subckt sg13g2_nor4_2 Y A B C D VDD VSS
.ends

* Black-box entry subcircuit for sg13g2_and4_2 abstract view
.subckt sg13g2_and4_2 X A B C D VDD VSS
.ends

* Black-box entry subcircuit for sg13g2_nand3b_1 abstract view
.subckt sg13g2_nand3b_1 Y A_N B C VDD VSS
.ends

* Black-box entry subcircuit for tempo_t350n abstract view
.subckt tempo_t350n VDD VSS RESET ARM INGRESS PG PROGRESS
.ends

* Black-box entry subcircuit for sg13g2_and3_1 abstract view
.subckt sg13g2_and3_1 X A B C VDD VSS
.ends

* Black-box entry subcircuit for sg13g2_buf_4 abstract view
.subckt sg13g2_buf_4 X A VDD VSS
.ends

.subckt dphy_tx PG VGND VPWR clk clk_hs_oe clk_lp_n clk_lp_p clk_ready clk_request
+ clk_run hs_oe[0] hs_oe[1] hs_oe[2] hs_oe[3] hs_sync[0] hs_sync[1] hs_sync[2] hs_sync[3]
+ hs_trail[0] hs_trail[1] hs_trail[2] hs_trail[3] lp_n[0] lp_n[1] lp_n[2] lp_n[3]
+ lp_p[0] lp_p[1] lp_p[2] lp_p[3] rst tx_ready_hs[0] tx_ready_hs[1] tx_ready_hs[2]
+ tx_ready_hs[3] tx_request_hs[0] tx_request_hs[1] tx_request_hs[2] tx_request_hs[3]
XFILLER_22_100 VPWR VGND sg13g2_decap_8
Xhold351 _0893_/A _1049_/Q VPWR VGND sg13g2_dlygate4sd3_1
XFILLER_13_100 VPWR VGND sg13g2_decap_8
XFILLER_1_560 VPWR VGND sg13g2_fill_2
XFILLER_5_398 VPWR VGND sg13g2_decap_8
X_0985_ _0985_/Q _0991_/CLK _0985_/D _0916_/X VPWR VGND sg13g2_dfrbpq_1
XFILLER_10_114 VPWR VGND sg13g2_decap_8
XFILLER_6_107 VPWR VGND sg13g2_decap_8
Xhold181 _0950_/A _1036_/Q VPWR VGND sg13g2_dlygate4sd3_1
Xhold192 hold192/X _1035_/Q VPWR VGND sg13g2_dlygate4sd3_1
X_0770_ _0771_/B _0989_/Q _0988_/Q _0987_/Q _0778_/D VPWR VGND sg13g2_nand4_1
XFILLER_24_228 VPWR VGND sg13g2_decap_8
Xclkbuf_4_12_0_clk _1011_/CLK clkbuf_0_clk/X VPWR VGND sg13g2_buf_8
X_0968_ _0968_/Q _0999_/CLK _0968_/D _0907_/X VPWR VGND sg13g2_dfrbpq_1
X_0899_ _0899_/X _0899_/A _0901_/B VPWR VGND sg13g2_and2_1
XFILLER_28_512 VPWR VGND sg13g2_decap_8
XFILLER_11_467 VPWR VGND sg13g2_decap_4
XFILLER_7_405 VPWR VGND sg13g2_decap_8
XFILLER_23_86 VPWR VGND sg13g2_decap_8
XFILLER_23_53 VPWR VGND sg13g2_fill_1
XFILLER_0_46 VPWR VGND sg13g2_decap_8
X_0822_ _0823_/B _0824_/A _0828_/A _0820_/A VPWR VGND sg13g2_a21o_1
X_0753_ _0753_/Y _0920_/A _0760_/B _0760_/C VPWR VGND sg13g2_nor3_1
X_0684_ _0684_/Y _1031_/Q _1030_/Q _1029_/Q _0684_/D VPWR VGND sg13g2_nor4_1
XFILLER_29_0 VPWR VGND sg13g2_decap_8
X_1098_ _1098_/X _1098_/A VPWR VGND sg13g2_buf_1
XFILLER_25_548 VPWR VGND sg13g2_decap_8
XFILLER_25_515 VPWR VGND sg13g2_decap_8
XFILLER_4_419 VPWR VGND sg13g2_decap_8
XFILLER_18_86 VPWR VGND sg13g2_decap_8
XFILLER_28_320 VPWR VGND sg13g2_decap_8
XFILLER_11_242 VPWR VGND sg13g2_decap_8
XFILLER_7_235 VPWR VGND sg13g2_decap_8
XFILLER_3_463 VPWR VGND sg13g2_decap_8
XFILLER_19_320 VPWR VGND sg13g2_decap_8
X_1021_ _1021_/Q _1021_/CLK _1021_/D _0939_/Y VPWR VGND sg13g2_dfrbpq_2
XFILLER_22_529 VPWR VGND sg13g2_decap_8
X_0805_ _0805_/Y _0805_/A VPWR VGND sg13g2_inv_4
XFILLER_30_562 VPWR VGND sg13g2_fill_1
X_0736_ _0736_/Y _0736_/A _0736_/B VPWR VGND sg13g2_nand2_1
X_0667_ _0667_/Y _0667_/A1 _0664_/Y _0666_/X VPWR VGND sg13g2_o21ai_1
X_0598_ _0598_/Y _0598_/A VPWR VGND sg13g2_inv_1
XFILLER_25_334 VPWR VGND sg13g2_decap_8
XFILLER_4_249 VPWR VGND sg13g2_decap_8
Xlane3.t_lpx.tempo VPWR VGND _0849_/B lane3.t_lpx.tempo/ARM _0798_/Y fanout63/X _0799_/B
+ tempo_t80n
XFILLER_16_334 VPWR VGND sg13g2_decap_8
XFILLER_28_150 VPWR VGND sg13g2_decap_8
XFILLER_19_150 VPWR VGND sg13g2_decap_8
Xlane1.t_lpx.tempo_75 lane1.t_lpx.tempo/ARM VPWR VGND sg13g2_tielo
X_1004_ _1004_/Q _1052_/CLK _1004_/D _0928_/Y VPWR VGND sg13g2_dfrbpq_1
XFILLER_22_348 VPWR VGND sg13g2_decap_8
Xrebuffer129 _0812_/A _0801_/A VPWR VGND sg13g2_buf_1
Xrebuffer118 _0901_/B _0804_/A VPWR VGND sg13g2_buf_1
Xrebuffer107 _0914_/B _0757_/B VPWR VGND sg13g2_buf_1
X_0719_ _0719_/Y _0719_/A _0719_/B _0719_/C _0719_/D VPWR VGND sg13g2_nand4_1
XFILLER_25_164 VPWR VGND sg13g2_decap_8
XFILLER_13_348 VPWR VGND sg13g2_decap_8
Xoutput7 clk_hs_oe _0838_/Y VPWR VGND sg13g2_buf_1
Xoutput31 lp_p[3] _1096_/X VPWR VGND sg13g2_buf_1
Xoutput20 hs_trail[0] _1085_/X VPWR VGND sg13g2_buf_1
XFILLER_16_164 VPWR VGND sg13g2_decap_8
XFILLER_11_0 VPWR VGND sg13g2_decap_8
XFILLER_22_178 VPWR VGND sg13g2_decap_8
Xhold341 _0895_/B _0894_/Y VPWR VGND sg13g2_dlygate4sd3_1
Xlane0.t_zero.tempo_73 lane0.t_zero.tempo/ARM VPWR VGND sg13g2_tielo
XFILLER_13_178 VPWR VGND sg13g2_decap_8
XFILLER_3_79 VPWR VGND sg13g2_decap_8
X_0984_ _0984_/Q _1014_/CLK _0984_/D _0915_/X VPWR VGND sg13g2_dfrbpq_1
Xhold182 _0875_/A _1017_/Q VPWR VGND sg13g2_dlygate4sd3_1
XFILLER_5_185 VPWR VGND sg13g2_decap_8
XFILLER_17_270 VPWR VGND sg13g2_decap_8
X_0967_ _0967_/Q _0976_/CLK _0967_/D _0906_/X VPWR VGND sg13g2_dfrbpq_1
XFILLER_9_480 VPWR VGND sg13g2_decap_8
X_0898_ _1045_/D _0898_/A VPWR VGND sg13g2_buf_1
XFILLER_0_25 VPWR VGND sg13g2_decap_8
X_0821_ _0968_/D _0968_/Q _0823_/A VPWR VGND sg13g2_xnor2_1
X_0752_ _0752_/Y _0920_/A _0752_/B _0754_/B VPWR VGND sg13g2_nor3_1
X_0683_ _1029_/D _0683_/A _0687_/A VPWR VGND sg13g2_xor2_1
XFILLER_6_483 VPWR VGND sg13g2_decap_8
X_1097_ _1097_/X _1097_/A VPWR VGND sg13g2_buf_1
XFILLER_25_527 VPWR VGND sg13g2_decap_8
Xlane2.t_lpx.tempo VPWR VGND _0846_/B lane2.t_lpx.tempo/ARM _0751_/Y fanout63/X _0752_/B
+ tempo_t80n
XFILLER_11_287 VPWR VGND sg13g2_fill_2
X_1020_ _1020_/Q _1020_/CLK _1020_/D _0938_/Y VPWR VGND sg13g2_dfrbpq_2
Xclkbuf_4_11_0_clk _1035_/CLK clkbuf_0_clk/X VPWR VGND sg13g2_buf_8
XFILLER_30_541 VPWR VGND sg13g2_decap_8
XFILLER_22_508 VPWR VGND sg13g2_decap_8
X_0804_ _0805_/A _0804_/A _0804_/B VPWR VGND sg13g2_and2_2
X_0735_ _0735_/X _1006_/Q _0736_/B VPWR VGND sg13g2_xor2_1
X_0666_ _0666_/X _0942_/A _0666_/B _1040_/Q input3/X VPWR VGND sg13g2_or4_1
X_0597_ _0853_/A _0597_/A VPWR VGND sg13g2_inv_1
XFILLER_29_107 VPWR VGND sg13g2_decap_8
XFILLER_25_313 VPWR VGND sg13g2_decap_8
XFILLER_4_228 VPWR VGND sg13g2_decap_8
XFILLER_29_86 VPWR VGND sg13g2_decap_8
XFILLER_16_313 VPWR VGND sg13g2_decap_8
Xclk_lane.t_lpx.tempo_65 clk_lane.t_lpx.tempo/ARM VPWR VGND sg13g2_tielo
XFILLER_6_79 VPWR VGND sg13g2_decap_8
XFILLER_6_68 VPWR VGND sg13g2_fill_1
XFILLER_13_4 VPWR VGND sg13g2_decap_8
X_1003_ _1003_/Q _1036_/CLK _1003_/D _0927_/Y VPWR VGND sg13g2_dfrbpq_1
Xrebuffer119 rebuffer119/X _0758_/A VPWR VGND sg13g2_buf_1
Xrebuffer108 rebuffer108/X _0805_/A VPWR VGND sg13g2_buf_1
XFILLER_22_327 VPWR VGND sg13g2_decap_8
X_0718_ _1021_/D _0718_/A _0926_/A VPWR VGND sg13g2_xor2_1
X_0649_ _0649_/X _0657_/B _0948_/A VPWR VGND sg13g2_and2_2
XFILLER_13_327 VPWR VGND sg13g2_decap_8
Xoutput8 clk_lp_n _0837_/Y VPWR VGND sg13g2_buf_1
Xoutput32 tx_ready_hs[0] _1097_/X VPWR VGND sg13g2_buf_1
Xoutput21 hs_trail[1] _1086_/X VPWR VGND sg13g2_buf_1
Xoutput10 clk_ready _0629_/X VPWR VGND sg13g2_buf_1
XFILLER_16_121 VPWR VGND sg13g2_fill_2
XFILLER_29_482 VPWR VGND sg13g2_decap_8
Xlane0.t_prep.tempo VPWR VGND _0654_/A lane0.t_prep.tempo/ARM _1037_/Q fanout61/X
+ _0608_/A tempo_t60n
Xclk_lane.t_exit.tempo_64 clk_lane.t_exit.tempo/ARM VPWR VGND sg13g2_tielo
XFILLER_10_319 VPWR VGND sg13g2_decap_8
XFILLER_22_157 VPWR VGND sg13g2_decap_8
Xhold320 hold320/X _0664_/A VPWR VGND sg13g2_dlygate4sd3_1
Xhold342 _0884_/A _1050_/Q VPWR VGND sg13g2_dlygate4sd3_1
XFILLER_13_157 VPWR VGND sg13g2_decap_8
XFILLER_5_334 VPWR VGND sg13g2_decap_8
XFILLER_1_562 VPWR VGND sg13g2_fill_1
X_0983_ _0983_/Q _1020_/CLK _0983_/D _0914_/X VPWR VGND sg13g2_dfrbpq_1
XFILLER_27_249 VPWR VGND sg13g2_decap_8
Xhold183 _1017_/D _0875_/Y VPWR VGND sg13g2_dlygate4sd3_1
Xhold194 _1026_/D _0689_/Y VPWR VGND sg13g2_dlygate4sd3_1
XFILLER_18_249 VPWR VGND sg13g2_decap_8
XFILLER_5_164 VPWR VGND sg13g2_decap_8
XFILLER_5_120 VPWR VGND sg13g2_fill_1
Xlane1.t_lpx.tempo VPWR VGND _0843_/A lane1.t_lpx.tempo/ARM _0698_/Y fanout61/X _0605_/A
+ tempo_t80n
X_0966_ _0966_/Q _0999_/CLK _0966_/D _0905_/X VPWR VGND sg13g2_dfrbpq_1
X_0897_ _0897_/Y _0595_/Y _0894_/Y _0596_/Y VPWR VGND sg13g2_o21ai_1
XFILLER_9_470 VPWR VGND sg13g2_decap_4
XFILLER_28_547 VPWR VGND sg13g2_decap_8
XFILLER_23_263 VPWR VGND sg13g2_decap_8
X_0820_ _0823_/A _0820_/A _0824_/A _0828_/A VPWR VGND sg13g2_nand3_1
X_0751_ _0751_/Y _0846_/B VPWR VGND sg13g2_inv_1
XFILLER_9_79 VPWR VGND sg13g2_decap_8
XFILLER_6_462 VPWR VGND sg13g2_decap_8
X_0682_ _1030_/D _0682_/A _0682_/B VPWR VGND sg13g2_and2_1
X_1096_ _1096_/X _1096_/A VPWR VGND sg13g2_buf_1
X_0949_ _0949_/X _0949_/A _0949_/B VPWR VGND sg13g2_and2_1
XFILLER_18_11 VPWR VGND sg13g2_fill_1
XFILLER_1_0 VPWR VGND sg13g2_decap_8
XFILLER_3_498 VPWR VGND sg13g2_decap_8
XFILLER_30_520 VPWR VGND sg13g2_decap_8
X_0803_ _0803_/Y _0848_/B VPWR VGND sg13g2_inv_1
X_0734_ _1007_/D _0734_/A _0734_/B VPWR VGND sg13g2_nor2_1
X_0665_ _0672_/C _0609_/Y _0656_/Y _0662_/Y VPWR VGND sg13g2_a21oi_1
XFILLER_6_270 VPWR VGND sg13g2_decap_8
X_0596_ _0596_/Y _0884_/B VPWR VGND sg13g2_inv_1
XFILLER_13_509 VPWR VGND sg13g2_decap_8
X_1079_ _1079_/X _1079_/A VPWR VGND sg13g2_buf_1
XFILLER_12_553 VPWR VGND sg13g2_fill_2
XFILLER_28_185 VPWR VGND sg13g2_decap_8
XFILLER_19_185 VPWR VGND sg13g2_decap_8
X_1002_ _1002_/Q _1025_/CLK _1002_/D _0926_/Y VPWR VGND sg13g2_dfrbpq_1
XFILLER_22_306 VPWR VGND sg13g2_decap_8
Xrebuffer109 _0802_/C _0977_/Q VPWR VGND sg13g2_buf_1
X_0717_ _0718_/A _0719_/D _0717_/B _0717_/C _0844_/B VPWR VGND sg13g2_and4_1
X_0648_ _0657_/B _0655_/B _1040_/Q VPWR VGND sg13g2_nor2_2
XFILLER_13_306 VPWR VGND sg13g2_decap_8
XFILLER_25_100 VPWR VGND sg13g2_decap_8
Xclkbuf_4_10_0_clk _1051_/CLK clkbuf_0_clk/X VPWR VGND sg13g2_buf_8
Xoutput9 clk_lp_p _0836_/Y VPWR VGND sg13g2_buf_1
Xoutput33 tx_ready_hs[1] _1098_/X VPWR VGND sg13g2_buf_1
Xoutput22 hs_trail[2] _1087_/X VPWR VGND sg13g2_buf_1
Xoutput11 clk_run _0851_/Y VPWR VGND sg13g2_buf_1
XFILLER_16_100 VPWR VGND sg13g2_decap_8
XFILLER_29_461 VPWR VGND sg13g2_decap_8
XFILLER_22_114 VPWR VGND sg13g2_decap_8
Xhold310 _0820_/A _0967_/Q VPWR VGND sg13g2_dlygate4sd3_1
Xhold332 _0674_/A _1040_/Q VPWR VGND sg13g2_dlygate4sd3_1
XFILLER_13_114 VPWR VGND sg13g2_decap_8
XFILLER_9_107 VPWR VGND sg13g2_decap_8
XFILLER_5_313 VPWR VGND sg13g2_decap_8
XFILLER_1_552 VPWR VGND sg13g2_fill_2
Xlane0.t_lpx.tempo VPWR VGND _0840_/C lane0.t_lpx.tempo/ARM _0661_/Y fanout61/X _0662_/D
+ tempo_t80n
X_0982_ _0982_/Q _1024_/CLK _0982_/D _0913_/X VPWR VGND sg13g2_dfrbpq_1
XFILLER_27_228 VPWR VGND sg13g2_decap_8
XFILLER_12_79 VPWR VGND sg13g2_decap_8
Xhold184 _0859_/A _0975_/Q VPWR VGND sg13g2_dlygate4sd3_1
XFILLER_18_228 VPWR VGND sg13g2_decap_8
Xclk_lane.t_prep.tempo VPWR VGND _0617_/A clk_lane.t_prep.tempo/ARM _0617_/Y fanout61/X
+ _0618_/B tempo_t60n
X_0965_ _0965_/Q _0972_/CLK _0965_/D _0904_/X VPWR VGND sg13g2_dfrbpq_1
X_0896_ _1050_/D _0887_/B _0896_/B VPWR VGND sg13g2_nand2b_1
XFILLER_28_526 VPWR VGND sg13g2_decap_8
XFILLER_7_419 VPWR VGND sg13g2_decap_8
XFILLER_23_286 VPWR VGND sg13g2_fill_1
XFILLER_23_242 VPWR VGND sg13g2_decap_8
XFILLER_10_470 VPWR VGND sg13g2_fill_1
X_0750_ _0846_/B _0754_/B _0914_/A VPWR VGND sg13g2_nand2b_1
X_0681_ _0682_/B _0683_/A _0687_/A _0679_/A VPWR VGND sg13g2_a21o_1
X_1095_ _1095_/X _1095_/A VPWR VGND sg13g2_buf_1
X_0948_ _0948_/X _0948_/A _0948_/B VPWR VGND sg13g2_and2_1
X_0879_ _1034_/D _0878_/A _0877_/B _0878_/Y VPWR VGND sg13g2_a21oi_1
XFILLER_28_334 VPWR VGND sg13g2_decap_8
XFILLER_24_562 VPWR VGND sg13g2_decap_8
XFILLER_11_256 VPWR VGND sg13g2_decap_8
XFILLER_7_249 VPWR VGND sg13g2_decap_8
XFILLER_3_477 VPWR VGND sg13g2_decap_8
XFILLER_19_334 VPWR VGND sg13g2_decap_8
X_0802_ _0848_/B _0908_/A _0802_/B _0802_/C VPWR VGND sg13g2_nand3_1
X_0733_ _0733_/Y _1006_/Q _0736_/B _1007_/Q VPWR VGND sg13g2_a21oi_1
X_0664_ _0664_/Y _0664_/A VPWR VGND sg13g2_inv_1
X_0595_ _0595_/Y _1050_/Q VPWR VGND sg13g2_inv_1
X_1078_ _1078_/X _1078_/A VPWR VGND sg13g2_buf_1
XFILLER_25_348 VPWR VGND sg13g2_decap_8
XFILLER_21_554 VPWR VGND sg13g2_fill_2
XFILLER_21_543 VPWR VGND sg13g2_decap_8
XFILLER_16_348 VPWR VGND sg13g2_decap_8
XFILLER_28_164 VPWR VGND sg13g2_decap_8
XFILLER_12_532 VPWR VGND sg13g2_decap_8
XFILLER_3_263 VPWR VGND sg13g2_decap_8
XFILLER_15_370 VPWR VGND sg13g2_fill_1
XFILLER_19_164 VPWR VGND sg13g2_decap_8
X_1001_ _1001_/Q _1024_/CLK _1001_/D rebuffer123/X VPWR VGND sg13g2_dfrbpq_1
X_0716_ _0721_/A _0716_/A _0719_/C _0719_/B VPWR VGND sg13g2_nand3_1
X_0647_ _0841_/B _0942_/B _0942_/C VPWR VGND sg13g2_nor2_1
XFILLER_15_79 VPWR VGND sg13g2_decap_8
XFILLER_25_178 VPWR VGND sg13g2_decap_8
Xoutput34 tx_ready_hs[2] _1099_/X VPWR VGND sg13g2_buf_1
Xoutput23 hs_trail[3] _1088_/X VPWR VGND sg13g2_buf_1
Xoutput12 hs_oe[0] _1077_/X VPWR VGND sg13g2_buf_1
XFILLER_29_440 VPWR VGND sg13g2_decap_8
XFILLER_16_178 VPWR VGND sg13g2_decap_8
Xhold311 _0765_/B _0847_/A VPWR VGND sg13g2_dlygate4sd3_1
Xhold322 _0815_/B _0800_/C VPWR VGND sg13g2_dlygate4sd3_1
Xhold333 _0721_/B _1019_/Q VPWR VGND sg13g2_dlygate4sd3_1
XFILLER_30_192 VPWR VGND sg13g2_decap_8
Xhold355 _0890_/A _1047_/Q VPWR VGND sg13g2_dlygate4sd3_1
Xhold366 _0940_/A _0942_/A VPWR VGND sg13g2_dlygate4sd3_1
XFILLER_21_192 VPWR VGND sg13g2_decap_8
XFILLER_29_270 VPWR VGND sg13g2_decap_8
X_0981_ _0981_/Q _1024_/CLK _0981_/D _0912_/X VPWR VGND sg13g2_dfrbpq_1
XFILLER_12_192 VPWR VGND sg13g2_decap_8
XFILLER_4_391 VPWR VGND sg13g2_decap_8
XFILLER_10_107 VPWR VGND sg13g2_decap_8
XFILLER_12_14 VPWR VGND sg13g2_decap_4
Xhold185 _0975_/D _0859_/Y VPWR VGND sg13g2_dlygate4sd3_1
Xhold196 _0781_/B _0780_/Y VPWR VGND sg13g2_dlygate4sd3_1
XFILLER_5_111 VPWR VGND sg13g2_decap_8
XFILLER_13_490 VPWR VGND sg13g2_fill_2
X_0964_ _0964_/Q _0972_/CLK _0964_/D _0903_/X VPWR VGND sg13g2_dfrbpq_1
X_0895_ _0896_/B _0895_/A _0895_/B VPWR VGND sg13g2_xnor2_1
XFILLER_28_505 VPWR VGND sg13g2_decap_8
XFILLER_23_79 VPWR VGND sg13g2_decap_8
XFILLER_0_39 VPWR VGND sg13g2_decap_8
XFILLER_27_560 VPWR VGND sg13g2_decap_8
X_0680_ _1031_/D _0680_/A _0682_/A VPWR VGND sg13g2_xnor2_1
XFILLER_6_497 VPWR VGND sg13g2_decap_8
X_1094_ _1094_/X _1094_/A VPWR VGND sg13g2_buf_1
XFILLER_25_508 VPWR VGND sg13g2_decap_8
X_0947_ _0947_/X _0948_/A _0948_/B VPWR VGND sg13g2_and2_1
X_0878_ _0878_/Y _0878_/A _0950_/A VPWR VGND sg13g2_nor2b_1
XFILLER_18_79 VPWR VGND sg13g2_decap_8
XFILLER_28_313 VPWR VGND sg13g2_decap_8
XFILLER_11_235 VPWR VGND sg13g2_decap_8
XFILLER_24_541 VPWR VGND sg13g2_decap_8
XFILLER_7_228 VPWR VGND sg13g2_decap_8
XFILLER_3_412 VPWR VGND sg13g2_decap_8
XFILLER_19_313 VPWR VGND sg13g2_decap_8
X_0801_ _1100_/A _0801_/A _0801_/B VPWR VGND sg13g2_nor2_1
XFILLER_30_555 VPWR VGND sg13g2_decap_8
X_0732_ _0736_/B _0731_/Y _1011_/Q VPWR VGND sg13g2_nand2b_1
X_0663_ _0664_/A _0942_/A _0942_/B _0942_/C VPWR VGND sg13g2_nor3_2
X_0594_ _0830_/A _0594_/A VPWR VGND sg13g2_inv_1
X_1077_ _1077_/X _1077_/A VPWR VGND sg13g2_buf_1
XFILLER_25_327 VPWR VGND sg13g2_decap_8
XFILLER_21_522 VPWR VGND sg13g2_decap_8
XFILLER_16_327 VPWR VGND sg13g2_decap_8
XFILLER_12_511 VPWR VGND sg13g2_decap_8
XFILLER_12_555 VPWR VGND sg13g2_fill_1
XFILLER_3_242 VPWR VGND sg13g2_decap_8
XFILLER_19_121 VPWR VGND sg13g2_fill_1
X_1000_ _1000_/Q _1021_/CLK _1000_/D _0925_/Y VPWR VGND sg13g2_dfrbpq_2
X_0715_ _0715_/Y input4/X _1098_/A _0604_/Y _0710_/Y _0714_/Y VPWR VGND sg13g2_a221oi_1
XFILLER_7_570 VPWR VGND sg13g2_fill_1
XFILLER_30_341 VPWR VGND sg13g2_decap_8
X_0646_ _1043_/D _0898_/A _0646_/B _0646_/C VPWR VGND sg13g2_or3_1
XFILLER_25_157 VPWR VGND sg13g2_decap_8
XFILLER_25_135 VPWR VGND sg13g2_fill_2
XFILLER_21_341 VPWR VGND sg13g2_decap_8
Xoutput35 tx_ready_hs[3] _1100_/X VPWR VGND sg13g2_buf_1
Xoutput24 lp_n[0] _1089_/X VPWR VGND sg13g2_buf_1
Xoutput13 hs_oe[1] _1078_/X VPWR VGND sg13g2_buf_1
XFILLER_16_157 VPWR VGND sg13g2_decap_8
XFILLER_29_496 VPWR VGND sg13g2_decap_8
XFILLER_12_341 VPWR VGND sg13g2_decap_8
XFILLER_30_171 VPWR VGND sg13g2_decap_8
Xhold301 _0593_/A _0807_/B VPWR VGND sg13g2_dlygate4sd3_1
Xhold312 _0954_/A _0955_/A VPWR VGND sg13g2_dlygate4sd3_1
Xhold323 _0768_/A _0760_/C VPWR VGND sg13g2_dlygate4sd3_1
Xhold345 hold345/X _0696_/A VPWR VGND sg13g2_dlygate4sd3_1
X_0629_ _0629_/X _0630_/A _0630_/C VPWR VGND sg13g2_and2_1
XFILLER_21_171 VPWR VGND sg13g2_decap_8
XFILLER_1_554 VPWR VGND sg13g2_fill_1
XFILLER_5_348 VPWR VGND sg13g2_decap_8
XFILLER_12_171 VPWR VGND sg13g2_decap_8
X_0980_ _0980_/Q _1021_/CLK _0980_/D rebuffer119/X VPWR VGND sg13g2_dfrbpq_1
Xhold186 _0867_/B _0997_/Q VPWR VGND sg13g2_dlygate4sd3_1
XFILLER_5_178 VPWR VGND sg13g2_decap_8
XFILLER_17_263 VPWR VGND sg13g2_decap_8
X_0963_ _0963_/Q _0972_/CLK _0963_/D _0902_/X VPWR VGND sg13g2_dfrbpq_1
X_0894_ _0894_/Y _1047_/Q _1048_/Q _1049_/Q VPWR VGND sg13g2_nand3_1
XFILLER_4_93 VPWR VGND sg13g2_decap_8
Xlane2.t_zero.tempo VPWR VGND _0758_/Y lane2.t_zero.tempo/ARM _0980_/Q fanout63/X
+ _0761_/A1 tempo_t150n
XFILLER_0_18 VPWR VGND sg13g2_decap_8
XFILLER_6_476 VPWR VGND sg13g2_decap_8
X_1093_ _1093_/X _1093_/A VPWR VGND sg13g2_buf_1
X_0946_ _0946_/X _0948_/A _0948_/B VPWR VGND sg13g2_and2_1
X_0877_ _1033_/D _0877_/A _0877_/B VPWR VGND sg13g2_nand2_1
XFILLER_9_270 VPWR VGND sg13g2_decap_8
XFILLER_24_520 VPWR VGND sg13g2_decap_8
XFILLER_10_291 VPWR VGND sg13g2_fill_2
X_0800_ _0800_/Y _0907_/A _0802_/B _0800_/C VPWR VGND sg13g2_nor3_1
X_0731_ _0731_/Y _1010_/Q _1009_/Q _1008_/Q _0731_/D VPWR VGND sg13g2_nor4_1
XFILLER_30_534 VPWR VGND sg13g2_decap_8
X_0662_ _0662_/Y _0662_/A _1041_/Q _0942_/C _0662_/D VPWR VGND sg13g2_nor4_1
X_0593_ _0593_/Y _0593_/A VPWR VGND sg13g2_inv_1
XFILLER_25_306 VPWR VGND sg13g2_decap_8
XFILLER_21_501 VPWR VGND sg13g2_decap_8
X_0929_ _0929_/X _0934_/A _0934_/B VPWR VGND sg13g2_and2_1
XFILLER_29_79 VPWR VGND sg13g2_decap_8
XFILLER_28_100 VPWR VGND sg13g2_decap_8
XFILLER_16_306 VPWR VGND sg13g2_decap_8
XFILLER_24_372 VPWR VGND sg13g2_fill_1
XFILLER_19_100 VPWR VGND sg13g2_decap_8
XFILLER_30_320 VPWR VGND sg13g2_decap_8
X_0714_ _0714_/Y _0712_/Y _0714_/A2 _0713_/X VPWR VGND sg13g2_o21ai_1
X_0645_ _0645_/Y _0646_/B _1045_/Q VPWR VGND sg13g2_nand2b_1
XFILLER_25_114 VPWR VGND sg13g2_decap_8
XFILLER_21_320 VPWR VGND sg13g2_decap_8
Xoutput25 lp_n[1] _1090_/X VPWR VGND sg13g2_buf_1
Xoutput14 hs_oe[2] _1079_/X VPWR VGND sg13g2_buf_1
XFILLER_16_114 VPWR VGND sg13g2_decap_8
XFILLER_29_475 VPWR VGND sg13g2_decap_8
XFILLER_12_320 VPWR VGND sg13g2_decap_8
XFILLER_24_191 VPWR VGND sg13g2_decap_8
XFILLER_12_397 VPWR VGND sg13g2_fill_2
XFILLER_30_150 VPWR VGND sg13g2_decap_8
Xhold302 _0640_/A _0630_/A VPWR VGND sg13g2_dlygate4sd3_1
Xhold313 _0641_/A _0619_/B VPWR VGND sg13g2_dlygate4sd3_1
Xhold324 _0940_/B _0942_/B VPWR VGND sg13g2_dlygate4sd3_1
X_0628_ _0638_/D _0628_/A _0628_/B VPWR VGND sg13g2_nor2_2
XFILLER_7_93 VPWR VGND sg13g2_decap_8
XFILLER_21_150 VPWR VGND sg13g2_decap_8
XFILLER_5_327 VPWR VGND sg13g2_decap_8
XFILLER_12_150 VPWR VGND sg13g2_decap_8
Xhold176 _0909_/A _0973_/Q VPWR VGND sg13g2_dlygate4sd3_1
Xhold187 _0996_/D _0867_/Y VPWR VGND sg13g2_dlygate4sd3_1
Xhold198 _0734_/B _0733_/Y VPWR VGND sg13g2_dlygate4sd3_1
XFILLER_22_470 VPWR VGND sg13g2_decap_4
XFILLER_5_157 VPWR VGND sg13g2_decap_8
XFILLER_17_242 VPWR VGND sg13g2_decap_8
XFILLER_13_492 VPWR VGND sg13g2_fill_1
X_0962_ _0962_/Q _0976_/CLK _0962_/D _0901_/X VPWR VGND sg13g2_dfrbpq_1
X_0893_ _1049_/D _0893_/A _0893_/B VPWR VGND sg13g2_xnor2_1
XFILLER_9_474 VPWR VGND sg13g2_fill_1
XFILLER_4_72 VPWR VGND sg13g2_decap_8
Xlane0.t_lpx.tempo_71 lane0.t_lpx.tempo/ARM VPWR VGND sg13g2_tielo
XFILLER_23_256 VPWR VGND sg13g2_decap_8
Xfanout60 _0958_/A input2/X VPWR VGND sg13g2_buf_1
X_1092_ _1092_/X _1092_/A VPWR VGND sg13g2_buf_1
X_0945_ _0945_/X _0949_/A _0948_/B VPWR VGND sg13g2_and2_1
X_0876_ _0877_/B _0878_/A hold192/X _0950_/A VPWR VGND sg13g2_a21oi_1
XFILLER_28_348 VPWR VGND sg13g2_decap_8
XFILLER_19_348 VPWR VGND sg13g2_decap_8
XFILLER_30_513 VPWR VGND sg13g2_decap_8
X_0730_ _1008_/D _0730_/A _0734_/A VPWR VGND sg13g2_xor2_1
X_0661_ _0661_/Y _0840_/C VPWR VGND sg13g2_inv_1
XFILLER_6_263 VPWR VGND sg13g2_decap_8
X_0592_ _0592_/Y _0592_/A VPWR VGND sg13g2_inv_8
X_0928_ _0928_/Y _0928_/A _0844_/B VPWR VGND sg13g2_nor2b_1
X_0859_ _0859_/Y _0859_/A _0976_/Q VPWR VGND sg13g2_xnor2_1
XFILLER_12_546 VPWR VGND sg13g2_decap_8
XFILLER_28_178 VPWR VGND sg13g2_decap_8
XFILLER_24_395 VPWR VGND sg13g2_fill_1
XFILLER_10_93 VPWR VGND sg13g2_decap_8
XFILLER_19_178 VPWR VGND sg13g2_decap_8
X_0713_ _0713_/X _0713_/A _0713_/B _0713_/C input4/X VPWR VGND sg13g2_or4_1
X_0644_ _1052_/D _0644_/A _0644_/B VPWR VGND sg13g2_and2_1
Xoutput26 lp_n[2] _1091_/X VPWR VGND sg13g2_buf_1
Xoutput15 hs_oe[3] _1080_/X VPWR VGND sg13g2_buf_1
XFILLER_29_454 VPWR VGND sg13g2_decap_8
XFILLER_24_170 VPWR VGND sg13g2_decap_8
XFILLER_22_107 VPWR VGND sg13g2_decap_8
XFILLER_15_192 VPWR VGND sg13g2_decap_8
XFILLER_7_72 VPWR VGND sg13g2_decap_8
Xhold314 hold314/X _1021_/Q VPWR VGND sg13g2_dlygate4sd3_1
X_0627_ _0628_/B _0627_/A VPWR VGND sg13g2_inv_2
XFILLER_7_391 VPWR VGND sg13g2_decap_8
XFILLER_13_107 VPWR VGND sg13g2_decap_8
XFILLER_5_306 VPWR VGND sg13g2_decap_8
XFILLER_1_545 VPWR VGND sg13g2_decap_8
Xhold177 _0922_/A _0994_/Q VPWR VGND sg13g2_dlygate4sd3_1
Xhold188 _0597_/A _0970_/Q VPWR VGND sg13g2_dlygate4sd3_1
Xlane2.t_prep.tempo_80 lane2.t_prep.tempo/ARM VPWR VGND sg13g2_tielo
XFILLER_17_210 VPWR VGND sg13g2_fill_1
XFILLER_13_460 VPWR VGND sg13g2_decap_8
X_0961_ _0961_/Q _0976_/CLK _0961_/D _0900_/X VPWR VGND sg13g2_dfrbpq_1
X_0892_ _1048_/D _0893_/B _0892_/B VPWR VGND sg13g2_and2_1
XFILLER_9_497 VPWR VGND sg13g2_decap_8
Xlane1.t_prep.tempo_76 lane1.t_prep.tempo/ARM VPWR VGND sg13g2_tielo
XFILLER_28_519 VPWR VGND sg13g2_decap_8
XFILLER_23_235 VPWR VGND sg13g2_decap_8
XFILLER_27_552 VPWR VGND sg13g2_decap_4
XFILLER_13_93 VPWR VGND sg13g2_decap_8
Xfanout50 _0713_/A _1021_/Q VPWR VGND sg13g2_buf_8
Xfanout61 fanout61/X fanout62/X VPWR VGND sg13g2_buf_1
XFILLER_6_412 VPWR VGND sg13g2_decap_8
XFILLER_29_7 VPWR VGND sg13g2_fill_2
X_1091_ _1091_/X _1091_/A VPWR VGND sg13g2_buf_1
X_0944_ _0944_/X _0949_/A _0948_/B VPWR VGND sg13g2_and2_1
X_0875_ _0875_/Y _0875_/A _1018_/Q VPWR VGND sg13g2_xnor2_1
XFILLER_18_27 VPWR VGND sg13g2_fill_1
XFILLER_28_327 VPWR VGND sg13g2_decap_8
XFILLER_24_555 VPWR VGND sg13g2_decap_8
XFILLER_11_249 VPWR VGND sg13g2_decap_8
XFILLER_3_426 VPWR VGND sg13g2_decap_8
XFILLER_19_327 VPWR VGND sg13g2_decap_8
XFILLER_24_92 VPWR VGND sg13g2_decap_8
X_0660_ _0840_/C _0942_/A _0660_/B VPWR VGND sg13g2_nand2b_1
X_0591_ _0783_/A _0984_/Q VPWR VGND sg13g2_inv_1
XFILLER_6_242 VPWR VGND sg13g2_decap_8
XFILLER_27_4 VPWR VGND sg13g2_decap_8
Xclk_lane.t_post.tempo VPWR VGND _0636_/B clk_lane.t_post.tempo/ARM _1046_/Q fanout62/X
+ _0636_/A tempo_t80n
X_0927_ _0927_/Y _0928_/A _0844_/B VPWR VGND sg13g2_nor2b_1
XFILLER_21_536 VPWR VGND sg13g2_decap_8
X_0858_ _0976_/D _0859_/A _0858_/B VPWR VGND sg13g2_or2_1
X_0789_ _0804_/A _0978_/Q _0790_/A VPWR VGND sg13g2_and2_2
XFILLER_28_157 VPWR VGND sg13g2_decap_8
XFILLER_12_525 VPWR VGND sg13g2_decap_8
XFILLER_24_341 VPWR VGND sg13g2_decap_8
XFILLER_10_72 VPWR VGND sg13g2_decap_8
XFILLER_3_256 VPWR VGND sg13g2_decap_8
XFILLER_15_341 VPWR VGND sg13g2_decap_8
XFILLER_19_157 VPWR VGND sg13g2_decap_8
X_0712_ _0712_/Y _0712_/A VPWR VGND sg13g2_inv_2
X_0643_ _0644_/B _0641_/C _0641_/B _0641_/A VPWR VGND sg13g2_a21o_1
XFILLER_18_0 VPWR VGND sg13g2_decap_4
Xoutput27 lp_n[3] _1092_/X VPWR VGND sg13g2_buf_1
Xoutput16 hs_sync[0] _1081_/X VPWR VGND sg13g2_buf_1
XFILLER_29_433 VPWR VGND sg13g2_decap_8
XFILLER_21_93 VPWR VGND sg13g2_decap_8
XFILLER_11_7 VPWR VGND sg13g2_fill_2
XFILLER_15_171 VPWR VGND sg13g2_decap_8
Xclkbuf_0_clk clkbuf_0_clk/X clk VPWR VGND sg13g2_buf_16
Xhold304 _0895_/A _0595_/Y VPWR VGND sg13g2_dlygate4sd3_1
XFILLER_30_185 VPWR VGND sg13g2_decap_8
Xhold348 _0940_/C _0942_/C VPWR VGND sg13g2_dlygate4sd3_1
Xhold359 _0890_/B _1048_/Q VPWR VGND sg13g2_dlygate4sd3_1
X_0626_ _0627_/A _0955_/B _0955_/A VPWR VGND sg13g2_nor2_2
XFILLER_21_185 VPWR VGND sg13g2_decap_8
XFILLER_29_263 VPWR VGND sg13g2_decap_8
XFILLER_16_93 VPWR VGND sg13g2_decap_8
XFILLER_17_469 VPWR VGND sg13g2_fill_1
XFILLER_25_480 VPWR VGND sg13g2_decap_8
XFILLER_12_185 VPWR VGND sg13g2_decap_8
XFILLER_4_384 VPWR VGND sg13g2_decap_8
Xhold178 _0883_/B _1039_/Q VPWR VGND sg13g2_dlygate4sd3_1
X_0609_ _0609_/Y _0609_/A VPWR VGND sg13g2_inv_1
XFILLER_5_104 VPWR VGND sg13g2_decap_8
XFILLER_22_494 VPWR VGND sg13g2_decap_8
XFILLER_13_483 VPWR VGND sg13g2_decap_8
XFILLER_17_299 VPWR VGND sg13g2_fill_2
X_0960_ _0960_/Q _0976_/CLK _0960_/D _0899_/X VPWR VGND sg13g2_dfrbpq_1
X_0891_ _0892_/B _0890_/A _0890_/C _0890_/B VPWR VGND sg13g2_a21o_1
XFILLER_9_487 VPWR VGND sg13g2_fill_1
XFILLER_4_192 VPWR VGND sg13g2_decap_8
XFILLER_23_203 VPWR VGND sg13g2_fill_1
Xfanout40 _0804_/B _0592_/Y VPWR VGND sg13g2_buf_16
Xfanout51 _0934_/A _1021_/Q VPWR VGND sg13g2_buf_1
Xfanout62 fanout62/X fanout63/X VPWR VGND sg13g2_buf_1
XFILLER_13_72 VPWR VGND sg13g2_decap_8
X_1090_ _1090_/X _1090_/A VPWR VGND sg13g2_buf_1
X_0943_ _0943_/X _0949_/A _0948_/B VPWR VGND sg13g2_and2_1
X_0874_ _1018_/D _0875_/A _0874_/B VPWR VGND sg13g2_or2_1
XFILLER_18_17 VPWR VGND sg13g2_fill_1
XFILLER_28_306 VPWR VGND sg13g2_decap_8
XFILLER_11_217 VPWR VGND sg13g2_fill_2
XFILLER_11_228 VPWR VGND sg13g2_decap_8
XFILLER_24_534 VPWR VGND sg13g2_decap_8
XFILLER_3_405 VPWR VGND sg13g2_decap_8
XFILLER_19_306 VPWR VGND sg13g2_decap_8
XFILLER_10_261 VPWR VGND sg13g2_decap_8
XFILLER_15_567 VPWR VGND sg13g2_decap_4
XFILLER_30_548 VPWR VGND sg13g2_decap_8
XFILLER_24_71 VPWR VGND sg13g2_decap_8
X_0590_ _0590_/Y _0590_/A VPWR VGND sg13g2_inv_1
XFILLER_1_42 VPWR VGND sg13g2_decap_8
XFILLER_21_515 VPWR VGND sg13g2_decap_8
X_0926_ _0926_/Y _0926_/A _0844_/B VPWR VGND sg13g2_nor2b_1
X_0857_ _0974_/D _0858_/B _0857_/B VPWR VGND sg13g2_or2_1
X_0788_ _0788_/X _0983_/Q _0788_/B VPWR VGND sg13g2_or2_1
XFILLER_28_114 VPWR VGND sg13g2_decap_8
XFILLER_24_320 VPWR VGND sg13g2_decap_8
XFILLER_12_504 VPWR VGND sg13g2_decap_8
XFILLER_10_62 VPWR VGND sg13g2_fill_1
XFILLER_3_235 VPWR VGND sg13g2_decap_8
XFILLER_19_114 VPWR VGND sg13g2_decap_8
XFILLER_15_320 VPWR VGND sg13g2_decap_8
XFILLER_19_93 VPWR VGND sg13g2_decap_8
X_0711_ _0712_/A _0713_/A _0695_/X VPWR VGND sg13g2_nor2b_2
XFILLER_30_334 VPWR VGND sg13g2_decap_8
X_0642_ _1053_/D _0583_/Y _0644_/A _0642_/B1 VPWR VGND sg13g2_a21oi_1
XFILLER_21_334 VPWR VGND sg13g2_decap_8
Xoutput28 lp_p[0] _1093_/X VPWR VGND sg13g2_buf_1
Xoutput17 hs_sync[1] _1082_/X VPWR VGND sg13g2_buf_1
X_0909_ _0973_/D _0909_/A VPWR VGND sg13g2_buf_1
XFILLER_29_489 VPWR VGND sg13g2_decap_8
XFILLER_12_334 VPWR VGND sg13g2_decap_8
XFILLER_21_72 VPWR VGND sg13g2_decap_8
XFILLER_15_150 VPWR VGND sg13g2_decap_8
XFILLER_30_164 VPWR VGND sg13g2_decap_8
Xhold305 _0639_/D _0623_/B VPWR VGND sg13g2_dlygate4sd3_1
Xhold338 _0813_/D _0790_/A VPWR VGND sg13g2_dlygate4sd3_1
X_0625_ _0638_/B _0625_/A _0625_/B VPWR VGND sg13g2_nor2_1
X_1039_ _1039_/Q _1054_/CLK _1039_/D rebuffer168/X VPWR VGND sg13g2_dfrbpq_1
XFILLER_21_131 VPWR VGND sg13g2_fill_2
XFILLER_21_164 VPWR VGND sg13g2_decap_8
Xclk_lane.t_post.tempo_66 clk_lane.t_post.tempo/ARM VPWR VGND sg13g2_tielo
XFILLER_29_242 VPWR VGND sg13g2_decap_8
XFILLER_16_72 VPWR VGND sg13g2_decap_8
XFILLER_12_164 VPWR VGND sg13g2_decap_8
XFILLER_4_341 VPWR VGND sg13g2_decap_8
Xhold179 _1038_/D _0883_/Y VPWR VGND sg13g2_dlygate4sd3_1
X_0608_ _0608_/Y _0608_/A VPWR VGND sg13g2_inv_1
XFILLER_22_440 VPWR VGND sg13g2_fill_2
Xlane1.t_prep.tempo VPWR VGND _0710_/A lane1.t_prep.tempo/ARM _1016_/Q fanout61/X
+ _0604_/A tempo_t60n
XFILLER_17_256 VPWR VGND sg13g2_decap_8
XFILLER_27_93 VPWR VGND sg13g2_decap_8
XFILLER_13_451 VPWR VGND sg13g2_decap_4
X_0890_ _0893_/B _0890_/A _0890_/B _0890_/C VPWR VGND sg13g2_nand3_1
XFILLER_4_171 VPWR VGND sg13g2_decap_8
XFILLER_4_86 VPWR VGND sg13g2_decap_8
XFILLER_4_53 VPWR VGND sg13g2_fill_2
Xfanout41 _0914_/A _0847_/A VPWR VGND sg13g2_buf_16
Xfanout63 fanout63/X PG VPWR VGND sg13g2_buf_1
XFILLER_22_270 VPWR VGND sg13g2_decap_8
XFILLER_10_498 VPWR VGND sg13g2_decap_8
XFILLER_6_469 VPWR VGND sg13g2_decap_8
XFILLER_13_270 VPWR VGND sg13g2_decap_8
X_0942_ _0942_/Y _0942_/A _0942_/B _0942_/C VPWR VGND sg13g2_nor3_1
X_0873_ _0873_/X _1018_/Q _0873_/B VPWR VGND sg13g2_or2_1
XFILLER_9_263 VPWR VGND sg13g2_decap_8
XFILLER_24_513 VPWR VGND sg13g2_decap_8
XFILLER_1_7 VPWR VGND sg13g2_decap_8
XFILLER_15_557 VPWR VGND sg13g2_fill_2
XFILLER_10_240 VPWR VGND sg13g2_decap_8
XFILLER_10_284 VPWR VGND sg13g2_decap_8
XFILLER_30_527 VPWR VGND sg13g2_decap_8
XFILLER_1_21 VPWR VGND sg13g2_decap_8
X_0925_ _0925_/Y _0939_/A VPWR VGND sg13g2_inv_1
X_0856_ _0972_/D _0854_/A _0853_/B hold211/X VPWR VGND sg13g2_a21o_1
X_0787_ _0787_/Y _0983_/Q _0787_/B VPWR VGND sg13g2_xnor2_1
XFILLER_19_72 VPWR VGND sg13g2_decap_8
XFILLER_30_313 VPWR VGND sg13g2_decap_8
XFILLER_27_192 VPWR VGND sg13g2_decap_8
XFILLER_11_560 VPWR VGND sg13g2_decap_8
X_0710_ _0710_/Y _0710_/A VPWR VGND sg13g2_inv_4
X_0641_ _0644_/A _0641_/A _0641_/B _0641_/C VPWR VGND sg13g2_nand3_1
XFILLER_18_192 VPWR VGND sg13g2_decap_8
XFILLER_25_107 VPWR VGND sg13g2_decap_8
XFILLER_21_313 VPWR VGND sg13g2_decap_8
Xoutput29 lp_p[1] _1094_/X VPWR VGND sg13g2_buf_1
Xoutput18 hs_sync[2] _1083_/X VPWR VGND sg13g2_buf_1
X_0908_ _0908_/X _0908_/A _0908_/B VPWR VGND sg13g2_and2_1
X_0839_ _1093_/A _0840_/A _0840_/B VPWR VGND sg13g2_nand2_1
XFILLER_29_468 VPWR VGND sg13g2_decap_8
XFILLER_12_313 VPWR VGND sg13g2_decap_8
XFILLER_16_107 VPWR VGND sg13g2_decap_8
XFILLER_24_184 VPWR VGND sg13g2_decap_8
Xhold317 _0719_/A _0713_/C VPWR VGND sg13g2_dlygate4sd3_1
Xhold339 _0590_/A _0760_/B VPWR VGND sg13g2_dlygate4sd3_1
X_0624_ _0624_/Y _0836_/B VPWR VGND sg13g2_inv_1
XFILLER_7_86 VPWR VGND sg13g2_decap_8
XFILLER_23_0 VPWR VGND sg13g2_fill_2
XFILLER_21_121 VPWR VGND sg13g2_fill_1
X_1038_ _1038_/Q _1054_/CLK _1038_/D rebuffer168/X VPWR VGND sg13g2_dfrbpq_1
XFILLER_4_320 VPWR VGND sg13g2_decap_8
X_0607_ _0607_/Y _1033_/Q VPWR VGND sg13g2_inv_1
XFILLER_22_474 VPWR VGND sg13g2_fill_1
XFILLER_17_235 VPWR VGND sg13g2_decap_8
XFILLER_27_72 VPWR VGND sg13g2_decap_8
XFILLER_23_249 VPWR VGND sg13g2_decap_8
XFILLER_27_533 VPWR VGND sg13g2_fill_1
XFILLER_27_522 VPWR VGND sg13g2_decap_8
XFILLER_10_466 VPWR VGND sg13g2_decap_4
Xfanout42 _0630_/A _1054_/Q VPWR VGND sg13g2_buf_8
Xfanout53 _0589_/A _1000_/Q VPWR VGND sg13g2_buf_16
XFILLER_6_426 VPWR VGND sg13g2_decap_8
X_0941_ _0941_/Y _0942_/A _0942_/B _0942_/C VPWR VGND sg13g2_nor3_1
X_0872_ _1014_/D _0870_/A _0869_/B hold205/X VPWR VGND sg13g2_a21o_1
XFILLER_9_242 VPWR VGND sg13g2_decap_8
XFILLER_24_569 VPWR VGND sg13g2_fill_2
XFILLER_30_506 VPWR VGND sg13g2_decap_8
XFILLER_27_341 VPWR VGND sg13g2_decap_8
XFILLER_6_256 VPWR VGND sg13g2_decap_8
XFILLER_18_341 VPWR VGND sg13g2_decap_8
X_0924_ _0924_/Y _0958_/A VPWR VGND sg13g2_inv_1
X_0855_ _0971_/D _0854_/A _0853_/B _0854_/Y VPWR VGND sg13g2_a21oi_1
X_0786_ _0786_/Y _0786_/A _0786_/B VPWR VGND sg13g2_xnor2_1
XFILLER_12_539 VPWR VGND sg13g2_decap_8
XFILLER_10_86 VPWR VGND sg13g2_decap_8
XFILLER_3_204 VPWR VGND sg13g2_decap_4
XFILLER_27_171 VPWR VGND sg13g2_decap_8
X_0640_ _1054_/D _0640_/A _0640_/B VPWR VGND sg13g2_xor2_1
XFILLER_25_4 VPWR VGND sg13g2_fill_2
XFILLER_18_171 VPWR VGND sg13g2_decap_8
X_1054_ _1054_/Q _1054_/CLK _1054_/D _0958_/Y VPWR VGND sg13g2_dfrbpq_2
X_0907_ _0907_/X _0907_/A _0907_/B VPWR VGND sg13g2_and2_1
Xoutput19 hs_sync[3] _1084_/X VPWR VGND sg13g2_buf_1
X_0838_ _0838_/Y _0955_/A _0955_/B VPWR VGND sg13g2_xnor2_1
X_0769_ _0778_/D _0986_/Q _0985_/Q VPWR VGND sg13g2_and2_1
XFILLER_29_447 VPWR VGND sg13g2_decap_8
XFILLER_24_163 VPWR VGND sg13g2_decap_8
XFILLER_28_491 VPWR VGND sg13g2_decap_8
XFILLER_15_185 VPWR VGND sg13g2_decap_8
XFILLER_30_100 VPWR VGND sg13g2_decap_8
Xhold307 _0926_/A _0713_/A VPWR VGND sg13g2_dlygate4sd3_1
Xhold318 _0901_/A _0592_/Y VPWR VGND sg13g2_dlygate4sd3_1
X_0623_ _0625_/B _0634_/B _0623_/B _0955_/A VPWR VGND sg13g2_nand3_1
XFILLER_7_384 VPWR VGND sg13g2_decap_8
XFILLER_21_100 VPWR VGND sg13g2_decap_8
XFILLER_21_133 VPWR VGND sg13g2_fill_1
X_1037_ _1037_/Q _1054_/CLK _1037_/D rebuffer168/X VPWR VGND sg13g2_dfrbpq_1
XFILLER_1_538 VPWR VGND sg13g2_decap_8
XFILLER_12_100 VPWR VGND sg13g2_decap_8
XFILLER_25_494 VPWR VGND sg13g2_decap_8
XFILLER_4_398 VPWR VGND sg13g2_decap_8
XFILLER_7_192 VPWR VGND sg13g2_decap_8
X_0606_ _0606_/Y _0606_/A VPWR VGND sg13g2_inv_1
XFILLER_22_486 VPWR VGND sg13g2_decap_4
XFILLER_22_442 VPWR VGND sg13g2_fill_1
XFILLER_5_118 VPWR VGND sg13g2_fill_2
XFILLER_23_228 VPWR VGND sg13g2_decap_8
XFILLER_27_501 VPWR VGND sg13g2_decap_8
XFILLER_27_545 VPWR VGND sg13g2_decap_8
XFILLER_13_86 VPWR VGND sg13g2_decap_8
Xfanout43 _0955_/A _1054_/Q VPWR VGND sg13g2_buf_8
Xfanout54 _0921_/A fanout54/A VPWR VGND sg13g2_buf_1
XFILLER_6_405 VPWR VGND sg13g2_decap_8
X_0940_ _0940_/Y _0940_/A _0940_/B _0940_/C VPWR VGND sg13g2_nor3_1
X_0871_ _1013_/D _0870_/A _0869_/B _0870_/Y VPWR VGND sg13g2_a21oi_1
XFILLER_24_548 VPWR VGND sg13g2_decap_8
XFILLER_3_419 VPWR VGND sg13g2_decap_8
XFILLER_27_320 VPWR VGND sg13g2_decap_8
XFILLER_27_375 VPWR VGND sg13g2_fill_2
XFILLER_24_85 VPWR VGND sg13g2_decap_8
XFILLER_10_275 VPWR VGND sg13g2_fill_2
XFILLER_6_235 VPWR VGND sg13g2_decap_8
XFILLER_18_320 VPWR VGND sg13g2_decap_8
X_0923_ _0923_/Y _0939_/A VPWR VGND sg13g2_inv_1
X_0854_ _0854_/Y _0854_/A _0909_/A VPWR VGND sg13g2_nor2b_1
XFILLER_21_529 VPWR VGND sg13g2_decap_8
X_0785_ _0786_/B _0983_/Q _0981_/Q VPWR VGND sg13g2_nand2b_1
XFILLER_12_518 VPWR VGND sg13g2_decap_8
XFILLER_24_334 VPWR VGND sg13g2_decap_8
Xlane2.t_zero.tempo_81 lane2.t_zero.tempo/ARM VPWR VGND sg13g2_tielo
XFILLER_3_249 VPWR VGND sg13g2_decap_8
XFILLER_15_334 VPWR VGND sg13g2_decap_8
XFILLER_19_63 VPWR VGND sg13g2_fill_2
XFILLER_27_150 VPWR VGND sg13g2_decap_8
XFILLER_30_348 VPWR VGND sg13g2_decap_8
XFILLER_18_4 VPWR VGND sg13g2_fill_1
XFILLER_18_150 VPWR VGND sg13g2_decap_8
X_1053_ _1053_/Q _1054_/CLK _1053_/D _0957_/Y VPWR VGND sg13g2_dfrbpq_2
X_0906_ _0906_/X _0907_/A _0907_/B VPWR VGND sg13g2_and2_1
X_0837_ _0837_/Y _0836_/Y _0837_/B VPWR VGND sg13g2_nand2b_1
XFILLER_21_348 VPWR VGND sg13g2_decap_8
X_0768_ _0998_/D _0768_/A _0768_/B VPWR VGND sg13g2_xnor2_1
X_0699_ _0843_/B _0713_/A _0699_/B _0704_/B VPWR VGND sg13g2_nand3_1
Xlane1.t_zero.tempo_77 lane1.t_zero.tempo/ARM VPWR VGND sg13g2_tielo
XFILLER_24_120 VPWR VGND sg13g2_fill_1
XFILLER_12_348 VPWR VGND sg13g2_decap_8
XFILLER_21_86 VPWR VGND sg13g2_decap_8
XFILLER_15_164 VPWR VGND sg13g2_decap_8
XFILLER_28_470 VPWR VGND sg13g2_decap_8
XFILLER_7_341 VPWR VGND sg13g2_decap_8
XFILLER_30_178 VPWR VGND sg13g2_decap_8
X_0622_ _0637_/B _0630_/A _0622_/B _0622_/C VPWR VGND sg13g2_nor3_1
XFILLER_23_2 VPWR VGND sg13g2_fill_1
XFILLER_21_178 VPWR VGND sg13g2_decap_8
X_1036_ _1036_/Q _1036_/CLK _1036_/D _1081_/A VPWR VGND sg13g2_dfrbpq_1
XFILLER_16_86 VPWR VGND sg13g2_decap_8
XFILLER_29_256 VPWR VGND sg13g2_decap_8
XFILLER_12_178 VPWR VGND sg13g2_decap_8
XFILLER_4_355 VPWR VGND sg13g2_fill_1
XFILLER_0_561 VPWR VGND sg13g2_decap_4
XFILLER_7_171 VPWR VGND sg13g2_decap_8
X_0605_ _0605_/Y _0605_/A VPWR VGND sg13g2_inv_1
X_1019_ _1019_/Q _1020_/CLK _1019_/D _0937_/Y VPWR VGND sg13g2_dfrbpq_2
XFILLER_13_476 VPWR VGND sg13g2_decap_8
XFILLER_25_270 VPWR VGND sg13g2_decap_8
XFILLER_4_185 VPWR VGND sg13g2_decap_8
XFILLER_23_207 VPWR VGND sg13g2_fill_2
XFILLER_16_270 VPWR VGND sg13g2_decap_8
Xfanout44 _0623_/B _1053_/Q VPWR VGND sg13g2_buf_8
Xfanout55 _0749_/B _0998_/Q VPWR VGND sg13g2_buf_16
XFILLER_22_295 VPWR VGND sg13g2_decap_4
X_0870_ _0870_/Y _0870_/A _0936_/A VPWR VGND sg13g2_nor2b_1
XFILLER_5_483 VPWR VGND sg13g2_fill_1
XFILLER_24_527 VPWR VGND sg13g2_decap_8
X_0999_ _0999_/Q _0999_/CLK _0999_/D _0924_/Y VPWR VGND sg13g2_dfrbpq_2
XFILLER_10_254 VPWR VGND sg13g2_decap_8
XFILLER_10_298 VPWR VGND sg13g2_decap_8
XFILLER_1_35 VPWR VGND sg13g2_decap_8
XFILLER_21_508 VPWR VGND sg13g2_decap_8
X_0922_ _0994_/D _0922_/A VPWR VGND sg13g2_buf_1
X_0853_ _0970_/D _0853_/A _0853_/B VPWR VGND sg13g2_nand2_1
X_0784_ _0983_/D _0786_/A _0787_/B hold285/X VPWR VGND sg13g2_a21o_1
Xinput1 input1/X clk_request VPWR VGND sg13g2_buf_1
Xlane3.t_zero.tempo VPWR VGND rebuffer132/X lane3.t_zero.tempo/ARM _0959_/Q PG _0808_/A2
+ tempo_t150n
XFILLER_28_107 VPWR VGND sg13g2_decap_8
XFILLER_24_313 VPWR VGND sg13g2_decap_8
XFILLER_3_228 VPWR VGND sg13g2_decap_8
XFILLER_19_107 VPWR VGND sg13g2_decap_8
XFILLER_19_53 VPWR VGND sg13g2_fill_1
XFILLER_15_313 VPWR VGND sg13g2_decap_8
XFILLER_19_86 VPWR VGND sg13g2_decap_8
XFILLER_30_327 VPWR VGND sg13g2_decap_8
XFILLER_23_390 VPWR VGND sg13g2_fill_1
X_1052_ _1052_/Q _1052_/CLK _1052_/D _0956_/Y VPWR VGND sg13g2_dfrbpq_2
XFILLER_25_6 VPWR VGND sg13g2_fill_1
XFILLER_21_327 VPWR VGND sg13g2_decap_8
X_0905_ _0905_/X _0907_/A _0907_/B VPWR VGND sg13g2_and2_1
X_0836_ _0836_/Y _0613_/Y _0836_/B VPWR VGND sg13g2_nand2b_1
X_0767_ _0999_/D _0766_/Y _0590_/Y _0767_/B1 VPWR VGND sg13g2_a21oi_1
X_0698_ _0698_/Y _0843_/A VPWR VGND sg13g2_inv_1
XFILLER_12_327 VPWR VGND sg13g2_decap_8
XFILLER_24_198 VPWR VGND sg13g2_fill_1
XFILLER_4_515 VPWR VGND sg13g2_fill_2
XFILLER_4_504 VPWR VGND sg13g2_decap_8
Xhold309 _0766_/A hold309/A VPWR VGND sg13g2_dlygate4sd3_1
X_0621_ _0621_/Y _0837_/B VPWR VGND sg13g2_inv_1
XFILLER_7_320 VPWR VGND sg13g2_decap_8
XFILLER_30_157 VPWR VGND sg13g2_decap_8
XFILLER_30_4 VPWR VGND sg13g2_decap_8
X_1035_ _1035_/Q _1035_/CLK _1035_/D _1081_/A VPWR VGND sg13g2_dfrbpq_1
XFILLER_21_157 VPWR VGND sg13g2_decap_8
X_0819_ _0828_/A _0969_/Q _0825_/D VPWR VGND sg13g2_nor2b_1
XFILLER_29_235 VPWR VGND sg13g2_decap_8
XFILLER_12_135 VPWR VGND sg13g2_fill_2
XFILLER_12_157 VPWR VGND sg13g2_decap_8
XFILLER_4_334 VPWR VGND sg13g2_decap_8
XFILLER_0_540 VPWR VGND sg13g2_decap_8
X_0604_ _0604_/Y _0604_/A VPWR VGND sg13g2_inv_1
XFILLER_7_150 VPWR VGND sg13g2_decap_8
X_1018_ _1018_/Q _1025_/CLK _1018_/D _0710_/Y VPWR VGND sg13g2_dfrbpq_1
XFILLER_22_433 VPWR VGND sg13g2_fill_2
XFILLER_22_411 VPWR VGND sg13g2_fill_2
XFILLER_17_249 VPWR VGND sg13g2_decap_8
XFILLER_27_86 VPWR VGND sg13g2_decap_8
XFILLER_13_455 VPWR VGND sg13g2_fill_1
XFILLER_4_164 VPWR VGND sg13g2_decap_8
XFILLER_4_142 VPWR VGND sg13g2_fill_2
XFILLER_4_79 VPWR VGND sg13g2_decap_8
Xfanout45 _0619_/B _1052_/Q VPWR VGND sg13g2_buf_8
Xfanout56 _0592_/A _0979_/Q VPWR VGND sg13g2_buf_16
XFILLER_22_263 VPWR VGND sg13g2_decap_8
XFILLER_10_436 VPWR VGND sg13g2_fill_2
XFILLER_13_263 VPWR VGND sg13g2_decap_8
XFILLER_9_256 VPWR VGND sg13g2_decap_8
XFILLER_5_462 VPWR VGND sg13g2_decap_8
XFILLER_24_506 VPWR VGND sg13g2_decap_8
X_0998_ _0998_/Q _1011_/CLK _0998_/D _0923_/Y VPWR VGND sg13g2_dfrbpq_2
XFILLER_27_355 VPWR VGND sg13g2_fill_2
XFILLER_10_233 VPWR VGND sg13g2_decap_8
XFILLER_1_14 VPWR VGND sg13g2_decap_8
Xlane0.t_exit.tempo_70 lane0.t_exit.tempo/ARM VPWR VGND sg13g2_tielo
X_0921_ _0921_/X _0921_/A _0921_/B VPWR VGND sg13g2_and2_1
X_0852_ _0853_/B _0854_/A hold211/X _0909_/A VPWR VGND sg13g2_a21oi_1
X_0783_ _0783_/Y _0783_/A _0783_/B VPWR VGND sg13g2_nand2_1
Xinput2 input2/X rst VPWR VGND sg13g2_buf_1
Xlane0.t_exit.tempo VPWR VGND _0840_/A lane0.t_exit.tempo/ARM _0656_/Y fanout62/X
+ _0609_/A tempo_t150n
XFILLER_30_306 VPWR VGND sg13g2_decap_8
XFILLER_27_185 VPWR VGND sg13g2_decap_8
XFILLER_11_553 VPWR VGND sg13g2_decap_8
XFILLER_18_185 VPWR VGND sg13g2_decap_8
X_1051_ _1051_/Q _1051_/CLK _1051_/D _0635_/Y VPWR VGND sg13g2_dfrbpq_1
X_0904_ _0904_/X _0908_/A _0907_/B VPWR VGND sg13g2_and2_1
XFILLER_21_306 VPWR VGND sg13g2_decap_8
X_0835_ _0835_/X _0962_/Q _0835_/B VPWR VGND sg13g2_or2_1
X_0766_ _0766_/Y _0766_/A _0766_/B _0766_/C _0766_/D VPWR VGND sg13g2_nand4_1
X_0697_ _0843_/A _0713_/A _0708_/A VPWR VGND sg13g2_nand2b_2
XFILLER_12_306 VPWR VGND sg13g2_decap_8
XFILLER_24_177 VPWR VGND sg13g2_decap_8
XFILLER_15_100 VPWR VGND sg13g2_decap_8
XFILLER_30_114 VPWR VGND sg13g2_decap_8
X_0620_ _0837_/B _0630_/A _0622_/C VPWR VGND sg13g2_or2_1
XFILLER_7_79 VPWR VGND sg13g2_decap_8
XFILLER_7_398 VPWR VGND sg13g2_decap_8
X_1034_ _1034_/Q _1035_/CLK _1034_/D _1081_/A VPWR VGND sg13g2_dfrbpq_1
XFILLER_21_114 VPWR VGND sg13g2_decap_8
X_0818_ _0818_/Y _0969_/Q _0818_/B VPWR VGND sg13g2_nand2b_1
X_0749_ _0754_/B _0999_/Q _0749_/B VPWR VGND sg13g2_nand2b_1
XFILLER_17_409 VPWR VGND sg13g2_fill_1
XFILLER_12_114 VPWR VGND sg13g2_decap_8
XFILLER_25_464 VPWR VGND sg13g2_decap_8
XFILLER_4_313 VPWR VGND sg13g2_decap_8
X_0603_ _0603_/Y _1012_/Q VPWR VGND sg13g2_inv_1
X_1017_ _1017_/Q _1025_/CLK _1017_/D _0710_/Y VPWR VGND sg13g2_dfrbpq_1
XFILLER_17_228 VPWR VGND sg13g2_decap_8
XFILLER_23_209 VPWR VGND sg13g2_fill_1
XFILLER_27_515 VPWR VGND sg13g2_decap_8
Xfanout46 _0942_/A _1042_/Q VPWR VGND sg13g2_buf_8
Xfanout57 _0908_/A fanout57/A VPWR VGND sg13g2_buf_1
XFILLER_22_242 VPWR VGND sg13g2_decap_8
XFILLER_6_419 VPWR VGND sg13g2_decap_8
XFILLER_13_242 VPWR VGND sg13g2_decap_8
XFILLER_9_235 VPWR VGND sg13g2_decap_8
XFILLER_9_213 VPWR VGND sg13g2_fill_2
X_0997_ _0997_/Q _1024_/CLK _0997_/D rebuffer143/X VPWR VGND sg13g2_dfrbpq_1
XFILLER_5_90 VPWR VGND sg13g2_decap_8
XFILLER_27_334 VPWR VGND sg13g2_decap_8
XFILLER_23_551 VPWR VGND sg13g2_decap_8
XFILLER_6_249 VPWR VGND sg13g2_decap_8
XFILLER_24_99 VPWR VGND sg13g2_decap_8
XFILLER_18_334 VPWR VGND sg13g2_decap_8
X_0920_ _0920_/X _0920_/A _0920_/B VPWR VGND sg13g2_and2_1
Xlane3.t_lpx.tempo_83 lane3.t_lpx.tempo/ARM VPWR VGND sg13g2_tielo
X_0851_ _0851_/Y _0851_/A _0955_/A VPWR VGND sg13g2_nor2b_1
X_0782_ _0782_/X _0985_/Q _0783_/B VPWR VGND sg13g2_xor2_1
Xinput3 input3/X tx_request_hs[0] VPWR VGND sg13g2_buf_1
XFILLER_24_348 VPWR VGND sg13g2_decap_8
Xclk_lane.t_lpx.tempo VPWR VGND _0837_/B clk_lane.t_lpx.tempo/ARM _0621_/Y fanout61/X
+ _0622_/B tempo_t80n
XFILLER_10_79 VPWR VGND sg13g2_decap_8
XFILLER_11_532 VPWR VGND sg13g2_decap_8
XFILLER_15_348 VPWR VGND sg13g2_decap_8
XFILLER_27_164 VPWR VGND sg13g2_decap_8
XFILLER_18_164 VPWR VGND sg13g2_decap_8
X_1050_ _1050_/Q _1050_/CLK _1050_/D _0635_/Y VPWR VGND sg13g2_dfrbpq_1
X_0903_ _0903_/X _0908_/A _0907_/B VPWR VGND sg13g2_and2_1
X_0834_ _0834_/Y _0962_/Q _0834_/B VPWR VGND sg13g2_xnor2_1
X_0765_ _1000_/D _0765_/A _0765_/B VPWR VGND sg13g2_xnor2_1
X_0696_ _0708_/A _0696_/A _1019_/Q VPWR VGND sg13g2_nor2b_1
XFILLER_29_418 VPWR VGND sg13g2_fill_2
XFILLER_24_156 VPWR VGND sg13g2_decap_8
XFILLER_28_484 VPWR VGND sg13g2_decap_8
XFILLER_15_178 VPWR VGND sg13g2_decap_8
X_1033_ _1033_/Q _1035_/CLK _1033_/D _1081_/A VPWR VGND sg13g2_dfrbpq_1
Xclk_lane.t_exit.tempo VPWR VGND _0836_/B clk_lane.t_exit.tempo/ARM _0624_/Y fanout62/X
+ _0625_/A tempo_t150n
X_0817_ _0818_/B _0968_/Q _0967_/Q _0966_/Q _0825_/D VPWR VGND sg13g2_nand4_1
X_0748_ _0748_/Y _0748_/A VPWR VGND sg13g2_inv_4
X_0679_ _0682_/A _0679_/A _0683_/A _0687_/A VPWR VGND sg13g2_nand3_1
XFILLER_29_215 VPWR VGND sg13g2_fill_2
XFILLER_16_67 VPWR VGND sg13g2_fill_2
XFILLER_25_487 VPWR VGND sg13g2_decap_8
XFILLER_11_192 VPWR VGND sg13g2_decap_8
X_0602_ _0602_/Y _0602_/A VPWR VGND sg13g2_inv_1
XFILLER_7_185 VPWR VGND sg13g2_decap_8
XFILLER_3_391 VPWR VGND sg13g2_decap_8
XFILLER_19_270 VPWR VGND sg13g2_decap_8
X_1016_ _1016_/Q _1025_/CLK _1016_/D _0710_/Y VPWR VGND sg13g2_dfrbpq_1
XFILLER_22_479 VPWR VGND sg13g2_decap_8
XFILLER_22_435 VPWR VGND sg13g2_fill_1
XFILLER_22_413 VPWR VGND sg13g2_fill_1
XFILLER_27_11 VPWR VGND sg13g2_decap_8
XFILLER_4_100 VPWR VGND sg13g2_decap_8
XFILLER_27_538 VPWR VGND sg13g2_decap_8
XFILLER_10_438 VPWR VGND sg13g2_fill_1
XFILLER_13_79 VPWR VGND sg13g2_decap_8
Xfanout36 _0794_/B _0908_/B VPWR VGND sg13g2_buf_8
Xfanout47 _0948_/A _1042_/Q VPWR VGND sg13g2_buf_2
Xfanout58 _0790_/A _0977_/Q VPWR VGND sg13g2_buf_16
XFILLER_5_453 VPWR VGND sg13g2_fill_2
X_0996_ _0996_/Q _1024_/CLK _0996_/D rebuffer143/X VPWR VGND sg13g2_dfrbpq_1
XFILLER_27_313 VPWR VGND sg13g2_decap_8
XFILLER_23_530 VPWR VGND sg13g2_decap_8
XFILLER_10_268 VPWR VGND sg13g2_decap_8
XFILLER_6_228 VPWR VGND sg13g2_decap_8
XFILLER_24_78 VPWR VGND sg13g2_decap_8
Xhold291 _0646_/C _1043_/Q VPWR VGND sg13g2_dlygate4sd3_1
XFILLER_18_313 VPWR VGND sg13g2_decap_8
XFILLER_1_49 VPWR VGND sg13g2_fill_1
X_0850_ _1080_/A _0899_/A _0901_/B VPWR VGND sg13g2_xnor2_1
X_0781_ _0986_/D _0781_/A _0781_/B VPWR VGND sg13g2_nor2_1
XFILLER_5_272 VPWR VGND sg13g2_decap_4
Xinput4 input4/X tx_request_hs[1] VPWR VGND sg13g2_buf_1
XFILLER_24_327 VPWR VGND sg13g2_decap_8
X_0979_ _0979_/Q _0999_/CLK _0979_/D _0911_/Y VPWR VGND sg13g2_dfrbpq_2
XFILLER_15_327 VPWR VGND sg13g2_decap_8
XFILLER_11_511 VPWR VGND sg13g2_decap_8
XFILLER_7_504 VPWR VGND sg13g2_decap_8
X_0902_ _0902_/X _0908_/A _0907_/B VPWR VGND sg13g2_and2_1
X_0833_ _0833_/Y _0833_/A _0833_/B VPWR VGND sg13g2_xnor2_1
X_0764_ _0765_/A _0764_/A _0766_/B _0766_/C _0914_/B VPWR VGND sg13g2_and4_1
X_0695_ _0695_/X _1019_/Q _1020_/Q VPWR VGND sg13g2_and2_2
XFILLER_24_113 VPWR VGND sg13g2_decap_8
XFILLER_21_79 VPWR VGND sg13g2_decap_8
XFILLER_15_157 VPWR VGND sg13g2_decap_8
XFILLER_28_463 VPWR VGND sg13g2_decap_8
XFILLER_11_341 VPWR VGND sg13g2_decap_8
XFILLER_7_334 VPWR VGND sg13g2_decap_8
X_1032_ _1032_/Q _1036_/CLK _1032_/D _0949_/X VPWR VGND sg13g2_dfrbpq_1
X_0816_ _0825_/D _0965_/Q _0964_/Q VPWR VGND sg13g2_and2_1
X_0747_ _0748_/A _0747_/A _0914_/A VPWR VGND sg13g2_nand2_2
X_0678_ _0687_/A _0678_/A _0684_/D VPWR VGND sg13g2_nor2b_1
XFILLER_29_249 VPWR VGND sg13g2_decap_8
XFILLER_16_79 VPWR VGND sg13g2_decap_8
XFILLER_4_348 VPWR VGND sg13g2_decap_8
XFILLER_0_554 VPWR VGND sg13g2_decap_8
XFILLER_0_565 VPWR VGND sg13g2_fill_2
XFILLER_11_171 VPWR VGND sg13g2_decap_8
X_0601_ _0601_/Y _0601_/A VPWR VGND sg13g2_inv_1
XFILLER_7_164 VPWR VGND sg13g2_decap_8
XFILLER_19_293 VPWR VGND sg13g2_fill_1
X_1015_ _1015_/Q _1035_/CLK _1015_/D _1082_/A VPWR VGND sg13g2_dfrbpq_1
XFILLER_25_263 VPWR VGND sg13g2_decap_8
XFILLER_21_480 VPWR VGND sg13g2_decap_8
XFILLER_4_178 VPWR VGND sg13g2_decap_8
XFILLER_16_263 VPWR VGND sg13g2_decap_8
Xfanout37 _0747_/A _0921_/B VPWR VGND sg13g2_buf_8
Xfanout48 _0949_/A hold299/A VPWR VGND sg13g2_buf_1
Xfanout59 _0939_/A _0958_/A VPWR VGND sg13g2_buf_1
XFILLER_13_288 VPWR VGND sg13g2_decap_4
XFILLER_5_476 VPWR VGND sg13g2_decap_8
X_0995_ _0995_/Q _1021_/CLK _0995_/D rebuffer143/X VPWR VGND sg13g2_dfrbpq_1
Xlane2.t_prep.tempo VPWR VGND _0748_/A lane2.t_prep.tempo/ARM _0995_/Q fanout63/X
+ _0601_/A tempo_t60n
XFILLER_10_247 VPWR VGND sg13g2_decap_8
XFILLER_1_28 VPWR VGND sg13g2_decap_8
Xhold270 _0882_/A _1038_/Q VPWR VGND sg13g2_dlygate4sd3_1
Xhold281 _0730_/A _1008_/Q VPWR VGND sg13g2_dlygate4sd3_1
X_0780_ _0780_/Y _0985_/Q _0783_/B _0986_/Q VPWR VGND sg13g2_a21oi_1
XFILLER_5_251 VPWR VGND sg13g2_decap_8
Xinput5 input5/X tx_request_hs[2] VPWR VGND sg13g2_buf_1
XFILLER_24_306 VPWR VGND sg13g2_decap_8
X_0978_ _0978_/Q _0999_/CLK _0978_/D _0910_/Y VPWR VGND sg13g2_dfrbpq_2
XFILLER_15_306 VPWR VGND sg13g2_decap_8
XFILLER_19_79 VPWR VGND sg13g2_decap_8
XFILLER_27_100 VPWR VGND sg13g2_decap_8
XFILLER_11_567 VPWR VGND sg13g2_decap_4
XFILLER_18_100 VPWR VGND sg13g2_decap_8
XFILLER_18_9 VPWR VGND sg13g2_fill_2
XFILLER_18_199 VPWR VGND sg13g2_fill_1
X_0901_ _0901_/X _0901_/A _0901_/B VPWR VGND sg13g2_and2_1
X_0832_ _0833_/B _0962_/Q _0960_/Q VPWR VGND sg13g2_nand2b_1
X_0763_ _0768_/B _0766_/B _0766_/C _0764_/A VPWR VGND sg13g2_nand3_1
X_0694_ _0694_/X _1025_/Q _0694_/B VPWR VGND sg13g2_or2_1
XFILLER_24_125 VPWR VGND sg13g2_fill_1
XFILLER_28_442 VPWR VGND sg13g2_decap_8
XFILLER_15_114 VPWR VGND sg13g2_decap_8
XFILLER_11_320 VPWR VGND sg13g2_decap_8
XFILLER_7_313 VPWR VGND sg13g2_decap_8
Xclkbuf_4_9_0_clk _1036_/CLK clkbuf_0_clk/X VPWR VGND sg13g2_buf_8
XFILLER_23_7 VPWR VGND sg13g2_fill_1
X_1031_ _1031_/Q _1052_/CLK _1031_/D _0948_/X VPWR VGND sg13g2_dfrbpq_1
X_1100_ _1100_/X _1100_/A VPWR VGND sg13g2_buf_1
X_0815_ _0977_/D _0815_/A _0815_/B VPWR VGND sg13g2_xnor2_1
X_0746_ _0766_/B _0783_/A _1087_/A _0745_/Y _0861_/A VPWR VGND sg13g2_a22oi_1
X_0677_ _0677_/Y _0678_/A _0677_/B VPWR VGND sg13g2_nand2b_1
XFILLER_29_228 VPWR VGND sg13g2_decap_8
XFILLER_0_533 VPWR VGND sg13g2_decap_8
XFILLER_4_327 VPWR VGND sg13g2_decap_8
XFILLER_28_261 VPWR VGND sg13g2_decap_8
XFILLER_11_150 VPWR VGND sg13g2_decap_8
Xclk_lane.t_trail.tempo_68 clk_lane.t_trail.tempo/ARM VPWR VGND sg13g2_tielo
X_0600_ _0861_/A _0600_/A VPWR VGND sg13g2_inv_1
X_1014_ _1014_/Q _1014_/CLK _1014_/D _1082_/A VPWR VGND sg13g2_dfrbpq_1
XFILLER_30_492 VPWR VGND sg13g2_decap_8
X_0729_ _1009_/D _0729_/A _0729_/B VPWR VGND sg13g2_and2_1
XFILLER_27_79 VPWR VGND sg13g2_decap_8
XFILLER_25_242 VPWR VGND sg13g2_decap_8
XFILLER_4_157 VPWR VGND sg13g2_decap_8
XFILLER_16_242 VPWR VGND sg13g2_decap_8
XFILLER_29_570 VPWR VGND sg13g2_fill_1
XFILLER_12_0 VPWR VGND sg13g2_decap_8
XFILLER_27_529 VPWR VGND sg13g2_decap_4
Xfanout38 _0709_/B _0702_/Y VPWR VGND sg13g2_buf_8
XFILLER_22_256 VPWR VGND sg13g2_decap_8
XFILLER_22_289 VPWR VGND sg13g2_fill_1
XFILLER_13_256 VPWR VGND sg13g2_decap_8
XFILLER_9_249 VPWR VGND sg13g2_decap_8
X_0994_ _0994_/Q _1014_/CLK _0994_/D _1083_/A VPWR VGND sg13g2_dfrbpq_1
XFILLER_27_348 VPWR VGND sg13g2_decap_8
XFILLER_10_226 VPWR VGND sg13g2_decap_8
XFILLER_23_565 VPWR VGND sg13g2_decap_4
Xhold260 _0881_/B _1037_/Q VPWR VGND sg13g2_dlygate4sd3_1
Xhold271 _0739_/A _1003_/Q VPWR VGND sg13g2_dlygate4sd3_1
Xhold282 hold282/X _1025_/Q VPWR VGND sg13g2_dlygate4sd3_1
Xhold293 _0741_/B _1001_/Q VPWR VGND sg13g2_dlygate4sd3_1
XFILLER_18_348 VPWR VGND sg13g2_decap_8
Xinput6 input6/X tx_request_hs[3] VPWR VGND sg13g2_buf_1
X_0977_ _0977_/Q _1020_/CLK _0977_/D _0610_/Y VPWR VGND sg13g2_dfrbpq_2
XFILLER_27_178 VPWR VGND sg13g2_decap_8
XFILLER_11_546 VPWR VGND sg13g2_decap_8
XFILLER_18_178 VPWR VGND sg13g2_decap_8
X_0900_ _0900_/X _0901_/A _0901_/B VPWR VGND sg13g2_and2_1
X_0831_ _0962_/D _0833_/A _0834_/B hold283/X VPWR VGND sg13g2_a21o_1
X_0762_ _0762_/Y _0748_/Y _0601_/Y _1099_/A input5/X _0761_/Y VPWR VGND sg13g2_a221oi_1
X_0693_ _0693_/Y _1025_/Q _0693_/B VPWR VGND sg13g2_xnor2_1
XFILLER_30_107 VPWR VGND sg13g2_decap_8
XFILLER_28_498 VPWR VGND sg13g2_decap_8
XFILLER_23_192 VPWR VGND sg13g2_decap_8
X_1030_ _1030_/Q _1052_/CLK _1030_/D _0947_/X VPWR VGND sg13g2_dfrbpq_1
XFILLER_21_107 VPWR VGND sg13g2_decap_8
X_0814_ _0978_/D _0813_/Y _0593_/Y _0812_/B VPWR VGND sg13g2_a21oi_1
Xlane3.t_prep.tempo_84 lane3.t_prep.tempo/ARM VPWR VGND sg13g2_tielo
X_0745_ _0745_/Y _0760_/C _0760_/B _0914_/A VPWR VGND sg13g2_nor3_2
X_0676_ _0677_/B _1031_/Q _1030_/Q _1029_/Q _0684_/D VPWR VGND sg13g2_nand4_1
XFILLER_6_391 VPWR VGND sg13g2_decap_8
XFILLER_12_107 VPWR VGND sg13g2_decap_8
XFILLER_4_306 VPWR VGND sg13g2_decap_8
XFILLER_28_240 VPWR VGND sg13g2_decap_8
XFILLER_7_100 VPWR VGND sg13g2_decap_8
X_1013_ _1013_/Q _1035_/CLK _1013_/D _1082_/A VPWR VGND sg13g2_dfrbpq_1
XFILLER_30_471 VPWR VGND sg13g2_decap_8
X_0728_ _0729_/B _0730_/A _0734_/A _0726_/A VPWR VGND sg13g2_a21o_1
X_0659_ _1097_/A _0942_/A _0660_/B VPWR VGND sg13g2_and2_1
Xclkbuf_4_8_0_clk _1050_/CLK clkbuf_0_clk/X VPWR VGND sg13g2_buf_8
XFILLER_4_114 VPWR VGND sg13g2_decap_4
XFILLER_27_508 VPWR VGND sg13g2_decap_8
Xfanout39 _0653_/B _0650_/Y VPWR VGND sg13g2_buf_8
XFILLER_22_235 VPWR VGND sg13g2_decap_8
XFILLER_13_235 VPWR VGND sg13g2_decap_8
XFILLER_9_228 VPWR VGND sg13g2_decap_8
XFILLER_5_412 VPWR VGND sg13g2_decap_8
X_0993_ _0993_/Q _1014_/CLK _0993_/D _1083_/A VPWR VGND sg13g2_dfrbpq_1
XFILLER_5_83 VPWR VGND sg13g2_decap_8
XFILLER_27_327 VPWR VGND sg13g2_decap_8
XFILLER_23_544 VPWR VGND sg13g2_decap_8
Xhold250 _1022_/D _0694_/X VPWR VGND sg13g2_dlygate4sd3_1
Xhold261 _0740_/B _1002_/Q VPWR VGND sg13g2_dlygate4sd3_1
Xhold272 _0866_/A _0996_/Q VPWR VGND sg13g2_dlygate4sd3_1
Xhold283 hold283/X _0962_/Q VPWR VGND sg13g2_dlygate4sd3_1
Xhold294 _0726_/A _1009_/Q VPWR VGND sg13g2_dlygate4sd3_1
XFILLER_18_327 VPWR VGND sg13g2_decap_8
X_0976_ _0976_/Q _0976_/CLK _0976_/D _0795_/Y VPWR VGND sg13g2_dfrbpq_1
XFILLER_27_157 VPWR VGND sg13g2_decap_8
XFILLER_23_341 VPWR VGND sg13g2_decap_8
XFILLER_11_525 VPWR VGND sg13g2_decap_8
XFILLER_18_157 VPWR VGND sg13g2_decap_8
X_0830_ _0830_/Y _0830_/A _0830_/B VPWR VGND sg13g2_nand2_1
X_0761_ _0761_/Y _0761_/A1 _0758_/Y _0760_/X VPWR VGND sg13g2_o21ai_1
X_0692_ _1024_/D _0692_/A _0692_/B VPWR VGND sg13g2_xnor2_1
XFILLER_24_149 VPWR VGND sg13g2_decap_8
X_0959_ _0959_/Q _0976_/CLK _0959_/D rebuffer108/X VPWR VGND sg13g2_dfrbpq_1
XFILLER_28_477 VPWR VGND sg13g2_decap_8
XFILLER_23_171 VPWR VGND sg13g2_decap_8
XFILLER_11_93 VPWR VGND sg13g2_decap_8
XFILLER_7_348 VPWR VGND sg13g2_decap_8
XFILLER_3_565 VPWR VGND sg13g2_fill_2
X_0813_ _0813_/Y _0813_/A _0813_/B _0813_/C _0813_/D VPWR VGND sg13g2_nand4_1
X_0744_ _1087_/A _0920_/A _0747_/A VPWR VGND sg13g2_and2_1
X_0675_ _0684_/D _1028_/Q _1027_/Q VPWR VGND sg13g2_and2_1
X_1089_ _1089_/X _1089_/A VPWR VGND sg13g2_buf_1
XFILLER_25_458 VPWR VGND sg13g2_fill_1
XFILLER_11_185 VPWR VGND sg13g2_decap_8
XFILLER_7_178 VPWR VGND sg13g2_decap_8
XFILLER_3_384 VPWR VGND sg13g2_decap_8
XFILLER_19_263 VPWR VGND sg13g2_decap_8
X_1012_ _1012_/Q _1035_/CLK _1012_/D _1082_/A VPWR VGND sg13g2_dfrbpq_1
X_0727_ _1010_/D _0727_/A _0729_/A VPWR VGND sg13g2_xnor2_1
XFILLER_30_450 VPWR VGND sg13g2_decap_8
X_0658_ _0660_/B _0666_/B _1040_/Q VPWR VGND sg13g2_nor2b_1
X_0589_ _0847_/A _0589_/A VPWR VGND sg13g2_inv_16
XFILLER_21_494 VPWR VGND sg13g2_decap_8
XFILLER_21_461 VPWR VGND sg13g2_fill_2
XFILLER_21_450 VPWR VGND sg13g2_decap_4
XFILLER_16_288 VPWR VGND sg13g2_fill_1
XFILLER_3_192 VPWR VGND sg13g2_fill_2
X_0992_ _0992_/Q _1014_/CLK _0992_/D _1083_/A VPWR VGND sg13g2_dfrbpq_1
Xclkbuf_4_7_0_clk _0999_/CLK clkbuf_0_clk/X VPWR VGND sg13g2_buf_8
XFILLER_4_490 VPWR VGND sg13g2_decap_8
XFILLER_27_306 VPWR VGND sg13g2_decap_8
XFILLER_24_27 VPWR VGND sg13g2_decap_4
XFILLER_23_523 VPWR VGND sg13g2_decap_8
Xhold251 _0788_/B _0980_/Q VPWR VGND sg13g2_dlygate4sd3_1
Xhold262 _1002_/D _0740_/Y VPWR VGND sg13g2_dlygate4sd3_1
Xhold273 _0787_/B _0981_/Q VPWR VGND sg13g2_dlygate4sd3_1
Xhold284 _0741_/A _1004_/Q VPWR VGND sg13g2_dlygate4sd3_1
XFILLER_18_306 VPWR VGND sg13g2_decap_8
XFILLER_5_276 VPWR VGND sg13g2_fill_1
XFILLER_5_265 VPWR VGND sg13g2_decap_8
X_0975_ _0975_/Q _1020_/CLK _0975_/D _0795_/Y VPWR VGND sg13g2_dfrbpq_1
XFILLER_9_560 VPWR VGND sg13g2_fill_2
XFILLER_27_114 VPWR VGND sg13g2_decap_8
XFILLER_11_504 VPWR VGND sg13g2_decap_8
XFILLER_23_320 VPWR VGND sg13g2_decap_8
XFILLER_18_114 VPWR VGND sg13g2_decap_8
XFILLER_10_570 VPWR VGND sg13g2_fill_1
X_0760_ _0760_/X _0920_/A _0760_/B _0760_/C input5/X VPWR VGND sg13g2_or4_1
X_0691_ _0692_/B hold282/X _0693_/B VPWR VGND sg13g2_nand2b_1
XFILLER_24_106 VPWR VGND sg13g2_decap_8
X_0958_ _0958_/Y _0958_/A VPWR VGND sg13g2_inv_1
X_0889_ _1047_/D _0890_/A _0890_/C _0888_/Y VPWR VGND sg13g2_a21oi_1
XFILLER_28_456 VPWR VGND sg13g2_decap_8
XFILLER_11_334 VPWR VGND sg13g2_decap_8
XFILLER_7_327 VPWR VGND sg13g2_decap_8
XFILLER_23_150 VPWR VGND sg13g2_decap_8
XFILLER_11_72 VPWR VGND sg13g2_decap_8
X_0812_ _0979_/D _0812_/A _0812_/B VPWR VGND sg13g2_xnor2_1
X_0743_ _0921_/B _0749_/B _0999_/Q VPWR VGND sg13g2_nor2b_2
X_0674_ _1040_/D _0674_/A _0674_/B VPWR VGND sg13g2_xnor2_1
XFILLER_28_0 VPWR VGND sg13g2_decap_8
XFILLER_25_404 VPWR VGND sg13g2_fill_2
X_1088_ _1088_/X _1088_/A VPWR VGND sg13g2_buf_1
XFILLER_0_547 VPWR VGND sg13g2_decap_8
XFILLER_28_275 VPWR VGND sg13g2_decap_4
XFILLER_11_164 VPWR VGND sg13g2_decap_8
XFILLER_7_157 VPWR VGND sg13g2_decap_8
XFILLER_22_93 VPWR VGND sg13g2_decap_8
XFILLER_19_242 VPWR VGND sg13g2_decap_8
X_1011_ _1011_/Q _1011_/CLK _1011_/D _0935_/X VPWR VGND sg13g2_dfrbpq_1
X_0726_ _0729_/A _0726_/A _0730_/A _0734_/A VPWR VGND sg13g2_nand3_1
X_0657_ _0840_/B _0948_/A _0657_/B VPWR VGND sg13g2_nand2b_1
X_0588_ _0588_/Y _1005_/Q VPWR VGND sg13g2_inv_1
XFILLER_25_256 VPWR VGND sg13g2_decap_8
XFILLER_21_473 VPWR VGND sg13g2_decap_8
XFILLER_4_138 VPWR VGND sg13g2_decap_4
XFILLER_16_223 VPWR VGND sg13g2_fill_1
XFILLER_16_256 VPWR VGND sg13g2_decap_8
XFILLER_17_93 VPWR VGND sg13g2_decap_8
XFILLER_3_171 VPWR VGND sg13g2_decap_8
XFILLER_30_270 VPWR VGND sg13g2_decap_8
X_0709_ _0710_/A _0713_/A _0709_/B VPWR VGND sg13g2_nand2b_2
XFILLER_5_469 VPWR VGND sg13g2_decap_8
XFILLER_21_270 VPWR VGND sg13g2_decap_8
XFILLER_12_270 VPWR VGND sg13g2_decap_8
X_0991_ _0991_/Q _0991_/CLK _0991_/D _1083_/A VPWR VGND sg13g2_dfrbpq_1
XFILLER_23_502 VPWR VGND sg13g2_decap_8
Xhold252 _0980_/D _0788_/X VPWR VGND sg13g2_dlygate4sd3_1
Xhold274 _0981_/D _0787_/Y VPWR VGND sg13g2_dlygate4sd3_1
Xhold285 hold285/X _0983_/Q VPWR VGND sg13g2_dlygate4sd3_1
Xhold296 _0773_/A _0988_/Q VPWR VGND sg13g2_dlygate4sd3_1
XFILLER_5_244 VPWR VGND sg13g2_decap_8
XFILLER_30_93 VPWR VGND sg13g2_decap_8
X_0974_ _0974_/Q _1020_/CLK _0974_/D _0795_/Y VPWR VGND sg13g2_dfrbpq_1
Xclk_lane.t_trail.tempo VPWR VGND _0633_/B clk_lane.t_trail.tempo/ARM _0632_/Y fanout62/X
+ _0633_/A tempo_t80n
Xclkbuf_4_6_0_clk _1021_/CLK clkbuf_0_clk/X VPWR VGND sg13g2_buf_8
X_0690_ _1025_/D _0692_/A _0693_/B hold282/X VPWR VGND sg13g2_a21o_1
XFILLER_25_93 VPWR VGND sg13g2_decap_8
XFILLER_17_192 VPWR VGND sg13g2_decap_8
X_0957_ _0957_/Y _0958_/A VPWR VGND sg13g2_inv_1
X_0888_ _0888_/Y _0890_/A _0890_/C _0888_/C VPWR VGND sg13g2_nor3_1
XFILLER_28_402 VPWR VGND sg13g2_fill_2
XFILLER_15_107 VPWR VGND sg13g2_decap_8
XFILLER_28_435 VPWR VGND sg13g2_decap_8
XFILLER_11_313 VPWR VGND sg13g2_decap_8
XFILLER_7_306 VPWR VGND sg13g2_decap_8
X_0811_ _0812_/B _0813_/B _0901_/B _0813_/C _0811_/D VPWR VGND sg13g2_and4_1
X_0742_ _0757_/B _0999_/Q _0749_/B VPWR VGND sg13g2_and2_2
X_0673_ _1041_/D _0940_/B _0672_/Y _0671_/A VPWR VGND sg13g2_a21oi_2
Xlane1.t_exit.tempo VPWR VGND _0843_/B lane1.t_exit.tempo/ARM _0700_/Y fanout62/X
+ _0606_/A tempo_t150n
X_1087_ _1087_/X _1087_/A VPWR VGND sg13g2_buf_1
XFILLER_0_526 VPWR VGND sg13g2_decap_8
XFILLER_28_254 VPWR VGND sg13g2_decap_8
XFILLER_7_114 VPWR VGND sg13g2_decap_8
XFILLER_22_72 VPWR VGND sg13g2_decap_8
XFILLER_3_353 VPWR VGND sg13g2_fill_2
X_1010_ _1010_/Q _1021_/CLK _1010_/D _0934_/X VPWR VGND sg13g2_dfrbpq_1
XFILLER_30_485 VPWR VGND sg13g2_decap_8
X_0725_ _0734_/A _0725_/A _0731_/D VPWR VGND sg13g2_nor2b_1
X_0656_ _0656_/Y _0840_/A VPWR VGND sg13g2_inv_1
X_0587_ _0587_/Y _0587_/A VPWR VGND sg13g2_inv_1
XFILLER_25_235 VPWR VGND sg13g2_decap_8
XFILLER_21_463 VPWR VGND sg13g2_fill_1
XFILLER_16_235 VPWR VGND sg13g2_decap_8
XFILLER_17_72 VPWR VGND sg13g2_decap_8
XFILLER_29_552 VPWR VGND sg13g2_decap_8
XFILLER_3_150 VPWR VGND sg13g2_decap_8
XFILLER_22_249 VPWR VGND sg13g2_decap_8
X_0708_ _1098_/A _0708_/A _0713_/A VPWR VGND sg13g2_and2_2
X_0639_ _0640_/B _0641_/C _0641_/A _0641_/B _0639_/D VPWR VGND sg13g2_and4_1
XFILLER_13_249 VPWR VGND sg13g2_decap_8
XFILLER_5_426 VPWR VGND sg13g2_decap_8
XFILLER_21_293 VPWR VGND sg13g2_decap_4
XFILLER_28_93 VPWR VGND sg13g2_decap_8
X_0990_ _0990_/Q _1011_/CLK _0990_/D _0921_/X VPWR VGND sg13g2_dfrbpq_1
XFILLER_5_97 VPWR VGND sg13g2_decap_8
XFILLER_23_569 VPWR VGND sg13g2_fill_2
XFILLER_23_558 VPWR VGND sg13g2_decap_8
Xhold220 _1023_/D _0693_/Y VPWR VGND sg13g2_dlygate4sd3_1
Xhold231 _1006_/D _0735_/X VPWR VGND sg13g2_dlygate4sd3_1
Xhold242 _0725_/A _1011_/Q VPWR VGND sg13g2_dlygate4sd3_1
Xhold253 _0683_/A _1029_/Q VPWR VGND sg13g2_dlygate4sd3_1
Xhold264 _0786_/A _0982_/Q VPWR VGND sg13g2_dlygate4sd3_1
Xhold286 _0777_/A _0987_/Q VPWR VGND sg13g2_dlygate4sd3_1
Xhold297 _0679_/A _1030_/Q VPWR VGND sg13g2_dlygate4sd3_1
XFILLER_30_72 VPWR VGND sg13g2_decap_8
XFILLER_17_341 VPWR VGND sg13g2_decap_8
X_0973_ _0973_/Q _0991_/CLK _0973_/D _1084_/A VPWR VGND sg13g2_dfrbpq_1
XFILLER_9_562 VPWR VGND sg13g2_fill_1
XFILLER_11_539 VPWR VGND sg13g2_decap_8
Xclk_lane.t_prep.tempo_67 clk_lane.t_prep.tempo/ARM VPWR VGND sg13g2_tielo
Xrebuffer90 _0813_/A _0811_/D VPWR VGND sg13g2_buf_1
XFILLER_25_72 VPWR VGND sg13g2_decap_8
XFILLER_10_561 VPWR VGND sg13g2_decap_8
XFILLER_17_171 VPWR VGND sg13g2_decap_8
X_0956_ _0956_/Y _0958_/A VPWR VGND sg13g2_inv_1
X_0887_ _1046_/D _0887_/A _0887_/B VPWR VGND sg13g2_or2_1
XFILLER_23_185 VPWR VGND sg13g2_decap_8
XFILLER_27_480 VPWR VGND sg13g2_decap_8
X_0810_ _0815_/A _0813_/A _0813_/C _0813_/B VPWR VGND sg13g2_nand3_1
X_0741_ _1001_/D _0741_/A _0741_/B VPWR VGND sg13g2_or2_1
X_0672_ _0672_/Y _0672_/A _0672_/B _0672_/C _0674_/A VPWR VGND sg13g2_nand4_1
XFILLER_6_384 VPWR VGND sg13g2_decap_8
X_1086_ _1086_/X _1086_/A VPWR VGND sg13g2_buf_1
X_0939_ _0939_/Y _0939_/A VPWR VGND sg13g2_inv_1
Xclkbuf_4_5_0_clk _0976_/CLK clkbuf_0_clk/X VPWR VGND sg13g2_buf_8
XFILLER_28_233 VPWR VGND sg13g2_decap_8
XFILLER_11_100 VPWR VGND sg13g2_decap_8
XFILLER_3_332 VPWR VGND sg13g2_decap_8
XFILLER_3_398 VPWR VGND sg13g2_decap_8
XFILLER_30_464 VPWR VGND sg13g2_decap_8
X_0724_ _0724_/Y _0725_/A _0724_/B VPWR VGND sg13g2_nand2b_1
X_0655_ _0840_/A _0948_/A _0655_/B _1040_/Q VPWR VGND sg13g2_nand3_1
X_0586_ _0689_/A _1026_/Q VPWR VGND sg13g2_inv_1
XFILLER_4_118 VPWR VGND sg13g2_fill_2
XFILLER_4_107 VPWR VGND sg13g2_decap_8
XFILLER_29_531 VPWR VGND sg13g2_decap_8
XFILLER_12_431 VPWR VGND sg13g2_fill_2
XFILLER_12_475 VPWR VGND sg13g2_fill_2
XFILLER_22_228 VPWR VGND sg13g2_decap_8
X_0707_ _0843_/C _0934_/A _0707_/B VPWR VGND sg13g2_nand2b_1
XFILLER_7_490 VPWR VGND sg13g2_decap_8
X_0638_ _0641_/C _0638_/A _0638_/B _0638_/C _0638_/D VPWR VGND sg13g2_nor4_2
XFILLER_13_228 VPWR VGND sg13g2_decap_8
XFILLER_5_405 VPWR VGND sg13g2_decap_8
XFILLER_28_72 VPWR VGND sg13g2_decap_8
XFILLER_28_61 VPWR VGND sg13g2_fill_2
XFILLER_5_76 VPWR VGND sg13g2_decap_8
XFILLER_23_537 VPWR VGND sg13g2_decap_8
Xhold210 _1005_/D _0736_/Y VPWR VGND sg13g2_dlygate4sd3_1
Xhold221 _0833_/A _0961_/Q VPWR VGND sg13g2_dlygate4sd3_1
Xhold232 _0870_/A _1013_/Q VPWR VGND sg13g2_dlygate4sd3_1
Xhold243 _1011_/D _0724_/Y VPWR VGND sg13g2_dlygate4sd3_1
Xhold254 _0884_/B _1051_/Q VPWR VGND sg13g2_dlygate4sd3_1
Xhold265 _0982_/D _0786_/Y VPWR VGND sg13g2_dlygate4sd3_1
Xhold276 _0874_/B _1018_/Q VPWR VGND sg13g2_dlygate4sd3_1
Xhold287 _0887_/A _1046_/Q VPWR VGND sg13g2_dlygate4sd3_1
Xlane3.t_zero.tempo_85 lane3.t_zero.tempo/ARM VPWR VGND sg13g2_tielo
XFILLER_17_320 VPWR VGND sg13g2_decap_8
X_0972_ _0972_/Q _0972_/CLK _0972_/D _1084_/A VPWR VGND sg13g2_dfrbpq_1
XFILLER_23_334 VPWR VGND sg13g2_decap_8
XFILLER_11_518 VPWR VGND sg13g2_decap_8
Xrebuffer91 _0669_/C _0672_/A VPWR VGND sg13g2_buf_1
XFILLER_10_540 VPWR VGND sg13g2_decap_8
Xrebuffer170 hold299/A _1042_/Q VPWR VGND sg13g2_buf_1
XFILLER_17_150 VPWR VGND sg13g2_decap_8
X_0955_ _0955_/Y _0955_/A _0955_/B VPWR VGND sg13g2_nor2_1
X_0886_ _0887_/B _0890_/C _0888_/C VPWR VGND sg13g2_nor2_1
XFILLER_11_348 VPWR VGND sg13g2_decap_8
XFILLER_23_164 VPWR VGND sg13g2_decap_8
XFILLER_11_86 VPWR VGND sg13g2_decap_8
X_0740_ _0740_/Y _1004_/Q _0740_/B VPWR VGND sg13g2_xnor2_1
X_0671_ _1042_/D _0671_/A _0671_/B VPWR VGND sg13g2_xor2_1
XFILLER_6_341 VPWR VGND sg13g2_decap_8
X_1085_ _1085_/X _1085_/A VPWR VGND sg13g2_buf_1
X_0938_ _0938_/Y _0939_/A VPWR VGND sg13g2_inv_1
X_0869_ _1012_/D _0869_/A _0869_/B VPWR VGND sg13g2_nand2_1
XFILLER_11_178 VPWR VGND sg13g2_decap_8
XFILLER_3_311 VPWR VGND sg13g2_decap_8
XFILLER_19_256 VPWR VGND sg13g2_decap_8
X_0723_ _0724_/B _0727_/A _1009_/Q _1008_/Q _0731_/D VPWR VGND sg13g2_nand4_1
XFILLER_30_443 VPWR VGND sg13g2_decap_8
X_0654_ _0654_/Y _0654_/A VPWR VGND sg13g2_inv_4
X_0585_ _0942_/C _1040_/Q VPWR VGND sg13g2_inv_2
XFILLER_6_193 VPWR VGND sg13g2_decap_4
XFILLER_21_487 VPWR VGND sg13g2_decap_8
XFILLER_21_443 VPWR VGND sg13g2_decap_8
XFILLER_29_510 VPWR VGND sg13g2_decap_8
XFILLER_24_270 VPWR VGND sg13g2_decap_8
XFILLER_3_185 VPWR VGND sg13g2_decap_8
Xclkbuf_4_4_0_clk _1020_/CLK clkbuf_0_clk/X VPWR VGND sg13g2_buf_8
X_0706_ _0717_/C _0588_/Y _1086_/A _0603_/Y _0705_/X VPWR VGND sg13g2_a22oi_1
X_0637_ _0641_/B _0637_/A _0637_/B _0637_/C _0637_/D VPWR VGND sg13g2_nor4_2
XFILLER_17_535 VPWR VGND sg13g2_fill_1
XFILLER_28_40 VPWR VGND sg13g2_decap_8
XFILLER_4_483 VPWR VGND sg13g2_decap_8
XFILLER_23_516 VPWR VGND sg13g2_decap_8
Xhold200 _1027_/D _0688_/X VPWR VGND sg13g2_dlygate4sd3_1
Xhold211 hold211/X _0972_/Q VPWR VGND sg13g2_dlygate4sd3_1
Xhold222 _0961_/D _0833_/Y VPWR VGND sg13g2_dlygate4sd3_1
Xhold233 _0862_/A _0992_/Q VPWR VGND sg13g2_dlygate4sd3_1
Xhold244 _0772_/A _0990_/Q VPWR VGND sg13g2_dlygate4sd3_1
Xhold255 _1051_/D _0897_/Y VPWR VGND sg13g2_dlygate4sd3_1
Xhold266 _0873_/B _1016_/Q VPWR VGND sg13g2_dlygate4sd3_1
Xhold277 _0774_/A _0989_/Q VPWR VGND sg13g2_dlygate4sd3_1
Xhold299 _0671_/B hold299/A VPWR VGND sg13g2_dlygate4sd3_1
XFILLER_5_258 VPWR VGND sg13g2_decap_8
XFILLER_29_192 VPWR VGND sg13g2_decap_8
XFILLER_13_560 VPWR VGND sg13g2_fill_2
X_0971_ _0971_/Q _0972_/CLK _0971_/D _1084_/A VPWR VGND sg13g2_dfrbpq_1
XFILLER_9_553 VPWR VGND sg13g2_fill_2
XFILLER_27_107 VPWR VGND sg13g2_decap_8
XFILLER_23_313 VPWR VGND sg13g2_decap_8
XFILLER_18_107 VPWR VGND sg13g2_decap_8
Xrebuffer92 _0669_/A _0672_/B VPWR VGND sg13g2_buf_1
Xrebuffer171 _0662_/A _1042_/Q VPWR VGND sg13g2_buf_1
Xrebuffer160 _1082_/A _0705_/X VPWR VGND sg13g2_buf_1
X_0954_ _0954_/Y _0954_/A _0955_/B VPWR VGND sg13g2_nor2_1
X_0885_ _0888_/C _0890_/A _0890_/B _0893_/A VPWR VGND sg13g2_nor3_1
Xlane3.t_prep.tempo VPWR VGND _0795_/A lane3.t_prep.tempo/ARM _0974_/Q fanout63/X
+ _0598_/A tempo_t60n
XFILLER_28_449 VPWR VGND sg13g2_decap_8
XFILLER_11_327 VPWR VGND sg13g2_decap_8
X_0670_ _0671_/A _0672_/A _0672_/B _0672_/C _0841_/B VPWR VGND sg13g2_and4_2
XFILLER_6_320 VPWR VGND sg13g2_decap_8
X_1084_ _1084_/X _1084_/A VPWR VGND sg13g2_buf_1
X_0937_ _0937_/Y _0939_/A VPWR VGND sg13g2_inv_1
X_0868_ _0869_/B _0870_/A hold205/X _0936_/A VPWR VGND sg13g2_a21oi_1
X_0799_ _0799_/Y _0907_/A _0799_/B _0801_/B VPWR VGND sg13g2_nor3_1
XFILLER_28_268 VPWR VGND sg13g2_decap_8
XFILLER_11_157 VPWR VGND sg13g2_decap_8
XFILLER_22_86 VPWR VGND sg13g2_decap_8
XFILLER_19_235 VPWR VGND sg13g2_decap_8
X_0722_ _0731_/D _1007_/Q _1006_/Q VPWR VGND sg13g2_and2_1
X_0653_ _0654_/A _0942_/A _0653_/B VPWR VGND sg13g2_nand2b_2
XFILLER_6_172 VPWR VGND sg13g2_decap_8
XFILLER_30_499 VPWR VGND sg13g2_decap_8
X_0584_ _0942_/B _1041_/Q VPWR VGND sg13g2_inv_2
XFILLER_25_249 VPWR VGND sg13g2_decap_8
XFILLER_29_566 VPWR VGND sg13g2_decap_4
XFILLER_16_249 VPWR VGND sg13g2_decap_8
XFILLER_17_86 VPWR VGND sg13g2_decap_8
XFILLER_3_164 VPWR VGND sg13g2_decap_8
XFILLER_12_7 VPWR VGND sg13g2_decap_8
XFILLER_30_263 VPWR VGND sg13g2_decap_8
X_0705_ _0705_/X _0934_/A _0707_/B VPWR VGND sg13g2_and2_2
X_0636_ _0637_/D _0636_/A _0636_/B VPWR VGND sg13g2_nor2_2
XFILLER_21_263 VPWR VGND sg13g2_decap_8
Xlane1.t_exit.tempo_74 lane1.t_exit.tempo/ARM VPWR VGND sg13g2_tielo
XFILLER_29_341 VPWR VGND sg13g2_decap_8
XFILLER_12_263 VPWR VGND sg13g2_decap_8
XFILLER_4_462 VPWR VGND sg13g2_decap_8
Xhold201 hold201/X _0993_/Q VPWR VGND sg13g2_dlygate4sd3_1
Xhold212 _0877_/A _0607_/Y VPWR VGND sg13g2_dlygate4sd3_1
Xhold223 _0594_/A _0963_/Q VPWR VGND sg13g2_dlygate4sd3_1
Xhold234 _0727_/A _1010_/Q VPWR VGND sg13g2_dlygate4sd3_1
Xhold245 _0990_/D _0771_/Y VPWR VGND sg13g2_dlygate4sd3_1
Xhold256 _0865_/B _0995_/Q VPWR VGND sg13g2_dlygate4sd3_1
Xhold267 _1016_/D _0873_/X VPWR VGND sg13g2_dlygate4sd3_1
Xhold278 _0857_/B _0974_/Q VPWR VGND sg13g2_dlygate4sd3_1
Xhold289 _0898_/A _1045_/Q VPWR VGND sg13g2_dlygate4sd3_1
X_0619_ _0622_/C _0623_/B _0619_/B VPWR VGND sg13g2_nand2b_1
XFILLER_22_550 VPWR VGND sg13g2_decap_8
XFILLER_5_237 VPWR VGND sg13g2_decap_8
XFILLER_5_215 VPWR VGND sg13g2_decap_4
XFILLER_30_86 VPWR VGND sg13g2_decap_8
Xclkbuf_4_3_0_clk _1025_/CLK clkbuf_0_clk/X VPWR VGND sg13g2_buf_8
XFILLER_29_171 VPWR VGND sg13g2_decap_8
X_0970_ _0970_/Q _0972_/CLK _0970_/D _1084_/A VPWR VGND sg13g2_dfrbpq_1
XFILLER_9_532 VPWR VGND sg13g2_decap_8
XFILLER_4_270 VPWR VGND sg13g2_decap_8
Xrebuffer93 _0716_/A _0719_/D VPWR VGND sg13g2_buf_1
XFILLER_25_86 VPWR VGND sg13g2_decap_8
XFILLER_17_185 VPWR VGND sg13g2_decap_8
XFILLER_13_391 VPWR VGND sg13g2_fill_2
X_0953_ _0953_/Y _0958_/A VPWR VGND sg13g2_inv_1
X_0884_ _0890_/C _0884_/A _0884_/B VPWR VGND sg13g2_nand2_1
XFILLER_23_100 VPWR VGND sg13g2_decap_8
XFILLER_11_306 VPWR VGND sg13g2_decap_8
XFILLER_23_199 VPWR VGND sg13g2_decap_4
XFILLER_23_144 VPWR VGND sg13g2_fill_1
XFILLER_3_505 VPWR VGND sg13g2_decap_4
XFILLER_27_494 VPWR VGND sg13g2_decap_8
XFILLER_6_398 VPWR VGND sg13g2_decap_8
X_1083_ _1083_/X _1083_/A VPWR VGND sg13g2_buf_1
X_0936_ _1015_/D _0936_/A VPWR VGND sg13g2_buf_1
X_0867_ _0867_/Y _0996_/Q _0867_/B VPWR VGND sg13g2_xnor2_1
X_0798_ _0798_/Y _0849_/B VPWR VGND sg13g2_inv_1
XFILLER_9_192 VPWR VGND sg13g2_decap_8
XFILLER_28_247 VPWR VGND sg13g2_decap_8
XFILLER_11_114 VPWR VGND sg13g2_decap_8
XFILLER_24_486 VPWR VGND sg13g2_decap_4
XFILLER_7_107 VPWR VGND sg13g2_decap_8
XFILLER_3_346 VPWR VGND sg13g2_decap_8
XFILLER_30_478 VPWR VGND sg13g2_decap_8
X_0721_ _1019_/D _0721_/A _0721_/B VPWR VGND sg13g2_xnor2_1
X_0652_ _0672_/B _0649_/X _0607_/Y _0651_/X _0689_/A VPWR VGND sg13g2_a22oi_1
X_0583_ _0583_/Y _0639_/D VPWR VGND sg13g2_inv_1
XFILLER_6_151 VPWR VGND sg13g2_decap_8
XFILLER_25_228 VPWR VGND sg13g2_decap_8
X_0919_ _0919_/X _0920_/A _0920_/B VPWR VGND sg13g2_and2_1
XFILLER_16_228 VPWR VGND sg13g2_decap_8
XFILLER_29_545 VPWR VGND sg13g2_decap_8
XFILLER_12_445 VPWR VGND sg13g2_fill_2
XFILLER_15_261 VPWR VGND sg13g2_decap_8
XFILLER_30_242 VPWR VGND sg13g2_decap_8
X_0704_ _0707_/B _0704_/A _0704_/B VPWR VGND sg13g2_nor2_1
X_0635_ _0635_/Y _0636_/B VPWR VGND sg13g2_inv_1
XFILLER_21_242 VPWR VGND sg13g2_decap_8
X_1049_ _1049_/Q _1051_/CLK _1049_/D _0635_/Y VPWR VGND sg13g2_dfrbpq_1
XFILLER_5_419 VPWR VGND sg13g2_decap_8
XFILLER_29_320 VPWR VGND sg13g2_decap_8
XFILLER_28_86 VPWR VGND sg13g2_decap_8
XFILLER_12_242 VPWR VGND sg13g2_decap_8
Xhold224 _0963_/D _0830_/Y VPWR VGND sg13g2_dlygate4sd3_1
Xhold235 _0854_/A _0971_/Q VPWR VGND sg13g2_dlygate4sd3_1
Xhold246 _0692_/A _1024_/Q VPWR VGND sg13g2_dlygate4sd3_1
Xhold257 _0858_/B _0976_/Q VPWR VGND sg13g2_dlygate4sd3_1
Xhold268 _0835_/B _0959_/Q VPWR VGND sg13g2_dlygate4sd3_1
X_0618_ _0638_/A _0630_/A _0618_/B _0618_/C VPWR VGND sg13g2_nor3_2
XFILLER_17_301 VPWR VGND sg13g2_fill_1
XFILLER_29_150 VPWR VGND sg13g2_decap_8
XFILLER_13_551 VPWR VGND sg13g2_decap_4
XFILLER_13_562 VPWR VGND sg13g2_fill_1
XFILLER_17_334 VPWR VGND sg13g2_decap_8
XFILLER_9_555 VPWR VGND sg13g2_fill_1
XFILLER_9_511 VPWR VGND sg13g2_decap_8
XFILLER_23_348 VPWR VGND sg13g2_decap_8
Xrebuffer94 _0713_/B _1020_/Q VPWR VGND sg13g2_buf_1
XFILLER_10_554 VPWR VGND sg13g2_decap_8
Xrebuffer140 _0907_/B _0794_/B VPWR VGND sg13g2_buf_1
XFILLER_17_164 VPWR VGND sg13g2_decap_8
X_0952_ _0952_/Y _0958_/A VPWR VGND sg13g2_inv_1
X_0883_ _0883_/Y _1038_/Q _0883_/B VPWR VGND sg13g2_xnor2_1
Xclkbuf_4_2_0_clk _1052_/CLK clkbuf_0_clk/X VPWR VGND sg13g2_buf_8
XFILLER_23_178 VPWR VGND sg13g2_decap_8
XFILLER_27_473 VPWR VGND sg13g2_decap_8
XFILLER_10_340 VPWR VGND sg13g2_decap_8
X_1082_ _1082_/X _1082_/A VPWR VGND sg13g2_buf_1
X_0935_ _0935_/X _0935_/A _0935_/B VPWR VGND sg13g2_and2_1
X_0866_ _0997_/D _0866_/A _0867_/B VPWR VGND sg13g2_or2_1
XFILLER_9_171 VPWR VGND sg13g2_decap_8
X_0797_ _0849_/B _0801_/B _0804_/B VPWR VGND sg13g2_nand2b_1
XFILLER_28_226 VPWR VGND sg13g2_decap_8
XFILLER_3_325 VPWR VGND sg13g2_decap_8
XFILLER_0_4 VPWR VGND sg13g2_decap_8
XFILLER_15_454 VPWR VGND sg13g2_fill_2
XFILLER_27_270 VPWR VGND sg13g2_decap_8
X_0720_ _1020_/D _0587_/Y _0719_/Y _0718_/A VPWR VGND sg13g2_a21oi_1
XFILLER_30_457 VPWR VGND sg13g2_decap_8
XFILLER_10_192 VPWR VGND sg13g2_decap_8
X_0651_ _0651_/X _0948_/A _0653_/B VPWR VGND sg13g2_and2_1
XFILLER_18_270 VPWR VGND sg13g2_decap_8
X_0918_ _0918_/X _0921_/A _0920_/B VPWR VGND sg13g2_and2_1
X_0849_ _1092_/A _1096_/A _0849_/B VPWR VGND sg13g2_nand2b_1
XFILLER_29_524 VPWR VGND sg13g2_decap_8
XFILLER_3_100 VPWR VGND sg13g2_decap_8
XFILLER_15_240 VPWR VGND sg13g2_decap_8
XFILLER_11_490 VPWR VGND sg13g2_decap_8
X_0703_ _1086_/A _0934_/A _0709_/B VPWR VGND sg13g2_and2_1
XFILLER_7_483 VPWR VGND sg13g2_decap_8
X_0634_ _0636_/B _0851_/A _0634_/B _0955_/A VPWR VGND sg13g2_nand3b_1
X_1048_ _1048_/Q _1051_/CLK _1048_/D _0635_/Y VPWR VGND sg13g2_dfrbpq_1
XFILLER_28_54 VPWR VGND sg13g2_decap_8
XFILLER_25_560 VPWR VGND sg13g2_fill_2
XFILLER_4_497 VPWR VGND sg13g2_decap_8
Xhold214 _0600_/A _0991_/Q VPWR VGND sg13g2_dlygate4sd3_1
Xhold225 _0834_/B _0960_/Q VPWR VGND sg13g2_dlygate4sd3_1
Xhold236 _0678_/A _1032_/Q VPWR VGND sg13g2_dlygate4sd3_1
Xhold258 _0824_/A _0966_/Q VPWR VGND sg13g2_dlygate4sd3_1
Xhold269 _0959_/D _0835_/X VPWR VGND sg13g2_dlygate4sd3_1
X_0617_ _0617_/Y _0617_/A VPWR VGND sg13g2_inv_1
XFILLER_30_11 VPWR VGND sg13g2_fill_1
XFILLER_17_313 VPWR VGND sg13g2_decap_8
XFILLER_13_530 VPWR VGND sg13g2_decap_8
Xlane0.t_zero.tempo VPWR VGND _0664_/Y lane0.t_zero.tempo/ARM _1022_/Q fanout61/X
+ _0667_/A1 tempo_t150n
XFILLER_23_327 VPWR VGND sg13g2_decap_8
Xrebuffer95 _0696_/A _1020_/Q VPWR VGND sg13g2_buf_1
XFILLER_10_533 VPWR VGND sg13g2_decap_8
Xrebuffer152 _0934_/B _0709_/B VPWR VGND sg13g2_buf_1
Xrebuffer141 _0760_/C _0749_/B VPWR VGND sg13g2_buf_2
Xrebuffer130 _0801_/A _0804_/B VPWR VGND sg13g2_buf_1
XFILLER_6_504 VPWR VGND sg13g2_decap_4
X_0951_ _0951_/Y _0958_/A VPWR VGND sg13g2_inv_1
X_0882_ _1039_/D _0882_/A _0883_/B VPWR VGND sg13g2_or2_1
XFILLER_9_353 VPWR VGND sg13g2_fill_2
XFILLER_23_157 VPWR VGND sg13g2_decap_8
XFILLER_11_79 VPWR VGND sg13g2_decap_8
XFILLER_27_452 VPWR VGND sg13g2_decap_8
XFILLER_6_334 VPWR VGND sg13g2_decap_8
XFILLER_28_7 VPWR VGND sg13g2_fill_2
X_1081_ _1081_/X _1081_/A VPWR VGND sg13g2_buf_1
X_0934_ _0934_/X _0934_/A _0934_/B VPWR VGND sg13g2_and2_1
X_0865_ _0995_/D _0867_/B _0865_/B VPWR VGND sg13g2_or2_1
XFILLER_9_150 VPWR VGND sg13g2_decap_8
X_0796_ _0801_/B _0807_/B _0807_/C VPWR VGND sg13g2_nand2b_1
XFILLER_24_499 VPWR VGND sg13g2_decap_8
XFILLER_19_249 VPWR VGND sg13g2_decap_8
XFILLER_10_171 VPWR VGND sg13g2_decap_8
XFILLER_30_436 VPWR VGND sg13g2_decap_8
X_0650_ _0650_/Y _1040_/Q _1041_/Q VPWR VGND sg13g2_nor2b_2
XFILLER_6_197 VPWR VGND sg13g2_fill_2
XFILLER_6_186 VPWR VGND sg13g2_decap_8
Xclkbuf_4_1_0_clk _1024_/CLK clkbuf_0_clk/X VPWR VGND sg13g2_buf_8
XFILLER_21_436 VPWR VGND sg13g2_decap_8
X_0917_ _0917_/X _0921_/A _0920_/B VPWR VGND sg13g2_and2_1
X_0848_ _1096_/A _0800_/Y _0848_/B VPWR VGND sg13g2_nand2b_1
X_0779_ _0783_/B _0778_/Y _0990_/Q VPWR VGND sg13g2_nand2b_1
XFILLER_29_503 VPWR VGND sg13g2_decap_8
XFILLER_24_263 VPWR VGND sg13g2_decap_8
XFILLER_12_447 VPWR VGND sg13g2_fill_1
Xclk_lane.t_zero.tempo_69 clk_lane.t_zero.tempo/ARM VPWR VGND sg13g2_tielo
XFILLER_3_178 VPWR VGND sg13g2_decap_8
X_0702_ _0702_/Y _1019_/Q _1020_/Q VPWR VGND sg13g2_nor2b_2
X_0633_ _0638_/C _0633_/A _0633_/B VPWR VGND sg13g2_nor2_1
XFILLER_7_462 VPWR VGND sg13g2_decap_8
X_1047_ _1047_/Q _1051_/CLK _1047_/D _0635_/Y VPWR VGND sg13g2_dfrbpq_1
XFILLER_4_476 VPWR VGND sg13g2_decap_8
XFILLER_23_509 VPWR VGND sg13g2_decap_8
Xhold204 _0984_/D _0783_/Y VPWR VGND sg13g2_dlygate4sd3_1
Xhold226 _0960_/D _0834_/Y VPWR VGND sg13g2_dlygate4sd3_1
Xhold237 _1032_/D _0677_/Y VPWR VGND sg13g2_dlygate4sd3_1
Xhold248 _0680_/A _1031_/Q VPWR VGND sg13g2_dlygate4sd3_1
X_0616_ _0617_/A _0630_/A _0618_/C VPWR VGND sg13g2_or2_1
XFILLER_7_270 VPWR VGND sg13g2_decap_8
XFILLER_22_564 VPWR VGND sg13g2_fill_2
XFILLER_29_185 VPWR VGND sg13g2_decap_8
XFILLER_29_130 VPWR VGND sg13g2_fill_2
XFILLER_9_546 VPWR VGND sg13g2_decap_8
XFILLER_23_306 VPWR VGND sg13g2_decap_8
XFILLER_10_512 VPWR VGND sg13g2_decap_8
Xrebuffer96 _0699_/B _0704_/A VPWR VGND sg13g2_buf_1
Xrebuffer153 _0851_/A _1053_/Q VPWR VGND sg13g2_buf_2
Xrebuffer142 _0920_/B _0747_/A VPWR VGND sg13g2_buf_1
Xrebuffer131 _0767_/B1 _0765_/A VPWR VGND sg13g2_buf_1
Xrebuffer120 hold309/A _0998_/Q VPWR VGND sg13g2_buf_1
XFILLER_17_100 VPWR VGND sg13g2_decap_8
X_0950_ _1036_/D _0950_/A VPWR VGND sg13g2_buf_1
X_0881_ _1037_/D _0883_/B _0881_/B VPWR VGND sg13g2_or2_1
XFILLER_9_332 VPWR VGND sg13g2_decap_8
XFILLER_23_114 VPWR VGND sg13g2_decap_8
XFILLER_6_313 VPWR VGND sg13g2_decap_8
X_1080_ _1080_/X _1080_/A VPWR VGND sg13g2_buf_1
Xclk_lane.t_zero.tempo VPWR VGND _0628_/B clk_lane.t_zero.tempo/ARM _1043_/Q fanout61/X
+ _0628_/A tempo_t350n
X_0933_ _0933_/X _0934_/A _0934_/B VPWR VGND sg13g2_and2_1
X_0864_ _0993_/D _0862_/A _0861_/B hold201/X VPWR VGND sg13g2_a21o_1
X_0795_ _0795_/Y _0795_/A VPWR VGND sg13g2_inv_4
XFILLER_9_140 VPWR VGND sg13g2_fill_1
XFILLER_22_79 VPWR VGND sg13g2_decap_8
XFILLER_19_228 VPWR VGND sg13g2_decap_8
XFILLER_15_456 VPWR VGND sg13g2_fill_1
XFILLER_10_150 VPWR VGND sg13g2_decap_8
XFILLER_6_165 VPWR VGND sg13g2_decap_8
XFILLER_19_4 VPWR VGND sg13g2_decap_4
X_0916_ _0916_/X _0921_/A _0920_/B VPWR VGND sg13g2_and2_1
X_0847_ _1079_/A _0847_/A _0914_/B VPWR VGND sg13g2_xnor2_1
X_0778_ _0778_/Y _0989_/Q _0988_/Q _0987_/Q _0778_/D VPWR VGND sg13g2_nor4_1
XFILLER_29_559 VPWR VGND sg13g2_decap_8
XFILLER_12_437 VPWR VGND sg13g2_fill_1
XFILLER_17_79 VPWR VGND sg13g2_decap_8
XFILLER_24_242 VPWR VGND sg13g2_decap_8
XFILLER_3_157 VPWR VGND sg13g2_decap_8
Xlane2.t_exit.tempo VPWR VGND _0845_/B lane2.t_exit.tempo/ARM _0756_/Y fanout63/X
+ _0602_/A tempo_t150n
XFILLER_15_275 VPWR VGND sg13g2_fill_2
XFILLER_30_256 VPWR VGND sg13g2_decap_8
X_0701_ _0717_/B _0698_/Y _0605_/Y _0700_/Y _0606_/Y VPWR VGND sg13g2_a22oi_1
X_0632_ _0632_/Y _0633_/B VPWR VGND sg13g2_inv_1
X_1046_ _1046_/Q _1050_/CLK _1046_/D _0635_/Y VPWR VGND sg13g2_dfrbpq_1
XFILLER_21_256 VPWR VGND sg13g2_decap_8
XFILLER_29_334 VPWR VGND sg13g2_decap_8
XFILLER_12_223 VPWR VGND sg13g2_fill_1
XFILLER_12_256 VPWR VGND sg13g2_decap_8
XFILLER_25_562 VPWR VGND sg13g2_fill_1
Xclkbuf_4_0_0_clk _1054_/CLK clkbuf_0_clk/X VPWR VGND sg13g2_buf_8
XFILLER_4_433 VPWR VGND sg13g2_fill_1
Xhold205 hold205/X _1014_/Q VPWR VGND sg13g2_dlygate4sd3_1
Xhold227 _0646_/B _1044_/Q VPWR VGND sg13g2_dlygate4sd3_1
Xhold249 _0694_/B _1022_/Q VPWR VGND sg13g2_dlygate4sd3_1
X_0615_ _0618_/C _0619_/B _0623_/B VPWR VGND sg13g2_nand2b_1
X_1029_ _1029_/Q _1050_/CLK _1029_/D _0946_/X VPWR VGND sg13g2_dfrbpq_1
XFILLER_22_543 VPWR VGND sg13g2_decap_8
XFILLER_5_219 VPWR VGND sg13g2_fill_2
XFILLER_30_79 VPWR VGND sg13g2_decap_8
XFILLER_17_348 VPWR VGND sg13g2_decap_8
XFILLER_29_164 VPWR VGND sg13g2_decap_8
XFILLER_9_525 VPWR VGND sg13g2_decap_8
XFILLER_4_263 VPWR VGND sg13g2_decap_8
Xrebuffer97 _0844_/B _0695_/X VPWR VGND sg13g2_buf_1
Xrebuffer86 _0766_/D _0764_/A VPWR VGND sg13g2_buf_1
XFILLER_10_568 VPWR VGND sg13g2_fill_2
Xrebuffer132 rebuffer132/X _0805_/Y VPWR VGND sg13g2_buf_1
Xrebuffer121 _0760_/B _0999_/Q VPWR VGND sg13g2_buf_2
Xrebuffer110 fanout57/A _0979_/Q VPWR VGND sg13g2_buf_1
XFILLER_25_79 VPWR VGND sg13g2_decap_8
Xrebuffer154 _0634_/B _1052_/Q VPWR VGND sg13g2_buf_8
Xrebuffer143 rebuffer143/X _0748_/Y VPWR VGND sg13g2_buf_1
XFILLER_17_178 VPWR VGND sg13g2_decap_8
X_0880_ _1035_/D _0878_/A _0877_/B hold192/X VPWR VGND sg13g2_a21o_1
XFILLER_9_311 VPWR VGND sg13g2_decap_8
XFILLER_3_509 VPWR VGND sg13g2_fill_2
XFILLER_27_487 VPWR VGND sg13g2_decap_8
XFILLER_10_354 VPWR VGND sg13g2_fill_1
XFILLER_10_387 VPWR VGND sg13g2_fill_2
XFILLER_22_192 VPWR VGND sg13g2_decap_8
XFILLER_28_9 VPWR VGND sg13g2_fill_1
XFILLER_13_192 VPWR VGND sg13g2_decap_8
X_0932_ _0932_/X _0934_/A _0934_/B VPWR VGND sg13g2_and2_1
X_0863_ _0992_/D _0862_/A _0861_/B _0862_/Y VPWR VGND sg13g2_a21oi_1
X_0794_ _0795_/A _0804_/B _0794_/B VPWR VGND sg13g2_nand2_2
XFILLER_9_185 VPWR VGND sg13g2_decap_8
XFILLER_5_391 VPWR VGND sg13g2_decap_8
XFILLER_3_93 VPWR VGND sg13g2_decap_8
XFILLER_11_107 VPWR VGND sg13g2_decap_8
XFILLER_22_25 VPWR VGND sg13g2_fill_1
XFILLER_3_339 VPWR VGND sg13g2_decap_8
XFILLER_6_100 VPWR VGND sg13g2_decap_8
X_0915_ _0915_/X _0921_/A _0920_/B VPWR VGND sg13g2_and2_1
X_0846_ _1091_/A _1095_/A _0846_/B VPWR VGND sg13g2_nand2b_1
X_0777_ _0987_/D _0777_/A _0781_/A VPWR VGND sg13g2_xor2_1
XFILLER_29_538 VPWR VGND sg13g2_decap_8
XFILLER_3_114 VPWR VGND sg13g2_decap_8
XFILLER_11_460 VPWR VGND sg13g2_decap_8
XFILLER_11_471 VPWR VGND sg13g2_fill_2
XFILLER_15_254 VPWR VGND sg13g2_decap_8
X_0700_ _0700_/Y _0843_/B VPWR VGND sg13g2_inv_1
XFILLER_30_235 VPWR VGND sg13g2_decap_8
X_0631_ _0633_/B _0634_/B _0851_/A _0955_/A VPWR VGND sg13g2_nand3b_1
XFILLER_7_497 VPWR VGND sg13g2_decap_8
XFILLER_19_560 VPWR VGND sg13g2_fill_2
XFILLER_21_235 VPWR VGND sg13g2_decap_8
X_1045_ _1045_/Q _1051_/CLK _1045_/D _0955_/Y VPWR VGND sg13g2_dfrbpq_1
X_0829_ _0964_/D _0964_/Q _0830_/B VPWR VGND sg13g2_xor2_1
XFILLER_29_313 VPWR VGND sg13g2_decap_8
XFILLER_28_79 VPWR VGND sg13g2_decap_8
XFILLER_25_541 VPWR VGND sg13g2_decap_8
XFILLER_12_235 VPWR VGND sg13g2_decap_8
XFILLER_4_412 VPWR VGND sg13g2_decap_8
Xhold217 _0869_/A _0603_/Y VPWR VGND sg13g2_dlygate4sd3_1
Xhold228 _1044_/D _0645_/Y VPWR VGND sg13g2_dlygate4sd3_1
Xhold239 _0969_/D _0818_/Y VPWR VGND sg13g2_dlygate4sd3_1
X_0614_ _0637_/A input1/X _0613_/Y VPWR VGND sg13g2_nor2b_1
X_1028_ _1028_/Q _1050_/CLK _1028_/D _0945_/X VPWR VGND sg13g2_dfrbpq_1
XFILLER_22_566 VPWR VGND sg13g2_fill_1
XFILLER_22_522 VPWR VGND sg13g2_decap_8
XFILLER_13_544 VPWR VGND sg13g2_decap_8
XFILLER_17_327 VPWR VGND sg13g2_decap_8
XFILLER_13_555 VPWR VGND sg13g2_fill_1
XFILLER_9_504 VPWR VGND sg13g2_decap_8
XFILLER_4_242 VPWR VGND sg13g2_decap_8
XFILLER_6_93 VPWR VGND sg13g2_decap_8
Xrebuffer98 _0719_/B _0717_/B VPWR VGND sg13g2_buf_2
Xrebuffer87 _0764_/A _0762_/Y VPWR VGND sg13g2_buf_2
XFILLER_10_547 VPWR VGND sg13g2_decap_8
Xrebuffer155 _0836_/B _0625_/B VPWR VGND sg13g2_buf_1
Xrebuffer133 _0587_/A hold345/X VPWR VGND sg13g2_buf_1
Xrebuffer122 _1083_/A _0745_/Y VPWR VGND sg13g2_buf_1
Xrebuffer111 _0807_/B _0978_/Q VPWR VGND sg13g2_buf_2
Xrebuffer100 _0713_/C _1019_/Q VPWR VGND sg13g2_buf_1
XFILLER_22_341 VPWR VGND sg13g2_decap_8
XFILLER_13_341 VPWR VGND sg13g2_decap_8
XFILLER_17_157 VPWR VGND sg13g2_decap_8
XFILLER_5_540 VPWR VGND sg13g2_decap_8
XFILLER_27_466 VPWR VGND sg13g2_decap_8
XFILLER_10_333 VPWR VGND sg13g2_decap_8
XFILLER_6_348 VPWR VGND sg13g2_decap_8
XFILLER_22_171 VPWR VGND sg13g2_decap_8
XFILLER_13_171 VPWR VGND sg13g2_decap_8
X_0931_ _0931_/X _0935_/A _0934_/B VPWR VGND sg13g2_and2_1
X_0862_ _0862_/Y _0862_/A _0922_/A VPWR VGND sg13g2_nor2b_1
XFILLER_9_164 VPWR VGND sg13g2_decap_8
X_0793_ _0793_/Y _0791_/X _0830_/A _0792_/Y _0853_/A VPWR VGND sg13g2_a22oi_1
XFILLER_3_72 VPWR VGND sg13g2_decap_8
XFILLER_3_318 VPWR VGND sg13g2_decap_8
XFILLER_27_263 VPWR VGND sg13g2_decap_8
XFILLER_10_185 VPWR VGND sg13g2_decap_8
XFILLER_18_263 VPWR VGND sg13g2_decap_8
X_0914_ _0914_/X _0914_/A _0914_/B VPWR VGND sg13g2_and2_1
X_0845_ _1095_/A _0753_/Y _0845_/B VPWR VGND sg13g2_nand2b_1
X_0776_ _0988_/D _0776_/A _0776_/B VPWR VGND sg13g2_and2_1
XFILLER_29_517 VPWR VGND sg13g2_decap_8
XFILLER_24_288 VPWR VGND sg13g2_fill_1
XFILLER_15_233 VPWR VGND sg13g2_decap_8
XFILLER_28_561 VPWR VGND sg13g2_decap_4
XFILLER_7_476 VPWR VGND sg13g2_decap_8
X_0630_ _0637_/C _0630_/A input1/X _0630_/C VPWR VGND sg13g2_and3_1
X_1044_ _1044_/Q _1052_/CLK _1044_/D _0954_/Y VPWR VGND sg13g2_dfrbpq_1
X_0828_ _0965_/D _0828_/A _0828_/B VPWR VGND sg13g2_nor2_1
X_0759_ _0766_/C _0602_/Y _0756_/Y _0752_/Y VPWR VGND sg13g2_a21oi_1
XFILLER_9_93 VPWR VGND sg13g2_decap_8
XFILLER_28_47 VPWR VGND sg13g2_decap_8
Xhold207 _0985_/D _0782_/X VPWR VGND sg13g2_dlygate4sd3_1
Xhold229 _0878_/A _1034_/Q VPWR VGND sg13g2_dlygate4sd3_1
X_0613_ _0613_/Y _0630_/A _0623_/B _0619_/B VPWR VGND sg13g2_nor3_2
X_1027_ _1027_/Q _1036_/CLK _1027_/D _0944_/X VPWR VGND sg13g2_dfrbpq_1
XFILLER_22_501 VPWR VGND sg13g2_decap_8
XFILLER_17_306 VPWR VGND sg13g2_decap_8
XFILLER_29_100 VPWR VGND sg13g2_decap_8
XFILLER_13_523 VPWR VGND sg13g2_decap_8
XFILLER_25_394 VPWR VGND sg13g2_fill_1
XFILLER_6_72 VPWR VGND sg13g2_decap_8
Xrebuffer99 _0719_/C _0717_/C VPWR VGND sg13g2_buf_2
Xrebuffer88 _0719_/D _0715_/Y VPWR VGND sg13g2_buf_2
XFILLER_25_59 VPWR VGND sg13g2_fill_1
XFILLER_22_320 VPWR VGND sg13g2_decap_8
XFILLER_10_526 VPWR VGND sg13g2_decap_8
Xrebuffer167 _0948_/B _0653_/B VPWR VGND sg13g2_buf_1
Xrebuffer123 rebuffer123/X _0712_/A VPWR VGND sg13g2_buf_1
Xrebuffer112 _0802_/B _0978_/Q VPWR VGND sg13g2_buf_1
Xrebuffer101 _0704_/B _1019_/Q VPWR VGND sg13g2_buf_1
XFILLER_6_508 VPWR VGND sg13g2_fill_1
XFILLER_17_114 VPWR VGND sg13g2_decap_8
XFILLER_13_320 VPWR VGND sg13g2_decap_8
XFILLER_9_346 VPWR VGND sg13g2_decap_8
XFILLER_27_445 VPWR VGND sg13g2_decap_8
XFILLER_10_312 VPWR VGND sg13g2_decap_8
XFILLER_22_150 VPWR VGND sg13g2_decap_8
XFILLER_10_389 VPWR VGND sg13g2_fill_1
XFILLER_6_327 VPWR VGND sg13g2_decap_8
XFILLER_13_150 VPWR VGND sg13g2_decap_8
X_0930_ _0930_/X _0934_/A _0934_/B VPWR VGND sg13g2_and2_1
X_0861_ _0991_/D _0861_/A _0861_/B VPWR VGND sg13g2_nand2_1
X_0792_ _0792_/Y _0807_/B _0792_/B _0800_/C VPWR VGND sg13g2_nor3_2
XFILLER_27_242 VPWR VGND sg13g2_decap_8
XFILLER_10_164 VPWR VGND sg13g2_decap_8
XFILLER_12_93 VPWR VGND sg13g2_decap_8
Xlane2.t_lpx.tempo_79 lane2.t_lpx.tempo/ARM VPWR VGND sg13g2_tielo
XFILLER_6_179 VPWR VGND sg13g2_decap_8
XFILLER_18_242 VPWR VGND sg13g2_decap_8
X_0913_ _0913_/X _0914_/A _0914_/B VPWR VGND sg13g2_and2_1
X_0844_ _1078_/A _0928_/A _0844_/B VPWR VGND sg13g2_xor2_1
X_0775_ _0776_/B _0777_/A _0781_/A _0773_/A VPWR VGND sg13g2_a21o_1
XFILLER_24_256 VPWR VGND sg13g2_decap_8
XFILLER_28_540 VPWR VGND sg13g2_decap_8
XFILLER_30_204 VPWR VGND sg13g2_fill_2
XFILLER_19_562 VPWR VGND sg13g2_fill_1
X_1043_ _1043_/Q _1051_/CLK _1043_/D rebuffer116/X VPWR VGND sg13g2_dfrbpq_1
XFILLER_9_72 VPWR VGND sg13g2_decap_8
X_0827_ _0828_/B _0964_/Q _0830_/B _0965_/Q VPWR VGND sg13g2_a21oi_1
X_0758_ _0758_/Y _0758_/A VPWR VGND sg13g2_inv_2
X_0689_ _0689_/Y _0689_/A _0689_/B VPWR VGND sg13g2_nand2_1
XFILLER_29_348 VPWR VGND sg13g2_decap_8
XFILLER_4_469 VPWR VGND sg13g2_decap_8
XFILLER_11_270 VPWR VGND sg13g2_decap_8
XFILLER_11_292 VPWR VGND sg13g2_fill_1
Xhold219 _0693_/B _1023_/Q VPWR VGND sg13g2_dlygate4sd3_1
X_0612_ _0630_/C _0623_/B _0619_/B VPWR VGND sg13g2_nor2_1
XFILLER_7_263 VPWR VGND sg13g2_decap_8
XFILLER_3_491 VPWR VGND sg13g2_decap_8
X_1026_ _1026_/Q _1036_/CLK _1026_/D _0943_/X VPWR VGND sg13g2_dfrbpq_1
XFILLER_22_557 VPWR VGND sg13g2_decap_8
XFILLER_29_178 VPWR VGND sg13g2_decap_8
XFILLER_13_502 VPWR VGND sg13g2_decap_8
XFILLER_9_539 VPWR VGND sg13g2_decap_8
XFILLER_4_277 VPWR VGND sg13g2_fill_1
XFILLER_10_505 VPWR VGND sg13g2_decap_8
X_1009_ _1009_/Q _1021_/CLK _1009_/D _0933_/X VPWR VGND sg13g2_dfrbpq_1
Xrebuffer89 _1084_/A _0792_/Y VPWR VGND sg13g2_buf_1
Xrebuffer168 rebuffer168/X _0654_/Y VPWR VGND sg13g2_buf_1
Xrebuffer124 _0935_/B _0702_/Y VPWR VGND sg13g2_buf_1
Xrebuffer113 fanout54/A _1000_/Q VPWR VGND sg13g2_buf_1
Xrebuffer102 _0666_/B _1041_/Q VPWR VGND sg13g2_buf_1
XFILLER_17_126 VPWR VGND sg13g2_decap_4
XFILLER_15_93 VPWR VGND sg13g2_decap_8
XFILLER_9_325 VPWR VGND sg13g2_decap_8
XFILLER_25_192 VPWR VGND sg13g2_decap_8
XFILLER_16_192 VPWR VGND sg13g2_decap_8
XFILLER_23_107 VPWR VGND sg13g2_decap_8
XFILLER_6_306 VPWR VGND sg13g2_decap_8
XFILLER_9_100 VPWR VGND sg13g2_decap_8
X_0860_ _0861_/B _0862_/A hold201/X _0922_/A VPWR VGND sg13g2_a21oi_1
X_0791_ _0791_/X _0907_/A _0794_/B VPWR VGND sg13g2_and2_1
X_0989_ _0989_/Q _1011_/CLK _0989_/D _0920_/X VPWR VGND sg13g2_dfrbpq_1
XFILLER_12_72 VPWR VGND sg13g2_decap_8
XFILLER_6_158 VPWR VGND sg13g2_decap_8
XFILLER_6_114 VPWR VGND sg13g2_decap_8
X_0912_ _0912_/X _0914_/A _0914_/B VPWR VGND sg13g2_and2_1
X_0843_ _1090_/A _0843_/A _0843_/B _0843_/C VPWR VGND sg13g2_nand3_1
X_0774_ _0989_/D _0774_/A _0776_/A VPWR VGND sg13g2_xnor2_1
XFILLER_24_235 VPWR VGND sg13g2_decap_8
XFILLER_15_268 VPWR VGND sg13g2_decap_8
XFILLER_30_249 VPWR VGND sg13g2_decap_8
XFILLER_7_456 VPWR VGND sg13g2_fill_1
XFILLER_7_412 VPWR VGND sg13g2_decap_8
XFILLER_23_93 VPWR VGND sg13g2_decap_8
XFILLER_0_53 VPWR VGND sg13g2_decap_4
X_1042_ _1042_/Q _1050_/CLK _1042_/D _0953_/Y VPWR VGND sg13g2_dfrbpq_2
XFILLER_21_249 VPWR VGND sg13g2_decap_8
X_0826_ _0830_/B _0825_/Y _0969_/Q VPWR VGND sg13g2_nand2b_1
X_0757_ _0758_/A _0914_/A _0757_/B VPWR VGND sg13g2_and2_1
X_0688_ _0688_/X _1027_/Q _0689_/B VPWR VGND sg13g2_xor2_1
Xclkbuf_4_15_0_clk _0991_/CLK clkbuf_0_clk/X VPWR VGND sg13g2_buf_8
XFILLER_29_327 VPWR VGND sg13g2_decap_8
XFILLER_12_249 VPWR VGND sg13g2_decap_8
Xlane0.t_prep.tempo_72 lane0.t_prep.tempo/ARM VPWR VGND sg13g2_tielo
XFILLER_25_555 VPWR VGND sg13g2_fill_1
XFILLER_4_426 VPWR VGND sg13g2_decap_8
XFILLER_18_93 VPWR VGND sg13g2_decap_8
Xhold209 _0736_/A _0588_/Y VPWR VGND sg13g2_dlygate4sd3_1
X_0611_ _0955_/B _0623_/B _0619_/B VPWR VGND sg13g2_nand2_2
XFILLER_7_242 VPWR VGND sg13g2_decap_8
XFILLER_3_470 VPWR VGND sg13g2_decap_8
X_1025_ _1025_/Q _1025_/CLK _1025_/D _0942_/Y VPWR VGND sg13g2_dfrbpq_1
XFILLER_22_536 VPWR VGND sg13g2_decap_8
X_0809_ _0811_/D _0795_/Y _0598_/Y _1100_/A input6/X _0808_/Y VPWR VGND sg13g2_a221oi_1
XFILLER_30_39 VPWR VGND sg13g2_decap_8
XFILLER_29_157 VPWR VGND sg13g2_decap_8
XFILLER_25_341 VPWR VGND sg13g2_decap_8
XFILLER_9_518 VPWR VGND sg13g2_decap_8
XFILLER_4_256 VPWR VGND sg13g2_decap_8
XFILLER_16_341 VPWR VGND sg13g2_decap_8
X_1008_ _1008_/Q _1011_/CLK _1008_/D _0932_/X VPWR VGND sg13g2_dfrbpq_1
Xrebuffer103 _0655_/B _1041_/Q VPWR VGND sg13g2_buf_2
Xrebuffer169 _1085_/A _0651_/X VPWR VGND sg13g2_buf_1
Xrebuffer136 _1088_/A _0791_/X VPWR VGND sg13g2_buf_1
Xrebuffer125 _0928_/A hold314/X VPWR VGND sg13g2_buf_1
Xrebuffer114 _0920_/A _0589_/A VPWR VGND sg13g2_buf_4
XFILLER_17_138 VPWR VGND sg13g2_fill_1
XFILLER_25_171 VPWR VGND sg13g2_decap_8
XFILLER_15_72 VPWR VGND sg13g2_decap_8
XFILLER_9_304 VPWR VGND sg13g2_decap_8
XFILLER_16_171 VPWR VGND sg13g2_decap_8
XFILLER_10_347 VPWR VGND sg13g2_decap_8
XFILLER_22_185 VPWR VGND sg13g2_decap_8
XFILLER_13_185 VPWR VGND sg13g2_decap_8
X_0790_ _0908_/B _0790_/A _0978_/Q VPWR VGND sg13g2_nor2b_2
XFILLER_9_178 VPWR VGND sg13g2_decap_8
XFILLER_5_384 VPWR VGND sg13g2_decap_8
XFILLER_3_86 VPWR VGND sg13g2_decap_8
X_0988_ _0988_/Q _0991_/CLK _0988_/D _0919_/X VPWR VGND sg13g2_dfrbpq_1
XFILLER_10_100 VPWR VGND sg13g2_decap_8
XFILLER_27_277 VPWR VGND sg13g2_fill_2
XFILLER_10_133 VPWR VGND sg13g2_fill_2
X_0911_ _0911_/Y _0939_/A VPWR VGND sg13g2_inv_1
X_0842_ _1094_/A _0843_/B _0843_/C VPWR VGND sg13g2_nand2_1
X_0773_ _0776_/A _0773_/A _0777_/A _0781_/A VPWR VGND sg13g2_nand3_1
XFILLER_5_192 VPWR VGND sg13g2_decap_8
XFILLER_3_107 VPWR VGND sg13g2_decap_8
XFILLER_15_247 VPWR VGND sg13g2_decap_8
XFILLER_30_228 VPWR VGND sg13g2_decap_8
XFILLER_30_206 VPWR VGND sg13g2_fill_1
XFILLER_23_72 VPWR VGND sg13g2_decap_8
XFILLER_11_497 VPWR VGND sg13g2_decap_8
XFILLER_0_32 VPWR VGND sg13g2_decap_8
XFILLER_21_228 VPWR VGND sg13g2_decap_8
X_1041_ _1041_/Q _1054_/CLK _1041_/D _0952_/Y VPWR VGND sg13g2_dfrbpq_2
X_0825_ _0825_/Y _0968_/Q _0967_/Q _0966_/Q _0825_/D VPWR VGND sg13g2_nor4_1
X_0756_ _0756_/Y _0845_/B VPWR VGND sg13g2_inv_1
X_0687_ _1028_/D _0687_/A _0687_/B VPWR VGND sg13g2_nor2_1
XFILLER_6_490 VPWR VGND sg13g2_decap_8
XFILLER_29_306 VPWR VGND sg13g2_decap_8
XFILLER_25_534 VPWR VGND sg13g2_decap_8
XFILLER_25_501 VPWR VGND sg13g2_decap_8
XFILLER_12_206 VPWR VGND sg13g2_fill_1
XFILLER_12_228 VPWR VGND sg13g2_decap_8
XFILLER_4_405 VPWR VGND sg13g2_decap_8
XFILLER_18_72 VPWR VGND sg13g2_decap_8
X_0610_ _0610_/Y _0939_/A VPWR VGND sg13g2_inv_1
X_1024_ _1024_/Q _1024_/CLK _1024_/D _0941_/Y VPWR VGND sg13g2_dfrbpq_1
XFILLER_22_515 VPWR VGND sg13g2_decap_8
X_0808_ _0808_/Y _0805_/Y _0808_/A2 _0807_/X VPWR VGND sg13g2_o21ai_1
X_0739_ _1003_/D _0739_/A _0739_/B VPWR VGND sg13g2_xnor2_1
XFILLER_29_114 VPWR VGND sg13g2_decap_8
XFILLER_25_320 VPWR VGND sg13g2_decap_8
XFILLER_13_537 VPWR VGND sg13g2_decap_8
XFILLER_4_235 VPWR VGND sg13g2_decap_8
XFILLER_29_93 VPWR VGND sg13g2_decap_8
XFILLER_16_320 VPWR VGND sg13g2_decap_8
Xclkbuf_4_14_0_clk _1014_/CLK clkbuf_0_clk/X VPWR VGND sg13g2_buf_8
XFILLER_6_86 VPWR VGND sg13g2_decap_8
XFILLER_3_290 VPWR VGND sg13g2_fill_2
X_1007_ _1007_/Q _1011_/CLK _1007_/D _0931_/X VPWR VGND sg13g2_dfrbpq_1
Xrebuffer137 _0813_/B _0793_/Y VPWR VGND sg13g2_buf_2
Xrebuffer126 _0935_/A hold314/X VPWR VGND sg13g2_buf_1
Xrebuffer115 _0907_/A _0592_/A VPWR VGND sg13g2_buf_2
Xrebuffer104 _0642_/B1 _0640_/B VPWR VGND sg13g2_buf_1
XFILLER_22_334 VPWR VGND sg13g2_decap_8
XFILLER_13_334 VPWR VGND sg13g2_decap_8
XFILLER_25_150 VPWR VGND sg13g2_decap_8
XFILLER_16_150 VPWR VGND sg13g2_decap_8
XFILLER_27_459 VPWR VGND sg13g2_decap_8
XFILLER_10_326 VPWR VGND sg13g2_decap_8
XFILLER_22_164 VPWR VGND sg13g2_decap_8
XFILLER_13_164 VPWR VGND sg13g2_decap_8
Xlane1.t_zero.tempo VPWR VGND _0712_/Y lane1.t_zero.tempo/ARM _1001_/Q fanout62/X
+ _0714_/A2 tempo_t150n
XFILLER_9_157 VPWR VGND sg13g2_decap_8
XFILLER_5_341 VPWR VGND sg13g2_decap_8
X_0987_ _0987_/Q _0991_/CLK _0987_/D _0918_/X VPWR VGND sg13g2_dfrbpq_1
XFILLER_27_256 VPWR VGND sg13g2_decap_8
XFILLER_10_178 VPWR VGND sg13g2_decap_8
XFILLER_18_256 VPWR VGND sg13g2_decap_8
X_0910_ _0910_/Y _0939_/A VPWR VGND sg13g2_inv_1
X_0841_ _1077_/A _0948_/A _0841_/B VPWR VGND sg13g2_xor2_1
X_0772_ _0781_/A _0772_/A _0778_/D VPWR VGND sg13g2_nor2b_1
XFILLER_5_171 VPWR VGND sg13g2_decap_8
XFILLER_15_226 VPWR VGND sg13g2_decap_8
XFILLER_28_565 VPWR VGND sg13g2_fill_2
XFILLER_28_554 VPWR VGND sg13g2_decap_8
XFILLER_23_270 VPWR VGND sg13g2_decap_8
XFILLER_7_469 VPWR VGND sg13g2_decap_8
XFILLER_0_11 VPWR VGND sg13g2_decap_8
X_1040_ _1040_/Q _1050_/CLK _1040_/D _0951_/Y VPWR VGND sg13g2_dfrbpq_2
X_0824_ _0966_/D _0824_/A _0828_/A VPWR VGND sg13g2_xor2_1
X_0755_ _0845_/B _0920_/A _0760_/B _0760_/C VPWR VGND sg13g2_nand3_1
XFILLER_9_86 VPWR VGND sg13g2_decap_8
X_0686_ _0686_/Y _1027_/Q _0689_/B _1028_/Q VPWR VGND sg13g2_a21oi_1
X_1023_ _1023_/Q _1025_/CLK _1023_/D _0940_/Y VPWR VGND sg13g2_dfrbpq_1
X_0807_ _0807_/X _0907_/A _0807_/B _0807_/C input6/X VPWR VGND sg13g2_or4_1
X_0738_ _0739_/B _0741_/A _0740_/B VPWR VGND sg13g2_nand2b_1
X_0669_ _0674_/B _0669_/A _0672_/C _0669_/C VPWR VGND sg13g2_nand3_1
XFILLER_13_516 VPWR VGND sg13g2_decap_8
XFILLER_21_560 VPWR VGND sg13g2_decap_8
XFILLER_29_72 VPWR VGND sg13g2_decap_8
XFILLER_28_192 VPWR VGND sg13g2_decap_8
XFILLER_12_560 VPWR VGND sg13g2_decap_8
XFILLER_19_192 VPWR VGND sg13g2_decap_8
X_1006_ _1006_/Q _1014_/CLK _1006_/D _0930_/X VPWR VGND sg13g2_dfrbpq_1
XFILLER_22_313 VPWR VGND sg13g2_decap_8
XFILLER_10_519 VPWR VGND sg13g2_decap_8
Xrebuffer138 _0807_/C _0790_/A VPWR VGND sg13g2_buf_1
Xrebuffer127 _0899_/A _0804_/B VPWR VGND sg13g2_buf_1
Xrebuffer116 rebuffer116/X _0627_/A VPWR VGND sg13g2_buf_1
Xrebuffer105 _0704_/A _1020_/Q VPWR VGND sg13g2_buf_1
XFILLER_17_107 VPWR VGND sg13g2_decap_8
XFILLER_13_313 VPWR VGND sg13g2_decap_8
XFILLER_9_339 VPWR VGND sg13g2_decap_8
XFILLER_5_556 VPWR VGND sg13g2_decap_8
XFILLER_10_305 VPWR VGND sg13g2_decap_8
Xclkbuf_4_13_0_clk _0972_/CLK clkbuf_0_clk/X VPWR VGND sg13g2_buf_8
XFILLER_9_114 VPWR VGND sg13g2_decap_8
XFILLER_5_320 VPWR VGND sg13g2_decap_8
X_0986_ _0986_/Q _0991_/CLK _0986_/D _0917_/X VPWR VGND sg13g2_dfrbpq_1
XFILLER_27_235 VPWR VGND sg13g2_decap_8
XFILLER_10_157 VPWR VGND sg13g2_decap_8
XFILLER_23_474 VPWR VGND sg13g2_fill_1
XFILLER_23_463 VPWR VGND sg13g2_fill_1
XFILLER_12_86 VPWR VGND sg13g2_decap_8
Xhold180 _0936_/A _1015_/Q VPWR VGND sg13g2_dlygate4sd3_1
Xhold191 _0687_/B _0686_/Y VPWR VGND sg13g2_dlygate4sd3_1
Xlane3.t_exit.tempo_82 lane3.t_exit.tempo/ARM VPWR VGND sg13g2_tielo
XFILLER_18_235 VPWR VGND sg13g2_decap_8
X_0840_ _1089_/A _0840_/A _0840_/B _0840_/C VPWR VGND sg13g2_nand3_1
X_0771_ _0771_/Y _0772_/A _0771_/B VPWR VGND sg13g2_nand2b_1
XFILLER_5_150 VPWR VGND sg13g2_decap_8
XFILLER_24_249 VPWR VGND sg13g2_decap_8
X_0969_ _0969_/Q _0999_/CLK _0969_/D _0908_/X VPWR VGND sg13g2_dfrbpq_1
Xlane2.t_exit.tempo_78 lane2.t_exit.tempo/ARM VPWR VGND sg13g2_tielo
XFILLER_28_533 VPWR VGND sg13g2_decap_8
XFILLER_7_426 VPWR VGND sg13g2_decap_4
X_0823_ _0967_/D _0823_/A _0823_/B VPWR VGND sg13g2_and2_1
X_0754_ _1099_/A _0914_/A _0754_/B VPWR VGND sg13g2_nor2_1
X_0685_ _0689_/B _0684_/Y _1032_/Q VPWR VGND sg13g2_nand2b_1
X_1099_ _1099_/X _1099_/A VPWR VGND sg13g2_buf_1
XFILLER_28_363 VPWR VGND sg13g2_fill_2
XFILLER_28_341 VPWR VGND sg13g2_decap_8
XFILLER_28_396 VPWR VGND sg13g2_fill_1
XFILLER_11_263 VPWR VGND sg13g2_decap_8
XFILLER_7_256 VPWR VGND sg13g2_decap_8
XFILLER_3_484 VPWR VGND sg13g2_decap_8
XFILLER_19_341 VPWR VGND sg13g2_decap_8
X_1022_ _1022_/Q _1052_/CLK _1022_/D hold320/X VPWR VGND sg13g2_dfrbpq_1
X_0806_ _0813_/C _0599_/Y _0803_/Y _0799_/Y VPWR VGND sg13g2_a21oi_1
X_0737_ _1004_/D _0739_/A _0740_/B _0741_/A VPWR VGND sg13g2_a21o_1
X_0668_ _0672_/A _0654_/Y _0608_/Y _1097_/A input3/X _0667_/Y VPWR VGND sg13g2_a221oi_1
X_0599_ _0599_/Y _0599_/A VPWR VGND sg13g2_inv_1
Xlane3.t_exit.tempo VPWR VGND _0848_/B lane3.t_exit.tempo/ARM _0803_/Y fanout63/X
+ _0599_/A tempo_t150n
XFILLER_21_550 VPWR VGND sg13g2_decap_4
XFILLER_28_171 VPWR VGND sg13g2_decap_8
XFILLER_3_270 VPWR VGND sg13g2_decap_8
XFILLER_3_292 VPWR VGND sg13g2_fill_1
XFILLER_19_171 VPWR VGND sg13g2_decap_8
X_1005_ _1005_/Q _1036_/CLK _1005_/D _0929_/X VPWR VGND sg13g2_dfrbpq_1
Xrebuffer139 _0800_/C _0790_/A VPWR VGND sg13g2_buf_1
Xrebuffer128 _0792_/B _0804_/B VPWR VGND sg13g2_buf_1
Xrebuffer117 _1081_/A _0649_/X VPWR VGND sg13g2_buf_1
Xrebuffer106 _0949_/B _0650_/Y VPWR VGND sg13g2_buf_1
XFILLER_15_86 VPWR VGND sg13g2_decap_8
XFILLER_9_318 VPWR VGND sg13g2_decap_8
XFILLER_25_185 VPWR VGND sg13g2_decap_8
Xoutput30 lp_p[2] _1095_/X VPWR VGND sg13g2_buf_1
XFILLER_16_185 VPWR VGND sg13g2_decap_8
.ends
