* NGSPICE file created from dphy_tx.ext - technology: ihp-sg13g2

* Black-box entry subcircuit for sg13g2_decap_8 abstract view
.subckt sg13g2_decap_8 VDD VSS
.ends

* Black-box entry subcircuit for sg13g2_fill_2 abstract view
.subckt sg13g2_fill_2 VDD VSS
.ends

* Black-box entry subcircuit for sg13g2_dlygate4sd3_1 abstract view
.subckt sg13g2_dlygate4sd3_1 X A VDD VSS
.ends

* Black-box entry subcircuit for sg13g2_nand2b_1 abstract view
.subckt sg13g2_nand2b_1 Y A_N B VDD VSS
.ends

* Black-box entry subcircuit for sg13g2_fill_1 abstract view
.subckt sg13g2_fill_1 VDD VSS
.ends

* Black-box entry subcircuit for sg13g2_dfrbpq_1 abstract view
.subckt sg13g2_dfrbpq_1 Q CLK D RESET_B VDD VSS
.ends

* Black-box entry subcircuit for sg13g2_buf_8 abstract view
.subckt sg13g2_buf_8 X A VDD VSS
.ends

* Black-box entry subcircuit for sg13g2_or2_1 abstract view
.subckt sg13g2_or2_1 X A B VDD VSS
.ends

* Black-box entry subcircuit for sg13g2_a221oi_1 abstract view
.subckt sg13g2_a221oi_1 Y A1 A2 B1 B2 C1 VDD VSS
.ends

* Black-box entry subcircuit for sg13g2_nand2_1 abstract view
.subckt sg13g2_nand2_1 Y A B VDD VSS
.ends

* Black-box entry subcircuit for sg13g2_decap_4 abstract view
.subckt sg13g2_decap_4 VDD VSS
.ends

* Black-box entry subcircuit for sg13g2_buf_1 abstract view
.subckt sg13g2_buf_1 X A VDD VSS
.ends

* Black-box entry subcircuit for sg13g2_nor3_2 abstract view
.subckt sg13g2_nor3_2 Y A B C VDD VSS
.ends

* Black-box entry subcircuit for sg13g2_nor3_1 abstract view
.subckt sg13g2_nor3_1 Y A B C VDD VSS
.ends

* Black-box entry subcircuit for sg13g2_inv_1 abstract view
.subckt sg13g2_inv_1 Y A VDD VSS
.ends

* Black-box entry subcircuit for tempo_t80n abstract view
.subckt tempo_t80n VDD VSS RESET ARM INGRESS PG PROGRESS
.ends

* Black-box entry subcircuit for sg13g2_nand4_1 abstract view
.subckt sg13g2_nand4_1 Y A B C D VDD VSS
.ends

* Black-box entry subcircuit for sg13g2_a21o_1 abstract view
.subckt sg13g2_a21o_1 X A1 A2 B1 VDD VSS
.ends

* Black-box entry subcircuit for sg13g2_o21ai_1 abstract view
.subckt sg13g2_o21ai_1 Y A1 A2 B1 VDD VSS
.ends

* Black-box entry subcircuit for sg13g2_xnor2_1 abstract view
.subckt sg13g2_xnor2_1 Y A B VDD VSS
.ends

* Black-box entry subcircuit for sg13g2_a21oi_1 abstract view
.subckt sg13g2_a21oi_1 Y A1 A2 B1 VDD VSS
.ends

* Black-box entry subcircuit for sg13g2_nand3b_1 abstract view
.subckt sg13g2_nand3b_1 Y A_N B C VDD VSS
.ends

* Black-box entry subcircuit for sg13g2_xor2_1 abstract view
.subckt sg13g2_xor2_1 X A B VDD VSS
.ends

* Black-box entry subcircuit for tempo_t60n abstract view
.subckt tempo_t60n VDD VSS RESET ARM INGRESS PG PROGRESS
.ends

* Black-box entry subcircuit for sg13g2_dfrbpq_2 abstract view
.subckt sg13g2_dfrbpq_2 Q CLK D RESET_B VDD VSS
.ends

* Black-box entry subcircuit for sg13g2_or4_1 abstract view
.subckt sg13g2_or4_1 X A B C D VDD VSS
.ends

* Black-box entry subcircuit for sg13g2_a21oi_2 abstract view
.subckt sg13g2_a21oi_2 Y A1 A2 B1 VDD VSS
.ends

* Black-box entry subcircuit for sg13g2_and2_2 abstract view
.subckt sg13g2_and2_2 X A B VDD VSS
.ends

* Black-box entry subcircuit for sg13g2_and3_1 abstract view
.subckt sg13g2_and3_1 X A B C VDD VSS
.ends

* Black-box entry subcircuit for sg13g2_and4_1 abstract view
.subckt sg13g2_and4_1 X A B C D VDD VSS
.ends

* Black-box entry subcircuit for sg13g2_nor2_1 abstract view
.subckt sg13g2_nor2_1 Y A B VDD VSS
.ends

* Black-box entry subcircuit for sg13g2_and2_1 abstract view
.subckt sg13g2_and2_1 X A B VDD VSS
.ends

* Black-box entry subcircuit for sg13g2_nor2b_2 abstract view
.subckt sg13g2_nor2b_2 Y A B_N VDD VSS
.ends

* Black-box entry subcircuit for sg13g2_nand3_1 abstract view
.subckt sg13g2_nand3_1 Y A B C VDD VSS
.ends

* Black-box entry subcircuit for sg13g2_tielo abstract view
.subckt sg13g2_tielo L_LO VDD VSS
.ends

* Black-box entry subcircuit for sg13g2_inv_4 abstract view
.subckt sg13g2_inv_4 Y A VDD VSS
.ends

* Black-box entry subcircuit for sg13g2_nand2_2 abstract view
.subckt sg13g2_nand2_2 Y A B VDD VSS
.ends

* Black-box entry subcircuit for tempo_t150n abstract view
.subckt tempo_t150n VDD VSS RESET ARM INGRESS PG PROGRESS
.ends

* Black-box entry subcircuit for sg13g2_nand2b_2 abstract view
.subckt sg13g2_nand2b_2 Y A_N B VDD VSS
.ends

* Black-box entry subcircuit for sg13g2_nor2b_1 abstract view
.subckt sg13g2_nor2b_1 Y A B_N VDD VSS
.ends

* Black-box entry subcircuit for sg13g2_a22oi_1 abstract view
.subckt sg13g2_a22oi_1 Y A1 A2 B1 B2 VDD VSS
.ends

* Black-box entry subcircuit for sg13g2_nor2_2 abstract view
.subckt sg13g2_nor2_2 Y A B VDD VSS
.ends

* Black-box entry subcircuit for sg13g2_buf_16 abstract view
.subckt sg13g2_buf_16 X A VDD VSS
.ends

* Black-box entry subcircuit for sg13g2_buf_2 abstract view
.subckt sg13g2_buf_2 X A VDD VSS
.ends

* Black-box entry subcircuit for sg13g2_nor4_2 abstract view
.subckt sg13g2_nor4_2 Y A B C D VDD VSS
.ends

* Black-box entry subcircuit for sg13g2_buf_4 abstract view
.subckt sg13g2_buf_4 X A VDD VSS
.ends

* Black-box entry subcircuit for tempo_t350n abstract view
.subckt tempo_t350n VDD VSS RESET ARM INGRESS PG PROGRESS
.ends

* Black-box entry subcircuit for sg13g2_inv_2 abstract view
.subckt sg13g2_inv_2 Y A VDD VSS
.ends

* Black-box entry subcircuit for sg13g2_or3_1 abstract view
.subckt sg13g2_or3_1 X A B C VDD VSS
.ends

* Black-box entry subcircuit for sg13g2_antennanp abstract view
.subckt sg13g2_antennanp A VDD VSS
.ends

.subckt dphy_tx PG VGND VPWR clk clk_hs_oe clk_lp_n clk_lp_p clk_ready clk_request
+ clk_run hs_oe[0] hs_oe[1] hs_oe[2] hs_oe[3] hs_sync[0] hs_sync[1] hs_sync[2] hs_sync[3]
+ hs_trail[0] hs_trail[1] hs_trail[2] hs_trail[3] lp_n[0] lp_n[1] lp_n[2] lp_n[3]
+ lp_p[0] lp_p[1] lp_p[2] lp_p[3] rst tx_ready_hs[0] tx_ready_hs[1] tx_ready_hs[2]
+ tx_ready_hs[3] tx_request_hs[0] tx_request_hs[1] tx_request_hs[2] tx_request_hs[3]
XFILLER_27_439 VPWR VGND sg13g2_decap_8
XFILLER_10_306 VPWR VGND sg13g2_decap_8
XFILLER_22_100 VPWR VGND sg13g2_decap_8
XFILLER_13_100 VPWR VGND sg13g2_decap_8
XFILLER_9_126 VPWR VGND sg13g2_fill_2
XFILLER_1_560 VPWR VGND sg13g2_fill_2
XFILLER_5_398 VPWR VGND sg13g2_decap_8
XFILLER_10_114 VPWR VGND sg13g2_decap_8
XFILLER_23_442 VPWR VGND sg13g2_fill_2
Xhold170 _0644_/A _0956_/Q VPWR VGND sg13g2_dlygate4sd3_1
Xhold181 _0830_/B _0961_/Q VPWR VGND sg13g2_dlygate4sd3_1
Xhold192 _0655_/A _0951_/Q VPWR VGND sg13g2_dlygate4sd3_1
X_0770_ _0770_/Y _0579_/Y _0770_/B VPWR VGND sg13g2_nand2b_1
XFILLER_24_228 VPWR VGND sg13g2_decap_8
XFILLER_24_217 VPWR VGND sg13g2_fill_1
X_0968_ _0968_/Q _0970_/CLK _0968_/D _0886_/Y VPWR VGND sg13g2_dfrbpq_1
Xclkbuf_4_12_0_clk _0937_/CLK clkbuf_0_clk/X VPWR VGND sg13g2_buf_8
X_0899_ _0899_/Q clkload3/A _0899_/D _0852_/X VPWR VGND sg13g2_dfrbpq_1
XFILLER_28_534 VPWR VGND sg13g2_decap_8
XFILLER_11_412 VPWR VGND sg13g2_decap_8
XFILLER_15_228 VPWR VGND sg13g2_decap_8
XFILLER_11_467 VPWR VGND sg13g2_fill_1
XFILLER_7_405 VPWR VGND sg13g2_decap_8
XFILLER_23_86 VPWR VGND sg13g2_decap_8
XFILLER_0_46 VPWR VGND sg13g2_decap_8
X_0822_ _0822_/X _0944_/Q _0822_/B VPWR VGND sg13g2_or2_1
X_0753_ _0755_/A _0739_/Y _0561_/Y _1028_/A input6/X _0752_/Y VPWR VGND sg13g2_a221oi_1
X_0684_ _0687_/B _0685_/B _0692_/A VPWR VGND sg13g2_nand2_1
XFILLER_29_0 VPWR VGND sg13g2_decap_8
XFILLER_25_548 VPWR VGND sg13g2_decap_8
XFILLER_4_419 VPWR VGND sg13g2_decap_4
XFILLER_18_86 VPWR VGND sg13g2_decap_8
XFILLER_28_320 VPWR VGND sg13g2_decap_8
XFILLER_11_242 VPWR VGND sg13g2_decap_8
XFILLER_7_235 VPWR VGND sg13g2_decap_8
XFILLER_19_320 VPWR VGND sg13g2_decap_8
X_1021_ _1021_/X _1021_/A VPWR VGND sg13g2_buf_1
X_0805_ _0919_/D _0805_/A _0805_/B VPWR VGND sg13g2_nand2_1
X_0736_ _0736_/Y _0751_/B _0784_/A _0751_/C VPWR VGND sg13g2_nor3_2
X_0667_ _0667_/Y _0675_/A _0667_/B _0669_/B VPWR VGND sg13g2_nor3_1
X_0598_ _0598_/Y _0599_/B VPWR VGND sg13g2_inv_1
XFILLER_25_334 VPWR VGND sg13g2_decap_8
XFILLER_21_551 VPWR VGND sg13g2_decap_4
Xlane3.t_lpx.tempo VPWR VGND _0783_/B lane3.t_lpx.tempo/ARM _0742_/Y fanout59/X _0743_/B
+ tempo_t80n
XFILLER_29_63 VPWR VGND sg13g2_decap_8
XFILLER_16_334 VPWR VGND sg13g2_decap_8
XFILLER_28_150 VPWR VGND sg13g2_decap_8
XFILLER_19_150 VPWR VGND sg13g2_decap_8
XFILLER_22_348 VPWR VGND sg13g2_decap_8
Xrebuffer129 rebuffer129/X _0739_/Y VPWR VGND sg13g2_buf_1
Xrebuffer118 _0708_/B _0927_/Q VPWR VGND sg13g2_buf_1
Xrebuffer107 _0881_/A fanout42/X VPWR VGND sg13g2_buf_1
X_0719_ _0719_/Y _0719_/A _0721_/B _0719_/C _0719_/D VPWR VGND sg13g2_nand4_1
XFILLER_25_164 VPWR VGND sg13g2_decap_8
XFILLER_13_348 VPWR VGND sg13g2_decap_8
Xoutput7 clk_hs_oe _0772_/Y VPWR VGND sg13g2_buf_1
Xoutput31 lp_p[3] _1024_/X VPWR VGND sg13g2_buf_1
Xoutput20 hs_trail[0] _1013_/X VPWR VGND sg13g2_buf_1
XFILLER_5_558 VPWR VGND sg13g2_decap_4
XFILLER_16_120 VPWR VGND sg13g2_fill_1
XFILLER_16_164 VPWR VGND sg13g2_decap_8
XFILLER_27_418 VPWR VGND sg13g2_decap_8
XFILLER_22_178 VPWR VGND sg13g2_decap_8
XFILLER_13_178 VPWR VGND sg13g2_decap_8
Xhold171 _0956_/D _0643_/Y VPWR VGND sg13g2_dlygate4sd3_1
Xhold182 _0793_/A _0901_/Q VPWR VGND sg13g2_dlygate4sd3_1
XFILLER_5_185 VPWR VGND sg13g2_decap_8
XFILLER_17_270 VPWR VGND sg13g2_decap_8
X_0967_ _0967_/Q _0970_/CLK _0967_/D hold269/X VPWR VGND sg13g2_dfrbpq_1
X_0898_ _0898_/Q clkload3/A _0898_/D _0851_/X VPWR VGND sg13g2_dfrbpq_1
XFILLER_28_513 VPWR VGND sg13g2_decap_8
XFILLER_0_25 VPWR VGND sg13g2_decap_8
X_0821_ _0940_/D _0819_/A _0818_/B hold175/X VPWR VGND sg13g2_a21o_1
X_0752_ _0752_/Y _0752_/A1 _0749_/A _0751_/X VPWR VGND sg13g2_o21ai_1
X_0683_ _0945_/D _0683_/A _0683_/B VPWR VGND sg13g2_xnor2_1
XFILLER_6_483 VPWR VGND sg13g2_decap_8
Xlane2.t_lpx.tempo VPWR VGND _0780_/B lane2.t_lpx.tempo/ARM _0704_/Y fanout59/X _0705_/B
+ tempo_t80n
XFILLER_18_43 VPWR VGND sg13g2_decap_8
XFILLER_28_387 VPWR VGND sg13g2_decap_8
XFILLER_3_497 VPWR VGND sg13g2_decap_8
X_1020_ _1020_/X _1020_/A VPWR VGND sg13g2_buf_1
Xclkbuf_4_11_0_clk clkload5/A clkbuf_0_clk/X VPWR VGND sg13g2_buf_8
XFILLER_19_398 VPWR VGND sg13g2_decap_8
X_0804_ _0805_/B _0806_/A hold154/X _0861_/A VPWR VGND sg13g2_a21oi_1
X_0735_ _0735_/Y _1016_/A VPWR VGND sg13g2_inv_1
X_0666_ _0666_/Y _0777_/B VPWR VGND sg13g2_inv_1
X_0597_ _0599_/B _0600_/B _0785_/A _0772_/A VPWR VGND sg13g2_nand3b_1
XFILLER_25_313 VPWR VGND sg13g2_decap_8
XFILLER_13_508 VPWR VGND sg13g2_decap_8
XFILLER_21_530 VPWR VGND sg13g2_decap_8
XFILLER_29_42 VPWR VGND sg13g2_decap_8
XFILLER_16_313 VPWR VGND sg13g2_decap_8
XFILLER_6_35 VPWR VGND sg13g2_decap_8
XFILLER_6_13 VPWR VGND sg13g2_fill_1
Xrebuffer108 rebuffer108/X _0629_/Y VPWR VGND sg13g2_buf_1
XFILLER_30_382 VPWR VGND sg13g2_decap_8
XFILLER_22_327 VPWR VGND sg13g2_decap_8
X_0718_ _0928_/D _0718_/A _0718_/B VPWR VGND sg13g2_xnor2_1
X_0649_ _0953_/D _0649_/A _0650_/B VPWR VGND sg13g2_xor2_1
XFILLER_13_327 VPWR VGND sg13g2_decap_8
Xoutput8 clk_lp_n _0771_/Y VPWR VGND sg13g2_buf_1
Xoutput32 tx_ready_hs[0] _1025_/X VPWR VGND sg13g2_buf_1
Xoutput21 hs_trail[1] _1014_/X VPWR VGND sg13g2_buf_1
Xoutput10 clk_ready _0595_/X VPWR VGND sg13g2_buf_1
Xlane0.t_prep.tempo VPWR VGND _0629_/A lane0.t_prep.tempo/ARM _0961_/Q fanout57/X
+ _0573_/A tempo_t60n
XFILLER_22_157 VPWR VGND sg13g2_decap_8
XFILLER_18_419 VPWR VGND sg13g2_decap_8
XFILLER_13_157 VPWR VGND sg13g2_decap_8
XFILLER_5_334 VPWR VGND sg13g2_decap_8
XFILLER_1_562 VPWR VGND sg13g2_fill_1
XFILLER_3_58 VPWR VGND sg13g2_decap_4
XFILLER_17_485 VPWR VGND sg13g2_fill_1
XFILLER_27_249 VPWR VGND sg13g2_decap_8
XFILLER_23_444 VPWR VGND sg13g2_fill_1
XFILLER_12_67 VPWR VGND sg13g2_fill_1
Xhold150 _0924_/D _0811_/Y VPWR VGND sg13g2_dlygate4sd3_1
Xhold161 _0898_/D _0764_/X VPWR VGND sg13g2_dlygate4sd3_1
Xhold172 hold172/X _0952_/Q VPWR VGND sg13g2_dlygate4sd3_1
Xhold183 _0788_/B _0894_/Q VPWR VGND sg13g2_dlygate4sd3_1
Xhold194 _0818_/A _0568_/Y VPWR VGND sg13g2_dlygate4sd3_1
XFILLER_18_249 VPWR VGND sg13g2_decap_8
XFILLER_5_164 VPWR VGND sg13g2_decap_8
X_0966_ _0966_/Q _0977_/CLK _0966_/D _0885_/Y VPWR VGND sg13g2_dfrbpq_2
Xlane1.t_lpx.tempo VPWR VGND _0777_/B lane1.t_lpx.tempo/ARM _0666_/Y fanout57/X _0667_/B
+ tempo_t80n
X_0897_ _0897_/Q clkload2/A _0897_/D _0850_/X VPWR VGND sg13g2_dfrbpq_1
XFILLER_9_492 VPWR VGND sg13g2_decap_4
XFILLER_23_263 VPWR VGND sg13g2_decap_8
X_0820_ _0939_/D _0819_/A _0818_/B _0819_/Y VPWR VGND sg13g2_a21oi_1
X_0751_ _0751_/X _0751_/A _0751_/B _0751_/C input6/X VPWR VGND sg13g2_or4_1
XFILLER_9_79 VPWR VGND sg13g2_decap_8
XFILLER_6_462 VPWR VGND sg13g2_decap_8
X_0682_ _0946_/D _0681_/Y _0552_/Y _0682_/B1 VPWR VGND sg13g2_a21oi_2
X_0949_ _0949_/Q _0978_/CLK _0949_/D _0874_/Y VPWR VGND sg13g2_dfrbpq_1
XFILLER_28_355 VPWR VGND sg13g2_decap_8
XFILLER_1_0 VPWR VGND sg13g2_decap_8
XFILLER_3_476 VPWR VGND sg13g2_decap_8
X_0803_ _0913_/D _0801_/A _0802_/A _0801_/B VPWR VGND sg13g2_a21o_1
X_0734_ _0734_/X _0738_/A _0751_/A VPWR VGND sg13g2_and2_2
X_0665_ _0777_/B _0669_/B _0778_/A VPWR VGND sg13g2_nand2b_1
XFILLER_6_270 VPWR VGND sg13g2_decap_8
X_0596_ _0603_/A _0596_/A input1/X _0596_/C VPWR VGND sg13g2_and3_1
XFILLER_29_119 VPWR VGND sg13g2_decap_8
XFILLER_29_98 VPWR VGND sg13g2_decap_8
XFILLER_29_21 VPWR VGND sg13g2_decap_8
XFILLER_28_185 VPWR VGND sg13g2_decap_8
XFILLER_24_391 VPWR VGND sg13g2_decap_8
XFILLER_19_185 VPWR VGND sg13g2_decap_8
XFILLER_22_306 VPWR VGND sg13g2_decap_8
XFILLER_15_391 VPWR VGND sg13g2_decap_8
Xrebuffer109 _0852_/B _0738_/A VPWR VGND sg13g2_buf_1
X_0717_ _0718_/B _0717_/A _0781_/B _0719_/C _0719_/D VPWR VGND sg13g2_and4_1
X_0648_ _0954_/D _0648_/A _0648_/B VPWR VGND sg13g2_nor2_1
X_0579_ _0579_/Y _0596_/A _0589_/A _0585_/B VPWR VGND sg13g2_nor3_2
XFILLER_13_306 VPWR VGND sg13g2_decap_8
XFILLER_15_34 VPWR VGND sg13g2_fill_1
XFILLER_25_100 VPWR VGND sg13g2_decap_8
Xclkbuf_4_10_0_clk _0975_/CLK clkbuf_0_clk/X VPWR VGND sg13g2_buf_8
XFILLER_5_516 VPWR VGND sg13g2_fill_1
Xoutput9 clk_lp_p _0770_/Y VPWR VGND sg13g2_buf_1
Xoutput33 tx_ready_hs[1] _1026_/X VPWR VGND sg13g2_buf_1
Xoutput22 hs_trail[2] _1015_/X VPWR VGND sg13g2_buf_1
Xoutput11 clk_run _0785_/Y VPWR VGND sg13g2_buf_1
XFILLER_29_483 VPWR VGND sg13g2_decap_8
XFILLER_12_383 VPWR VGND sg13g2_decap_8
XFILLER_22_114 VPWR VGND sg13g2_decap_8
XFILLER_13_114 VPWR VGND sg13g2_decap_8
XFILLER_9_107 VPWR VGND sg13g2_decap_8
XFILLER_5_313 VPWR VGND sg13g2_decap_8
XFILLER_1_552 VPWR VGND sg13g2_fill_2
XFILLER_3_37 VPWR VGND sg13g2_decap_8
XFILLER_29_291 VPWR VGND sg13g2_decap_4
Xlane0.t_lpx.tempo VPWR VGND _0774_/A lane0.t_lpx.tempo/ARM _0616_/Y fanout57/X _0574_/A
+ tempo_t80n
XFILLER_27_228 VPWR VGND sg13g2_decap_8
XFILLER_23_412 VPWR VGND sg13g2_decap_8
XFILLER_12_79 VPWR VGND sg13g2_decap_8
Xhold140 _0832_/B _0963_/Q VPWR VGND sg13g2_dlygate4sd3_1
Xhold151 hold151/X _0914_/Q VPWR VGND sg13g2_dlygate4sd3_1
Xhold162 _0806_/A _0920_/Q VPWR VGND sg13g2_dlygate4sd3_1
XFILLER_18_206 VPWR VGND sg13g2_fill_1
Xhold173 _0612_/B _0968_/Q VPWR VGND sg13g2_dlygate4sd3_1
Xhold195 _0843_/C _0973_/Q VPWR VGND sg13g2_dlygate4sd3_1
XFILLER_18_228 VPWR VGND sg13g2_decap_8
Xclk_lane.t_prep.tempo VPWR VGND _0583_/A clk_lane.t_prep.tempo/ARM _0583_/Y fanout57/X
+ _0584_/B tempo_t60n
X_0965_ _0965_/Q _0977_/CLK _0965_/D _0884_/Y VPWR VGND sg13g2_dfrbpq_2
X_0896_ _0896_/Q clkload3/A _0896_/D _0849_/X VPWR VGND sg13g2_dfrbpq_1
XFILLER_9_460 VPWR VGND sg13g2_fill_1
XFILLER_28_548 VPWR VGND sg13g2_decap_8
XFILLER_11_426 VPWR VGND sg13g2_decap_8
XFILLER_7_419 VPWR VGND sg13g2_decap_8
XFILLER_23_242 VPWR VGND sg13g2_decap_8
X_0750_ _0757_/C _0562_/Y _0747_/Y _0743_/Y VPWR VGND sg13g2_a21oi_1
X_0681_ _0681_/Y _0681_/A _0681_/B _0681_/C _0681_/D VPWR VGND sg13g2_nand4_1
X_0948_ _0948_/Q clkload0/A _0948_/D rebuffer113/X VPWR VGND sg13g2_dfrbpq_1
X_0879_ _0879_/X _0881_/A _0881_/B VPWR VGND sg13g2_and2_1
XFILLER_28_334 VPWR VGND sg13g2_decap_8
XFILLER_24_551 VPWR VGND sg13g2_decap_8
XFILLER_11_256 VPWR VGND sg13g2_decap_8
XFILLER_7_249 VPWR VGND sg13g2_decap_8
XFILLER_19_334 VPWR VGND sg13g2_decap_8
X_0802_ _0912_/D _0802_/A _0802_/B VPWR VGND sg13g2_xnor2_1
XFILLER_30_543 VPWR VGND sg13g2_decap_8
X_0733_ _0738_/A _0751_/C _0751_/B VPWR VGND sg13g2_nor2b_2
X_0664_ _0669_/B fanout45/X _0675_/C VPWR VGND sg13g2_nand2b_1
X_0595_ _0595_/X _0596_/A _0596_/C VPWR VGND sg13g2_and2_1
XFILLER_25_348 VPWR VGND sg13g2_decap_8
XFILLER_16_348 VPWR VGND sg13g2_decap_8
XFILLER_29_77 VPWR VGND sg13g2_decap_8
XFILLER_28_164 VPWR VGND sg13g2_decap_8
XFILLER_3_263 VPWR VGND sg13g2_decap_8
XFILLER_19_164 VPWR VGND sg13g2_decap_8
X_0716_ _0721_/A _0719_/D _0719_/C _0717_/A VPWR VGND sg13g2_nand3_1
X_0647_ _0648_/B _0649_/A _0650_/B _0641_/A VPWR VGND sg13g2_a21oi_1
X_0578_ _0596_/C _0589_/A _0585_/B VPWR VGND sg13g2_nor2_1
XFILLER_15_79 VPWR VGND sg13g2_decap_8
XFILLER_25_178 VPWR VGND sg13g2_decap_8
XFILLER_21_384 VPWR VGND sg13g2_decap_8
Xoutput34 tx_ready_hs[2] _1027_/X VPWR VGND sg13g2_buf_1
Xoutput23 hs_trail[3] _1016_/X VPWR VGND sg13g2_buf_1
Xoutput12 hs_oe[0] _1005_/X VPWR VGND sg13g2_buf_1
XFILLER_29_440 VPWR VGND sg13g2_decap_4
XFILLER_16_178 VPWR VGND sg13g2_decap_8
XFILLER_29_462 VPWR VGND sg13g2_decap_8
XFILLER_30_192 VPWR VGND sg13g2_decap_8
XFILLER_21_192 VPWR VGND sg13g2_decap_8
XFILLER_29_270 VPWR VGND sg13g2_decap_8
XFILLER_12_192 VPWR VGND sg13g2_decap_8
XFILLER_4_391 VPWR VGND sg13g2_decap_8
XFILLER_10_107 VPWR VGND sg13g2_decap_8
XFILLER_23_457 VPWR VGND sg13g2_fill_2
Xhold141 _0962_/D _0832_/Y VPWR VGND sg13g2_dlygate4sd3_1
Xhold152 _0914_/D _0731_/Y VPWR VGND sg13g2_dlygate4sd3_1
Xhold174 _0968_/D _0611_/Y VPWR VGND sg13g2_dlygate4sd3_1
Xhold185 _0822_/B _0942_/Q VPWR VGND sg13g2_dlygate4sd3_1
XFILLER_5_100 VPWR VGND sg13g2_decap_8
X_0964_ _0964_/Q _0977_/CLK _0964_/D _0883_/Y VPWR VGND sg13g2_dfrbpq_2
X_0895_ _0895_/Q clkload6/A _0895_/D _0848_/X VPWR VGND sg13g2_dfrbpq_1
XFILLER_28_527 VPWR VGND sg13g2_decap_8
XFILLER_11_405 VPWR VGND sg13g2_decap_8
XFILLER_23_79 VPWR VGND sg13g2_decap_8
XFILLER_0_39 VPWR VGND sg13g2_decap_8
XFILLER_19_505 VPWR VGND sg13g2_fill_1
XFILLER_27_560 VPWR VGND sg13g2_decap_8
X_0680_ _0947_/D _0680_/A _0680_/B VPWR VGND sg13g2_xnor2_1
XFILLER_6_497 VPWR VGND sg13g2_decap_8
XFILLER_6_431 VPWR VGND sg13g2_fill_1
Xlane0.t_prep.tempo_69 lane0.t_prep.tempo/ARM VPWR VGND sg13g2_tielo
X_0947_ _0947_/Q clkload5/A _0947_/D _0873_/Y VPWR VGND sg13g2_dfrbpq_1
X_0878_ _0878_/X _0878_/A _0881_/B VPWR VGND sg13g2_and2_1
XFILLER_18_79 VPWR VGND sg13g2_decap_8
XFILLER_28_313 VPWR VGND sg13g2_decap_8
XFILLER_11_235 VPWR VGND sg13g2_decap_8
Xclkload0 clkload0/Y clkload0/A VPWR VGND sg13g2_inv_1
XFILLER_7_228 VPWR VGND sg13g2_decap_8
XFILLER_3_412 VPWR VGND sg13g2_decap_8
XFILLER_19_313 VPWR VGND sg13g2_decap_8
XFILLER_27_390 VPWR VGND sg13g2_decap_8
X_0801_ _0911_/D _0801_/A _0801_/B VPWR VGND sg13g2_xnor2_1
XFILLER_30_522 VPWR VGND sg13g2_decap_8
X_0732_ _0784_/B _0751_/B _0751_/C VPWR VGND sg13g2_and2_1
X_0663_ _0663_/Y _0663_/A VPWR VGND sg13g2_inv_4
X_0594_ _0604_/D _0594_/A _0594_/B VPWR VGND sg13g2_nor2_1
XFILLER_25_327 VPWR VGND sg13g2_decap_8
XFILLER_21_544 VPWR VGND sg13g2_decap_8
XFILLER_21_566 VPWR VGND sg13g2_fill_1
XFILLER_29_56 VPWR VGND sg13g2_decap_8
XFILLER_16_327 VPWR VGND sg13g2_decap_8
XFILLER_6_49 VPWR VGND sg13g2_decap_4
XFILLER_3_286 VPWR VGND sg13g2_fill_2
XFILLER_3_242 VPWR VGND sg13g2_decap_8
X_0715_ _0715_/Y _0701_/Y _0565_/Y _1027_/A input5/X _0714_/Y VPWR VGND sg13g2_a221oi_1
XFILLER_30_396 VPWR VGND sg13g2_decap_8
X_0646_ _0650_/B _0645_/A _0641_/A _0644_/A VPWR VGND sg13g2_o21ai_1
X_0577_ _0887_/B _0589_/A _0585_/B VPWR VGND sg13g2_nand2_2
XFILLER_25_157 VPWR VGND sg13g2_decap_8
XFILLER_21_341 VPWR VGND sg13g2_decap_8
Xoutput35 tx_ready_hs[3] _1028_/X VPWR VGND sg13g2_buf_1
Xoutput24 lp_n[0] _1017_/X VPWR VGND sg13g2_buf_1
Xoutput13 hs_oe[1] _1006_/X VPWR VGND sg13g2_buf_1
XFILLER_16_113 VPWR VGND sg13g2_decap_8
XFILLER_16_157 VPWR VGND sg13g2_decap_8
XFILLER_12_341 VPWR VGND sg13g2_decap_8
XFILLER_30_171 VPWR VGND sg13g2_decap_8
X_0629_ _0629_/Y _0629_/A VPWR VGND sg13g2_inv_4
XFILLER_21_171 VPWR VGND sg13g2_decap_8
XFILLER_1_554 VPWR VGND sg13g2_fill_1
XFILLER_5_348 VPWR VGND sg13g2_decap_8
XFILLER_17_433 VPWR VGND sg13g2_fill_2
XFILLER_12_171 VPWR VGND sg13g2_decap_8
XFILLER_27_208 VPWR VGND sg13g2_fill_2
Xhold142 _0861_/A _0922_/Q VPWR VGND sg13g2_dlygate4sd3_1
Xhold153 hold153/X _0959_/Q VPWR VGND sg13g2_dlygate4sd3_1
Xhold164 _0805_/A _0564_/Y VPWR VGND sg13g2_dlygate4sd3_1
Xhold175 hold175/X _0940_/Q VPWR VGND sg13g2_dlygate4sd3_1
Xhold186 _0942_/D _0822_/X VPWR VGND sg13g2_dlygate4sd3_1
Xhold197 _0789_/A _0893_/Q VPWR VGND sg13g2_dlygate4sd3_1
XFILLER_5_178 VPWR VGND sg13g2_decap_8
XFILLER_5_134 VPWR VGND sg13g2_decap_4
XFILLER_17_263 VPWR VGND sg13g2_decap_8
X_0963_ _0963_/Q _0978_/CLK _0963_/D rebuffer108/X VPWR VGND sg13g2_dfrbpq_1
X_0894_ _0894_/Q _0925_/CLK _0894_/D _0749_/Y VPWR VGND sg13g2_dfrbpq_1
XFILLER_4_93 VPWR VGND sg13g2_decap_8
XFILLER_28_506 VPWR VGND sg13g2_decap_8
Xlane1.t_prep.tempo_74 lane1.t_prep.tempo/ARM VPWR VGND sg13g2_tielo
Xlane2.t_zero.tempo VPWR VGND _0711_/A lane2.t_zero.tempo/ARM _0910_/Q fanout59/X
+ _0714_/A1 tempo_t150n
XFILLER_0_18 VPWR VGND sg13g2_decap_8
XFILLER_6_410 VPWR VGND sg13g2_decap_8
XFILLER_10_472 VPWR VGND sg13g2_fill_1
XFILLER_6_476 VPWR VGND sg13g2_decap_8
X_0946_ _0946_/Q _0970_/CLK _0946_/D _0872_/Y VPWR VGND sg13g2_dfrbpq_2
X_0877_ _0877_/X _0877_/A _0881_/B VPWR VGND sg13g2_and2_1
XFILLER_9_270 VPWR VGND sg13g2_decap_8
XFILLER_18_36 VPWR VGND sg13g2_decap_8
XFILLER_18_58 VPWR VGND sg13g2_fill_2
XFILLER_28_369 VPWR VGND sg13g2_decap_8
Xclkload1 clkload1/Y clkload1/A VPWR VGND sg13g2_inv_1
XFILLER_30_501 VPWR VGND sg13g2_decap_8
X_0800_ _0802_/B _0801_/B _0801_/A VPWR VGND sg13g2_nand2b_1
X_0731_ _0731_/Y hold151/X _0731_/B VPWR VGND sg13g2_nand2b_1
X_0662_ _0663_/A _0662_/A _0778_/A VPWR VGND sg13g2_nand2_2
X_0593_ _0594_/B _0593_/A VPWR VGND sg13g2_inv_1
XFILLER_25_306 VPWR VGND sg13g2_decap_8
XFILLER_18_391 VPWR VGND sg13g2_decap_8
X_0929_ _0929_/Q clkload1/A _0929_/D _0673_/Y VPWR VGND sg13g2_dfrbpq_1
XFILLER_29_35 VPWR VGND sg13g2_decap_8
XFILLER_16_306 VPWR VGND sg13g2_decap_8
XFILLER_19_100 VPWR VGND sg13g2_decap_8
XFILLER_30_353 VPWR VGND sg13g2_fill_2
X_0714_ _0714_/Y _0714_/A1 _0711_/A _0713_/X VPWR VGND sg13g2_o21ai_1
X_0645_ _0955_/D _0645_/A _0648_/A VPWR VGND sg13g2_xor2_1
X_0576_ _0576_/Y _0873_/A VPWR VGND sg13g2_inv_1
XFILLER_25_114 VPWR VGND sg13g2_decap_8
XFILLER_21_320 VPWR VGND sg13g2_decap_8
XFILLER_21_375 VPWR VGND sg13g2_fill_2
Xoutput25 lp_n[1] _1018_/X VPWR VGND sg13g2_buf_1
Xoutput14 hs_oe[2] _1007_/X VPWR VGND sg13g2_buf_1
XFILLER_29_497 VPWR VGND sg13g2_decap_8
XFILLER_12_320 VPWR VGND sg13g2_decap_8
XFILLER_12_397 VPWR VGND sg13g2_decap_8
XFILLER_30_150 VPWR VGND sg13g2_decap_8
X_0628_ _0629_/A _0878_/A _0881_/B VPWR VGND sg13g2_nand2b_2
XFILLER_7_93 VPWR VGND sg13g2_decap_8
X_0559_ _0559_/Y _0559_/A VPWR VGND sg13g2_inv_1
XFILLER_21_150 VPWR VGND sg13g2_decap_8
XFILLER_5_327 VPWR VGND sg13g2_decap_8
Xclk_lane.t_post.tempo_63 clk_lane.t_post.tempo/ARM VPWR VGND sg13g2_tielo
XFILLER_17_412 VPWR VGND sg13g2_decap_8
XFILLER_12_150 VPWR VGND sg13g2_decap_8
XFILLER_23_426 VPWR VGND sg13g2_decap_8
Xhold143 _0882_/A _0960_/Q VPWR VGND sg13g2_dlygate4sd3_1
Xhold154 hold154/X _0921_/Q VPWR VGND sg13g2_dlygate4sd3_1
Xhold165 _0819_/A _0939_/Q VPWR VGND sg13g2_dlygate4sd3_1
Xhold176 _0653_/A _0950_/Q VPWR VGND sg13g2_dlygate4sd3_1
Xhold187 _0810_/B _0925_/Q VPWR VGND sg13g2_dlygate4sd3_1
Xhold198 _0802_/A _0912_/Q VPWR VGND sg13g2_dlygate4sd3_1
XFILLER_5_157 VPWR VGND sg13g2_decap_8
XFILLER_17_242 VPWR VGND sg13g2_decap_8
X_0962_ _0962_/Q _0978_/CLK _0962_/D rebuffer108/X VPWR VGND sg13g2_dfrbpq_1
X_0893_ _0893_/Q _0925_/CLK _0893_/D _0749_/Y VPWR VGND sg13g2_dfrbpq_1
XFILLER_9_496 VPWR VGND sg13g2_fill_1
XFILLER_4_72 VPWR VGND sg13g2_decap_8
XFILLER_23_256 VPWR VGND sg13g2_decap_8
XFILLER_23_212 VPWR VGND sg13g2_fill_2
XFILLER_27_540 VPWR VGND sg13g2_decap_8
Xfanout60 fanout60/X PG VPWR VGND sg13g2_buf_1
X_0945_ _0945_/Q _0970_/CLK _0945_/D _0871_/Y VPWR VGND sg13g2_dfrbpq_2
X_0876_ _0876_/Y _0876_/A _0775_/B VPWR VGND sg13g2_nor2b_1
XFILLER_28_348 VPWR VGND sg13g2_decap_8
Xclkload2 clkload2/Y clkload2/A VPWR VGND sg13g2_inv_1
XFILLER_24_565 VPWR VGND sg13g2_decap_4
XFILLER_3_469 VPWR VGND sg13g2_decap_8
XFILLER_19_348 VPWR VGND sg13g2_decap_8
XFILLER_10_270 VPWR VGND sg13g2_decap_8
X_0730_ _0730_/X _0915_/Q _0731_/B VPWR VGND sg13g2_xor2_1
X_0661_ _0679_/B _1014_/A _0567_/Y _0660_/Y _0568_/Y VPWR VGND sg13g2_a22oi_1
XFILLER_6_263 VPWR VGND sg13g2_decap_8
XFILLER_30_557 VPWR VGND sg13g2_decap_4
X_0592_ _0593_/A _0772_/A _0887_/B VPWR VGND sg13g2_nor2_2
X_0928_ _0928_/Q _0928_/CLK _0928_/D _0864_/Y VPWR VGND sg13g2_dfrbpq_2
X_0859_ _0859_/X _0860_/A _0860_/B VPWR VGND sg13g2_and2_1
XFILLER_29_14 VPWR VGND sg13g2_decap_8
XFILLER_28_112 VPWR VGND sg13g2_decap_8
XFILLER_28_178 VPWR VGND sg13g2_decap_8
XFILLER_24_384 VPWR VGND sg13g2_decap_8
XFILLER_10_93 VPWR VGND sg13g2_decap_8
XFILLER_3_288 VPWR VGND sg13g2_fill_1
XFILLER_19_178 VPWR VGND sg13g2_decap_8
XFILLER_15_340 VPWR VGND sg13g2_decap_8
XFILLER_15_384 VPWR VGND sg13g2_decap_8
XFILLER_30_332 VPWR VGND sg13g2_decap_8
X_0713_ _0713_/X _0713_/A _0713_/B _0713_/C input5/X VPWR VGND sg13g2_or4_1
X_0644_ _0648_/A _0644_/A _0644_/B VPWR VGND sg13g2_nor2_1
XFILLER_7_550 VPWR VGND sg13g2_decap_8
X_0575_ _0575_/Y _0575_/A VPWR VGND sg13g2_inv_1
XFILLER_25_137 VPWR VGND sg13g2_decap_4
XFILLER_21_398 VPWR VGND sg13g2_decap_8
Xoutput26 lp_n[2] _1019_/X VPWR VGND sg13g2_buf_1
Xoutput15 hs_oe[3] _1008_/X VPWR VGND sg13g2_buf_1
XFILLER_29_476 VPWR VGND sg13g2_decap_8
XFILLER_24_192 VPWR VGND sg13g2_decap_8
XFILLER_22_107 VPWR VGND sg13g2_decap_8
XFILLER_15_192 VPWR VGND sg13g2_decap_8
XFILLER_7_72 VPWR VGND sg13g2_decap_8
X_0627_ _1025_/A _0876_/A _0627_/B VPWR VGND sg13g2_and2_2
X_0558_ _0558_/Y _0833_/B VPWR VGND sg13g2_inv_1
XFILLER_7_391 VPWR VGND sg13g2_decap_8
XFILLER_13_107 VPWR VGND sg13g2_decap_8
XFILLER_5_306 VPWR VGND sg13g2_decap_8
XFILLER_1_545 VPWR VGND sg13g2_decap_8
XFILLER_17_435 VPWR VGND sg13g2_fill_1
XFILLER_29_295 VPWR VGND sg13g2_fill_2
XFILLER_29_284 VPWR VGND sg13g2_decap_8
XFILLER_16_92 VPWR VGND sg13g2_decap_8
XFILLER_23_405 VPWR VGND sg13g2_decap_8
Xhold144 _0824_/A _0943_/Q VPWR VGND sg13g2_dlygate4sd3_1
Xhold155 hold155/X _0895_/Q VPWR VGND sg13g2_dlygate4sd3_1
Xhold177 _0950_/D _0653_/Y VPWR VGND sg13g2_dlygate4sd3_1
XFILLER_5_114 VPWR VGND sg13g2_fill_2
XFILLER_17_221 VPWR VGND sg13g2_fill_2
X_0961_ _0961_/Q _0978_/CLK _0961_/D rebuffer108/X VPWR VGND sg13g2_dfrbpq_1
X_0892_ _0892_/Q clkload2/A _0892_/D _0749_/Y VPWR VGND sg13g2_dfrbpq_1
XFILLER_11_419 VPWR VGND sg13g2_decap_8
XFILLER_23_27 VPWR VGND sg13g2_fill_2
XFILLER_23_235 VPWR VGND sg13g2_decap_8
XFILLER_13_93 VPWR VGND sg13g2_decap_8
Xfanout50 _0713_/C _0926_/Q VPWR VGND sg13g2_buf_8
XFILLER_29_7 VPWR VGND sg13g2_decap_8
X_0944_ _0944_/Q clkload1/A _0944_/D rebuffer124/X VPWR VGND sg13g2_dfrbpq_1
X_0875_ _0875_/Y _0876_/A _0775_/B VPWR VGND sg13g2_nor2b_1
XFILLER_28_327 VPWR VGND sg13g2_decap_8
XFILLER_11_249 VPWR VGND sg13g2_decap_8
Xclkload3 clkload3/Y clkload3/A VPWR VGND sg13g2_inv_1
XFILLER_3_426 VPWR VGND sg13g2_fill_2
XFILLER_19_327 VPWR VGND sg13g2_decap_8
XFILLER_30_536 VPWR VGND sg13g2_decap_8
Xlane0.t_trail.tempo_70 lane0.t_trail.tempo/ARM VPWR VGND sg13g2_tielo
X_0660_ _0660_/Y _0668_/B _0778_/A _0675_/C VPWR VGND sg13g2_nor3_2
X_0591_ _0604_/B _0591_/A _0591_/B VPWR VGND sg13g2_nor2_2
XFILLER_6_242 VPWR VGND sg13g2_decap_8
XFILLER_27_4 VPWR VGND sg13g2_decap_8
X_0927_ _0927_/Q _0928_/CLK _0927_/D _0863_/Y VPWR VGND sg13g2_dfrbpq_2
Xclk_lane.t_post.tempo VPWR VGND _0601_/A clk_lane.t_post.tempo/ARM _0970_/Q fanout58/X
+ _0602_/A tempo_t80n
X_0858_ _0858_/X _0860_/A _0860_/B VPWR VGND sg13g2_and2_1
X_0789_ _0893_/D _0789_/A _0789_/B VPWR VGND sg13g2_xnor2_1
XFILLER_28_157 VPWR VGND sg13g2_decap_8
XFILLER_24_374 VPWR VGND sg13g2_fill_1
XFILLER_24_341 VPWR VGND sg13g2_decap_8
XFILLER_10_72 VPWR VGND sg13g2_decap_8
XFILLER_3_256 VPWR VGND sg13g2_decap_8
XFILLER_19_157 VPWR VGND sg13g2_decap_8
XFILLER_30_311 VPWR VGND sg13g2_decap_8
X_0712_ _0719_/C _0566_/Y _0709_/Y _0705_/Y VPWR VGND sg13g2_a21oi_1
X_0643_ _0643_/Y _0644_/A _0643_/B VPWR VGND sg13g2_nand2b_1
X_0574_ _0574_/Y _0574_/A VPWR VGND sg13g2_inv_1
XFILLER_21_377 VPWR VGND sg13g2_fill_1
Xoutput27 lp_n[3] _1020_/X VPWR VGND sg13g2_buf_1
Xoutput16 hs_sync[0] _1009_/X VPWR VGND sg13g2_buf_1
XFILLER_29_455 VPWR VGND sg13g2_decap_8
XFILLER_29_433 VPWR VGND sg13g2_decap_8
XFILLER_24_171 VPWR VGND sg13g2_decap_8
XFILLER_21_93 VPWR VGND sg13g2_decap_8
XFILLER_15_171 VPWR VGND sg13g2_decap_8
Xclkbuf_0_clk clkbuf_0_clk/X clk VPWR VGND sg13g2_buf_16
XFILLER_30_185 VPWR VGND sg13g2_decap_8
X_0626_ _0774_/C _0775_/A _0626_/B VPWR VGND sg13g2_nand2b_1
X_0557_ _0844_/A _0833_/A VPWR VGND sg13g2_inv_1
XFILLER_21_185 VPWR VGND sg13g2_decap_8
XFILLER_29_263 VPWR VGND sg13g2_decap_8
XFILLER_16_71 VPWR VGND sg13g2_decap_8
XFILLER_12_185 VPWR VGND sg13g2_decap_8
XFILLER_4_384 VPWR VGND sg13g2_decap_8
Xhold145 _0943_/D _0824_/Y VPWR VGND sg13g2_dlygate4sd3_1
Xhold156 _0895_/D _0769_/Y VPWR VGND sg13g2_dlygate4sd3_1
Xhold167 _0826_/A _0572_/Y VPWR VGND sg13g2_dlygate4sd3_1
Xhold178 _0560_/A _0900_/Q VPWR VGND sg13g2_dlygate4sd3_1
Xhold189 _0896_/D _0768_/X VPWR VGND sg13g2_dlygate4sd3_1
X_0609_ _0610_/B _0607_/B _0607_/C _0607_/A VPWR VGND sg13g2_a21o_1
XFILLER_27_81 VPWR VGND sg13g2_decap_8
X_0960_ _0960_/Q clkload5/A _0960_/D _1009_/A VPWR VGND sg13g2_dfrbpq_1
X_0891_ _0891_/Q _0928_/CLK _0891_/D _0749_/Y VPWR VGND sg13g2_dfrbpq_1
XFILLER_23_214 VPWR VGND sg13g2_fill_1
Xfanout40 _0878_/A fanout42/X VPWR VGND sg13g2_buf_16
Xfanout51 _0751_/A _0909_/Q VPWR VGND sg13g2_buf_8
XFILLER_10_442 VPWR VGND sg13g2_decap_4
XFILLER_13_72 VPWR VGND sg13g2_decap_8
XFILLER_6_424 VPWR VGND sg13g2_decap_8
XFILLER_18_564 VPWR VGND sg13g2_decap_8
X_0943_ _0943_/Q clkload1/A _0943_/D rebuffer124/X VPWR VGND sg13g2_dfrbpq_1
X_0874_ _0874_/Y _0874_/A _0775_/B VPWR VGND sg13g2_nor2b_1
XFILLER_28_306 VPWR VGND sg13g2_decap_8
XFILLER_11_228 VPWR VGND sg13g2_decap_8
Xclkload4 clkload4/Y clkload4/A VPWR VGND sg13g2_inv_1
XFILLER_3_405 VPWR VGND sg13g2_decap_8
XFILLER_3_438 VPWR VGND sg13g2_fill_1
XFILLER_19_306 VPWR VGND sg13g2_decap_8
XFILLER_27_383 VPWR VGND sg13g2_decap_8
XFILLER_30_515 VPWR VGND sg13g2_decap_8
XFILLER_24_93 VPWR VGND sg13g2_decap_8
X_0590_ _0590_/Y _0770_/B VPWR VGND sg13g2_inv_1
XFILLER_1_42 VPWR VGND sg13g2_decap_8
XFILLER_21_537 VPWR VGND sg13g2_decap_8
X_0926_ _0926_/Q _0928_/CLK _0926_/D _0862_/Y VPWR VGND sg13g2_dfrbpq_2
X_0857_ _0857_/X _0860_/A _0860_/B VPWR VGND sg13g2_and2_1
XFILLER_21_559 VPWR VGND sg13g2_decap_8
X_0788_ _0892_/D _0788_/A _0788_/B VPWR VGND sg13g2_xnor2_1
XFILLER_29_49 VPWR VGND sg13g2_decap_8
XFILLER_24_320 VPWR VGND sg13g2_decap_8
XFILLER_3_235 VPWR VGND sg13g2_decap_8
XFILLER_19_114 VPWR VGND sg13g2_decap_8
XFILLER_19_93 VPWR VGND sg13g2_decap_8
X_0711_ _0711_/Y _0711_/A VPWR VGND sg13g2_inv_1
XFILLER_30_389 VPWR VGND sg13g2_decap_8
X_0642_ _0643_/B _0955_/Q _0954_/Q _0953_/Q VPWR VGND sg13g2_nand3_1
X_0573_ _0573_/Y _0573_/A VPWR VGND sg13g2_inv_1
XFILLER_21_334 VPWR VGND sg13g2_decap_8
Xoutput28 lp_p[0] _1021_/X VPWR VGND sg13g2_buf_1
Xoutput17 hs_sync[1] _1010_/X VPWR VGND sg13g2_buf_1
X_0909_ _0909_/Q clkload3/A _0909_/D _0855_/Y VPWR VGND sg13g2_dfrbpq_2
XFILLER_29_412 VPWR VGND sg13g2_decap_8
XFILLER_16_106 VPWR VGND sg13g2_decap_8
XFILLER_24_150 VPWR VGND sg13g2_decap_8
XFILLER_12_334 VPWR VGND sg13g2_decap_8
XFILLER_21_72 VPWR VGND sg13g2_decap_8
XFILLER_15_150 VPWR VGND sg13g2_decap_8
XFILLER_30_164 VPWR VGND sg13g2_decap_8
X_0625_ _0636_/C _0571_/Y _1013_/A _0572_/Y _1009_/A VPWR VGND sg13g2_a22oi_1
X_0556_ _0556_/Y _0556_/A VPWR VGND sg13g2_inv_1
XFILLER_21_164 VPWR VGND sg13g2_decap_8
XFILLER_17_426 VPWR VGND sg13g2_decap_8
XFILLER_29_242 VPWR VGND sg13g2_decap_8
XFILLER_12_164 VPWR VGND sg13g2_decap_8
Xhold146 _0798_/A _0905_/Q VPWR VGND sg13g2_dlygate4sd3_1
Xhold157 _0827_/A _0958_/Q VPWR VGND sg13g2_dlygate4sd3_1
Xhold179 _0796_/B _0904_/Q VPWR VGND sg13g2_dlygate4sd3_1
X_0608_ _0977_/D hold247/X _0610_/A _0606_/A VPWR VGND sg13g2_a21oi_1
Xlane1.t_prep.tempo VPWR VGND _0663_/A lane1.t_prep.tempo/ARM _0942_/Q fanout57/X
+ _0569_/A tempo_t60n
XFILLER_17_256 VPWR VGND sg13g2_decap_8
XFILLER_27_60 VPWR VGND sg13g2_decap_8
X_0890_ _0890_/Y _0890_/A VPWR VGND sg13g2_inv_1
XFILLER_4_182 VPWR VGND sg13g2_decap_8
XFILLER_4_86 VPWR VGND sg13g2_decap_8
XFILLER_23_29 VPWR VGND sg13g2_fill_1
XFILLER_27_554 VPWR VGND sg13g2_fill_2
XFILLER_27_521 VPWR VGND sg13g2_fill_1
XFILLER_27_510 VPWR VGND sg13g2_decap_8
Xfanout41 _0876_/A _0966_/Q VPWR VGND sg13g2_buf_2
Xfanout52 _0746_/A _0909_/Q VPWR VGND sg13g2_buf_1
XFILLER_22_270 VPWR VGND sg13g2_decap_8
XFILLER_6_469 VPWR VGND sg13g2_decap_8
XFILLER_6_403 VPWR VGND sg13g2_decap_8
XFILLER_13_270 VPWR VGND sg13g2_decap_8
X_0942_ _0942_/Q clkload1/A _0942_/D rebuffer124/X VPWR VGND sg13g2_dfrbpq_1
X_0873_ _0873_/Y _0873_/A VPWR VGND sg13g2_inv_1
XFILLER_9_263 VPWR VGND sg13g2_decap_8
Xclkload5 clkload5/Y clkload5/A VPWR VGND sg13g2_inv_1
XFILLER_1_7 VPWR VGND sg13g2_decap_8
XFILLER_27_362 VPWR VGND sg13g2_decap_8
XFILLER_24_72 VPWR VGND sg13g2_decap_8
XFILLER_1_21 VPWR VGND sg13g2_decap_8
XFILLER_18_384 VPWR VGND sg13g2_decap_8
X_0925_ _0925_/Q _0925_/CLK _0925_/D _0701_/Y VPWR VGND sg13g2_dfrbpq_1
X_0856_ _0856_/X _0856_/A _0860_/B VPWR VGND sg13g2_and2_1
X_0787_ _0789_/B _0788_/B _0788_/A VPWR VGND sg13g2_nand2b_1
XFILLER_29_28 VPWR VGND sg13g2_decap_8
XFILLER_12_549 VPWR VGND sg13g2_decap_8
XFILLER_24_398 VPWR VGND sg13g2_decap_8
XFILLER_19_126 VPWR VGND sg13g2_fill_2
XFILLER_19_72 VPWR VGND sg13g2_decap_8
XFILLER_15_354 VPWR VGND sg13g2_fill_1
XFILLER_15_398 VPWR VGND sg13g2_decap_8
XFILLER_30_346 VPWR VGND sg13g2_decap_8
XFILLER_27_192 VPWR VGND sg13g2_decap_8
X_0710_ _0711_/A _0713_/A _0713_/B _0713_/C VPWR VGND sg13g2_nand3b_1
X_0641_ _0644_/B _0641_/A _0649_/A VPWR VGND sg13g2_nand2_1
XFILLER_7_564 VPWR VGND sg13g2_fill_2
X_0572_ _0572_/Y _0572_/A VPWR VGND sg13g2_inv_1
XFILLER_18_192 VPWR VGND sg13g2_decap_8
XFILLER_25_107 VPWR VGND sg13g2_decap_8
XFILLER_21_313 VPWR VGND sg13g2_decap_8
Xoutput29 lp_p[1] _1022_/X VPWR VGND sg13g2_buf_1
Xoutput18 hs_sync[2] _1011_/X VPWR VGND sg13g2_buf_1
X_0908_ _0908_/Q _0928_/CLK _0908_/D _0854_/Y VPWR VGND sg13g2_dfrbpq_2
X_0839_ _0842_/B _0843_/A _0843_/B _0839_/C VPWR VGND sg13g2_nand3_1
XFILLER_12_313 VPWR VGND sg13g2_decap_8
X_0624_ _1009_/A _0878_/A _0626_/B VPWR VGND sg13g2_and2_1
XFILLER_7_86 VPWR VGND sg13g2_decap_8
X_0555_ _0784_/A _0751_/A VPWR VGND sg13g2_inv_4
XFILLER_17_405 VPWR VGND sg13g2_decap_8
XFILLER_4_353 VPWR VGND sg13g2_fill_2
XFILLER_23_419 VPWR VGND sg13g2_decap_8
Xhold147 _0905_/D _0798_/Y VPWR VGND sg13g2_dlygate4sd3_1
Xhold158 _0870_/A _0941_/Q VPWR VGND sg13g2_dlygate4sd3_1
Xhold169 _0899_/D _0762_/Y VPWR VGND sg13g2_dlygate4sd3_1
X_0607_ _0610_/A _0607_/A _0607_/B _0607_/C VPWR VGND sg13g2_nand3_1
XFILLER_22_474 VPWR VGND sg13g2_decap_4
XFILLER_17_235 VPWR VGND sg13g2_decap_8
XFILLER_9_412 VPWR VGND sg13g2_decap_8
XFILLER_4_161 VPWR VGND sg13g2_decap_8
XFILLER_23_249 VPWR VGND sg13g2_decap_8
XFILLER_27_533 VPWR VGND sg13g2_decap_8
Xfanout42 fanout42/X _0966_/Q VPWR VGND sg13g2_buf_8
Xfanout53 _0751_/B _0908_/Q VPWR VGND sg13g2_buf_8
X_0941_ _0941_/Q _0941_/CLK _0941_/D _1010_/A VPWR VGND sg13g2_dfrbpq_1
X_0872_ _0872_/Y _0890_/A VPWR VGND sg13g2_inv_1
XFILLER_9_242 VPWR VGND sg13g2_decap_8
XFILLER_5_481 VPWR VGND sg13g2_fill_2
Xclkload6 clkload6/Y clkload6/A VPWR VGND sg13g2_inv_1
XFILLER_24_569 VPWR VGND sg13g2_fill_2
XFILLER_24_558 VPWR VGND sg13g2_decap_8
XFILLER_27_341 VPWR VGND sg13g2_decap_8
XFILLER_10_263 VPWR VGND sg13g2_decap_8
XFILLER_6_256 VPWR VGND sg13g2_decap_8
XFILLER_18_341 VPWR VGND sg13g2_decap_8
X_0924_ _0924_/Q clkload1/A _0924_/D _0701_/Y VPWR VGND sg13g2_dfrbpq_1
X_0855_ _0855_/Y _0873_/A VPWR VGND sg13g2_inv_1
X_0786_ _0891_/D _0788_/B _0786_/B VPWR VGND sg13g2_or2_1
XFILLER_28_105 VPWR VGND sg13g2_decap_8
XFILLER_10_86 VPWR VGND sg13g2_decap_8
XFILLER_27_171 VPWR VGND sg13g2_decap_8
XFILLER_15_333 VPWR VGND sg13g2_decap_8
XFILLER_30_325 VPWR VGND sg13g2_decap_8
X_0640_ _0964_/D _0640_/A _0640_/B VPWR VGND sg13g2_xnor2_1
X_0571_ _0571_/Y _0571_/A VPWR VGND sg13g2_inv_1
XFILLER_7_543 VPWR VGND sg13g2_decap_8
XFILLER_18_171 VPWR VGND sg13g2_decap_8
X_0907_ _0907_/Q clkload6/A _0907_/D _0576_/Y VPWR VGND sg13g2_dfrbpq_2
Xoutput19 hs_sync[3] _1012_/X VPWR VGND sg13g2_buf_1
X_0838_ _0971_/D _0843_/A _0839_/C _0837_/Y VPWR VGND sg13g2_a21oi_1
X_0769_ _0769_/Y hold155/X _0769_/B VPWR VGND sg13g2_nand2b_1
Xlane1.t_zero.tempo_76 lane1.t_zero.tempo/ARM VPWR VGND sg13g2_tielo
XFILLER_29_469 VPWR VGND sg13g2_decap_8
XFILLER_24_185 VPWR VGND sg13g2_decap_8
XFILLER_4_502 VPWR VGND sg13g2_decap_4
XFILLER_11_391 VPWR VGND sg13g2_decap_8
XFILLER_15_185 VPWR VGND sg13g2_decap_8
XFILLER_30_199 VPWR VGND sg13g2_decap_4
X_0623_ _0626_/B _0623_/A _0623_/B VPWR VGND sg13g2_nor2_1
X_0554_ _0554_/Y _0554_/A VPWR VGND sg13g2_inv_1
XFILLER_7_384 VPWR VGND sg13g2_decap_8
XFILLER_21_100 VPWR VGND sg13g2_decap_8
XFILLER_1_538 VPWR VGND sg13g2_decap_8
XFILLER_29_277 VPWR VGND sg13g2_decap_8
XFILLER_12_100 VPWR VGND sg13g2_decap_8
XFILLER_16_85 VPWR VGND sg13g2_decap_8
XFILLER_4_398 VPWR VGND sg13g2_decap_8
XFILLER_4_332 VPWR VGND sg13g2_decap_8
XFILLER_7_192 VPWR VGND sg13g2_fill_2
Xhold148 _0853_/A _0903_/Q VPWR VGND sg13g2_dlygate4sd3_1
Xhold159 hold159/X _0902_/Q VPWR VGND sg13g2_dlygate4sd3_1
X_0606_ _0978_/D _0606_/A _0606_/B VPWR VGND sg13g2_xor2_1
XFILLER_5_107 VPWR VGND sg13g2_decap_8
XFILLER_27_95 VPWR VGND sg13g2_decap_8
XFILLER_23_228 VPWR VGND sg13g2_decap_8
XFILLER_10_412 VPWR VGND sg13g2_decap_8
XFILLER_13_86 VPWR VGND sg13g2_decap_8
Xfanout43 _0675_/A _0947_/Q VPWR VGND sg13g2_buf_8
Xfanout54 _0751_/C _0907_/Q VPWR VGND sg13g2_buf_8
X_0940_ _0940_/Q _0941_/CLK _0940_/D _1010_/A VPWR VGND sg13g2_dfrbpq_1
X_0871_ _0871_/Y _0890_/A VPWR VGND sg13g2_inv_1
XFILLER_5_460 VPWR VGND sg13g2_decap_8
Xclkload7 clkload7/Y clkload7/A VPWR VGND sg13g2_inv_1
XFILLER_3_419 VPWR VGND sg13g2_decap_8
XFILLER_27_320 VPWR VGND sg13g2_decap_8
XFILLER_30_529 VPWR VGND sg13g2_decap_8
XFILLER_27_397 VPWR VGND sg13g2_decap_8
XFILLER_10_242 VPWR VGND sg13g2_decap_8
XFILLER_6_235 VPWR VGND sg13g2_decap_8
XFILLER_18_320 VPWR VGND sg13g2_decap_8
X_0923_ _0923_/Q _0928_/CLK _0923_/D _0701_/Y VPWR VGND sg13g2_dfrbpq_1
X_0854_ _0854_/Y _0873_/A VPWR VGND sg13g2_inv_1
X_0785_ _0785_/Y _0785_/A _0772_/A VPWR VGND sg13g2_nor2b_1
XFILLER_24_334 VPWR VGND sg13g2_decap_8
Xlane2.t_zero.tempo_81 lane2.t_zero.tempo/ARM VPWR VGND sg13g2_tielo
XFILLER_3_249 VPWR VGND sg13g2_decap_8
XFILLER_15_312 VPWR VGND sg13g2_decap_8
XFILLER_27_150 VPWR VGND sg13g2_decap_8
XFILLER_11_551 VPWR VGND sg13g2_decap_8
XFILLER_30_304 VPWR VGND sg13g2_decap_8
X_0570_ _0570_/Y _0570_/A VPWR VGND sg13g2_inv_1
XFILLER_7_566 VPWR VGND sg13g2_fill_1
XFILLER_18_150 VPWR VGND sg13g2_decap_8
XFILLER_21_348 VPWR VGND sg13g2_decap_8
X_0906_ _0906_/Q clkload2/A _0906_/D rebuffer129/X VPWR VGND sg13g2_dfrbpq_1
X_0837_ _0837_/Y _0843_/A _0839_/C _0837_/C VPWR VGND sg13g2_nor3_1
X_0768_ _0768_/X _0896_/Q _0769_/B VPWR VGND sg13g2_xor2_1
X_0699_ _0717_/A _0696_/X _0563_/Y _0698_/Y _0564_/Y VPWR VGND sg13g2_a22oi_1
XFILLER_29_448 VPWR VGND sg13g2_decap_8
XFILLER_29_426 VPWR VGND sg13g2_decap_8
XFILLER_12_348 VPWR VGND sg13g2_decap_8
XFILLER_24_164 VPWR VGND sg13g2_decap_8
XFILLER_21_86 VPWR VGND sg13g2_decap_8
XFILLER_15_164 VPWR VGND sg13g2_decap_8
XFILLER_28_492 VPWR VGND sg13g2_decap_8
XFILLER_7_341 VPWR VGND sg13g2_decap_4
XFILLER_30_178 VPWR VGND sg13g2_decap_8
X_0622_ _0622_/Y _1013_/A VPWR VGND sg13g2_inv_1
X_0553_ _0781_/A _0713_/A VPWR VGND sg13g2_inv_4
XFILLER_21_178 VPWR VGND sg13g2_decap_8
XFILLER_29_256 VPWR VGND sg13g2_decap_8
XFILLER_12_178 VPWR VGND sg13g2_decap_8
XFILLER_4_311 VPWR VGND sg13g2_decap_8
XFILLER_0_561 VPWR VGND sg13g2_decap_4
XFILLER_16_440 VPWR VGND sg13g2_decap_8
Xhold149 _0811_/A _0924_/Q VPWR VGND sg13g2_dlygate4sd3_1
XFILLER_7_171 VPWR VGND sg13g2_decap_8
X_0605_ _0606_/A _0605_/A _0607_/A _0605_/C _0605_/D VPWR VGND sg13g2_and4_1
X_1019_ _1019_/X _1019_/A VPWR VGND sg13g2_buf_1
XFILLER_27_74 VPWR VGND sg13g2_decap_8
XFILLER_25_270 VPWR VGND sg13g2_decap_8
XFILLER_13_487 VPWR VGND sg13g2_fill_2
XFILLER_4_196 VPWR VGND sg13g2_fill_2
XFILLER_16_270 VPWR VGND sg13g2_decap_8
Xfanout44 hold278/A _0947_/Q VPWR VGND sg13g2_buf_1
Xfanout55 _0890_/A input2/X VPWR VGND sg13g2_buf_1
XFILLER_10_468 VPWR VGND sg13g2_decap_4
XFILLER_6_417 VPWR VGND sg13g2_decap_8
XFILLER_18_557 VPWR VGND sg13g2_decap_8
X_0870_ _0941_/D _0870_/A VPWR VGND sg13g2_buf_1
XFILLER_5_483 VPWR VGND sg13g2_fill_1
XFILLER_27_376 VPWR VGND sg13g2_decap_8
XFILLER_30_508 VPWR VGND sg13g2_decap_8
XFILLER_24_86 VPWR VGND sg13g2_decap_8
XFILLER_23_560 VPWR VGND sg13g2_decap_8
XFILLER_1_35 VPWR VGND sg13g2_decap_8
XFILLER_18_398 VPWR VGND sg13g2_decap_8
X_0922_ _0922_/Q clkload7/A _0922_/D _1011_/A VPWR VGND sg13g2_dfrbpq_1
X_0853_ _0903_/D _0853_/A VPWR VGND sg13g2_buf_1
X_0784_ _1008_/A _0784_/A _0784_/B VPWR VGND sg13g2_xnor2_1
Xinput1 input1/X clk_request VPWR VGND sg13g2_buf_1
Xlane3.t_zero.tempo VPWR VGND _0749_/A lane3.t_zero.tempo/ARM _0891_/Q fanout59/X
+ _0752_/A1 tempo_t150n
XFILLER_24_313 VPWR VGND sg13g2_decap_8
XFILLER_3_228 VPWR VGND sg13g2_decap_8
XFILLER_19_107 VPWR VGND sg13g2_decap_8
XFILLER_19_86 VPWR VGND sg13g2_decap_8
XFILLER_21_327 VPWR VGND sg13g2_decap_8
X_0905_ _0905_/Q clkload2/A _0905_/D rebuffer129/X VPWR VGND sg13g2_dfrbpq_1
X_0836_ _0970_/D _0836_/A _0836_/B VPWR VGND sg13g2_or2_1
X_0767_ _0897_/D _0767_/A _0767_/B VPWR VGND sg13g2_nor2_1
X_0698_ _0698_/Y _0713_/C _0713_/B _0781_/A VPWR VGND sg13g2_nor3_2
XFILLER_29_405 VPWR VGND sg13g2_decap_8
XFILLER_12_327 VPWR VGND sg13g2_decap_8
XFILLER_30_102 VPWR VGND sg13g2_decap_8
XFILLER_28_471 VPWR VGND sg13g2_decap_8
X_0621_ _1013_/A _0877_/A _0881_/B VPWR VGND sg13g2_and2_1
XFILLER_7_320 VPWR VGND sg13g2_decap_8
XFILLER_30_157 VPWR VGND sg13g2_decap_8
X_0552_ _0552_/Y _0552_/A VPWR VGND sg13g2_inv_1
XFILLER_30_4 VPWR VGND sg13g2_decap_8
XFILLER_21_157 VPWR VGND sg13g2_decap_8
X_0819_ _0819_/Y _0819_/A _0870_/A VPWR VGND sg13g2_nor2b_1
XFILLER_17_419 VPWR VGND sg13g2_decap_8
Xlane1.t_trail.tempo VPWR VGND _0659_/Y lane1.t_trail.tempo/ARM _0933_/Q fanout60/X
+ _0567_/A tempo_t80n
XFILLER_29_235 VPWR VGND sg13g2_decap_8
XFILLER_12_157 VPWR VGND sg13g2_decap_8
XFILLER_0_540 VPWR VGND sg13g2_decap_8
X_0604_ _0605_/A _0604_/A _0604_/B _0604_/C _0604_/D VPWR VGND sg13g2_nor4_2
XFILLER_7_150 VPWR VGND sg13g2_decap_8
XFILLER_21_0 VPWR VGND sg13g2_decap_8
X_1018_ _1018_/X _1018_/A VPWR VGND sg13g2_buf_1
XFILLER_17_249 VPWR VGND sg13g2_decap_8
XFILLER_27_53 VPWR VGND sg13g2_decap_8
XFILLER_9_426 VPWR VGND sg13g2_decap_8
XFILLER_4_175 VPWR VGND sg13g2_decap_8
XFILLER_4_79 VPWR VGND sg13g2_decap_8
XFILLER_27_547 VPWR VGND sg13g2_decap_8
XFILLER_27_503 VPWR VGND sg13g2_decap_8
Xfanout45 fanout45/X _0946_/Q VPWR VGND sg13g2_buf_8
Xfanout56 _0873_/A input2/X VPWR VGND sg13g2_buf_1
XFILLER_22_263 VPWR VGND sg13g2_decap_8
XFILLER_13_263 VPWR VGND sg13g2_decap_8
XFILLER_9_256 VPWR VGND sg13g2_decap_8
XFILLER_27_355 VPWR VGND sg13g2_decap_8
XFILLER_1_14 VPWR VGND sg13g2_decap_8
X_0921_ _0921_/Q clkload7/A _0921_/D _1011_/A VPWR VGND sg13g2_dfrbpq_1
X_0852_ _0852_/X _0852_/A _0852_/B VPWR VGND sg13g2_and2_1
X_0783_ _1020_/A _1024_/A _0783_/B VPWR VGND sg13g2_nand2b_1
XFILLER_5_281 VPWR VGND sg13g2_decap_8
Xinput2 input2/X rst VPWR VGND sg13g2_buf_1
XFILLER_28_119 VPWR VGND sg13g2_decap_4
Xlane0.t_exit.tempo VPWR VGND _0774_/B lane0.t_exit.tempo/ARM _0618_/Y fanout58/X
+ _0575_/A tempo_t150n
XFILLER_15_347 VPWR VGND sg13g2_decap_8
XFILLER_27_185 VPWR VGND sg13g2_decap_8
XFILLER_7_557 VPWR VGND sg13g2_decap_8
XFILLER_30_339 VPWR VGND sg13g2_decap_8
XFILLER_23_391 VPWR VGND sg13g2_decap_8
XFILLER_23_380 VPWR VGND sg13g2_fill_1
XFILLER_18_185 VPWR VGND sg13g2_decap_8
XFILLER_21_306 VPWR VGND sg13g2_decap_8
X_0904_ _0904_/Q clkload2/A _0904_/D rebuffer129/X VPWR VGND sg13g2_dfrbpq_1
X_0835_ _0836_/B _0839_/C _0837_/C VPWR VGND sg13g2_nor2_1
X_0766_ _0766_/Y _0896_/Q _0769_/B _0897_/Q VPWR VGND sg13g2_a21oi_1
X_0697_ _0697_/Y _1015_/A VPWR VGND sg13g2_inv_1
XFILLER_12_306 VPWR VGND sg13g2_decap_8
XFILLER_24_100 VPWR VGND sg13g2_decap_8
XFILLER_15_100 VPWR VGND sg13g2_decap_8
XFILLER_28_450 VPWR VGND sg13g2_decap_8
X_0620_ _0881_/B _0623_/B _0965_/Q VPWR VGND sg13g2_nor2b_2
X_0551_ _0778_/A _0675_/A VPWR VGND sg13g2_inv_4
XFILLER_7_79 VPWR VGND sg13g2_decap_8
XFILLER_7_398 VPWR VGND sg13g2_decap_8
XFILLER_7_365 VPWR VGND sg13g2_decap_8
XFILLER_21_114 VPWR VGND sg13g2_decap_8
X_0818_ _0938_/D _0818_/A _0818_/B VPWR VGND sg13g2_nand2_1
X_0749_ _0749_/Y _0749_/A VPWR VGND sg13g2_inv_1
XFILLER_12_114 VPWR VGND sg13g2_decap_8
XFILLER_16_99 VPWR VGND sg13g2_decap_8
XFILLER_4_346 VPWR VGND sg13g2_decap_8
Xclk_lane.t_trail.tempo_65 clk_lane.t_trail.tempo/ARM VPWR VGND sg13g2_tielo
X_0603_ _0605_/C _0603_/A _0603_/B _0603_/C _0603_/D VPWR VGND sg13g2_nor4_2
X_1017_ _1017_/X _1017_/A VPWR VGND sg13g2_buf_1
XFILLER_22_445 VPWR VGND sg13g2_fill_2
XFILLER_22_412 VPWR VGND sg13g2_decap_8
XFILLER_17_228 VPWR VGND sg13g2_decap_8
XFILLER_27_32 VPWR VGND sg13g2_decap_8
XFILLER_13_412 VPWR VGND sg13g2_decap_8
XFILLER_13_489 VPWR VGND sg13g2_fill_1
XFILLER_9_438 VPWR VGND sg13g2_fill_2
XFILLER_9_405 VPWR VGND sg13g2_decap_8
XFILLER_25_294 VPWR VGND sg13g2_fill_2
XFILLER_4_198 VPWR VGND sg13g2_fill_1
XFILLER_4_154 VPWR VGND sg13g2_decap_8
Xlane0.t_lpx.tempo_68 lane0.t_lpx.tempo/ARM VPWR VGND sg13g2_tielo
XFILLER_27_526 VPWR VGND sg13g2_decap_8
XFILLER_10_426 VPWR VGND sg13g2_decap_8
Xfanout46 _0675_/C _0945_/Q VPWR VGND sg13g2_buf_8
Xfanout57 fanout57/X fanout58/X VPWR VGND sg13g2_buf_1
XFILLER_22_242 VPWR VGND sg13g2_decap_8
XFILLER_13_242 VPWR VGND sg13g2_decap_8
XFILLER_9_235 VPWR VGND sg13g2_decap_8
XFILLER_5_474 VPWR VGND sg13g2_decap_8
XFILLER_27_334 VPWR VGND sg13g2_decap_8
XFILLER_10_212 VPWR VGND sg13g2_fill_1
XFILLER_10_256 VPWR VGND sg13g2_decap_8
XFILLER_6_249 VPWR VGND sg13g2_decap_8
Xhold290 _0572_/A _0957_/Q VPWR VGND sg13g2_dlygate4sd3_1
XFILLER_18_301 VPWR VGND sg13g2_fill_2
XFILLER_18_334 VPWR VGND sg13g2_decap_8
X_0920_ _0920_/Q clkload7/A _0920_/D _1011_/A VPWR VGND sg13g2_dfrbpq_1
Xlane3.t_lpx.tempo_83 lane3.t_lpx.tempo/ARM VPWR VGND sg13g2_tielo
X_0851_ _0851_/X _0852_/A _0852_/B VPWR VGND sg13g2_and2_1
X_0782_ _1024_/A _0744_/Y _0782_/B VPWR VGND sg13g2_nand2b_1
Xinput3 input3/X tx_request_hs[0] VPWR VGND sg13g2_buf_1
XFILLER_24_348 VPWR VGND sg13g2_decap_8
Xclk_lane.t_lpx.tempo VPWR VGND _0771_/B clk_lane.t_lpx.tempo/ARM _0587_/Y fanout57/X
+ _0588_/B tempo_t80n
XFILLER_10_79 VPWR VGND sg13g2_decap_8
XFILLER_19_44 VPWR VGND sg13g2_fill_1
XFILLER_15_326 VPWR VGND sg13g2_decap_8
XFILLER_30_318 VPWR VGND sg13g2_decap_8
XFILLER_27_164 VPWR VGND sg13g2_decap_8
XFILLER_11_565 VPWR VGND sg13g2_decap_4
XFILLER_18_164 VPWR VGND sg13g2_decap_8
X_0903_ _0903_/Q _0937_/CLK _0903_/D _1012_/A VPWR VGND sg13g2_dfrbpq_1
X_0834_ _0837_/C _0843_/A _0843_/B _0843_/C VPWR VGND sg13g2_nor3_1
X_0765_ _0769_/B _0898_/Q _0897_/Q _0899_/Q VPWR VGND sg13g2_o21ai_1
X_0696_ _0696_/X _0696_/A _0713_/A VPWR VGND sg13g2_and2_2
XFILLER_24_178 VPWR VGND sg13g2_decap_8
XFILLER_4_506 VPWR VGND sg13g2_fill_2
XFILLER_11_384 VPWR VGND sg13g2_decap_8
XFILLER_15_178 VPWR VGND sg13g2_decap_8
X_0550_ _0550_/Y _0550_/A VPWR VGND sg13g2_inv_1
Xclk_lane.t_exit.tempo VPWR VGND _0770_/B clk_lane.t_exit.tempo/ARM _0590_/Y fanout58/X
+ _0591_/A tempo_t150n
X_0817_ _0818_/B _0819_/A hold175/X _0870_/A VPWR VGND sg13g2_a21oi_1
X_0748_ _0749_/A _0751_/A _0751_/B _0751_/C VPWR VGND sg13g2_nand3b_1
X_0679_ _0680_/A _0679_/A _0679_/B _0681_/C _0778_/B VPWR VGND sg13g2_and4_1
XFILLER_16_78 VPWR VGND sg13g2_decap_8
XFILLER_25_487 VPWR VGND sg13g2_fill_2
XFILLER_4_325 VPWR VGND sg13g2_decap_8
XFILLER_28_281 VPWR VGND sg13g2_fill_1
XFILLER_28_270 VPWR VGND sg13g2_decap_8
XFILLER_11_192 VPWR VGND sg13g2_decap_8
X_0602_ _0603_/D _0602_/A _0602_/B VPWR VGND sg13g2_nor2_2
XFILLER_7_185 VPWR VGND sg13g2_decap_8
XFILLER_3_391 VPWR VGND sg13g2_decap_8
XFILLER_19_270 VPWR VGND sg13g2_decap_8
X_1016_ _1016_/X _1016_/A VPWR VGND sg13g2_buf_1
XFILLER_27_11 VPWR VGND sg13g2_decap_8
XFILLER_27_88 VPWR VGND sg13g2_decap_8
XFILLER_4_100 VPWR VGND sg13g2_decap_8
XFILLER_10_405 VPWR VGND sg13g2_decap_8
XFILLER_13_79 VPWR VGND sg13g2_decap_8
Xfanout36 _0596_/A _0978_/Q VPWR VGND sg13g2_buf_8
Xfanout47 _0713_/A _0928_/Q VPWR VGND sg13g2_buf_8
Xfanout58 fanout58/X fanout60/X VPWR VGND sg13g2_buf_1
XFILLER_17_560 VPWR VGND sg13g2_decap_8
XFILLER_27_313 VPWR VGND sg13g2_decap_8
XFILLER_10_235 VPWR VGND sg13g2_decap_8
XFILLER_6_228 VPWR VGND sg13g2_decap_8
Xhold280 _0681_/D _0945_/Q VPWR VGND sg13g2_dlygate4sd3_1
XFILLER_18_313 VPWR VGND sg13g2_decap_8
XFILLER_18_379 VPWR VGND sg13g2_fill_1
XFILLER_1_49 VPWR VGND sg13g2_fill_1
X_0850_ _0850_/X _0850_/A _0852_/B VPWR VGND sg13g2_and2_1
X_0781_ _1007_/A _0781_/A _0781_/B VPWR VGND sg13g2_xnor2_1
XFILLER_5_261 VPWR VGND sg13g2_decap_8
Xinput4 input4/X tx_request_hs[1] VPWR VGND sg13g2_buf_1
XFILLER_24_327 VPWR VGND sg13g2_decap_8
XFILLER_15_305 VPWR VGND sg13g2_decap_8
X_0902_ _0902_/Q clkload7/A _0902_/D _1012_/A VPWR VGND sg13g2_dfrbpq_1
X_0833_ _0839_/C _0833_/A _0833_/B VPWR VGND sg13g2_nand2_1
X_0764_ _0764_/X _0898_/Q _0764_/B VPWR VGND sg13g2_xor2_1
X_0695_ _0700_/A _0713_/C _0713_/B VPWR VGND sg13g2_nor2b_2
XFILLER_29_419 VPWR VGND sg13g2_decap_8
XFILLER_24_157 VPWR VGND sg13g2_decap_8
XFILLER_21_79 VPWR VGND sg13g2_decap_8
XFILLER_15_157 VPWR VGND sg13g2_decap_8
XFILLER_28_485 VPWR VGND sg13g2_decap_8
XFILLER_11_341 VPWR VGND sg13g2_decap_8
XFILLER_7_345 VPWR VGND sg13g2_fill_2
XFILLER_7_334 VPWR VGND sg13g2_decap_8
XFILLER_30_116 VPWR VGND sg13g2_decap_8
X_0816_ _0932_/D _0814_/A _0815_/A _0814_/B VPWR VGND sg13g2_a21o_1
X_0747_ _0747_/Y _0782_/B VPWR VGND sg13g2_inv_1
X_0678_ _0683_/A _0681_/A _0681_/C _0678_/C VPWR VGND sg13g2_nand3_1
XFILLER_29_249 VPWR VGND sg13g2_decap_8
XFILLER_4_359 VPWR VGND sg13g2_fill_1
XFILLER_4_304 VPWR VGND sg13g2_decap_8
XFILLER_0_554 VPWR VGND sg13g2_decap_8
XFILLER_0_565 VPWR VGND sg13g2_fill_2
XFILLER_16_433 VPWR VGND sg13g2_decap_8
XFILLER_11_171 VPWR VGND sg13g2_decap_8
X_0601_ _0601_/Y _0601_/A VPWR VGND sg13g2_inv_1
XFILLER_7_164 VPWR VGND sg13g2_decap_8
X_1015_ _1015_/X _1015_/A VPWR VGND sg13g2_buf_1
XFILLER_30_480 VPWR VGND sg13g2_decap_8
XFILLER_27_67 VPWR VGND sg13g2_decap_8
XFILLER_25_296 VPWR VGND sg13g2_fill_1
XFILLER_25_263 VPWR VGND sg13g2_decap_8
XFILLER_4_189 VPWR VGND sg13g2_decap_8
XFILLER_12_491 VPWR VGND sg13g2_decap_4
XFILLER_16_263 VPWR VGND sg13g2_decap_8
XFILLER_27_517 VPWR VGND sg13g2_decap_4
Xfanout37 _0772_/A _0978_/Q VPWR VGND sg13g2_buf_4
Xfanout48 _0860_/A hold274/X VPWR VGND sg13g2_buf_1
Xfanout59 fanout59/X fanout60/X VPWR VGND sg13g2_buf_1
XFILLER_24_509 VPWR VGND sg13g2_fill_1
XFILLER_27_369 VPWR VGND sg13g2_decap_8
Xlane2.t_prep.tempo VPWR VGND _0701_/A lane2.t_prep.tempo/ARM _0923_/Q fanout59/X
+ _0565_/A tempo_t60n
XFILLER_24_79 VPWR VGND sg13g2_decap_8
XFILLER_23_542 VPWR VGND sg13g2_decap_8
XFILLER_1_28 VPWR VGND sg13g2_decap_8
XFILLER_6_4 VPWR VGND sg13g2_decap_4
X_0780_ _1019_/A _1023_/A _0780_/B VPWR VGND sg13g2_nand2b_1
XFILLER_5_240 VPWR VGND sg13g2_decap_8
Xinput5 input5/X tx_request_hs[2] VPWR VGND sg13g2_buf_1
XFILLER_17_391 VPWR VGND sg13g2_decap_8
XFILLER_24_306 VPWR VGND sg13g2_decap_8
X_0978_ _0978_/Q _0978_/CLK _0978_/D _0890_/Y VPWR VGND sg13g2_dfrbpq_2
XFILLER_19_79 VPWR VGND sg13g2_decap_8
XFILLER_18_100 VPWR VGND sg13g2_decap_8
X_0901_ _0901_/Q _0941_/CLK _0901_/D _1012_/A VPWR VGND sg13g2_dfrbpq_1
X_0832_ _0832_/Y _0962_/Q _0832_/B VPWR VGND sg13g2_xnor2_1
X_0763_ _0764_/B _0899_/Q _0763_/B VPWR VGND sg13g2_nor2_1
X_0694_ _0781_/B _0713_/B _0713_/C VPWR VGND sg13g2_and2_1
XFILLER_24_114 VPWR VGND sg13g2_decap_8
XFILLER_24_136 VPWR VGND sg13g2_fill_1
XFILLER_21_14 VPWR VGND sg13g2_fill_2
XFILLER_15_114 VPWR VGND sg13g2_decap_8
XFILLER_28_464 VPWR VGND sg13g2_decap_8
XFILLER_11_320 VPWR VGND sg13g2_decap_8
XFILLER_7_313 VPWR VGND sg13g2_decap_8
XFILLER_7_27 VPWR VGND sg13g2_decap_4
Xclkbuf_4_9_0_clk clkload4/A clkbuf_0_clk/X VPWR VGND sg13g2_buf_8
XFILLER_19_442 VPWR VGND sg13g2_fill_2
XFILLER_19_453 VPWR VGND sg13g2_fill_2
X_0815_ _0931_/D _0815_/A _0815_/B VPWR VGND sg13g2_xnor2_1
X_0746_ _0782_/B _0746_/A _0908_/Q _0907_/Q VPWR VGND sg13g2_nand3_1
X_0677_ _0679_/A _0663_/Y _0569_/Y _1026_/A input4/X _0676_/Y VPWR VGND sg13g2_a221oi_1
XFILLER_29_228 VPWR VGND sg13g2_decap_8
XFILLER_29_217 VPWR VGND sg13g2_fill_2
XFILLER_25_412 VPWR VGND sg13g2_decap_8
XFILLER_0_533 VPWR VGND sg13g2_decap_8
XFILLER_16_412 VPWR VGND sg13g2_decap_8
XFILLER_11_150 VPWR VGND sg13g2_decap_8
XFILLER_28_294 VPWR VGND sg13g2_fill_2
X_0600_ _0602_/B _0785_/A _0600_/B _0772_/A VPWR VGND sg13g2_nand3b_1
Xlane2.t_prep.tempo_79 lane2.t_prep.tempo/ARM VPWR VGND sg13g2_tielo
XFILLER_19_294 VPWR VGND sg13g2_fill_2
X_1014_ _1014_/X _1014_/A VPWR VGND sg13g2_buf_1
XFILLER_22_426 VPWR VGND sg13g2_decap_8
X_0729_ _0916_/D _0729_/A _0729_/B VPWR VGND sg13g2_nor2_1
XFILLER_27_46 VPWR VGND sg13g2_decap_8
XFILLER_13_426 VPWR VGND sg13g2_decap_8
XFILLER_9_419 VPWR VGND sg13g2_decap_8
XFILLER_25_242 VPWR VGND sg13g2_decap_8
XFILLER_21_470 VPWR VGND sg13g2_fill_2
XFILLER_4_168 VPWR VGND sg13g2_decap_8
XFILLER_16_242 VPWR VGND sg13g2_decap_8
Xfanout38 _0589_/A _0977_/Q VPWR VGND sg13g2_buf_8
Xfanout49 _0713_/B _0927_/Q VPWR VGND sg13g2_buf_8
XFILLER_22_256 VPWR VGND sg13g2_decap_8
XFILLER_13_256 VPWR VGND sg13g2_decap_8
XFILLER_9_249 VPWR VGND sg13g2_decap_8
XFILLER_27_348 VPWR VGND sg13g2_decap_8
Xhold282 hold282/X _0875_/Y VPWR VGND sg13g2_dlygate4sd3_1
XFILLER_18_348 VPWR VGND sg13g2_decap_8
Xinput6 input6/X tx_request_hs[3] VPWR VGND sg13g2_buf_1
X_0977_ _0977_/Q _0977_/CLK _0977_/D _0889_/Y VPWR VGND sg13g2_dfrbpq_2
XFILLER_27_178 VPWR VGND sg13g2_decap_8
XFILLER_23_384 VPWR VGND sg13g2_decap_8
XFILLER_18_178 VPWR VGND sg13g2_decap_8
X_0900_ _0900_/Q clkload6/A _0900_/D _1012_/A VPWR VGND sg13g2_dfrbpq_1
X_0831_ _0963_/D _0831_/A _0832_/B VPWR VGND sg13g2_or2_1
X_0762_ _0762_/Y _0899_/Q _0762_/B VPWR VGND sg13g2_nand2b_1
X_0693_ _0933_/D hold237/X _0693_/B VPWR VGND sg13g2_nand2b_1
XFILLER_28_443 VPWR VGND sg13g2_decap_8
XFILLER_23_192 VPWR VGND sg13g2_decap_8
XFILLER_11_398 VPWR VGND sg13g2_decap_8
XFILLER_21_107 VPWR VGND sg13g2_decap_8
X_0814_ _0930_/D _0814_/A _0814_/B VPWR VGND sg13g2_xnor2_1
Xlane3.t_prep.tempo_84 lane3.t_prep.tempo/ARM VPWR VGND sg13g2_tielo
X_0745_ _1028_/A _0784_/A _0745_/B VPWR VGND sg13g2_nor2_2
X_0676_ _0676_/Y _0676_/A1 _0673_/A _0675_/X VPWR VGND sg13g2_o21ai_1
XFILLER_12_107 VPWR VGND sg13g2_decap_8
XFILLER_4_339 VPWR VGND sg13g2_decap_8
XFILLER_7_100 VPWR VGND sg13g2_decap_8
X_1013_ _1013_/X _1013_/A VPWR VGND sg13g2_buf_1
XFILLER_22_405 VPWR VGND sg13g2_decap_8
X_0728_ _0728_/Y _0915_/Q _0731_/B _0916_/Q VPWR VGND sg13g2_a21oi_1
X_0659_ _0659_/Y _1014_/A VPWR VGND sg13g2_inv_1
XFILLER_27_25 VPWR VGND sg13g2_decap_8
XFILLER_13_405 VPWR VGND sg13g2_decap_8
Xclkbuf_4_8_0_clk _0970_/CLK clkbuf_0_clk/X VPWR VGND sg13g2_buf_8
XFILLER_4_114 VPWR VGND sg13g2_decap_4
XFILLER_29_560 VPWR VGND sg13g2_decap_8
XFILLER_10_419 VPWR VGND sg13g2_decap_8
Xfanout39 _0585_/B _0976_/Q VPWR VGND sg13g2_buf_8
XFILLER_22_235 VPWR VGND sg13g2_decap_8
XFILLER_13_235 VPWR VGND sg13g2_decap_8
XFILLER_9_228 VPWR VGND sg13g2_decap_8
XFILLER_9_217 VPWR VGND sg13g2_fill_2
XFILLER_5_412 VPWR VGND sg13g2_decap_8
XFILLER_5_467 VPWR VGND sg13g2_decap_8
XFILLER_27_327 VPWR VGND sg13g2_decap_8
XFILLER_10_249 VPWR VGND sg13g2_decap_8
Xhold250 _0556_/A _0751_/B VPWR VGND sg13g2_dlygate4sd3_1
Xhold261 _0718_/A _0781_/A VPWR VGND sg13g2_dlygate4sd3_1
Xhold272 _0680_/B _0778_/A VPWR VGND sg13g2_dlygate4sd3_1
Xhold283 _0874_/A _0876_/A VPWR VGND sg13g2_dlygate4sd3_1
XFILLER_18_327 VPWR VGND sg13g2_decap_8
X_0976_ _0976_/Q _0977_/CLK _0976_/D _0888_/Y VPWR VGND sg13g2_dfrbpq_2
XFILLER_27_102 VPWR VGND sg13g2_decap_8
XFILLER_15_319 VPWR VGND sg13g2_decap_8
XFILLER_27_157 VPWR VGND sg13g2_decap_8
XFILLER_23_341 VPWR VGND sg13g2_decap_8
XFILLER_11_558 VPWR VGND sg13g2_decap_8
XFILLER_11_569 VPWR VGND sg13g2_fill_2
Xclk_lane.t_prep.tempo_64 clk_lane.t_prep.tempo/ARM VPWR VGND sg13g2_tielo
XFILLER_18_157 VPWR VGND sg13g2_decap_8
X_0830_ _0961_/D _0832_/B _0830_/B VPWR VGND sg13g2_or2_1
X_0761_ _0762_/B _0898_/Q _0897_/Q _0896_/Q VPWR VGND sg13g2_nand3_1
X_0692_ _0934_/D _0692_/A _0693_/B VPWR VGND sg13g2_xor2_1
XFILLER_21_16 VPWR VGND sg13g2_fill_1
X_0959_ _0959_/Q clkload5/A _0959_/D _1009_/A VPWR VGND sg13g2_dfrbpq_1
XFILLER_28_499 VPWR VGND sg13g2_decap_8
XFILLER_28_422 VPWR VGND sg13g2_decap_8
XFILLER_23_171 VPWR VGND sg13g2_decap_8
XFILLER_11_93 VPWR VGND sg13g2_decap_8
X_0813_ _0815_/B _0814_/B _0814_/A VPWR VGND sg13g2_nand2b_1
X_0744_ _0744_/Y _0751_/A _0751_/B _0907_/Q VPWR VGND sg13g2_nor3_1
X_0675_ _0675_/X _0675_/A _0675_/B _0675_/C input4/X VPWR VGND sg13g2_or4_1
XFILLER_4_318 VPWR VGND sg13g2_decap_8
Xlane3.t_trail.tempo_85 lane3.t_trail.tempo/ARM VPWR VGND sg13g2_tielo
XFILLER_28_296 VPWR VGND sg13g2_fill_1
XFILLER_28_263 VPWR VGND sg13g2_decap_8
XFILLER_11_185 VPWR VGND sg13g2_decap_8
XFILLER_7_178 VPWR VGND sg13g2_decap_8
XFILLER_3_384 VPWR VGND sg13g2_decap_8
XFILLER_19_263 VPWR VGND sg13g2_decap_8
X_1012_ _1012_/X _1012_/A VPWR VGND sg13g2_buf_1
X_0727_ _0731_/B _0917_/Q _0916_/Q _0918_/Q VPWR VGND sg13g2_o21ai_1
XFILLER_30_494 VPWR VGND sg13g2_decap_8
X_0658_ _1014_/A _0662_/A _0675_/A VPWR VGND sg13g2_and2_2
X_0589_ _0591_/B _0589_/A _0772_/A _0600_/B VPWR VGND sg13g2_nand3_1
XFILLER_3_192 VPWR VGND sg13g2_decap_8
XFILLER_17_553 VPWR VGND sg13g2_fill_2
XFILLER_29_391 VPWR VGND sg13g2_decap_8
XFILLER_28_91 VPWR VGND sg13g2_decap_8
Xclkbuf_4_7_0_clk clkload3/A clkbuf_0_clk/X VPWR VGND sg13g2_buf_8
XFILLER_27_306 VPWR VGND sg13g2_decap_8
XFILLER_24_27 VPWR VGND sg13g2_fill_1
XFILLER_10_228 VPWR VGND sg13g2_decap_8
XFILLER_23_567 VPWR VGND sg13g2_decap_4
Xhold251 _0554_/A _0713_/B VPWR VGND sg13g2_dlygate4sd3_1
Xhold273 _0887_/A _0772_/A VPWR VGND sg13g2_dlygate4sd3_1
Xhold284 _0850_/A _0746_/A VPWR VGND sg13g2_dlygate4sd3_1
XFILLER_18_306 VPWR VGND sg13g2_decap_8
XFILLER_5_254 VPWR VGND sg13g2_decap_8
XFILLER_30_81 VPWR VGND sg13g2_decap_8
X_0975_ _0975_/Q _0975_/CLK _0975_/D _0601_/Y VPWR VGND sg13g2_dfrbpq_1
XFILLER_9_560 VPWR VGND sg13g2_fill_2
XFILLER_23_320 VPWR VGND sg13g2_decap_8
XFILLER_7_519 VPWR VGND sg13g2_fill_1
XFILLER_18_114 VPWR VGND sg13g2_decap_8
X_0760_ _0763_/B _0897_/Q _0896_/Q VPWR VGND sg13g2_nand2_1
X_0691_ _0935_/D _0691_/A _0691_/B VPWR VGND sg13g2_nor2_1
X_0958_ _0958_/Q clkload5/A _0958_/D _1009_/A VPWR VGND sg13g2_dfrbpq_1
X_0889_ _0889_/Y _0890_/A VPWR VGND sg13g2_inv_1
XFILLER_28_478 VPWR VGND sg13g2_decap_8
XFILLER_28_401 VPWR VGND sg13g2_decap_8
XFILLER_11_334 VPWR VGND sg13g2_decap_8
XFILLER_7_327 VPWR VGND sg13g2_decap_8
XFILLER_30_109 VPWR VGND sg13g2_decap_8
XFILLER_23_150 VPWR VGND sg13g2_decap_8
XFILLER_11_72 VPWR VGND sg13g2_decap_8
XFILLER_19_412 VPWR VGND sg13g2_decap_8
X_0812_ _0929_/D _0814_/B _0812_/B VPWR VGND sg13g2_or2_1
X_0743_ _0743_/Y _0751_/A _0743_/B _0745_/B VPWR VGND sg13g2_nor3_1
X_0674_ _0681_/C _0570_/Y _0671_/Y _0667_/Y VPWR VGND sg13g2_a21oi_1
XFILLER_28_0 VPWR VGND sg13g2_decap_8
XFILLER_25_426 VPWR VGND sg13g2_decap_8
XFILLER_0_547 VPWR VGND sg13g2_decap_8
XFILLER_16_426 VPWR VGND sg13g2_decap_8
XFILLER_28_242 VPWR VGND sg13g2_decap_8
XFILLER_11_164 VPWR VGND sg13g2_decap_8
XFILLER_7_157 VPWR VGND sg13g2_decap_8
XFILLER_22_93 VPWR VGND sg13g2_decap_8
XFILLER_3_341 VPWR VGND sg13g2_decap_8
XFILLER_19_242 VPWR VGND sg13g2_decap_8
X_1011_ _1011_/X _1011_/A VPWR VGND sg13g2_buf_1
XFILLER_21_7 VPWR VGND sg13g2_decap_8
XFILLER_30_473 VPWR VGND sg13g2_decap_8
X_0726_ _0726_/X _0917_/Q _0726_/B VPWR VGND sg13g2_xor2_1
X_0657_ _0662_/A _0675_/C fanout45/X VPWR VGND sg13g2_nor2b_2
X_0588_ _0603_/B _0596_/A _0588_/B _0588_/C VPWR VGND sg13g2_nor3_1
XFILLER_25_256 VPWR VGND sg13g2_decap_8
XFILLER_16_256 VPWR VGND sg13g2_decap_8
XFILLER_17_93 VPWR VGND sg13g2_decap_8
XFILLER_3_171 VPWR VGND sg13g2_decap_8
X_0709_ _0709_/Y _0779_/B VPWR VGND sg13g2_inv_1
XFILLER_9_219 VPWR VGND sg13g2_fill_1
XFILLER_28_70 VPWR VGND sg13g2_decap_8
XFILLER_12_270 VPWR VGND sg13g2_decap_8
XFILLER_23_535 VPWR VGND sg13g2_decap_8
Xhold230 _0812_/B _0929_/Q VPWR VGND sg13g2_dlygate4sd3_1
Xhold241 _0655_/B _0948_/Q VPWR VGND sg13g2_dlygate4sd3_1
Xhold252 hold252/X _0964_/Q VPWR VGND sg13g2_dlygate4sd3_1
Xhold263 _0756_/A _0784_/A VPWR VGND sg13g2_dlygate4sd3_1
Xhold274 hold274/X _0928_/Q VPWR VGND sg13g2_dlygate4sd3_1
Xhold285 _0605_/D _0589_/A VPWR VGND sg13g2_dlygate4sd3_1
XFILLER_5_233 VPWR VGND sg13g2_decap_8
XFILLER_30_60 VPWR VGND sg13g2_decap_8
XFILLER_17_373 VPWR VGND sg13g2_fill_2
XFILLER_17_384 VPWR VGND sg13g2_decap_8
X_0974_ _0974_/Q _0975_/CLK _0974_/D _0601_/Y VPWR VGND sg13g2_dfrbpq_1
XFILLER_23_398 VPWR VGND sg13g2_decap_8
Xclk_lane.t_trail.tempo VPWR VGND _0599_/B clk_lane.t_trail.tempo/ARM _0598_/Y fanout58/X
+ _0599_/A tempo_t80n
Xclkbuf_4_6_0_clk _0928_/CLK clkbuf_0_clk/X VPWR VGND sg13g2_buf_8
X_0690_ _0691_/B _0692_/A _0693_/B _0685_/B VPWR VGND sg13g2_a21oi_1
XFILLER_25_93 VPWR VGND sg13g2_decap_8
XFILLER_6_564 VPWR VGND sg13g2_fill_1
XFILLER_24_107 VPWR VGND sg13g2_decap_8
XFILLER_17_192 VPWR VGND sg13g2_decap_8
X_0957_ _0957_/Q clkload4/A _0957_/D _1009_/A VPWR VGND sg13g2_dfrbpq_1
X_0888_ _0888_/Y _0890_/A VPWR VGND sg13g2_inv_1
XFILLER_9_391 VPWR VGND sg13g2_decap_8
XFILLER_15_107 VPWR VGND sg13g2_decap_8
XFILLER_28_457 VPWR VGND sg13g2_decap_8
XFILLER_11_313 VPWR VGND sg13g2_decap_8
XFILLER_7_306 VPWR VGND sg13g2_decap_8
X_0811_ _0811_/Y _0811_/A _0925_/Q VPWR VGND sg13g2_xnor2_1
X_0742_ _0742_/Y _0783_/B VPWR VGND sg13g2_inv_1
X_0673_ _0673_/Y _0673_/A VPWR VGND sg13g2_inv_1
Xlane1.t_exit.tempo VPWR VGND _0776_/B lane1.t_exit.tempo/ARM _0671_/Y fanout58/X
+ _0570_/A tempo_t150n
XFILLER_25_405 VPWR VGND sg13g2_decap_8
XFILLER_0_526 VPWR VGND sg13g2_decap_8
XFILLER_16_405 VPWR VGND sg13g2_decap_8
XFILLER_28_287 VPWR VGND sg13g2_fill_1
XFILLER_7_114 VPWR VGND sg13g2_decap_4
XFILLER_3_320 VPWR VGND sg13g2_decap_8
XFILLER_22_72 VPWR VGND sg13g2_decap_8
X_1010_ _1010_/X _1010_/A VPWR VGND sg13g2_buf_1
XFILLER_30_452 VPWR VGND sg13g2_decap_8
XFILLER_22_419 VPWR VGND sg13g2_decap_8
X_0725_ _0726_/B _0918_/Q _0725_/B VPWR VGND sg13g2_nor2_1
X_0656_ _0778_/B _0656_/A _0675_/C VPWR VGND sg13g2_and2_1
X_0587_ _0587_/Y _0771_/B VPWR VGND sg13g2_inv_1
XFILLER_27_39 VPWR VGND sg13g2_decap_8
XFILLER_13_419 VPWR VGND sg13g2_decap_8
XFILLER_25_235 VPWR VGND sg13g2_decap_8
XFILLER_16_235 VPWR VGND sg13g2_decap_8
XFILLER_17_72 VPWR VGND sg13g2_decap_8
XFILLER_3_150 VPWR VGND sg13g2_decap_8
XFILLER_22_249 VPWR VGND sg13g2_decap_8
XFILLER_30_271 VPWR VGND sg13g2_decap_4
X_0708_ _0779_/B _0713_/A _0708_/B _0926_/Q VPWR VGND sg13g2_nand3_1
X_0639_ _0965_/D _0638_/Y _0550_/Y _0637_/B VPWR VGND sg13g2_a21oi_1
XFILLER_13_249 VPWR VGND sg13g2_decap_8
XFILLER_5_426 VPWR VGND sg13g2_decap_8
XFILLER_17_555 VPWR VGND sg13g2_fill_1
XFILLER_4_481 VPWR VGND sg13g2_decap_8
Xhold220 _0833_/B _0975_/Q VPWR VGND sg13g2_dlygate4sd3_1
Xhold242 _0801_/B _0913_/Q VPWR VGND sg13g2_dlygate4sd3_1
Xhold253 _0833_/A _0974_/Q VPWR VGND sg13g2_dlygate4sd3_1
Xhold264 _0607_/A _0585_/B VPWR VGND sg13g2_dlygate4sd3_1
Xlane0.t_exit.tempo_67 lane0.t_exit.tempo/ARM VPWR VGND sg13g2_tielo
XFILLER_17_341 VPWR VGND sg13g2_decap_8
X_0973_ _0973_/Q _0975_/CLK _0973_/D _0601_/Y VPWR VGND sg13g2_dfrbpq_1
XFILLER_9_562 VPWR VGND sg13g2_fill_1
XFILLER_27_116 VPWR VGND sg13g2_decap_8
XFILLER_23_300 VPWR VGND sg13g2_fill_1
Xrebuffer90 _1010_/A _0660_/Y VPWR VGND sg13g2_buf_1
XFILLER_25_72 VPWR VGND sg13g2_decap_8
XFILLER_17_171 VPWR VGND sg13g2_decap_8
X_0956_ _0956_/Q clkload4/A _0956_/D _0881_/X VPWR VGND sg13g2_dfrbpq_1
X_0887_ _0887_/Y _0887_/A _0887_/B VPWR VGND sg13g2_nor2_1
XFILLER_28_436 VPWR VGND sg13g2_decap_8
XFILLER_23_185 VPWR VGND sg13g2_decap_8
X_0810_ _0925_/D _0811_/A _0810_/B VPWR VGND sg13g2_or2_1
XFILLER_10_391 VPWR VGND sg13g2_decap_8
X_0741_ _0783_/B _0745_/B _0784_/A VPWR VGND sg13g2_nand2b_1
X_0672_ _0673_/A _0675_/A _0675_/B _0675_/C VPWR VGND sg13g2_nand3b_1
X_0939_ _0939_/Q _0941_/CLK _0939_/D _1010_/A VPWR VGND sg13g2_dfrbpq_1
Xclkbuf_4_5_0_clk clkload2/A clkbuf_0_clk/X VPWR VGND sg13g2_buf_8
XFILLER_11_100 VPWR VGND sg13g2_decap_8
XFILLER_3_398 VPWR VGND sg13g2_decap_8
XFILLER_30_431 VPWR VGND sg13g2_decap_8
X_0724_ _0724_/Y _0918_/Q _0724_/B VPWR VGND sg13g2_nand2b_1
X_0655_ _0948_/D _0655_/A _0655_/B VPWR VGND sg13g2_or2_1
X_0586_ _0771_/B _0596_/A _0588_/C VPWR VGND sg13g2_or2_1
XFILLER_6_192 VPWR VGND sg13g2_decap_8
XFILLER_27_18 VPWR VGND sg13g2_decap_8
XFILLER_4_118 VPWR VGND sg13g2_fill_2
XFILLER_4_107 VPWR VGND sg13g2_decap_8
XFILLER_29_553 VPWR VGND sg13g2_decap_8
XFILLER_22_228 VPWR VGND sg13g2_decap_8
X_0707_ _1027_/A _0781_/A _0707_/B VPWR VGND sg13g2_nor2_1
XFILLER_30_250 VPWR VGND sg13g2_decap_8
X_0638_ _0638_/Y _0640_/B _0638_/B _0638_/C _0638_/D VPWR VGND sg13g2_nand4_1
X_0569_ _0569_/Y _0569_/A VPWR VGND sg13g2_inv_1
XFILLER_13_217 VPWR VGND sg13g2_fill_2
XFILLER_13_228 VPWR VGND sg13g2_decap_8
XFILLER_21_261 VPWR VGND sg13g2_decap_8
Xlane3.t_trail.tempo VPWR VGND _0735_/Y lane3.t_trail.tempo/ARM _0895_/Q fanout60/X
+ _0559_/A tempo_t80n
XFILLER_5_405 VPWR VGND sg13g2_decap_8
Xlane1.t_exit.tempo_72 lane1.t_exit.tempo/ARM VPWR VGND sg13g2_tielo
Xhold210 _0641_/A _0954_/Q VPWR VGND sg13g2_dlygate4sd3_1
Xhold221 _0649_/A _0953_/Q VPWR VGND sg13g2_dlygate4sd3_1
Xhold232 _0918_/D _0724_/Y VPWR VGND sg13g2_dlygate4sd3_1
Xhold243 _0843_/A _0971_/Q VPWR VGND sg13g2_dlygate4sd3_1
Xhold276 hold276/X _0876_/Y VPWR VGND sg13g2_dlygate4sd3_1
Xhold287 _0767_/A _0764_/B VPWR VGND sg13g2_dlygate4sd3_1
XFILLER_5_268 VPWR VGND sg13g2_fill_1
XFILLER_30_95 VPWR VGND sg13g2_decap_8
XFILLER_17_320 VPWR VGND sg13g2_decap_8
XFILLER_17_375 VPWR VGND sg13g2_fill_1
X_0972_ _0972_/Q _0975_/CLK _0972_/D _0601_/Y VPWR VGND sg13g2_dfrbpq_1
XFILLER_23_334 VPWR VGND sg13g2_decap_8
Xrebuffer91 _0869_/B _0662_/A VPWR VGND sg13g2_buf_1
XFILLER_17_150 VPWR VGND sg13g2_decap_8
X_0955_ _0955_/Q clkload4/A _0955_/D _0880_/X VPWR VGND sg13g2_dfrbpq_1
X_0886_ _0886_/Y _0887_/A _0887_/B VPWR VGND sg13g2_nor2_1
XFILLER_28_415 VPWR VGND sg13g2_decap_8
XFILLER_11_348 VPWR VGND sg13g2_decap_8
XFILLER_23_164 VPWR VGND sg13g2_decap_8
XFILLER_11_86 VPWR VGND sg13g2_decap_8
XFILLER_19_426 VPWR VGND sg13g2_decap_8
XFILLER_27_481 VPWR VGND sg13g2_fill_2
X_0740_ _0745_/B _0751_/B _0751_/C VPWR VGND sg13g2_nand2b_1
X_0671_ _0671_/Y _0776_/B VPWR VGND sg13g2_inv_1
XFILLER_6_396 VPWR VGND sg13g2_decap_8
XFILLER_6_374 VPWR VGND sg13g2_decap_4
XFILLER_6_341 VPWR VGND sg13g2_decap_8
X_0938_ _0938_/Q _0941_/CLK _0938_/D _1010_/A VPWR VGND sg13g2_dfrbpq_1
X_0869_ _0869_/X _0869_/A _0869_/B VPWR VGND sg13g2_and2_1
XFILLER_28_256 VPWR VGND sg13g2_decap_8
XFILLER_28_223 VPWR VGND sg13g2_fill_1
XFILLER_11_178 VPWR VGND sg13g2_decap_8
XFILLER_19_256 VPWR VGND sg13g2_decap_8
XFILLER_30_410 VPWR VGND sg13g2_decap_8
X_0723_ _0724_/B _0917_/Q _0916_/Q _0915_/Q VPWR VGND sg13g2_nand3_1
XFILLER_6_171 VPWR VGND sg13g2_decap_8
XFILLER_30_487 VPWR VGND sg13g2_decap_8
X_0654_ _0949_/D _0655_/A _0654_/B VPWR VGND sg13g2_xnor2_1
X_0585_ _0588_/C _0589_/A _0585_/B VPWR VGND sg13g2_nand2b_1
XFILLER_29_532 VPWR VGND sg13g2_decap_8
XFILLER_24_270 VPWR VGND sg13g2_decap_8
XFILLER_12_432 VPWR VGND sg13g2_fill_1
XFILLER_3_185 VPWR VGND sg13g2_decap_8
XFILLER_15_270 VPWR VGND sg13g2_decap_8
Xclkbuf_4_4_0_clk _0925_/CLK clkbuf_0_clk/X VPWR VGND sg13g2_buf_8
X_0706_ _0706_/Y _0713_/A _0713_/B _0926_/Q VPWR VGND sg13g2_nor3_1
X_0637_ _0966_/D _0874_/A _0637_/B VPWR VGND sg13g2_xor2_1
X_0568_ _0568_/Y _0938_/Q VPWR VGND sg13g2_inv_1
XFILLER_21_240 VPWR VGND sg13g2_decap_8
XFILLER_29_384 VPWR VGND sg13g2_decap_8
XFILLER_29_362 VPWR VGND sg13g2_decap_8
XFILLER_28_84 VPWR VGND sg13g2_decap_8
XFILLER_5_44 VPWR VGND sg13g2_fill_1
XFILLER_23_549 VPWR VGND sg13g2_decap_8
Xhold211 _0801_/A _0911_/Q VPWR VGND sg13g2_dlygate4sd3_1
Xhold233 _0645_/A _0955_/Q VPWR VGND sg13g2_dlygate4sd3_1
Xhold244 _0550_/A _0965_/Q VPWR VGND sg13g2_dlygate4sd3_1
Xhold255 _0683_/B _0675_/C VPWR VGND sg13g2_dlygate4sd3_1
Xhold266 _0856_/A _0713_/A VPWR VGND sg13g2_dlygate4sd3_1
Xhold288 _0729_/A _0726_/B VPWR VGND sg13g2_dlygate4sd3_1
Xlane3.t_zero.tempo_86 lane3.t_zero.tempo/ARM VPWR VGND sg13g2_tielo
XFILLER_5_247 VPWR VGND sg13g2_decap_8
XFILLER_30_74 VPWR VGND sg13g2_decap_8
XFILLER_17_398 VPWR VGND sg13g2_decap_8
XFILLER_29_192 VPWR VGND sg13g2_decap_8
XFILLER_13_560 VPWR VGND sg13g2_fill_2
X_0971_ _0971_/Q _0975_/CLK _0971_/D _0601_/Y VPWR VGND sg13g2_dfrbpq_1
XFILLER_23_313 VPWR VGND sg13g2_decap_8
XFILLER_18_107 VPWR VGND sg13g2_decap_8
Xrebuffer92 _1012_/A _0736_/Y VPWR VGND sg13g2_buf_1
X_0954_ _0954_/Q clkload4/A _0954_/D _0879_/X VPWR VGND sg13g2_dfrbpq_1
X_0885_ _0885_/Y _0890_/A VPWR VGND sg13g2_inv_1
Xlane3.t_prep.tempo VPWR VGND _0739_/A lane3.t_prep.tempo/ARM _0904_/Q fanout59/X
+ _0561_/A tempo_t60n
XFILLER_11_327 VPWR VGND sg13g2_decap_8
XFILLER_23_143 VPWR VGND sg13g2_decap_8
XFILLER_23_132 VPWR VGND sg13g2_fill_2
XFILLER_23_121 VPWR VGND sg13g2_decap_8
XFILLER_3_504 VPWR VGND sg13g2_decap_8
XFILLER_19_405 VPWR VGND sg13g2_decap_8
XFILLER_27_460 VPWR VGND sg13g2_decap_8
X_0670_ _0776_/B _0675_/A _0670_/B _0945_/Q VPWR VGND sg13g2_nand3_1
XFILLER_6_320 VPWR VGND sg13g2_decap_8
XFILLER_25_419 VPWR VGND sg13g2_decap_8
X_0937_ _0937_/Q _0937_/CLK _0937_/D _0869_/X VPWR VGND sg13g2_dfrbpq_1
X_0868_ _0868_/X _0869_/A _0869_/B VPWR VGND sg13g2_and2_1
X_0799_ _0910_/D _0801_/B _0799_/B VPWR VGND sg13g2_or2_1
XFILLER_16_419 VPWR VGND sg13g2_decap_8
XFILLER_28_235 VPWR VGND sg13g2_decap_8
XFILLER_11_157 VPWR VGND sg13g2_decap_8
XFILLER_3_334 VPWR VGND sg13g2_decap_8
XFILLER_22_86 VPWR VGND sg13g2_decap_8
XFILLER_19_235 VPWR VGND sg13g2_decap_8
XFILLER_15_463 VPWR VGND sg13g2_fill_2
X_0722_ _0725_/B _0916_/Q _0915_/Q VPWR VGND sg13g2_nand2_1
X_0653_ _0653_/Y _0653_/A _0653_/B VPWR VGND sg13g2_xnor2_1
XFILLER_6_150 VPWR VGND sg13g2_decap_8
XFILLER_30_466 VPWR VGND sg13g2_decap_8
X_0584_ _0604_/A _0596_/A _0584_/B _0584_/C VPWR VGND sg13g2_nor3_1
XFILLER_25_249 VPWR VGND sg13g2_decap_8
XFILLER_17_31 VPWR VGND sg13g2_decap_4
XFILLER_29_511 VPWR VGND sg13g2_decap_8
XFILLER_12_411 VPWR VGND sg13g2_decap_8
XFILLER_16_249 VPWR VGND sg13g2_decap_8
XFILLER_17_86 VPWR VGND sg13g2_decap_8
XFILLER_3_120 VPWR VGND sg13g2_fill_1
Xclk_lane.t_zero.tempo_66 clk_lane.t_zero.tempo/ARM VPWR VGND sg13g2_tielo
XFILLER_3_164 VPWR VGND sg13g2_decap_8
X_0705_ _0705_/Y _0713_/A _0705_/B _0707_/B VPWR VGND sg13g2_nor3_1
X_0636_ _0637_/B _0636_/A _0636_/B _0636_/C _0775_/B VPWR VGND sg13g2_and4_1
X_0567_ _0567_/Y _0567_/A VPWR VGND sg13g2_inv_1
XFILLER_29_341 VPWR VGND sg13g2_decap_8
XFILLER_28_63 VPWR VGND sg13g2_decap_8
XFILLER_12_263 VPWR VGND sg13g2_decap_8
XFILLER_4_495 VPWR VGND sg13g2_decap_8
Xhold201 _0917_/D _0726_/X VPWR VGND sg13g2_dlygate4sd3_1
Xhold223 _0767_/B _0766_/Y VPWR VGND sg13g2_dlygate4sd3_1
Xhold234 _0836_/A _0970_/Q VPWR VGND sg13g2_dlygate4sd3_1
Xhold256 _0759_/A _0751_/C VPWR VGND sg13g2_dlygate4sd3_1
Xhold267 _0852_/A _0751_/A VPWR VGND sg13g2_dlygate4sd3_1
Xhold278 _0869_/A hold278/A VPWR VGND sg13g2_dlygate4sd3_1
Xhold289 _0552_/A _0656_/A VPWR VGND sg13g2_dlygate4sd3_1
X_0619_ _0636_/B _0616_/Y _0574_/Y _0618_/Y _0575_/Y VPWR VGND sg13g2_a22oi_1
XFILLER_5_226 VPWR VGND sg13g2_decap_8
XFILLER_30_53 VPWR VGND sg13g2_decap_8
Xclkbuf_4_3_0_clk clkload1/A clkbuf_0_clk/X VPWR VGND sg13g2_buf_8
XFILLER_29_171 VPWR VGND sg13g2_decap_8
XFILLER_13_550 VPWR VGND sg13g2_fill_2
X_0970_ _0970_/Q _0970_/CLK _0970_/D _0601_/Y VPWR VGND sg13g2_dfrbpq_1
Xrebuffer93 _0860_/B _0696_/A VPWR VGND sg13g2_buf_1
XFILLER_10_564 VPWR VGND sg13g2_decap_8
XFILLER_25_86 VPWR VGND sg13g2_decap_8
XFILLER_22_391 VPWR VGND sg13g2_decap_8
XFILLER_17_185 VPWR VGND sg13g2_decap_8
XFILLER_13_391 VPWR VGND sg13g2_decap_8
X_0953_ _0953_/Q clkload4/A _0953_/D _0878_/X VPWR VGND sg13g2_dfrbpq_1
X_0884_ _0884_/Y _0890_/A VPWR VGND sg13g2_inv_1
XFILLER_9_384 VPWR VGND sg13g2_decap_8
XFILLER_23_100 VPWR VGND sg13g2_decap_8
XFILLER_11_306 VPWR VGND sg13g2_decap_8
XFILLER_3_516 VPWR VGND sg13g2_fill_1
XFILLER_27_483 VPWR VGND sg13g2_fill_1
XFILLER_10_372 VPWR VGND sg13g2_decap_8
X_0936_ _0936_/Q _0941_/CLK _0936_/D _0868_/X VPWR VGND sg13g2_dfrbpq_1
X_0867_ _0867_/X _0869_/A _0869_/B VPWR VGND sg13g2_and2_1
X_0798_ _0798_/Y _0798_/A _0906_/Q VPWR VGND sg13g2_xnor2_1
XFILLER_9_192 VPWR VGND sg13g2_decap_8
XFILLER_28_203 VPWR VGND sg13g2_fill_1
XFILLER_11_114 VPWR VGND sg13g2_decap_8
XFILLER_7_107 VPWR VGND sg13g2_decap_8
XFILLER_3_313 VPWR VGND sg13g2_decap_8
XFILLER_30_445 VPWR VGND sg13g2_decap_8
X_0721_ _0926_/D _0721_/A _0721_/B VPWR VGND sg13g2_xnor2_1
X_0652_ _0653_/B _0951_/Q _0949_/Q VPWR VGND sg13g2_nand2b_1
X_0583_ _0583_/Y _0583_/A VPWR VGND sg13g2_inv_1
XFILLER_25_228 VPWR VGND sg13g2_decap_8
XFILLER_25_217 VPWR VGND sg13g2_decap_8
XFILLER_21_412 VPWR VGND sg13g2_decap_8
X_0919_ _0919_/Q _0937_/CLK _0919_/D _1011_/A VPWR VGND sg13g2_dfrbpq_1
XFILLER_16_206 VPWR VGND sg13g2_fill_2
XFILLER_16_228 VPWR VGND sg13g2_decap_8
XFILLER_29_567 VPWR VGND sg13g2_decap_4
XFILLER_30_275 VPWR VGND sg13g2_fill_2
XFILLER_30_264 VPWR VGND sg13g2_decap_8
X_0704_ _0704_/Y _0780_/B VPWR VGND sg13g2_inv_1
X_0635_ _0640_/A _0638_/D _0638_/C _0638_/B VPWR VGND sg13g2_nand3_1
X_0566_ _0566_/Y _0566_/A VPWR VGND sg13g2_inv_1
XFILLER_21_275 VPWR VGND sg13g2_fill_2
XFILLER_5_419 VPWR VGND sg13g2_decap_8
XFILLER_29_320 VPWR VGND sg13g2_decap_8
XFILLER_28_42 VPWR VGND sg13g2_decap_8
XFILLER_12_242 VPWR VGND sg13g2_decap_8
XFILLER_5_24 VPWR VGND sg13g2_decap_4
XFILLER_4_474 VPWR VGND sg13g2_decap_8
Xhold202 _0823_/B _0944_/Q VPWR VGND sg13g2_dlygate4sd3_1
Xhold213 _0685_/B _0935_/Q VPWR VGND sg13g2_dlygate4sd3_1
Xhold235 _0788_/A _0892_/Q VPWR VGND sg13g2_dlygate4sd3_1
Xhold257 _0606_/B _0596_/A VPWR VGND sg13g2_dlygate4sd3_1
Xhold279 _0865_/A _0675_/A VPWR VGND sg13g2_dlygate4sd3_1
X_0618_ _0618_/Y _0774_/B VPWR VGND sg13g2_inv_1
X_0549_ _0549_/Y _0589_/A VPWR VGND sg13g2_inv_1
XFILLER_30_32 VPWR VGND sg13g2_decap_8
XFILLER_29_150 VPWR VGND sg13g2_decap_8
XFILLER_13_562 VPWR VGND sg13g2_fill_1
XFILLER_17_334 VPWR VGND sg13g2_decap_8
XFILLER_27_109 VPWR VGND sg13g2_decap_8
XFILLER_23_348 VPWR VGND sg13g2_decap_8
Xrebuffer94 _0696_/A _0700_/A VPWR VGND sg13g2_buf_2
XFILLER_6_569 VPWR VGND sg13g2_fill_2
XFILLER_17_164 VPWR VGND sg13g2_decap_8
X_0952_ _0952_/Q _0970_/CLK _0952_/D _0877_/X VPWR VGND sg13g2_dfrbpq_1
XFILLER_9_341 VPWR VGND sg13g2_decap_8
X_0883_ _0883_/Y _0890_/A VPWR VGND sg13g2_inv_1
XFILLER_28_429 VPWR VGND sg13g2_decap_8
Xclkbuf_4_2_0_clk _0977_/CLK clkbuf_0_clk/X VPWR VGND sg13g2_buf_8
XFILLER_23_178 VPWR VGND sg13g2_decap_8
XFILLER_10_384 VPWR VGND sg13g2_decap_8
X_0935_ _0935_/Q clkload5/A _0935_/D _0867_/X VPWR VGND sg13g2_dfrbpq_1
X_0866_ _0866_/X _0869_/A _0869_/B VPWR VGND sg13g2_and2_1
XFILLER_9_171 VPWR VGND sg13g2_decap_8
X_0797_ _0906_/D _0798_/A _0797_/B VPWR VGND sg13g2_or2_1
XFILLER_0_4 VPWR VGND sg13g2_decap_8
XFILLER_15_454 VPWR VGND sg13g2_fill_1
XFILLER_27_270 VPWR VGND sg13g2_decap_8
X_0720_ _0927_/D _0719_/Y _0554_/Y _0718_/B VPWR VGND sg13g2_a21oi_1
XFILLER_30_424 VPWR VGND sg13g2_decap_8
XFILLER_10_192 VPWR VGND sg13g2_decap_8
X_0651_ _0951_/D _0653_/A _0654_/B _0655_/A VPWR VGND sg13g2_a21o_1
X_0582_ _0583_/A _0596_/A _0584_/C VPWR VGND sg13g2_or2_1
XFILLER_6_185 VPWR VGND sg13g2_decap_8
XFILLER_18_270 VPWR VGND sg13g2_decap_8
XFILLER_18_281 VPWR VGND sg13g2_fill_1
X_0918_ _0918_/Q clkload7/A _0918_/D _0860_/X VPWR VGND sg13g2_dfrbpq_1
X_0849_ _0849_/X _0850_/A _0852_/B VPWR VGND sg13g2_and2_1
XFILLER_29_546 VPWR VGND sg13g2_decap_8
Xlane0.t_trail.tempo VPWR VGND _0622_/Y lane0.t_trail.tempo/ARM _0952_/Q fanout58/X
+ _0571_/A tempo_t80n
X_0703_ _0780_/B _0707_/B _0781_/A VPWR VGND sg13g2_nand2b_1
XFILLER_7_483 VPWR VGND sg13g2_fill_1
XFILLER_30_243 VPWR VGND sg13g2_decap_8
X_0634_ _0636_/A input3/X _1025_/A _0573_/Y _0629_/Y _0633_/Y VPWR VGND sg13g2_a221oi_1
X_0565_ _0565_/Y _0565_/A VPWR VGND sg13g2_inv_1
XFILLER_21_254 VPWR VGND sg13g2_decap_8
XFILLER_28_21 VPWR VGND sg13g2_decap_8
XFILLER_29_398 VPWR VGND sg13g2_decap_8
XFILLER_29_376 VPWR VGND sg13g2_decap_4
XFILLER_28_98 VPWR VGND sg13g2_decap_8
XFILLER_25_560 VPWR VGND sg13g2_fill_2
Xhold203 _0831_/A _0962_/Q VPWR VGND sg13g2_dlygate4sd3_1
Xhold214 _0814_/B _0932_/Q VPWR VGND sg13g2_dlygate4sd3_1
Xhold225 _0729_/B _0728_/Y VPWR VGND sg13g2_dlygate4sd3_1
Xhold236 _0847_/A _0969_/Q VPWR VGND sg13g2_dlygate4sd3_1
Xhold247 hold247/X _0549_/Y VPWR VGND sg13g2_dlygate4sd3_1
Xhold269 hold269/X _0593_/A VPWR VGND sg13g2_dlygate4sd3_1
X_0617_ _0774_/B _0617_/A _0623_/A _0623_/B VPWR VGND sg13g2_nand3_1
XFILLER_30_11 VPWR VGND sg13g2_decap_8
XFILLER_30_88 VPWR VGND sg13g2_decap_8
XFILLER_17_313 VPWR VGND sg13g2_decap_8
XFILLER_29_140 VPWR VGND sg13g2_decap_4
Xlane0.t_zero.tempo VPWR VGND _0631_/Y lane0.t_zero.tempo/ARM _0948_/Q fanout57/X
+ _0633_/A1 tempo_t150n
XFILLER_4_272 VPWR VGND sg13g2_decap_4
XFILLER_23_327 VPWR VGND sg13g2_decap_8
Xrebuffer95 _0757_/A _0755_/A VPWR VGND sg13g2_buf_1
XFILLER_10_533 VPWR VGND sg13g2_fill_2
Xrebuffer130 _1016_/A _0734_/X VPWR VGND sg13g2_buf_1
XFILLER_6_504 VPWR VGND sg13g2_decap_8
XFILLER_17_121 VPWR VGND sg13g2_fill_2
X_0951_ _0951_/Q _0977_/CLK _0951_/D hold276/X VPWR VGND sg13g2_dfrbpq_1
X_0882_ _0960_/D _0882_/A VPWR VGND sg13g2_buf_1
XFILLER_9_320 VPWR VGND sg13g2_decap_8
XFILLER_28_408 VPWR VGND sg13g2_decap_8
XFILLER_23_157 VPWR VGND sg13g2_decap_8
XFILLER_11_79 VPWR VGND sg13g2_decap_8
XFILLER_19_419 VPWR VGND sg13g2_decap_8
XFILLER_27_496 VPWR VGND sg13g2_decap_8
XFILLER_27_474 VPWR VGND sg13g2_decap_8
XFILLER_10_341 VPWR VGND sg13g2_decap_8
XFILLER_6_367 VPWR VGND sg13g2_decap_8
XFILLER_6_334 VPWR VGND sg13g2_decap_8
XFILLER_28_7 VPWR VGND sg13g2_decap_8
X_0934_ _0934_/Q _0937_/CLK _0934_/D _0866_/X VPWR VGND sg13g2_dfrbpq_1
X_0865_ _0865_/X _0865_/A _0869_/B VPWR VGND sg13g2_and2_1
XFILLER_9_150 VPWR VGND sg13g2_decap_8
X_0796_ _0796_/X _0906_/Q _0796_/B VPWR VGND sg13g2_or2_1
Xlane1.t_trail.tempo_75 lane1.t_trail.tempo/ARM VPWR VGND sg13g2_tielo
XFILLER_28_249 VPWR VGND sg13g2_decap_8
XFILLER_3_348 VPWR VGND sg13g2_decap_8
XFILLER_19_249 VPWR VGND sg13g2_decap_8
XFILLER_30_403 VPWR VGND sg13g2_decap_8
XFILLER_10_171 VPWR VGND sg13g2_decap_8
XFILLER_15_488 VPWR VGND sg13g2_fill_1
XFILLER_6_120 VPWR VGND sg13g2_fill_1
X_0650_ _0952_/D hold172/X _0650_/B VPWR VGND sg13g2_nand2b_1
X_0581_ _0584_/C _0585_/B _0589_/A VPWR VGND sg13g2_nand2b_1
XFILLER_6_164 VPWR VGND sg13g2_decap_8
Xclkbuf_4_1_0_clk clkload0/A clkbuf_0_clk/X VPWR VGND sg13g2_buf_8
X_0917_ _0917_/Q _0937_/CLK _0917_/D _0859_/X VPWR VGND sg13g2_dfrbpq_1
X_0848_ _0848_/X _0850_/A _0852_/B VPWR VGND sg13g2_and2_1
X_0779_ _1023_/A _0706_/Y _0779_/B VPWR VGND sg13g2_nand2b_1
XFILLER_29_525 VPWR VGND sg13g2_decap_8
XFILLER_24_263 VPWR VGND sg13g2_decap_8
XFILLER_12_425 VPWR VGND sg13g2_decap_8
XFILLER_3_178 VPWR VGND sg13g2_decap_8
XFILLER_15_263 VPWR VGND sg13g2_decap_8
XFILLER_30_222 VPWR VGND sg13g2_decap_8
X_0702_ _0707_/B _0713_/B _0713_/C VPWR VGND sg13g2_nand2b_1
X_0633_ _0633_/Y _0633_/A1 _0631_/Y _0632_/X VPWR VGND sg13g2_o21ai_1
XFILLER_7_462 VPWR VGND sg13g2_decap_8
X_0564_ _0564_/Y _0919_/Q VPWR VGND sg13g2_inv_1
XFILLER_21_233 VPWR VGND sg13g2_decap_8
XFILLER_21_277 VPWR VGND sg13g2_fill_1
XFILLER_29_355 VPWR VGND sg13g2_decap_8
XFILLER_28_77 VPWR VGND sg13g2_decap_8
XFILLER_5_37 VPWR VGND sg13g2_decap_8
Xhold226 _0814_/A _0930_/Q VPWR VGND sg13g2_dlygate4sd3_1
Xhold237 hold237/X _0933_/Q VPWR VGND sg13g2_dlygate4sd3_1
Xhold248 _0843_/B _0972_/Q VPWR VGND sg13g2_dlygate4sd3_1
X_0616_ _0616_/Y _0774_/A VPWR VGND sg13g2_inv_1
XFILLER_7_270 VPWR VGND sg13g2_decap_8
XFILLER_30_67 VPWR VGND sg13g2_decap_8
XFILLER_29_185 VPWR VGND sg13g2_decap_8
XFILLER_13_542 VPWR VGND sg13g2_fill_2
XFILLER_25_391 VPWR VGND sg13g2_decap_8
XFILLER_4_251 VPWR VGND sg13g2_decap_8
XFILLER_16_391 VPWR VGND sg13g2_decap_8
XFILLER_23_306 VPWR VGND sg13g2_decap_8
Xrebuffer96 _0775_/B _0613_/X VPWR VGND sg13g2_buf_1
XFILLER_17_100 VPWR VGND sg13g2_decap_8
X_0950_ _0950_/Q _0978_/CLK _0950_/D hold282/X VPWR VGND sg13g2_dfrbpq_1
X_0881_ _0881_/X _0881_/A _0881_/B VPWR VGND sg13g2_and2_1
XFILLER_9_398 VPWR VGND sg13g2_decap_8
XFILLER_23_114 VPWR VGND sg13g2_decap_8
XFILLER_27_453 VPWR VGND sg13g2_decap_8
XFILLER_10_320 VPWR VGND sg13g2_decap_8
XFILLER_6_313 VPWR VGND sg13g2_decap_8
Xclk_lane.t_zero.tempo VPWR VGND _0594_/B clk_lane.t_zero.tempo/ARM _0967_/Q fanout57/X
+ _0594_/A tempo_t350n
X_0933_ _0933_/Q _0937_/CLK _0933_/D _0865_/X VPWR VGND sg13g2_dfrbpq_1
X_0864_ _0864_/Y _0873_/A VPWR VGND sg13g2_inv_1
X_0795_ _0902_/D _0793_/A _0792_/B hold159/X VPWR VGND sg13g2_a21o_1
XFILLER_28_228 VPWR VGND sg13g2_decap_8
XFILLER_24_412 VPWR VGND sg13g2_decap_8
XFILLER_22_35 VPWR VGND sg13g2_fill_1
XFILLER_3_327 VPWR VGND sg13g2_decap_8
XFILLER_22_79 VPWR VGND sg13g2_decap_8
XFILLER_19_228 VPWR VGND sg13g2_decap_8
XFILLER_15_412 VPWR VGND sg13g2_decap_8
XFILLER_10_150 VPWR VGND sg13g2_decap_8
XFILLER_30_459 VPWR VGND sg13g2_decap_8
X_0580_ _0603_/C input1/X _0579_/Y VPWR VGND sg13g2_nor2b_1
X_0916_ _0916_/Q clkload6/A _0916_/D _0858_/X VPWR VGND sg13g2_dfrbpq_1
XFILLER_21_426 VPWR VGND sg13g2_decap_8
X_0847_ _0969_/D _0847_/A VPWR VGND sg13g2_buf_1
X_0778_ _1006_/A _0778_/A _0778_/B VPWR VGND sg13g2_xnor2_1
XFILLER_29_504 VPWR VGND sg13g2_decap_8
XFILLER_12_404 VPWR VGND sg13g2_decap_8
XFILLER_17_35 VPWR VGND sg13g2_fill_1
XFILLER_17_79 VPWR VGND sg13g2_decap_8
XFILLER_24_242 VPWR VGND sg13g2_decap_8
XFILLER_3_157 VPWR VGND sg13g2_decap_8
XFILLER_3_113 VPWR VGND sg13g2_decap_8
Xlane2.t_exit.tempo VPWR VGND _0779_/B lane2.t_exit.tempo/ARM _0709_/Y fanout59/X
+ _0566_/A tempo_t150n
XFILLER_15_242 VPWR VGND sg13g2_decap_8
X_0701_ _0701_/Y _0701_/A VPWR VGND sg13g2_inv_4
X_0632_ _0632_/X _0876_/A _0632_/B _0964_/Q input3/X VPWR VGND sg13g2_or4_1
X_0563_ _0563_/Y _0563_/A VPWR VGND sg13g2_inv_1
XFILLER_7_430 VPWR VGND sg13g2_fill_2
XFILLER_29_334 VPWR VGND sg13g2_decap_8
XFILLER_28_56 VPWR VGND sg13g2_decap_8
XFILLER_12_212 VPWR VGND sg13g2_fill_1
XFILLER_12_256 VPWR VGND sg13g2_decap_8
XFILLER_25_562 VPWR VGND sg13g2_fill_1
Xclkbuf_4_0_0_clk _0978_/CLK clkbuf_0_clk/X VPWR VGND sg13g2_buf_8
XFILLER_4_488 VPWR VGND sg13g2_decap_8
Xhold205 _0915_/D _0730_/X VPWR VGND sg13g2_dlygate4sd3_1
Xhold216 _0687_/A _0937_/Q VPWR VGND sg13g2_dlygate4sd3_1
Xhold227 _0809_/B _0923_/Q VPWR VGND sg13g2_dlygate4sd3_1
Xhold238 _0692_/A _0934_/Q VPWR VGND sg13g2_dlygate4sd3_1
Xhold249 _0721_/B _0713_/C VPWR VGND sg13g2_dlygate4sd3_1
X_0615_ _0774_/A _0876_/A _0627_/B VPWR VGND sg13g2_nand2b_1
XFILLER_30_46 VPWR VGND sg13g2_decap_8
XFILLER_17_348 VPWR VGND sg13g2_decap_8
XFILLER_29_164 VPWR VGND sg13g2_decap_8
Xrebuffer97 _0682_/B1 _0680_/A VPWR VGND sg13g2_buf_1
XFILLER_10_535 VPWR VGND sg13g2_fill_1
Xrebuffer110 _0607_/C _0605_/A VPWR VGND sg13g2_buf_1
XFILLER_25_79 VPWR VGND sg13g2_decap_8
XFILLER_25_46 VPWR VGND sg13g2_fill_1
XFILLER_22_384 VPWR VGND sg13g2_decap_8
XFILLER_17_123 VPWR VGND sg13g2_fill_1
XFILLER_17_178 VPWR VGND sg13g2_decap_8
XFILLER_9_300 VPWR VGND sg13g2_fill_1
XFILLER_13_373 VPWR VGND sg13g2_fill_1
XFILLER_13_384 VPWR VGND sg13g2_decap_8
X_0880_ _0880_/X _0881_/A _0881_/B VPWR VGND sg13g2_and2_1
XFILLER_9_355 VPWR VGND sg13g2_fill_2
XFILLER_27_432 VPWR VGND sg13g2_decap_8
XFILLER_10_398 VPWR VGND sg13g2_decap_8
XFILLER_22_192 VPWR VGND sg13g2_decap_8
XFILLER_7_0 VPWR VGND sg13g2_fill_1
XFILLER_13_192 VPWR VGND sg13g2_decap_8
X_0932_ _0932_/Q clkload0/A _0932_/D _0673_/Y VPWR VGND sg13g2_dfrbpq_1
X_0863_ _0863_/Y _0873_/A VPWR VGND sg13g2_inv_1
X_0794_ _0901_/D _0793_/A _0792_/B _0793_/Y VPWR VGND sg13g2_a21oi_1
XFILLER_9_185 VPWR VGND sg13g2_decap_8
XFILLER_5_391 VPWR VGND sg13g2_decap_8
XFILLER_11_107 VPWR VGND sg13g2_decap_8
XFILLER_3_306 VPWR VGND sg13g2_decap_8
XFILLER_30_438 VPWR VGND sg13g2_decap_8
X_0915_ _0915_/Q clkload6/A _0915_/D _0857_/X VPWR VGND sg13g2_dfrbpq_1
XFILLER_21_405 VPWR VGND sg13g2_decap_8
X_0846_ _0975_/D _0844_/A _0844_/B _0558_/Y VPWR VGND sg13g2_o21ai_1
X_0777_ _1018_/A _1022_/A _0777_/B VPWR VGND sg13g2_nand2b_1
X_0700_ _0701_/A _0700_/A _0781_/A VPWR VGND sg13g2_nand2_2
XFILLER_30_257 VPWR VGND sg13g2_decap_8
X_0631_ _0631_/Y _0631_/A VPWR VGND sg13g2_inv_2
X_0562_ _0562_/Y _0562_/A VPWR VGND sg13g2_inv_1
XFILLER_19_560 VPWR VGND sg13g2_fill_2
XFILLER_21_268 VPWR VGND sg13g2_decap_8
X_0829_ _0959_/D _0827_/A _0826_/B hold153/X VPWR VGND sg13g2_a21o_1
XFILLER_29_313 VPWR VGND sg13g2_decap_8
XFILLER_28_35 VPWR VGND sg13g2_decap_8
XFILLER_12_235 VPWR VGND sg13g2_decap_8
XFILLER_5_17 VPWR VGND sg13g2_decap_8
XFILLER_4_467 VPWR VGND sg13g2_decap_8
XFILLER_4_445 VPWR VGND sg13g2_fill_1
XFILLER_4_423 VPWR VGND sg13g2_fill_1
XFILLER_4_412 VPWR VGND sg13g2_decap_8
Xhold206 _0815_/A _0931_/Q VPWR VGND sg13g2_dlygate4sd3_1
Xhold228 _0612_/C _0967_/Q VPWR VGND sg13g2_dlygate4sd3_1
Xhold239 _0799_/B _0910_/Q VPWR VGND sg13g2_dlygate4sd3_1
X_0614_ _0627_/B _0632_/B _0964_/Q VPWR VGND sg13g2_nor2b_1
X_1028_ _1028_/X _1028_/A VPWR VGND sg13g2_buf_1
XFILLER_22_566 VPWR VGND sg13g2_fill_1
XFILLER_30_25 VPWR VGND sg13g2_decap_8
XFILLER_13_544 VPWR VGND sg13g2_fill_1
XFILLER_17_327 VPWR VGND sg13g2_decap_8
Xrebuffer98 _1011_/A _0698_/Y VPWR VGND sg13g2_buf_1
Xrebuffer87 _0681_/A _0679_/A VPWR VGND sg13g2_buf_1
Xrebuffer133 _0601_/A _0602_/B VPWR VGND sg13g2_buf_1
Xrebuffer111 _0638_/B _0636_/B VPWR VGND sg13g2_buf_1
Xrebuffer100 _0623_/B _0964_/Q VPWR VGND sg13g2_buf_8
XFILLER_22_341 VPWR VGND sg13g2_decap_8
XFILLER_13_341 VPWR VGND sg13g2_decap_8
XFILLER_17_157 VPWR VGND sg13g2_decap_8
XFILLER_9_334 VPWR VGND sg13g2_decap_8
XFILLER_5_562 VPWR VGND sg13g2_fill_2
XFILLER_5_551 VPWR VGND sg13g2_decap_8
XFILLER_27_411 VPWR VGND sg13g2_decap_8
XFILLER_10_355 VPWR VGND sg13g2_decap_4
XFILLER_10_366 VPWR VGND sg13g2_fill_1
XFILLER_6_348 VPWR VGND sg13g2_decap_8
XFILLER_22_171 VPWR VGND sg13g2_decap_8
XFILLER_13_171 VPWR VGND sg13g2_decap_8
X_0931_ _0931_/Q clkload0/A _0931_/D _0673_/Y VPWR VGND sg13g2_dfrbpq_1
X_0862_ _0862_/Y _0873_/A VPWR VGND sg13g2_inv_1
XFILLER_9_164 VPWR VGND sg13g2_decap_8
X_0793_ _0793_/Y _0793_/A _0853_/A VPWR VGND sg13g2_nor2b_1
XFILLER_27_263 VPWR VGND sg13g2_decap_8
XFILLER_30_417 VPWR VGND sg13g2_decap_8
XFILLER_10_185 VPWR VGND sg13g2_decap_8
XFILLER_6_178 VPWR VGND sg13g2_decap_8
Xlane2.t_lpx.tempo_78 lane2.t_lpx.tempo/ARM VPWR VGND sg13g2_tielo
XFILLER_18_263 VPWR VGND sg13g2_decap_8
X_0914_ _0914_/Q clkload3/A _0914_/D _0856_/X VPWR VGND sg13g2_dfrbpq_1
X_0845_ _0974_/D _0836_/B _0845_/B VPWR VGND sg13g2_nand2b_1
X_0776_ _1022_/A _0668_/Y _0776_/B VPWR VGND sg13g2_nand2b_1
XFILLER_29_539 VPWR VGND sg13g2_decap_8
XFILLER_11_472 VPWR VGND sg13g2_fill_1
XFILLER_7_476 VPWR VGND sg13g2_decap_8
XFILLER_30_236 VPWR VGND sg13g2_decap_8
X_0630_ _0631_/A _0876_/A _0613_/X VPWR VGND sg13g2_nor2b_2
X_0561_ _0561_/Y _0561_/A VPWR VGND sg13g2_inv_1
XFILLER_21_247 VPWR VGND sg13g2_decap_8
X_0828_ _0958_/D _0827_/A _0826_/B _0827_/Y VPWR VGND sg13g2_a21oi_1
X_0759_ _0907_/D _0759_/A _0759_/B VPWR VGND sg13g2_xnor2_1
XFILLER_9_93 VPWR VGND sg13g2_decap_8
XFILLER_28_14 VPWR VGND sg13g2_decap_8
XFILLER_29_369 VPWR VGND sg13g2_decap_8
XFILLER_28_380 VPWR VGND sg13g2_decap_8
Xhold218 _0797_/B _0906_/Q VPWR VGND sg13g2_dlygate4sd3_1
X_0613_ _0613_/X _0964_/Q _0965_/Q VPWR VGND sg13g2_and2_2
XFILLER_3_490 VPWR VGND sg13g2_decap_8
XFILLER_19_391 VPWR VGND sg13g2_decap_8
X_1027_ _1027_/X _1027_/A VPWR VGND sg13g2_buf_1
XFILLER_17_306 VPWR VGND sg13g2_decap_8
XFILLER_29_144 VPWR VGND sg13g2_fill_2
XFILLER_29_133 VPWR VGND sg13g2_decap_8
XFILLER_9_549 VPWR VGND sg13g2_decap_8
XFILLER_4_276 VPWR VGND sg13g2_fill_1
XFILLER_4_265 VPWR VGND sg13g2_decap_8
XFILLER_16_361 VPWR VGND sg13g2_fill_1
Xrebuffer99 _0640_/B hold252/X VPWR VGND sg13g2_buf_1
Xrebuffer88 _0719_/D _0715_/Y VPWR VGND sg13g2_buf_2
XFILLER_22_320 VPWR VGND sg13g2_decap_8
Xrebuffer134 _0600_/B _0976_/Q VPWR VGND sg13g2_buf_2
Xrebuffer123 _0670_/B _0946_/Q VPWR VGND sg13g2_buf_1
Xrebuffer112 _0638_/C _0636_/C VPWR VGND sg13g2_buf_1
Xrebuffer101 _0719_/A _0717_/A VPWR VGND sg13g2_buf_1
XFILLER_17_114 VPWR VGND sg13g2_decap_8
XFILLER_13_320 VPWR VGND sg13g2_decap_8
XFILLER_9_313 VPWR VGND sg13g2_decap_8
XFILLER_23_128 VPWR VGND sg13g2_decap_4
XFILLER_27_467 VPWR VGND sg13g2_decap_8
XFILLER_10_301 VPWR VGND sg13g2_fill_1
XFILLER_10_334 VPWR VGND sg13g2_decap_8
XFILLER_27_489 VPWR VGND sg13g2_decap_8
XFILLER_22_150 VPWR VGND sg13g2_decap_8
XFILLER_6_327 VPWR VGND sg13g2_decap_8
XFILLER_18_412 VPWR VGND sg13g2_decap_8
XFILLER_13_150 VPWR VGND sg13g2_decap_8
X_0930_ _0930_/Q clkload0/A _0930_/D _0673_/Y VPWR VGND sg13g2_dfrbpq_1
X_0861_ _0922_/D _0861_/A VPWR VGND sg13g2_buf_1
X_0792_ _0900_/D _0792_/A _0792_/B VPWR VGND sg13g2_nand2_1
XFILLER_3_62 VPWR VGND sg13g2_fill_1
XFILLER_3_51 VPWR VGND sg13g2_decap_8
XFILLER_24_426 VPWR VGND sg13g2_decap_8
XFILLER_15_426 VPWR VGND sg13g2_decap_8
XFILLER_27_242 VPWR VGND sg13g2_decap_8
XFILLER_10_164 VPWR VGND sg13g2_decap_8
XFILLER_6_113 VPWR VGND sg13g2_decap_8
XFILLER_12_93 VPWR VGND sg13g2_decap_8
XFILLER_6_157 VPWR VGND sg13g2_decap_8
XFILLER_18_242 VPWR VGND sg13g2_decap_8
X_0913_ _0913_/Q clkload0/A _0913_/D _0711_/Y VPWR VGND sg13g2_dfrbpq_1
X_0844_ _0845_/B _0844_/A _0844_/B VPWR VGND sg13g2_xnor2_1
X_0775_ _1005_/A _0775_/A _0775_/B VPWR VGND sg13g2_xor2_1
XFILLER_29_518 VPWR VGND sg13g2_decap_8
XFILLER_12_418 VPWR VGND sg13g2_decap_8
XFILLER_24_256 VPWR VGND sg13g2_decap_8
XFILLER_15_256 VPWR VGND sg13g2_decap_8
XFILLER_28_562 VPWR VGND sg13g2_decap_4
X_0560_ _0792_/A _0560_/A VPWR VGND sg13g2_inv_1
XFILLER_19_551 VPWR VGND sg13g2_fill_1
XFILLER_19_562 VPWR VGND sg13g2_fill_1
XFILLER_21_226 VPWR VGND sg13g2_decap_8
XFILLER_9_72 VPWR VGND sg13g2_decap_8
X_0827_ _0827_/Y _0827_/A _0882_/A VPWR VGND sg13g2_nor2b_1
X_0758_ _0908_/D _0757_/Y _0556_/Y _0756_/B VPWR VGND sg13g2_a21oi_1
X_0689_ _0693_/B _0688_/A _0685_/B _0687_/A VPWR VGND sg13g2_o21ai_1
XFILLER_29_348 VPWR VGND sg13g2_decap_8
XFILLER_11_270 VPWR VGND sg13g2_decap_8
Xhold208 _0688_/A _0936_/Q VPWR VGND sg13g2_dlygate4sd3_1
Xhold219 _0786_/B _0891_/Q VPWR VGND sg13g2_dlygate4sd3_1
X_0612_ _0967_/D _0847_/A _0612_/B _0612_/C VPWR VGND sg13g2_or3_1
XFILLER_7_263 VPWR VGND sg13g2_decap_8
X_1026_ _1026_/X _1026_/A VPWR VGND sg13g2_buf_1
XFILLER_29_178 VPWR VGND sg13g2_decap_8
XFILLER_29_112 VPWR VGND sg13g2_decap_8
XFILLER_25_384 VPWR VGND sg13g2_decap_8
XFILLER_4_244 VPWR VGND sg13g2_decap_8
XFILLER_16_384 VPWR VGND sg13g2_decap_8
XFILLER_29_91 VPWR VGND sg13g2_decap_8
X_1009_ _1009_/X _1009_/A VPWR VGND sg13g2_buf_1
Xrebuffer89 _0638_/D _0636_/A VPWR VGND sg13g2_buf_1
XFILLER_25_27 VPWR VGND sg13g2_fill_1
Xrebuffer135 _0785_/A _0977_/Q VPWR VGND sg13g2_buf_1
Xrebuffer124 rebuffer124/X _0663_/Y VPWR VGND sg13g2_buf_1
Xrebuffer113 rebuffer113/X _0631_/A VPWR VGND sg13g2_buf_1
Xrebuffer102 _0607_/B _0605_/C VPWR VGND sg13g2_buf_1
XFILLER_22_398 VPWR VGND sg13g2_decap_8
XFILLER_13_398 VPWR VGND sg13g2_decap_8
XFILLER_15_93 VPWR VGND sg13g2_decap_8
XFILLER_25_192 VPWR VGND sg13g2_decap_8
XFILLER_16_192 VPWR VGND sg13g2_decap_8
XFILLER_23_107 VPWR VGND sg13g2_decap_8
XFILLER_27_446 VPWR VGND sg13g2_decap_8
XFILLER_10_313 VPWR VGND sg13g2_decap_8
XFILLER_6_306 VPWR VGND sg13g2_decap_8
XFILLER_10_379 VPWR VGND sg13g2_fill_1
XFILLER_9_100 VPWR VGND sg13g2_decap_8
X_0860_ _0860_/X _0860_/A _0860_/B VPWR VGND sg13g2_and2_1
X_0791_ _0792_/B _0793_/A hold159/X _0853_/A VPWR VGND sg13g2_a21oi_1
XFILLER_24_405 VPWR VGND sg13g2_decap_8
XFILLER_15_405 VPWR VGND sg13g2_decap_8
XFILLER_12_72 VPWR VGND sg13g2_decap_8
X_0912_ _0912_/Q _0925_/CLK _0912_/D _0711_/Y VPWR VGND sg13g2_dfrbpq_1
XFILLER_21_419 VPWR VGND sg13g2_decap_8
X_0843_ _0844_/B _0843_/A _0843_/B _0843_/C VPWR VGND sg13g2_nand3_1
X_0774_ _1017_/A _0774_/A _0774_/B _0774_/C VPWR VGND sg13g2_nand3_1
XFILLER_24_235 VPWR VGND sg13g2_decap_8
XFILLER_3_106 VPWR VGND sg13g2_decap_8
XFILLER_28_541 VPWR VGND sg13g2_decap_8
XFILLER_15_235 VPWR VGND sg13g2_decap_8
XFILLER_7_412 VPWR VGND sg13g2_decap_8
XFILLER_23_93 VPWR VGND sg13g2_decap_8
XFILLER_0_53 VPWR VGND sg13g2_decap_4
X_0826_ _0957_/D _0826_/A _0826_/B VPWR VGND sg13g2_nand2_1
X_0757_ _0757_/Y _0757_/A _0757_/B _0757_/C _0759_/A VPWR VGND sg13g2_nand4_1
X_0688_ _0936_/D _0688_/A _0691_/A VPWR VGND sg13g2_xor2_1
Xclkbuf_4_15_0_clk clkload7/A clkbuf_0_clk/X VPWR VGND sg13g2_buf_8
XFILLER_29_327 VPWR VGND sg13g2_decap_8
XFILLER_28_49 VPWR VGND sg13g2_decap_8
XFILLER_12_205 VPWR VGND sg13g2_fill_1
XFILLER_12_249 VPWR VGND sg13g2_decap_8
XFILLER_25_555 VPWR VGND sg13g2_fill_1
XFILLER_18_93 VPWR VGND sg13g2_decap_8
X_0611_ _0611_/Y _0612_/B _0969_/Q VPWR VGND sg13g2_nand2b_1
XFILLER_7_242 VPWR VGND sg13g2_decap_8
X_1025_ _1025_/X _1025_/A VPWR VGND sg13g2_buf_1
X_0809_ _0923_/D _0810_/B _0809_/B VPWR VGND sg13g2_or2_1
XFILLER_30_39 VPWR VGND sg13g2_decap_8
XFILLER_29_157 VPWR VGND sg13g2_decap_8
XFILLER_25_341 VPWR VGND sg13g2_decap_8
XFILLER_4_212 VPWR VGND sg13g2_decap_8
XFILLER_29_70 VPWR VGND sg13g2_decap_8
XFILLER_16_341 VPWR VGND sg13g2_decap_8
XANTENNA_1 _0907_/D VPWR VGND sg13g2_antennanp
X_1008_ _1008_/X _1008_/A VPWR VGND sg13g2_buf_1
Xrebuffer103 _0632_/B _0965_/Q VPWR VGND sg13g2_buf_8
Xrebuffer125 _0668_/B fanout45/X VPWR VGND sg13g2_buf_1
Xrebuffer114 _0775_/A _0617_/A VPWR VGND sg13g2_buf_1
XFILLER_25_171 VPWR VGND sg13g2_decap_8
XFILLER_15_72 VPWR VGND sg13g2_decap_8
XFILLER_9_348 VPWR VGND sg13g2_decap_8
XFILLER_16_171 VPWR VGND sg13g2_decap_8
XFILLER_27_425 VPWR VGND sg13g2_decap_8
XFILLER_22_185 VPWR VGND sg13g2_decap_8
XFILLER_13_185 VPWR VGND sg13g2_decap_8
X_0790_ _0894_/D _0788_/A _0789_/A _0788_/B VPWR VGND sg13g2_a21o_1
XFILLER_9_178 VPWR VGND sg13g2_decap_8
XFILLER_5_384 VPWR VGND sg13g2_decap_8
XFILLER_10_100 VPWR VGND sg13g2_decap_8
XFILLER_27_277 VPWR VGND sg13g2_fill_2
XFILLER_23_450 VPWR VGND sg13g2_decap_8
X_0911_ _0911_/Q _0925_/CLK _0911_/D _0711_/Y VPWR VGND sg13g2_dfrbpq_1
X_0842_ _0973_/D _0843_/C _0842_/B VPWR VGND sg13g2_xnor2_1
X_0773_ _1021_/A _0774_/B _0774_/C VPWR VGND sg13g2_nand2_1
XFILLER_5_192 VPWR VGND sg13g2_decap_8
XFILLER_28_520 VPWR VGND sg13g2_decap_8
XFILLER_23_72 VPWR VGND sg13g2_decap_8
XFILLER_0_32 VPWR VGND sg13g2_decap_8
X_0825_ _0826_/B _0827_/A hold153/X _0882_/A VPWR VGND sg13g2_a21oi_1
X_0756_ _0909_/D _0756_/A _0756_/B VPWR VGND sg13g2_xnor2_1
X_0687_ _0691_/A _0687_/A _0687_/B VPWR VGND sg13g2_nor2_1
XFILLER_6_490 VPWR VGND sg13g2_decap_8
XFILLER_29_306 VPWR VGND sg13g2_decap_8
XFILLER_28_28 VPWR VGND sg13g2_decap_8
XFILLER_12_228 VPWR VGND sg13g2_decap_8
XFILLER_4_438 VPWR VGND sg13g2_decap_8
XFILLER_4_405 VPWR VGND sg13g2_decap_8
XFILLER_18_72 VPWR VGND sg13g2_decap_8
XFILLER_28_394 VPWR VGND sg13g2_decap_8
XFILLER_7_221 VPWR VGND sg13g2_fill_2
X_0610_ _0976_/D _0610_/A _0610_/B VPWR VGND sg13g2_and2_1
X_1024_ _1024_/X _1024_/A VPWR VGND sg13g2_buf_1
XFILLER_22_559 VPWR VGND sg13g2_decap_8
X_0808_ _0921_/D _0806_/A _0805_/B hold154/X VPWR VGND sg13g2_a21o_1
XFILLER_30_18 VPWR VGND sg13g2_decap_8
X_0739_ _0739_/Y _0739_/A VPWR VGND sg13g2_inv_4
XFILLER_25_320 VPWR VGND sg13g2_decap_8
XFILLER_16_320 VPWR VGND sg13g2_decap_8
Xclkbuf_4_14_0_clk _0941_/CLK clkbuf_0_clk/X VPWR VGND sg13g2_buf_8
XFILLER_6_53 VPWR VGND sg13g2_fill_1
XFILLER_6_42 VPWR VGND sg13g2_decap_8
X_1007_ _1007_/X _1007_/A VPWR VGND sg13g2_buf_1
Xrebuffer126 _0656_/A fanout45/X VPWR VGND sg13g2_buf_1
Xrebuffer115 _0617_/A _0878_/A VPWR VGND sg13g2_buf_1
Xrebuffer104 _0623_/A _0965_/Q VPWR VGND sg13g2_buf_2
XFILLER_22_334 VPWR VGND sg13g2_decap_8
XFILLER_13_334 VPWR VGND sg13g2_decap_8
XFILLER_25_150 VPWR VGND sg13g2_decap_8
XFILLER_9_327 VPWR VGND sg13g2_decap_8
XFILLER_5_544 VPWR VGND sg13g2_decap_8
XFILLER_16_150 VPWR VGND sg13g2_decap_8
XFILLER_27_404 VPWR VGND sg13g2_decap_8
XFILLER_10_348 VPWR VGND sg13g2_decap_8
XFILLER_10_359 VPWR VGND sg13g2_fill_2
XFILLER_22_164 VPWR VGND sg13g2_decap_8
XFILLER_18_426 VPWR VGND sg13g2_decap_8
XFILLER_13_164 VPWR VGND sg13g2_decap_8
Xlane1.t_zero.tempo VPWR VGND _0673_/A lane1.t_zero.tempo/ARM _0929_/Q fanout58/X
+ _0676_/A1 tempo_t150n
XFILLER_9_157 VPWR VGND sg13g2_decap_8
XFILLER_5_341 VPWR VGND sg13g2_decap_8
XFILLER_27_256 VPWR VGND sg13g2_decap_8
XFILLER_10_178 VPWR VGND sg13g2_decap_8
Xhold190 _0654_/B _0949_/Q VPWR VGND sg13g2_dlygate4sd3_1
XFILLER_18_256 VPWR VGND sg13g2_decap_8
X_0910_ _0910_/Q _0925_/CLK _0910_/D _0711_/Y VPWR VGND sg13g2_dfrbpq_1
X_0841_ _0972_/D _0842_/B _0841_/B VPWR VGND sg13g2_and2_1
X_0772_ _0772_/Y _0772_/A _0887_/B VPWR VGND sg13g2_xnor2_1
XFILLER_5_171 VPWR VGND sg13g2_decap_8
Xlane2.t_exit.tempo_77 lane2.t_exit.tempo/ARM VPWR VGND sg13g2_tielo
XFILLER_11_454 VPWR VGND sg13g2_fill_1
XFILLER_11_487 VPWR VGND sg13g2_fill_1
XFILLER_30_229 VPWR VGND sg13g2_decap_8
XFILLER_23_270 VPWR VGND sg13g2_decap_8
XFILLER_7_469 VPWR VGND sg13g2_decap_8
XFILLER_0_11 VPWR VGND sg13g2_decap_8
X_0824_ _0824_/Y _0824_/A _0944_/Q VPWR VGND sg13g2_xnor2_1
X_0755_ _0756_/B _0755_/A _0755_/B _0757_/C _0784_/B VPWR VGND sg13g2_and4_1
XFILLER_9_86 VPWR VGND sg13g2_decap_8
X_0686_ _0937_/D _0687_/A _0686_/B VPWR VGND sg13g2_nand2b_1
XFILLER_28_362 VPWR VGND sg13g2_decap_8
XFILLER_3_483 VPWR VGND sg13g2_decap_8
XFILLER_19_384 VPWR VGND sg13g2_decap_8
X_1023_ _1023_/X _1023_/A VPWR VGND sg13g2_buf_1
X_0807_ _0920_/D _0806_/A _0805_/B _0806_/Y VPWR VGND sg13g2_a21oi_1
X_0738_ _0739_/A _0738_/A _0784_/A VPWR VGND sg13g2_nand2_2
X_0669_ _1026_/A _0778_/A _0669_/B VPWR VGND sg13g2_nor2_2
XFILLER_29_126 VPWR VGND sg13g2_decap_8
XFILLER_25_398 VPWR VGND sg13g2_decap_8
XFILLER_4_258 VPWR VGND sg13g2_decap_8
XFILLER_28_192 VPWR VGND sg13g2_decap_8
XFILLER_12_560 VPWR VGND sg13g2_decap_8
XFILLER_16_398 VPWR VGND sg13g2_decap_8
Xclk_lane.t_lpx.tempo_62 clk_lane.t_lpx.tempo/ARM VPWR VGND sg13g2_tielo
Xlane1.t_lpx.tempo_73 lane1.t_lpx.tempo/ARM VPWR VGND sg13g2_tielo
XFILLER_19_192 VPWR VGND sg13g2_decap_8
X_1006_ _1006_/X _1006_/A VPWR VGND sg13g2_buf_1
XFILLER_22_313 VPWR VGND sg13g2_decap_8
Xrebuffer127 _0675_/B fanout45/X VPWR VGND sg13g2_buf_1
Xrebuffer116 _0877_/A _0878_/A VPWR VGND sg13g2_buf_1
Xrebuffer105 _0678_/C _0679_/B VPWR VGND sg13g2_buf_1
XFILLER_17_107 VPWR VGND sg13g2_decap_8
XFILLER_13_313 VPWR VGND sg13g2_decap_8
XFILLER_13_379 VPWR VGND sg13g2_fill_1
XFILLER_9_306 VPWR VGND sg13g2_decap_8
XFILLER_29_490 VPWR VGND sg13g2_decap_8
XFILLER_12_390 VPWR VGND sg13g2_decap_8
Xclk_lane.t_exit.tempo_61 clk_lane.t_exit.tempo/ARM VPWR VGND sg13g2_tielo
XFILLER_10_327 VPWR VGND sg13g2_decap_8
Xclkbuf_4_13_0_clk clkload6/A clkbuf_0_clk/X VPWR VGND sg13g2_buf_8
XFILLER_18_405 VPWR VGND sg13g2_decap_8
Xlane0.t_zero.tempo_71 lane0.t_zero.tempo/ARM VPWR VGND sg13g2_tielo
XFILLER_9_114 VPWR VGND sg13g2_decap_8
XFILLER_5_320 VPWR VGND sg13g2_decap_8
XFILLER_3_99 VPWR VGND sg13g2_decap_8
XFILLER_3_44 VPWR VGND sg13g2_decap_8
XFILLER_24_419 VPWR VGND sg13g2_decap_8
XFILLER_15_419 VPWR VGND sg13g2_decap_8
XFILLER_27_235 VPWR VGND sg13g2_decap_8
XFILLER_10_157 VPWR VGND sg13g2_decap_8
XFILLER_6_106 VPWR VGND sg13g2_decap_8
XFILLER_12_86 VPWR VGND sg13g2_decap_8
Xhold180 _0904_/D _0796_/X VPWR VGND sg13g2_dlygate4sd3_1
Xlane3.t_exit.tempo_82 lane3.t_exit.tempo/ARM VPWR VGND sg13g2_tielo
XFILLER_18_235 VPWR VGND sg13g2_decap_8
X_0840_ _0841_/B _0843_/A _0839_/C _0843_/B VPWR VGND sg13g2_a21o_1
X_0771_ _0771_/Y _0770_/Y _0771_/B VPWR VGND sg13g2_nand2b_1
XFILLER_5_150 VPWR VGND sg13g2_decap_8
XFILLER_24_249 VPWR VGND sg13g2_decap_8
X_0969_ _0969_/Q _0975_/CLK _0969_/D _0887_/Y VPWR VGND sg13g2_dfrbpq_1
XFILLER_15_249 VPWR VGND sg13g2_decap_8
XFILLER_28_566 VPWR VGND sg13g2_fill_1
XFILLER_28_555 VPWR VGND sg13g2_decap_8
XFILLER_7_426 VPWR VGND sg13g2_decap_4
X_0823_ _0944_/D _0824_/A _0823_/B VPWR VGND sg13g2_or2_1
X_0754_ _0759_/B _0755_/B _0757_/C _0755_/A VPWR VGND sg13g2_nand3_1
X_0685_ _0686_/B _0688_/A _0685_/B _0692_/A VPWR VGND sg13g2_nand3_1
XFILLER_28_341 VPWR VGND sg13g2_decap_8
XFILLER_11_263 VPWR VGND sg13g2_decap_8
XFILLER_7_256 VPWR VGND sg13g2_decap_8
XFILLER_7_223 VPWR VGND sg13g2_fill_1
XFILLER_3_462 VPWR VGND sg13g2_decap_8
XFILLER_19_341 VPWR VGND sg13g2_decap_8
X_1022_ _1022_/X _1022_/A VPWR VGND sg13g2_buf_1
Xlane2.t_trail.tempo_80 lane2.t_trail.tempo/ARM VPWR VGND sg13g2_tielo
XFILLER_30_561 VPWR VGND sg13g2_fill_2
XFILLER_30_550 VPWR VGND sg13g2_decap_8
X_0806_ _0806_/Y _0806_/A _0861_/A VPWR VGND sg13g2_nor2b_1
X_0737_ _0755_/B _0734_/X _0559_/Y _0736_/Y _0792_/A VPWR VGND sg13g2_a22oi_1
X_0668_ _0668_/Y _0675_/A _0668_/B _0675_/C VPWR VGND sg13g2_nor3_1
X_0599_ _0604_/C _0599_/A _0599_/B VPWR VGND sg13g2_nor2_2
XFILLER_29_105 VPWR VGND sg13g2_decap_8
Xlane3.t_exit.tempo VPWR VGND _0782_/B lane3.t_exit.tempo/ARM _0747_/Y fanout60/X
+ _0562_/A tempo_t150n
XFILLER_4_237 VPWR VGND sg13g2_decap_8
XFILLER_29_84 VPWR VGND sg13g2_decap_8
XFILLER_28_171 VPWR VGND sg13g2_decap_8
Xlane2.t_trail.tempo VPWR VGND _0697_/Y lane2.t_trail.tempo/ARM _0914_/Q fanout59/X
+ _0563_/A tempo_t80n
XFILLER_6_99 VPWR VGND sg13g2_decap_8
XFILLER_19_171 VPWR VGND sg13g2_decap_8
X_1005_ _1005_/X _1005_/A VPWR VGND sg13g2_buf_1
Xrebuffer139 _0770_/B _0591_/B VPWR VGND sg13g2_buf_1
Xrebuffer128 _0757_/B _0755_/B VPWR VGND sg13g2_buf_1
Xrebuffer117 _1015_/A _0696_/X VPWR VGND sg13g2_buf_1
Xrebuffer106 _0681_/B _0679_/B VPWR VGND sg13g2_buf_1
XFILLER_15_86 VPWR VGND sg13g2_decap_8
XFILLER_25_185 VPWR VGND sg13g2_decap_8
XFILLER_21_391 VPWR VGND sg13g2_decap_8
Xoutput30 lp_p[2] _1023_/X VPWR VGND sg13g2_buf_1
XFILLER_16_185 VPWR VGND sg13g2_decap_8
.ends
