* NGSPICE file created from hs_tx_pd.ext - technology: ihp-sg13g2

* Black-box entry subcircuit for sg13g2_decap_8 abstract view
.subckt sg13g2_decap_8 VDD VSS
.ends

* Black-box entry subcircuit for sg13g2_decap_4 abstract view
.subckt sg13g2_decap_4 VDD VSS
.ends

* Black-box entry subcircuit for sg13g2_fill_1 abstract view
.subckt sg13g2_fill_1 VDD VSS
.ends

* Black-box entry subcircuit for sg13g2_buf_2 abstract view
.subckt sg13g2_buf_2 X A VDD VSS
.ends

* Black-box entry subcircuit for sg13g2_inv_1 abstract view
.subckt sg13g2_inv_1 Y A VDD VSS
.ends

* Black-box entry subcircuit for sg13g2_fill_2 abstract view
.subckt sg13g2_fill_2 VDD VSS
.ends

* Black-box entry subcircuit for sg13g2_inv_16 abstract view
.subckt sg13g2_inv_16 Y A VDD VSS
.ends

* Black-box entry subcircuit for sg13g2_nand2_2 abstract view
.subckt sg13g2_nand2_2 Y A B VDD VSS
.ends

.subckt hs_tx_pd VGND VPWR d hsn hsp lpinn lpinp lpn lpp oe
XFILLER_0_35 VPWR VGND sg13g2_decap_8
XFILLER_3_35 VPWR VGND sg13g2_decap_8
XFILLER_3_56 VPWR VGND sg13g2_decap_4
XFILLER_6_34 VPWR VGND sg13g2_decap_8
XFILLER_7_7 VPWR VGND sg13g2_decap_8
XFILLER_0_14 VPWR VGND sg13g2_decap_8
XFILLER_3_14 VPWR VGND sg13g2_decap_8
XFILLER_6_13 VPWR VGND sg13g2_decap_8
XFILLER_1_0 VPWR VGND sg13g2_decap_4
XFILLER_0_28 VPWR VGND sg13g2_decap_8
XFILLER_0_49 VPWR VGND sg13g2_decap_8
XFILLER_3_49 VPWR VGND sg13g2_decap_8
XFILLER_6_48 VPWR VGND sg13g2_decap_8
XFILLER_6_59 VPWR VGND sg13g2_fill_1
XFILLER_3_28 VPWR VGND sg13g2_decap_8
XFILLER_6_27 VPWR VGND sg13g2_decap_8
Xxdt xnn/A d VPWR VGND sg13g2_buf_2
XFILLER_3_7 VPWR VGND sg13g2_decap_8
XFILLER_4_40 VPWR VGND sg13g2_decap_8
XFILLER_1_31 VPWR VGND sg13g2_decap_8
XFILLER_7_42 VPWR VGND sg13g2_decap_8
Xxoeb xlp/B oe VPWR VGND sg13g2_inv_1
XFILLER_4_54 VPWR VGND sg13g2_decap_4
XFILLER_7_21 VPWR VGND sg13g2_decap_8
XFILLER_4_12 VPWR VGND sg13g2_decap_8
XFILLER_4_33 VPWR VGND sg13g2_decap_8
XFILLER_1_24 VPWR VGND sg13g2_decap_8
XFILLER_6_0 VPWR VGND sg13g2_decap_8
XFILLER_7_56 VPWR VGND sg13g2_decap_4
XFILLER_4_47 VPWR VGND sg13g2_decap_8
XFILLER_4_58 VPWR VGND sg13g2_fill_2
XFILLER_7_35 VPWR VGND sg13g2_decap_8
XFILLER_1_38 VPWR VGND sg13g2_fill_2
XFILLER_1_59 VPWR VGND sg13g2_fill_1
XFILLER_4_26 VPWR VGND sg13g2_decap_8
XFILLER_7_14 VPWR VGND sg13g2_decap_8
XFILLER_4_0 VPWR VGND sg13g2_decap_8
XFILLER_7_49 VPWR VGND sg13g2_decap_8
XFILLER_2_0 VPWR VGND sg13g2_decap_8
XFILLER_7_28 VPWR VGND sg13g2_decap_8
XFILLER_2_41 VPWR VGND sg13g2_decap_8
XFILLER_4_19 VPWR VGND sg13g2_decap_8
XFILLER_5_41 VPWR VGND sg13g2_decap_8
XFILLER_0_0 VPWR VGND sg13g2_decap_8
XFILLER_5_20 VPWR VGND sg13g2_decap_8
XFILLER_2_11 VPWR VGND sg13g2_fill_1
XFILLER_2_55 VPWR VGND sg13g2_decap_4
XFILLER_4_7 VPWR VGND sg13g2_fill_2
XFILLER_5_55 VPWR VGND sg13g2_decap_4
Xxdb xnp/A xdb/A VPWR VGND sg13g2_inv_1
XFILLER_5_34 VPWR VGND sg13g2_decap_8
Xxon hsn xon/A VPWR VGND sg13g2_inv_16
XFILLER_5_13 VPWR VGND sg13g2_decap_8
Xxnn xon/A xnn/A oe VPWR VGND sg13g2_nand2_2
XFILLER_2_48 VPWR VGND sg13g2_decap_8
XFILLER_2_59 VPWR VGND sg13g2_fill_1
XFILLER_2_7 VPWR VGND sg13g2_decap_4
Xxop hsp xop/A VPWR VGND sg13g2_inv_16
XFILLER_5_48 VPWR VGND sg13g2_decap_8
XFILLER_5_59 VPWR VGND sg13g2_fill_1
Xxln lpinn lpn xlp/B VPWR VGND sg13g2_nand2_2
Xxnp xop/A xnp/A oe VPWR VGND sg13g2_nand2_2
XFILLER_0_7 VPWR VGND sg13g2_decap_8
XFILLER_5_27 VPWR VGND sg13g2_decap_8
XFILLER_7_0 VPWR VGND sg13g2_decap_8
Xxlp lpinp lpp xlp/B VPWR VGND sg13g2_nand2_2
XFILLER_2_18 VPWR VGND sg13g2_decap_4
XFILLER_0_42 VPWR VGND sg13g2_decap_8
XFILLER_5_0 VPWR VGND sg13g2_decap_8
XFILLER_0_21 VPWR VGND sg13g2_decap_8
XFILLER_3_42 VPWR VGND sg13g2_decap_8
XFILLER_6_41 VPWR VGND sg13g2_decap_8
XFILLER_3_21 VPWR VGND sg13g2_decap_8
XFILLER_6_20 VPWR VGND sg13g2_decap_8
XFILLER_0_56 VPWR VGND sg13g2_decap_4
XFILLER_3_0 VPWR VGND sg13g2_decap_8
XFILLER_6_55 VPWR VGND sg13g2_decap_4
Xxdb1 xdb2/A d VPWR VGND sg13g2_inv_1
Xxdb2 xdb/A xdb2/A VPWR VGND sg13g2_inv_1
.ends
