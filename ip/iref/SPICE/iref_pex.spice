* iref_pex_rc.spice -> iref (vdd vss pg) ; C retirees sur corps rppd flottants : 1.44e-14 F
* NGSPICE file created from iref.ext - technology: ihp-sg13g2

.subckt iref_x VSS VDD PG
X0 PG a_2364_6920# a_2432_6796# VSS.t1 sg13_lv_nmos ad=0.38p pd=2.38u as=0.68p ps=4.68u w=2u l=1u
X1 a_638_5440# a_478_354# VSS.t14 rppd l=25u w=0.5u
X2 a_5218_5640# VDD VSS.t31 rppd l=26u w=0.5u
X3 a_964_6920# a_2432_6796# a_2364_6920# VDD sg13_lv_pmos ad=0.76p pd=4.38u as=1.36p ps=8.68u w=4u l=2u
X4 a_4258_5640# a_4098_354# VSS.t20 rppd l=26u w=0.5u
X5 a_4578_5640# a_4738_354# VSS.t27 rppd l=26u w=0.5u
X6 a_958_5440# a_1118_354# VSS.t0 rppd l=25u w=0.5u
X7 a_3618_5640# VSS VSS.t19 rppd l=26u w=0.5u
X8 a_908_6084# a_908_6084# VSS.t3 VSS.t9 sg13_lv_nmos ad=0.34p pd=2.68u as=0.34p ps=2.68u w=1u l=6u
X9 a_2432_6796# a_2364_6920# PG VSS.t2 sg13_lv_nmos ad=0.68p pd=4.68u as=0.38p ps=2.38u w=2u l=1u
X10 a_638_5440# a_798_354# VSS.t5 rppd l=25u w=0.5u
X11 a_2364_6920# a_2432_6796# a_964_6920# VDD sg13_lv_pmos ad=1.36p pd=8.68u as=0.76p ps=4.38u w=4u l=2u
X12 a_964_6920# a_1260_6796# a_908_6084# VDD sg13_lv_pmos ad=0.76p pd=4.38u as=1.36p ps=8.68u w=4u l=2u
X13 a_4898_5640# a_4738_354# VSS.t29 rppd l=26u w=0.5u
X14 a_1278_5440# a_1118_354# VSS.t16 rppd l=25u w=0.5u
X15 a_3618_5640# a_3778_354# VSS.t25 rppd l=26u w=0.5u
X16 a_2364_6920# a_908_6084# VSS.t8 VSS.t7 sg13_lv_nmos ad=0.34p pd=2.68u as=0.34p ps=2.68u w=1u l=6u
X17 a_908_6084# a_1260_6796# a_964_6920# VDD sg13_lv_pmos ad=1.36p pd=8.68u as=0.76p ps=4.38u w=4u l=2u
X18 a_318_5440# a_268_6796# VSS.t21 rppd l=25u w=0.5u
X19 a_4898_5640# a_5058_354# VSS.t24 rppd l=26u w=0.5u
X20 a_2432_6796# a_2880_354# VSS.t10 rppd l=22u w=1u
X21 a_964_6920# a_268_6796# VDD VDD sg13_lv_pmos ad=0.68p pd=4.68u as=0.68p ps=4.68u w=2u l=1u
X22 a_4258_5640# a_4418_354# VSS.t26 rppd l=26u w=0.5u
X23 a_2100_4840# a_2360_354# VSS.t18 rppd l=22u w=1u
X24 a_2620_4840# a_2880_354# VSS.t13 rppd l=22u w=1u
X25 a_2364_6920# VSS.t3 cap_cmim l=6u w=6u
X26 a_318_5440# a_478_354# VSS.t15 rppd l=25u w=0.5u
X27 a_958_5440# a_798_354# VSS.t6 rppd l=25u w=0.5u
X28 a_1260_6796# a_4098_354# VSS.t22 rppd l=26u w=0.5u
X29 a_268_6796# a_268_6796# VDD VDD sg13_lv_pmos ad=0.68p pd=4.68u as=0.68p ps=4.68u w=2u l=1u
X30 a_4578_5640# a_4418_354# VSS.t30 rppd l=26u w=0.5u
X31 a_1278_5440# VSS VSS.t17 rppd l=25u w=0.5u
X32 a_2100_4840# VSS VSS.t12 rppd l=22u w=1u
X33 a_2620_4840# a_2360_354# VSS.t11 rppd l=22u w=1u
X34 a_1260_6796# a_3778_354# VSS.t23 rppd l=26u w=0.5u
X35 a_5218_5640# a_5058_354# VSS.t28 rppd l=26u w=0.5u
X36 PG PG VDD VDD sg13_lv_pmos ad=0.76p pd=4.38u as=1.36p ps=8.68u w=4u l=4u
X37 VDD PG PG VDD sg13_lv_pmos ad=1.36p pd=8.68u as=0.76p ps=4.38u w=4u l=4u
R0 VSS.t21 VSS.n28 31.4966
R1 VSS.t15 VSS.n27 31.4966
R2 VSS.t14 VSS.n26 31.4966
R3 VSS.t5 VSS.n25 31.4966
R4 VSS.t6 VSS.n24 31.4966
R5 VSS.t0 VSS.n23 31.4966
R6 VSS.t16 VSS.n22 31.4966
R7 VSS.t18 VSS.n16 26.2472
R8 VSS.t9 VSS.n21 22.7477
R9 VSS.t19 VSS.n42 22.7477
R10 VSS.n43 VSS.t25 22.7477
R11 VSS.n45 VSS.t22 22.7477
R12 VSS.n46 VSS.t20 22.7477
R13 VSS.n47 VSS.t26 22.7477
R14 VSS.n48 VSS.t30 22.7477
R15 VSS.n49 VSS.t27 22.7477
R16 VSS.n50 VSS.t29 22.7477
R17 VSS.n51 VSS.t24 22.7477
R18 VSS.n86 VSS.t28 22.7477
R19 VSS.n84 VSS.t31 22.7477
R20 VSS.n73 VSS.t7 20.9979
R21 VSS.n57 VSS.t11 17.4983
R22 VSS.t11 VSS.n38 17.4983
R23 VSS.t1 VSS.t23 17.4983
R24 VSS.n54 VSS.n12 17.2468
R25 VSS.n58 VSS.n15 17.2468
R26 VSS.n60 VSS.n17 17.2468
R27 VSS.n61 VSS.n18 17.2468
R28 VSS.n62 VSS.n19 17.2468
R29 VSS.n64 VSS.n20 17.2468
R30 VSS.n63 VSS.n20 17.2468
R31 VSS.n63 VSS.n36 17.2468
R32 VSS.n62 VSS.n36 17.2468
R33 VSS.n61 VSS.n19 17.2468
R34 VSS.n59 VSS.n17 17.2468
R35 VSS.n72 VSS.n14 17.2468
R36 VSS.n56 VSS.n39 17.2468
R37 VSS.n55 VSS.n39 17.2468
R38 VSS.n54 VSS.n40 17.2468
R39 VSS.n53 VSS.n12 17.2468
R40 VSS.n53 VSS.n41 17.2468
R41 VSS.n84 VSS 17.0007
R42 VSS VSS.n1 17.0005
R43 VSS VSS.n86 17.0005
R44 VSS VSS.n2 17.0005
R45 VSS VSS.n51 17.0005
R46 VSS VSS.n3 17.0005
R47 VSS VSS.n50 17.0005
R48 VSS VSS.n4 17.0005
R49 VSS VSS.n49 17.0005
R50 VSS VSS.n5 17.0005
R51 VSS VSS.n48 17.0005
R52 VSS VSS.n6 17.0005
R53 VSS VSS.n47 17.0005
R54 VSS VSS.n7 17.0005
R55 VSS VSS.n46 17.0005
R56 VSS VSS.n8 17.0005
R57 VSS VSS.n45 17.0005
R58 VSS VSS.n9 17.0005
R59 VSS VSS.n44 17.0005
R60 VSS VSS.n10 17.0005
R61 VSS VSS.n43 17.0005
R62 VSS VSS.n11 17.0005
R63 VSS VSS.n42 17.0005
R64 VSS VSS.n13 17.0005
R65 VSS VSS.n38 17.0005
R66 VSS VSS.n16 17.0005
R67 VSS VSS.n37 17.0005
R68 VSS VSS.n21 17.0005
R69 VSS VSS.n35 17.0005
R70 VSS VSS.n22 17.0005
R71 VSS VSS.n34 17.0005
R72 VSS VSS.n23 17.0005
R73 VSS VSS.n33 17.0005
R74 VSS VSS.n24 17.0005
R75 VSS VSS.n32 17.0005
R76 VSS VSS.n25 17.0005
R77 VSS VSS.n31 17.0005
R78 VSS VSS.n26 17.0005
R79 VSS VSS.n30 17.0005
R80 VSS VSS.n27 17.0005
R81 VSS VSS.n29 17.0005
R82 VSS VSS.n28 17.0005
R83 VSS.t3 VSS.n84 17.0005
R84 VSS.t3 VSS.n52 17.0005
R85 VSS.t3 VSS.n73 17.0005
R86 VSS.t3 VSS.n57 17.0005
R87 VSS.n52 VSS.t19 12.249
R88 VSS.t25 VSS.n11 12.249
R89 VSS.t23 VSS.n10 12.249
R90 VSS.t22 VSS.n9 12.249
R91 VSS.t26 VSS.n7 12.249
R92 VSS.t30 VSS.n6 12.249
R93 VSS.t27 VSS.n5 12.249
R94 VSS.t29 VSS.n4 12.249
R95 VSS.t24 VSS.n3 12.249
R96 VSS.t28 VSS.n2 12.249
R97 VSS.t31 VSS.n1 12.249
R98 VSS.t2 VSS.n8 10.4992
R99 VSS.t17 VSS.t9 8.74941
R100 VSS.n37 VSS.t18 8.74941
R101 VSS.t13 VSS.n13 8.74941
R102 VSS.n52 VSS.n41 8.62366
R103 VSS.n73 VSS.n14 8.62366
R104 VSS.n85 VSS.n1 8.62366
R105 VSS.n83 VSS.n2 8.62366
R106 VSS.n82 VSS.n3 8.62366
R107 VSS.n81 VSS.n4 8.62366
R108 VSS.n80 VSS.n5 8.62366
R109 VSS.n79 VSS.n6 8.62366
R110 VSS.n78 VSS.n7 8.62366
R111 VSS.n77 VSS.n8 8.62366
R112 VSS.n76 VSS.n9 8.62366
R113 VSS.n75 VSS.n10 8.62366
R114 VSS.n74 VSS.n11 8.62366
R115 VSS.n55 VSS.t10 8.62366
R116 VSS.n59 VSS.n37 8.62366
R117 VSS.n65 VSS.n35 8.62366
R118 VSS.n66 VSS.n34 8.62366
R119 VSS.n67 VSS.n33 8.62366
R120 VSS.n68 VSS.n32 8.62366
R121 VSS.n69 VSS.n31 8.62366
R122 VSS.n70 VSS.n30 8.62366
R123 VSS.n71 VSS.n29 8.62366
R124 VSS.t3 VSS.n0 4.25232
R125 VSS.n71 VSS.n28 8.62366
R126 VSS.n70 VSS.n27 8.62366
R127 VSS.n69 VSS.n26 8.62366
R128 VSS.n68 VSS.n25 8.62366
R129 VSS.n67 VSS.n24 8.62366
R130 VSS.n66 VSS.n23 8.62366
R131 VSS.n65 VSS.n22 8.62366
R132 VSS.n64 VSS.n21 8.62366
R133 VSS.t12 VSS.n18 8.62366
R134 VSS.n60 VSS.t12 8.62366
R135 VSS.n58 VSS.n16 8.62366
R136 VSS.n57 VSS.n15 8.62366
R137 VSS.n72 VSS.n38 8.62366
R138 VSS.n56 VSS.n13 8.62366
R139 VSS.t10 VSS.n40 8.62366
R140 VSS.n74 VSS.n42 8.62366
R141 VSS.n75 VSS.n43 8.62366
R142 VSS.n76 VSS.n44 8.62366
R143 VSS.n77 VSS.n45 8.62366
R144 VSS.n78 VSS.n46 8.62366
R145 VSS.n79 VSS.n47 8.62366
R146 VSS.n80 VSS.n48 8.62366
R147 VSS.n81 VSS.n49 8.62366
R148 VSS.n82 VSS.n50 8.62366
R149 VSS.n83 VSS.n51 8.62366
R150 VSS.n86 VSS.n85 8.62366
R151 VSS.t3 VSS 5.44006
R152 VSS.t7 VSS.t13 5.24984
R153 VSS.n44 VSS.t1 5.24984
R154 VSS VSS.n12 4.18967
R155 VSS VSS.n40 4.18967
R156 VSS VSS.n39 4.18967
R157 VSS VSS.n14 4.18967
R158 VSS VSS.n15 4.18967
R159 VSS VSS.n17 4.18967
R160 VSS VSS.n18 4.18967
R161 VSS VSS.n19 4.18967
R162 VSS VSS.n36 4.18967
R163 VSS VSS.n20 4.18967
R164 VSS.n85 VSS.t3 4.18967
R165 VSS.t3 VSS.n83 4.18967
R166 VSS.t3 VSS.n82 4.18967
R167 VSS.t3 VSS.n81 4.18967
R168 VSS.t3 VSS.n80 4.18967
R169 VSS.t3 VSS.n79 4.18967
R170 VSS.t3 VSS.n78 4.18967
R171 VSS.t3 VSS.n77 4.18967
R172 VSS.t3 VSS.n76 4.18967
R173 VSS.t3 VSS.n75 4.18967
R174 VSS.t3 VSS.n74 4.18967
R175 VSS.t3 VSS.n53 4.18967
R176 VSS.t3 VSS.n54 4.18967
R177 VSS.t3 VSS.n55 4.18967
R178 VSS.t3 VSS.n56 4.18967
R179 VSS.t3 VSS.n72 4.18967
R180 VSS.t3 VSS.n58 4.18967
R181 VSS.t3 VSS.n59 4.18967
R182 VSS.t3 VSS.n60 4.18967
R183 VSS.t3 VSS.n61 4.18967
R184 VSS.t3 VSS.n62 4.18967
R185 VSS.t3 VSS.n63 4.18967
R186 VSS.t3 VSS.n64 4.18967
R187 VSS.t3 VSS.n65 4.18967
R188 VSS.t3 VSS.n66 4.18967
R189 VSS.t3 VSS.n67 4.18967
R190 VSS.t3 VSS.n68 4.18967
R191 VSS.t3 VSS.n69 4.18967
R192 VSS.t3 VSS.n70 4.18967
R193 VSS.t3 VSS.n71 4.18967
R194 VSS.n0 VSS 4.2515
R195 VSS.n0 VSS.t21 8.44695
R196 VSS VSS.n41 4.99925
R197 VSS.n29 VSS.t15 3.50006
R198 VSS.n30 VSS.t14 3.50006
R199 VSS.n31 VSS.t5 3.50006
R200 VSS.n32 VSS.t6 3.50006
R201 VSS.n33 VSS.t0 3.50006
R202 VSS.n34 VSS.t16 3.50006
R203 VSS.n35 VSS.t17 3.50006
R204 VSS.t20 VSS.t2 1.75028
R205 VSS.t3 VSS.t8 1.02703
C5 a_964_6920# a_2432_6796# 0.41052f
C8 a_1278_5440# a_908_6084# 0.00221f
C12 a_958_5440# a_908_6084# 0.00221f
C13 a_2364_6920# VDD 0.51487f
C14 a_2364_6920# a_4578_5640# 0
C16 a_4418_354# a_4098_354# 0.02433f
C21 a_798_354# a_268_6796# 0.00191f
C24 a_2364_6920# a_2432_6796# 1.17175f
C26 a_964_6920# a_908_6084# 0.16874f
C27 a_2620_4840# a_2432_6796# 0.03037f
C29 VDD a_268_6796# 0.94643f
C30 a_2364_6920# a_3618_5640# 0
C31 a_318_5440# a_268_6796# 0.03585f
C32 a_2432_6796# a_2100_4840# 0.00107f
C39 a_4738_354# VDD 0.00191f
C44 a_2364_6920# a_908_6084# 0.2761f
C46 a_2620_4840# a_908_6084# 0.00206f
C50 a_908_6084# a_2100_4840# 0.00111f
C53 a_964_6920# a_1260_6796# 0.50982f
C54 a_958_5440# a_638_5440# 0.02433f
C59 a_2364_6920# a_4258_5640# 0.00181f
C62 a_268_6796# a_908_6084# 0.0349f
C71 a_318_5440# VDD 0
C72 a_4578_5640# VDD 0.00117f
C73 a_5218_5640# VDD 0.03327f
C74 a_4898_5640# a_2364_6920# -0
C76 a_2364_6920# a_1260_6796# 0.03049f
C82 a_1260_6796# a_2620_4840# 0.00408f
C84 a_2364_6920# PG 0.45076f
C89 a_1260_6796# a_2100_4840# 0.00408f
C93 VDD a_2432_6796# 1.93925f
C95 a_4578_5640# a_2432_6796# 0
C96 a_958_5440# a_1278_5440# 0.02433f
C99 VDD a_3618_5640# 0
C101 a_478_354# a_268_6796# 0.03213f
C102 a_1260_6796# a_268_6796# 0.01507f
C110 a_268_6796# a_1118_354# 0
C113 a_3618_5640# a_2432_6796# 0.00591f
C116 VDD a_908_6084# 0.29665f
C121 a_638_5440# a_268_6796# 0.00387f
C125 a_908_6084# a_2432_6796# 0.17532f
C127 a_4258_5640# VDD 0
C129 a_4258_5640# a_4578_5640# 0.02433f
C130 a_478_354# a_798_354# 0.02433f
C133 VDD a_4098_354# 0
C136 a_4738_354# a_5058_354# 0.02433f
C137 a_3778_354# VDD 0
C139 a_798_354# a_1118_354# 0.02433f
C140 a_4898_5640# VDD 0.00336f
C141 a_4258_5640# a_2432_6796# 0.00265f
C142 a_1260_6796# VDD 1.92406f
C143 a_4898_5640# a_4578_5640# 0.02433f
C144 a_4898_5640# a_5218_5640# 0.02433f
C145 a_1260_6796# a_4578_5640# 0.00285f
C146 a_1260_6796# a_5218_5640# 0
C148 PG VDD 4.60414f
C150 a_4418_354# a_4738_354# 0.02433f
C151 PG a_4578_5640# 0.00209f
C153 PG a_5218_5640# 0.00124f
C154 a_1278_5440# a_268_6796# 0
C155 a_964_6920# a_2364_6920# 0.07603f
C157 a_958_5440# a_268_6796# 0.00117f
C159 a_1260_6796# a_2432_6796# 0.12617f
C160 PG a_2432_6796# 0.15698f
C161 a_1260_6796# a_3618_5640# 0.04668f
C162 a_638_5440# VDD 0
C163 a_318_5440# a_638_5440# 0.02433f
C165 a_2360_354# a_2880_354# 0.02433f
C167 PG a_3618_5640# 0.00113f
C170 VDD a_5058_354# 0.03213f
C172 a_964_6920# a_268_6796# 0.06087f
C176 a_1260_6796# a_908_6084# 1.09331f
C177 a_4418_354# VDD 0
C179 a_2620_4840# a_2100_4840# 0.02433f
C181 PG a_908_6084# 0.00133f
C189 a_1260_6796# a_4258_5640# 0.03202f
C190 a_3778_354# a_4098_354# 0.02433f
C195 PG a_4258_5640# 0.00166f
C201 a_4898_5640# a_1260_6796# 0.00142f
C204 a_4898_5640# PG 0.00207f
C205 a_1260_6796# PG 0.00881f
C206 a_964_6920# VDD 1.24041f
C211 VDD VSS 9.40268f
C212 a_5218_5640# VSS 2.46773f
C213 a_5058_354# VSS 2.06445f
C214 a_4898_5640# VSS 2.05781f
C215 a_4738_354# VSS 2.05846f
C216 a_4578_5640# VSS 2.06026f
C217 a_4418_354# VSS 2.07782f
C218 a_4258_5640# VSS 2.05614f
C219 a_4098_354# VSS 2.05377f
C220 a_3778_354# VSS 2.0781f
C221 a_2880_354# VSS 3.11635f
C222 a_2620_4840# VSS 2.84508f
C223 a_2360_354# VSS 2.88975f
C224 a_2100_4840# VSS 3.16031f
C225 a_1278_5440# VSS 2.32196f
C226 a_1118_354# VSS 2.02331f
C227 a_958_5440# VSS 1.96104f
C228 a_798_354# VSS 1.98943f
C229 a_638_5440# VSS 1.97897f
C230 a_478_354# VSS 2.03273f
C231 a_318_5440# VSS 2.50013f
C232 a_3618_5640# VSS 2.35731f
C233 a_964_6920# VSS 4.50743f
C234 a_2432_6796# VSS 1.49003f
C235 a_1260_6796# VSS 1.86741f
C236 VSS.t8 VSS 0.38387f
C237 VSS.t3 VSS 2.87676f
.ends iref_x

.subckt iref vdd vss pg
Xx vss vdd pg iref_x
.ends iref
