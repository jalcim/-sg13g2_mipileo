* NGSPICE file created from sr16_rx4.ext - technology: ihp-sg13g2

.subckt sg13_lv_nmos_AD63GD G D8 D6 sub D4 D2 D0 S8 S7 S5 S3 S1
X0 S1 G D0 sub sg13_lv_nmos ad=63.19999f pd=0.74u as=0.1082p ps=1.34u w=0.26u l=0.38u
X1 S3 G D2 sub sg13_lv_nmos ad=63.19999f pd=0.74u as=63.19999f ps=0.74u w=0.26u l=0.38u
X2 D8 G S7 sub sg13_lv_nmos ad=63.19999f pd=0.74u as=63.19999f ps=0.74u w=0.26u l=0.38u
X3 D6 G S5 sub sg13_lv_nmos ad=63.19999f pd=0.74u as=63.19999f ps=0.74u w=0.26u l=0.38u
X4 D4 G S3 sub sg13_lv_nmos ad=63.19999f pd=0.74u as=63.19999f ps=0.74u w=0.26u l=0.38u
X5 S5 G D4 sub sg13_lv_nmos ad=63.19999f pd=0.74u as=63.19999f ps=0.74u w=0.26u l=0.38u
X6 S7 G D6 sub sg13_lv_nmos ad=63.19999f pd=0.74u as=63.19999f ps=0.74u w=0.26u l=0.38u
X7 D2 G S1 sub sg13_lv_nmos ad=63.19999f pd=0.74u as=63.19999f ps=0.74u w=0.26u l=0.38u
X8 S8 G D8 sub sg13_lv_nmos ad=0.1082p pd=1.34u as=63.19999f ps=0.74u w=0.26u l=0.38u
.ends

.subckt rppd_6K5NNH B R2 R1
X0 R1 R2 B rppd l=5.17u w=1u
.ends

.subckt sg13_lv_nmos_72NHQF D10 G S12 S11 D8 D6 sub D4 D2 D0 S9 S7 S5 S3 S1 D12
X0 D8 G S7 sub sg13_lv_nmos ad=89.3f pd=0.85u as=89.3f ps=0.85u w=0.47u l=0.16u
X1 S9 G D8 sub sg13_lv_nmos ad=89.3f pd=0.85u as=89.3f ps=0.85u w=0.47u l=0.16u
X2 S7 G D6 sub sg13_lv_nmos ad=89.3f pd=0.85u as=89.3f ps=0.85u w=0.47u l=0.16u
X3 D10 G S9 sub sg13_lv_nmos ad=89.3f pd=0.85u as=89.3f ps=0.85u w=0.47u l=0.16u
X4 S11 G D10 sub sg13_lv_nmos ad=89.3f pd=0.85u as=89.3f ps=0.85u w=0.47u l=0.16u
X5 D12 G S11 sub sg13_lv_nmos ad=89.3f pd=0.85u as=89.3f ps=0.85u w=0.47u l=0.16u
X6 D6 G S5 sub sg13_lv_nmos ad=89.3f pd=0.85u as=89.3f ps=0.85u w=0.47u l=0.16u
X7 S12 G D12 sub sg13_lv_nmos ad=0.1598p pd=1.62u as=89.3f ps=0.85u w=0.47u l=0.16u
X8 S5 G D4 sub sg13_lv_nmos ad=89.3f pd=0.85u as=89.3f ps=0.85u w=0.47u l=0.16u
X9 D4 G S3 sub sg13_lv_nmos ad=89.3f pd=0.85u as=89.3f ps=0.85u w=0.47u l=0.16u
X10 S3 G D2 sub sg13_lv_nmos ad=89.3f pd=0.85u as=89.3f ps=0.85u w=0.47u l=0.16u
X11 D2 G S1 sub sg13_lv_nmos ad=89.3f pd=0.85u as=89.3f ps=0.85u w=0.47u l=0.16u
X12 S1 G D0 sub sg13_lv_nmos ad=89.3f pd=0.85u as=0.1598p ps=1.62u w=0.47u l=0.16u
.ends

.subckt sg13_lv_nmos_KUKXB4 D22 S17 D10 D20 S15 G S13 S23 S11 S21 D8 D6 sub D4 D2
+ D0 S9 S7 D18 S5 a_1420_n17# D16 S3 D14 S19 S1 D12
X0 S7 G D6 sub sg13_lv_nmos ad=56.9f pd=0.74u as=56.9f ps=0.74u w=0.17u l=0.17u
X1 D16 G S15 sub sg13_lv_nmos ad=56.9f pd=0.74u as=56.9f ps=0.74u w=0.17u l=0.17u
X2 S21 G D20 sub sg13_lv_nmos ad=56.9f pd=0.74u as=56.9f ps=0.74u w=0.17u l=0.17u
X3 D18 G S17 sub sg13_lv_nmos ad=56.9f pd=0.74u as=56.9f ps=0.74u w=0.17u l=0.17u
X4 S23 G D22 sub sg13_lv_nmos ad=56.9f pd=0.74u as=56.9f ps=0.74u w=0.17u l=0.17u
X5 D20 G S19 sub sg13_lv_nmos ad=56.9f pd=0.74u as=56.9f ps=0.74u w=0.17u l=0.17u
X6 S3 G D2 sub sg13_lv_nmos ad=56.9f pd=0.74u as=56.9f ps=0.74u w=0.17u l=0.17u
X7 S5 G D4 sub sg13_lv_nmos ad=56.9f pd=0.74u as=56.9f ps=0.74u w=0.17u l=0.17u
X8 S15 G D14 sub sg13_lv_nmos ad=56.9f pd=0.74u as=56.9f ps=0.74u w=0.17u l=0.17u
X9 D10 G S9 sub sg13_lv_nmos ad=56.9f pd=0.74u as=56.9f ps=0.74u w=0.17u l=0.17u
X10 D8 G S7 sub sg13_lv_nmos ad=56.9f pd=0.74u as=56.9f ps=0.74u w=0.17u l=0.17u
X11 S13 G D12 sub sg13_lv_nmos ad=56.9f pd=0.74u as=56.9f ps=0.74u w=0.17u l=0.17u
X12 S11 G D10 sub sg13_lv_nmos ad=56.9f pd=0.74u as=56.9f ps=0.74u w=0.17u l=0.17u
X13 S17 G D16 sub sg13_lv_nmos ad=56.9f pd=0.74u as=56.9f ps=0.74u w=0.17u l=0.17u
X14 S1 G D0 sub sg13_lv_nmos ad=56.9f pd=0.74u as=0.1019p ps=1.34u w=0.17u l=0.17u
X15 D22 G S21 sub sg13_lv_nmos ad=56.9f pd=0.74u as=56.9f ps=0.74u w=0.17u l=0.17u
X16 S19 G D18 sub sg13_lv_nmos ad=56.9f pd=0.74u as=56.9f ps=0.74u w=0.17u l=0.17u
X17 D14 G S13 sub sg13_lv_nmos ad=56.9f pd=0.74u as=56.9f ps=0.74u w=0.17u l=0.17u
X18 a_1420_n17# G S23 sub sg13_lv_nmos ad=0.1019p pd=1.34u as=56.9f ps=0.74u w=0.17u l=0.17u
X19 D4 G S3 sub sg13_lv_nmos ad=56.9f pd=0.74u as=56.9f ps=0.74u w=0.17u l=0.17u
X20 D6 G S5 sub sg13_lv_nmos ad=56.9f pd=0.74u as=56.9f ps=0.74u w=0.17u l=0.17u
X21 D2 G S1 sub sg13_lv_nmos ad=56.9f pd=0.74u as=56.9f ps=0.74u w=0.17u l=0.17u
X22 D12 G S11 sub sg13_lv_nmos ad=56.9f pd=0.74u as=56.9f ps=0.74u w=0.17u l=0.17u
X23 S9 G D8 sub sg13_lv_nmos ad=56.9f pd=0.74u as=56.9f ps=0.74u w=0.17u l=0.17u
.ends

.subckt sg13_lv_nmos_98SV2Z G sub D2 a_166_n823# D0 S3 S1
X0 S3 G D2 sub sg13_lv_nmos ad=1.5637p pd=8.61u as=1.5637p ps=8.61u w=8.23u l=0.13u
X1 D2 G S1 sub sg13_lv_nmos ad=1.5637p pd=8.61u as=1.5637p ps=8.61u w=8.23u l=0.13u
X2 a_166_n823# G S3 sub sg13_lv_nmos ad=2.7982p pd=17.14u as=1.5637p ps=8.61u w=8.23u l=0.13u
X3 S1 G D0 sub sg13_lv_nmos ad=1.5637p pd=8.61u as=2.7982p ps=17.14u w=8.23u l=0.13u
.ends

.subckt cml_tlatch VDD OUTN OUTP CKN CKP INP INN POLN VSS
Xxamp.xn INN xmux.xn/S9 xmux.xn/S9 VSS xmux.xn/S9 xmux.xn/S9 xmux.xn/S9 OUTP OUTP
+ OUTP OUTP OUTP sg13_lv_nmos_AD63GD
Xxamp.xp INP xmux.xn/S9 xmux.xn/S9 VSS xmux.xn/S9 xmux.xn/S9 xmux.xn/S9 OUTN OUTN
+ OUTN OUTN OUTN sg13_lv_nmos_AD63GD
Xxlp.xrl VSS OUTP VDD rppd_6K5NNH
Xxmux.xn xtail/S3 CKP xmux.xn/S9 xmux.xn/S9 xtail/S3 xtail/S3 VSS xtail/S3 xtail/S3
+ xtail/S3 xmux.xn/S9 xmux.xn/S9 xmux.xn/S9 xmux.xn/S9 xmux.xn/S9 xtail/S3 sg13_lv_nmos_72NHQF
Xxmux.xp xtail/S3 CKN xmux.xp/S9 xmux.xp/S9 xtail/S3 xtail/S3 VSS xtail/S3 xtail/S3
+ xtail/S3 xmux.xp/S9 xmux.xp/S9 xmux.xp/S9 xmux.xp/S9 xmux.xp/S9 xtail/S3 sg13_lv_nmos_72NHQF
Xxln.xrl VSS OUTN VDD rppd_6K5NNH
Xxmem.xn xmux.xp/S9 OUTN xmux.xp/S9 xmux.xp/S9 OUTN OUTP OUTN OUTN OUTN OUTN xmux.xp/S9
+ xmux.xp/S9 VSS xmux.xp/S9 xmux.xp/S9 xmux.xp/S9 OUTN OUTN xmux.xp/S9 OUTN xmux.xp/S9
+ xmux.xp/S9 OUTN xmux.xp/S9 OUTN OUTN xmux.xp/S9 sg13_lv_nmos_KUKXB4
Xxmem.xp xmux.xp/S9 OUTP xmux.xp/S9 xmux.xp/S9 OUTP OUTN OUTP OUTP OUTP OUTP xmux.xp/S9
+ xmux.xp/S9 VSS xmux.xp/S9 xmux.xp/S9 xmux.xp/S9 OUTP OUTP xmux.xp/S9 OUTP xmux.xp/S9
+ xmux.xp/S9 OUTP xmux.xp/S9 OUTP OUTP xmux.xp/S9 sg13_lv_nmos_KUKXB4
Xxtail POLN VSS VSS VSS VSS xtail/S3 xtail/S3 sg13_lv_nmos_98SV2Z
.ends

.subckt sg13_lv_nmos_5A5R5E G sub D0 a_80_n77# S1
X0 S1 G D0 sub sg13_lv_nmos ad=0.1463p pd=1.15u as=0.2618p ps=2.22u w=0.77u l=0.21u
X1 a_80_n77# G S1 sub sg13_lv_nmos ad=0.2618p pd=2.22u as=0.1463p ps=1.15u w=0.77u l=0.21u
.ends

.subckt rppd_2ZAP6P B R2 R1
X0 R1 R2 B rppd l=13.09u w=1u
.ends

.subckt rppd_ACUNYL B R2 R1
X0 R1 R2 B rppd l=2.72u w=1u
.ends

.subckt cml_drvb VDD INP OUTN OUTP INN VSS
Xxamp.xn INP VSS OUTN OUTN xrtail/R1 sg13_lv_nmos_5A5R5E
Xxamp.xp INN VSS OUTP OUTP xrtail/R1 sg13_lv_nmos_5A5R5E
Xxlp.xrl VSS OUTP VDD rppd_2ZAP6P
Xxrtail VSS VSS xrtail/R1 rppd_ACUNYL
Xxln.xrl VSS VDD OUTN rppd_2ZAP6P
.ends

.subckt rppd_RFWDE4 B R2 R1
X0 R1 R2 B rppd l=4.25u w=1u
.ends

.subckt sg13_lv_nmos_2HGZLP G D8 D6 sub D4 a_1722_n1090# D2 D0 S9 S7 S5 S3 S1
X0 D6 G S5 sub sg13_lv_nmos ad=2.071p pd=11.28u as=2.071p ps=11.28u w=10.9u l=1.38u
X1 D4 G S3 sub sg13_lv_nmos ad=2.071p pd=11.28u as=2.071p ps=11.28u w=10.9u l=1.38u
X2 S7 G D6 sub sg13_lv_nmos ad=2.071p pd=11.28u as=2.071p ps=11.28u w=10.9u l=1.38u
X3 S9 G D8 sub sg13_lv_nmos ad=2.071p pd=11.28u as=2.071p ps=11.28u w=10.9u l=1.38u
X4 S5 G D4 sub sg13_lv_nmos ad=2.071p pd=11.28u as=2.071p ps=11.28u w=10.9u l=1.38u
X5 S1 G D0 sub sg13_lv_nmos ad=2.071p pd=11.28u as=3.706p ps=22.48u w=10.9u l=1.38u
X6 D2 G S1 sub sg13_lv_nmos ad=2.071p pd=11.28u as=2.071p ps=11.28u w=10.9u l=1.38u
X7 S3 G D2 sub sg13_lv_nmos ad=2.071p pd=11.28u as=2.071p ps=11.28u w=10.9u l=1.38u
X8 D8 G S7 sub sg13_lv_nmos ad=2.071p pd=11.28u as=2.071p ps=11.28u w=10.9u l=1.38u
X9 a_1722_n1090# G S9 sub sg13_lv_nmos ad=3.706p pd=22.48u as=2.071p ps=11.28u w=10.9u l=1.38u
.ends

.subckt sg13_lv_nmos_G385L9 G a_166_n1000# sub D2 D0 S3 S1
X0 D2 G S1 sub sg13_lv_nmos ad=1.9p pd=10.38u as=1.9p ps=10.38u w=10u l=0.13u
X1 a_166_n1000# G S3 sub sg13_lv_nmos ad=3.4p pd=20.68u as=1.9p ps=10.38u w=10u l=0.13u
X2 S1 G D0 sub sg13_lv_nmos ad=1.9p pd=10.38u as=3.4p ps=20.68u w=10u l=0.13u
X3 S3 G D2 sub sg13_lv_nmos ad=1.9p pd=10.38u as=1.9p ps=10.38u w=10u l=0.13u
.ends

.subckt sg13_lv_nmos_B8H2RM G sub D2 D0 S2 S1
X0 D2 G S1 sub sg13_lv_nmos ad=0.228p pd=1.58u as=0.228p ps=1.58u w=1.2u l=0.2u
X1 S2 G D2 sub sg13_lv_nmos ad=0.408p pd=3.08u as=0.228p ps=1.58u w=1.2u l=0.2u
X2 S1 G D0 sub sg13_lv_nmos ad=0.228p pd=1.58u as=0.408p ps=3.08u w=1.2u l=0.2u
.ends

.subckt rppd_HNU9MK B R2 R1
X0 R1 R2 B rppd l=0.68u w=1u
.ends

.subckt hs_to_clk VDD INN INP OUTN OUTP POLN VSS
Xrppd_RFWDE4_0 VSS rppd_RFWDE4_1/R1 OUTN rppd_RFWDE4
Xrppd_RFWDE4_1 VSS OUTP rppd_RFWDE4_1/R1 rppd_RFWDE4
Xsg13_lv_nmos_2HGZLP_0 rppd_RFWDE4_1/R1 VSS VSS VSS VSS VSS VSS VSS VSS VSS VSS VSS
+ VSS sg13_lv_nmos_2HGZLP
Xsg13_lv_nmos_G385L9_0 POLN D2 VSS D2 D2 VSS VSS sg13_lv_nmos_G385L9
Xsg13_lv_nmos_B8H2RM_0 INN VSS D2 D2 OUTN OUTN sg13_lv_nmos_B8H2RM
Xrppd_HNU9MK_0 VSS rppd_RFWDE4_1/R1 VDD rppd_HNU9MK
X0 D2 INP OUTP VSS sg13_lv_nmos ad=0.228p pd=1.58u as=0.408p ps=3.08u w=1.2u l=0.2u
X1 D2 INP OUTP VSS sg13_lv_nmos ad=0.408p pd=3.08u as=0.228p ps=1.58u w=1.2u l=0.2u
X2 OUTP INP D2 VSS sg13_lv_nmos ad=0.228p pd=1.58u as=0.228p ps=1.58u w=1.2u l=0.2u
.ends

.subckt rppd_W2KASE B R2 R1
X0 R1 R2 B rppd l=7.42u w=1u
.ends

.subckt sg13_lv_nmos_FTPY57 D10 G S11 D8 D6 sub D4 D2 D0 S9 S7 S5 S3 a_574_n53# S1
X0 S5 G D4 sub sg13_lv_nmos ad=0.1007p pd=0.91u as=0.1007p ps=0.91u w=0.53u l=0.13u
X1 D4 G S3 sub sg13_lv_nmos ad=0.1007p pd=0.91u as=0.1007p ps=0.91u w=0.53u l=0.13u
X2 S3 G D2 sub sg13_lv_nmos ad=0.1007p pd=0.91u as=0.1007p ps=0.91u w=0.53u l=0.13u
X3 D2 G S1 sub sg13_lv_nmos ad=0.1007p pd=0.91u as=0.1007p ps=0.91u w=0.53u l=0.13u
X4 S1 G D0 sub sg13_lv_nmos ad=0.1007p pd=0.91u as=0.1802p ps=1.74u w=0.53u l=0.13u
X5 D8 G S7 sub sg13_lv_nmos ad=0.1007p pd=0.91u as=0.1007p ps=0.91u w=0.53u l=0.13u
X6 S9 G D8 sub sg13_lv_nmos ad=0.1007p pd=0.91u as=0.1007p ps=0.91u w=0.53u l=0.13u
X7 D10 G S9 sub sg13_lv_nmos ad=0.1007p pd=0.91u as=0.1007p ps=0.91u w=0.53u l=0.13u
X8 S11 G D10 sub sg13_lv_nmos ad=0.1007p pd=0.91u as=0.1007p ps=0.91u w=0.53u l=0.13u
X9 D6 G S5 sub sg13_lv_nmos ad=0.1007p pd=0.91u as=0.1007p ps=0.91u w=0.53u l=0.13u
X10 a_574_n53# G S11 sub sg13_lv_nmos ad=0.1802p pd=1.74u as=0.1007p ps=0.91u w=0.53u l=0.13u
X11 S7 G D6 sub sg13_lv_nmos ad=0.1007p pd=0.91u as=0.1007p ps=0.91u w=0.53u l=0.13u
.ends

.subckt rppd_XV6GFH B R2 R1
X0 R1 R2 B rppd l=4.86u w=1u
.ends

.subckt cml_gate2 VDD AN AP XN XP BN BP VSS
Xxlp.xrl VSS XP VDD rppd_W2KASE
Xsg13_lv_nmos_FTPY57_0 xmux.xn/S9 AN XP xmux.xn/S9 xmux.xn/S9 VSS xmux.xn/S9 xmux.xn/S9
+ xmux.xn/S9 XP XP XP XP xmux.xn/S9 XP sg13_lv_nmos_FTPY57
Xsg13_lv_nmos_FTPY57_1 xmux.xn/S9 AP XN xmux.xn/S9 xmux.xn/S9 VSS xmux.xn/S9 xmux.xn/S9
+ xmux.xn/S9 XN XN XN XN xmux.xn/S9 XN sg13_lv_nmos_FTPY57
Xxmux.xn xrtail/R1 BP xmux.xn/S9 xrtail/R1 xrtail/R1 VSS xrtail/R1 xrtail/R1 xrtail/R1
+ xmux.xn/S9 xmux.xn/S9 xmux.xn/S9 xmux.xn/S9 xrtail/R1 xmux.xn/S9 sg13_lv_nmos_FTPY57
Xxrtail VSS VSS xrtail/R1 rppd_XV6GFH
Xxmux.xp xrtail/R1 BN XP xrtail/R1 xrtail/R1 VSS xrtail/R1 xrtail/R1 xrtail/R1 XP
+ XP XP XP xrtail/R1 XP sg13_lv_nmos_FTPY57
Xxln.xrl VSS XN VDD rppd_W2KASE
.ends

.subckt sg13_lv_nmos_MZQ2E7 D10 G S10 D8 D6 sub D4 D2 D0 S9 S7 S5 S3 S1
X0 S9 G D8 sub sg13_lv_nmos ad=56.2f pd=0.74u as=56.2f ps=0.74u w=0.16u l=0.19u
X1 S5 G D4 sub sg13_lv_nmos ad=56.2f pd=0.74u as=56.2f ps=0.74u w=0.16u l=0.19u
X2 D8 G S7 sub sg13_lv_nmos ad=56.2f pd=0.74u as=56.2f ps=0.74u w=0.16u l=0.19u
X3 S3 G D2 sub sg13_lv_nmos ad=56.2f pd=0.74u as=56.2f ps=0.74u w=0.16u l=0.19u
X4 D10 G S9 sub sg13_lv_nmos ad=56.2f pd=0.74u as=56.2f ps=0.74u w=0.16u l=0.19u
X5 D4 G S3 sub sg13_lv_nmos ad=56.2f pd=0.74u as=56.2f ps=0.74u w=0.16u l=0.19u
X6 S1 G D0 sub sg13_lv_nmos ad=56.2f pd=0.74u as=0.1012p ps=1.34u w=0.16u l=0.19u
X7 S7 G D6 sub sg13_lv_nmos ad=56.2f pd=0.74u as=56.2f ps=0.74u w=0.16u l=0.19u
X8 D2 G S1 sub sg13_lv_nmos ad=56.2f pd=0.74u as=56.2f ps=0.74u w=0.16u l=0.19u
X9 S10 G D10 sub sg13_lv_nmos ad=0.1012p pd=1.34u as=56.2f ps=0.74u w=0.16u l=0.19u
X10 D6 G S5 sub sg13_lv_nmos ad=56.2f pd=0.74u as=56.2f ps=0.74u w=0.16u l=0.19u
.ends

.subckt rppd_KGSVTB B R2 R1
X0 R1 R2 B rppd l=8.13u w=1u
.ends

.subckt rppd_WT5RT4 B R2 R1
X0 R1 R2 B rppd l=5.65u w=1u
.ends

.subckt cml_drv VDD INN INP OUTN OUTP VSS
Xxamp.xn OUTN INP xrtail/R1 OUTN OUTN VSS OUTN OUTN OUTN xrtail/R1 xrtail/R1 xrtail/R1
+ xrtail/R1 xrtail/R1 sg13_lv_nmos_MZQ2E7
Xxamp.xp OUTP INN xrtail/R1 OUTP OUTP VSS OUTP OUTP OUTP xrtail/R1 xrtail/R1 xrtail/R1
+ xrtail/R1 xrtail/R1 sg13_lv_nmos_MZQ2E7
Xxlp.xrl VSS OUTP VDD rppd_KGSVTB
Xxrtail VSS VSS xrtail/R1 rppd_WT5RT4
Xxln.xrl VSS OUTN VDD rppd_KGSVTB
.ends

.subckt sr16_rx4 VSS VDD CK_N CK_P D0_N D0_P D1_N D1_P D2_N D2_P D3_N D3_P POLN MOT0_N
+ MOT0_P MOT1_N MOT1_P MOT2_N MOT2_P MOT3_N MOT3_P MOT4_N MOT4_P MOT5_N MOT5_P MOT6_N
+ MOT6_P MOT7_N MOT7_P MOT8_N MOT8_P MOT9_N MOT9_P MOT10_N MOT10_P MOT11_N MOT11_P
+ MOT12_N MOT12_P MOT13_N MOT13_P MOT14_N MOT14_P MOT15_N MOT15_P MOT16_N MOT16_P
+ MOT17_N MOT17_P MOT18_N MOT18_P MOT19_N MOT19_P MOT20_N MOT20_P MOT21_N MOT21_P
+ MOT22_N MOT22_P MOT23_N MOT23_P MOT24_N MOT24_P MOT25_N MOT25_P MOT26_N MOT26_P
+ MOT27_N MOT27_P MOT28_N MOT28_P MOT29_N MOT29_P MOT30_N MOT30_P MOT31_N MOT31_P
+ CLK_W_N CLK_W_P
Xcml_tlatch_19 VDD MOT5_N MOT5_P CKHB0_N CKHB0_P stub_bi_2/INP stub_bi_2/INN POLN
+ VSS cml_tlatch
Xcml_drvb_1 VDD GB0_P CKHB0_N CKHB0_P GB0_N VSS cml_drvb
Xcml_tlatch_3 VDD stub_bi_4/INN stub_bi_4/INP CKA0_N CKA0_P stub_bi_5/INP stub_bi_5/INN
+ POLN VSS cml_tlatch
Xcml_drvb_2 VDD GA0_P CKHA0_N CKHA0_P GA0_N VSS cml_drvb
Xcml_tlatch_4 VDD MOT9_N MOT9_P CKHB1_N CKHB1_P B1_8_P B1_8_N POLN VSS cml_tlatch
Xcml_drvb_3 VDD GA1_P CKHA1_N CKHA1_P GA1_N VSS cml_drvb
Xcml_tlatch_5 VDD MOT11_N MOT11_P CKHB1_N CKHB1_P stub_bi_12/INP stub_bi_12/INN POLN
+ VSS cml_tlatch
Xcml_drvb_4 VDD GA2_P CKHA2_N CKHA2_P GA2_N VSS cml_drvb
Xcml_tlatch_6 VDD MOT13_N MOT13_P CKHB1_N CKHB1_P stub_bi_14/INP stub_bi_14/INN POLN
+ VSS cml_tlatch
Xcml_drvb_5 VDD GA3_P CKHA3_N CKHA3_P GA3_N VSS cml_drvb
Xcml_tlatch_7 VDD MOT15_N MOT15_P CKHB1_N CKHB1_P B1_2_P B1_2_N POLN VSS cml_tlatch
Xcml_drvb_6 VDD GB3_P CKHB3_N CKHB3_P GB3_N VSS cml_drvb
Xcml_tlatch_8 VDD stub_bi_5/INN stub_bi_5/INP CKA0_P CKA0_N stub_bi_6/INP stub_bi_6/INN
+ POLN VSS cml_tlatch
Xcml_drvb_7 VDD GB2_P CKHB2_N CKHB2_P GB2_N VSS cml_drvb
Xcml_tlatch_9 VDD stub_bi_6/INN stub_bi_6/INP CKA0_N CKA0_P stub_bi_7/INP stub_bi_7/INN
+ POLN VSS cml_tlatch
Xcml_drvb_8 VDD J4_N NS1_N NS1_P J4_P VSS cml_drvb
Xhs_to_clk_0 VDD CK_N CK_P CKA0_N CKA0_P POLN VSS hs_to_clk
Xcml_drvb_9 VDD CLK_W_P NM1_N NM1_P CLK_W_N VSS cml_drvb
Xhs_to_clk_1 VDD CK_P CK_N CKB0_N CKB0_P POLN VSS hs_to_clk
Xcml_gate2_0 VDD ENB1_N ENB1_P GB1_N GB1_P CKA1_N CKA1_P VSS cml_gate2
Xhs_to_clk_2 VDD CK_P CK_N CKB1_N CKB1_P POLN VSS hs_to_clk
Xcml_gate2_1 VDD ENB1_N ENB1_P GB0_N GB0_P CKA0_N CKA0_P VSS cml_gate2
Xhs_to_clk_3 VDD CK_N CK_P CKA1_N CKA1_P POLN VSS hs_to_clk
Xcml_gate2_2 VDD ENA0_N ENA0_P GA0_N GA0_P CKB0_N CKB0_P VSS cml_gate2
Xhs_to_clk_4 VDD CK_N CK_P CKA2_N CKA2_P POLN VSS hs_to_clk
Xcml_gate2_3 VDD ENA0_N ENA0_P GA1_N GA1_P CKB1_N CKB1_P VSS cml_gate2
Xhs_to_clk_5 VDD CK_P CK_N CKB3_N CKB3_P POLN VSS hs_to_clk
Xcml_gate2_4 VDD ENA1_N ENA1_P GA2_N GA2_P CKB2_N CKB2_P VSS cml_gate2
Xhs_to_clk_6 VDD CK_P CK_N CKB2_N CKB2_P POLN VSS hs_to_clk
Xcml_gate2_5 VDD ENA1_N ENA1_P GA3_N GA3_P CKB3_N CKB3_P VSS cml_gate2
Xhs_to_clk_7 VDD CK_N CK_P CKA3_N CKA3_P POLN VSS hs_to_clk
Xcml_gate2_6 VDD ENB0_N ENB0_P GB3_N GB3_P CKA3_N CKA3_P VSS cml_gate2
Xhs_to_clk_8 VDD CK_N CK_P CKJ_N CKJ_P POLN VSS hs_to_clk
Xcml_gate2_7 VDD ENB0_N ENB0_P GB2_N GB2_P CKA2_N CKA2_P VSS cml_gate2
Xcml_gate2_8 VDD J2_N J2_P ENB_N ENB_P NS1_N NS1_P VSS cml_gate2
Xcml_drv_0 VDD ENB_N ENB_P ENB1_N ENB1_P VSS cml_drv
Xcml_gate2_9 VDD J1_N J1_P ENA_N ENA_P NM1_N NM1_P VSS cml_gate2
Xcml_drv_1 VDD ENA_N ENA_P ENA1_N ENA1_P VSS cml_drv
Xcml_drv_2 VDD ENB_N ENB_P ENB0_N ENB0_P VSS cml_drv
Xcml_tlatch_90 VDD J4_N J4_P CKJ_P CKJ_N CLK_W_N CLK_W_P POLN VSS cml_tlatch
Xcml_drv_3 VDD ENA_N ENA_P ENA0_N ENA0_P VSS cml_drv
Xcml_tlatch_91 VDD CLK_W_P CLK_W_N CKJ_N CKJ_P J2_P J2_N POLN VSS cml_tlatch
Xcml_tlatch_80 VDD stub_bi_59/INN stub_bi_59/INP CKB2_N CKB2_P stub_bi_60/INP stub_bi_60/INN
+ POLN VSS cml_tlatch
Xcml_tlatch_92 VDD J2_N J2_P CKJ_P CKJ_N J1_P J1_N POLN VSS cml_tlatch
Xcml_tlatch_81 VDD A2_8_N A2_8_P CKA2_P CKA2_N stub_bi_62/INP stub_bi_62/INN POLN
+ VSS cml_tlatch
Xcml_tlatch_70 VDD MOT29_N MOT29_P CKHB3_N CKHB3_P stub_bi_48/INP stub_bi_48/INN POLN
+ VSS cml_tlatch
Xcml_tlatch_60 VDD B3_8_N B3_8_P CKB3_P CKB3_N stub_bi_45/INP stub_bi_45/INN POLN
+ VSS cml_tlatch
Xcml_tlatch_93 VDD J1_N J1_P CKJ_N CKJ_P J4_N J4_P POLN VSS cml_tlatch
Xcml_tlatch_82 VDD stub_bi_62/INN stub_bi_62/INP CKA2_N CKA2_P stub_bi_63/INP stub_bi_63/INN
+ POLN VSS cml_tlatch
Xcml_tlatch_71 VDD MOT31_N MOT31_P CKHB3_N CKHB3_P B3_2_P B3_2_N POLN VSS cml_tlatch
Xcml_tlatch_94 VDD stub_bi_14/INN stub_bi_14/INP CKB1_P CKB1_N stub_bi_26/INP stub_bi_26/INN
+ POLN VSS cml_tlatch
Xcml_tlatch_83 VDD stub_bi_63/INN stub_bi_63/INP CKA2_P CKA2_N stub_bi_49/INP stub_bi_49/INN
+ POLN VSS cml_tlatch
Xcml_tlatch_72 VDD stub_bi_49/INN stub_bi_49/INP CKA2_N CKA2_P stub_bi_55/INP stub_bi_55/INN
+ POLN VSS cml_tlatch
Xcml_tlatch_50 VDD MOT20_N MOT20_P CKHA2_N CKHA2_P stub_bi_55/INP stub_bi_55/INN POLN
+ VSS cml_tlatch
Xcml_tlatch_61 VDD stub_bi_45/INN stub_bi_45/INP CKB3_N CKB3_P stub_bi_46/INP stub_bi_46/INN
+ POLN VSS cml_tlatch
Xcml_tlatch_40 VDD MOT12_N MOT12_P CKHA1_N CKHA1_P stub_bi_0/INP stub_bi_0/INN POLN
+ VSS cml_tlatch
Xcml_tlatch_51 VDD MOT22_N MOT22_P CKHA2_N CKHA2_P A2_2_P A2_2_N POLN VSS cml_tlatch
Xcml_tlatch_62 VDD stub_bi_46/INN stub_bi_46/INP CKB3_P CKB3_N stub_bi_47/INP stub_bi_47/INN
+ POLN VSS cml_tlatch
Xcml_tlatch_95 VDD stub_bi_0/INN stub_bi_0/INP CKA1_P CKA1_N stub_bi_29/INP stub_bi_29/INN
+ POLN VSS cml_tlatch
Xcml_tlatch_73 VDD MOT17_N MOT17_P CKHB2_N CKHB2_P B2_8_P B2_8_N POLN VSS cml_tlatch
Xcml_tlatch_84 VDD stub_bi_48/INN stub_bi_48/INP CKB3_P CKB3_N stub_bi_35/INP stub_bi_35/INN
+ POLN VSS cml_tlatch
Xcml_tlatch_30 VDD stub_bi_23/INN stub_bi_23/INP CKA0_N CKA0_P A0_2_P A0_2_N POLN
+ VSS cml_tlatch
Xcml_tlatch_41 VDD MOT14_N MOT14_P CKHA1_N CKHA1_P A1_2_P A1_2_N POLN VSS cml_tlatch
Xcml_tlatch_96 VDD MOT8_N MOT8_P CKHA1_N CKHA1_P A1_8_P A1_8_N POLN VSS cml_tlatch
Xcml_tlatch_74 VDD MOT19_N MOT19_P CKHB2_N CKHB2_P stub_bi_58/INP stub_bi_58/INN POLN
+ VSS cml_tlatch
Xcml_tlatch_52 VDD stub_bi_39/INN stub_bi_39/INP CKA3_N CKA3_P A3_2_P A3_2_N POLN
+ VSS cml_tlatch
Xcml_tlatch_85 VDD stub_bi_54/INN stub_bi_54/INP CKA3_P CKA3_N stub_bi_39/INP stub_bi_39/INN
+ POLN VSS cml_tlatch
Xcml_tlatch_63 VDD stub_bi_47/INN stub_bi_47/INP CKB3_N CKB3_P stub_bi_48/INP stub_bi_48/INN
+ POLN VSS cml_tlatch
Xcml_tlatch_64 VDD A3_8_N A3_8_P CKA3_P CKA3_N stub_bi_51/INP stub_bi_51/INN POLN
+ VSS cml_tlatch
Xcml_tlatch_20 VDD MOT7_N MOT7_P CKHB0_N CKHB0_P B0_2_P B0_2_N POLN VSS cml_tlatch
Xcml_tlatch_97 VDD MOT0_N MOT0_P CKHA0_N CKHA0_P A0_8_P A0_8_N POLN VSS cml_tlatch
Xcml_tlatch_31 VDD A0_2_N A0_2_P CKA0_P CKA0_N stub_bi_25/INP stub_bi_25/INN POLN
+ VSS cml_tlatch
Xcml_tlatch_42 VDD stub_bi_32/INN stub_bi_32/INP CKA2_N CKA2_P D2_P D2_N POLN VSS
+ cml_tlatch
Xcml_tlatch_75 VDD MOT21_N MOT21_P CKHB2_N CKHB2_P stub_bi_60/INP stub_bi_60/INN POLN
+ VSS cml_tlatch
Xcml_tlatch_86 VDD MOT24_N MOT24_P CKHA3_N CKHA3_P A3_8_P A3_8_N POLN VSS cml_tlatch
Xcml_tlatch_53 VDD A3_2_N A3_2_P CKA3_P CKA3_N stub_bi_41/INP stub_bi_41/INN POLN
+ VSS cml_tlatch
Xcml_tlatch_65 VDD stub_bi_51/INN stub_bi_51/INP CKA3_N CKA3_P stub_bi_52/INP stub_bi_52/INN
+ POLN VSS cml_tlatch
Xcml_tlatch_10 VDD B0_8_N B0_8_P CKB0_P CKB0_N stub_bi_9/INP stub_bi_9/INN POLN VSS
+ cml_tlatch
Xcml_tlatch_98 VDD stub_bi_2/INN stub_bi_2/INP CKB0_P CKB0_N stub_bi_20/INP stub_bi_20/INN
+ POLN VSS cml_tlatch
Xcml_tlatch_21 VDD A1_8_N A1_8_P CKA1_P CKA1_N stub_bi_17/INP stub_bi_17/INN POLN
+ VSS cml_tlatch
Xcml_tlatch_32 VDD stub_bi_26/INN stub_bi_26/INP CKB1_N CKB1_P B1_2_P B1_2_N POLN
+ VSS cml_tlatch
Xcml_tlatch_43 VDD stub_bi_33/INN stub_bi_33/INP CKB2_N CKB2_P B2_2_P B2_2_N POLN
+ VSS cml_tlatch
Xcml_tlatch_87 VDD MOT16_N MOT16_P CKHA2_N CKHA2_P A2_8_P A2_8_N POLN VSS cml_tlatch
Xcml_tlatch_76 VDD MOT23_N MOT23_P CKHB2_N CKHB2_P B2_2_P B2_2_N POLN VSS cml_tlatch
Xcml_tlatch_54 VDD stub_bi_41/INN stub_bi_41/INP CKA3_N CKA3_P D3_P D3_N POLN VSS
+ cml_tlatch
Xcml_tlatch_11 VDD stub_bi_9/INN stub_bi_9/INP CKB0_N CKB0_P stub_bi_5/TOPN stub_bi_5/TOPP
+ POLN VSS cml_tlatch
Xcml_tlatch_99 VDD stub_bi_7/INN stub_bi_7/INP CKA0_P CKA0_N stub_bi_23/INP stub_bi_23/INN
+ POLN VSS cml_tlatch
Xcml_tlatch_22 VDD stub_bi_17/INN stub_bi_17/INP CKA1_N CKA1_P stub_bi_18/INP stub_bi_18/INN
+ POLN VSS cml_tlatch
Xcml_tlatch_33 VDD B1_2_N B1_2_P CKB1_P CKB1_N stub_bi_28/INP stub_bi_28/INN POLN
+ VSS cml_tlatch
Xcml_tlatch_55 VDD stub_bi_42/INN stub_bi_42/INP CKA2_N CKA2_P A2_2_P A2_2_N POLN
+ VSS cml_tlatch
Xcml_tlatch_44 VDD B2_2_N B2_2_P CKB2_P CKB2_N stub_bi_38/INP stub_bi_38/INN POLN
+ VSS cml_tlatch
Xcml_tlatch_88 VDD stub_bi_60/INN stub_bi_60/INP CKB2_P CKB2_N stub_bi_33/INP stub_bi_33/INN
+ POLN VSS cml_tlatch
Xcml_tlatch_77 VDD B2_8_N B2_8_P CKB2_P CKB2_N stub_bi_57/INP stub_bi_57/INN POLN
+ VSS cml_tlatch
Xcml_tlatch_66 VDD stub_bi_52/INN stub_bi_52/INP CKA3_P CKA3_N stub_bi_53/INP stub_bi_53/INN
+ POLN VSS cml_tlatch
Xcml_tlatch_23 VDD stub_bi_18/INN stub_bi_18/INP CKA1_P CKA1_N stub_bi_19/INP stub_bi_19/INN
+ POLN VSS cml_tlatch
Xcml_tlatch_34 VDD stub_bi_28/INN stub_bi_28/INP CKB1_N CKB1_P D1_P D1_N POLN VSS
+ cml_tlatch
Xcml_tlatch_12 VDD B1_8_N B1_8_P CKB1_P CKB1_N stub_bi_11/INP stub_bi_11/INN POLN
+ VSS cml_tlatch
Xcml_tlatch_56 VDD A2_2_N A2_2_P CKA2_P CKA2_N stub_bi_32/INP stub_bi_32/INN POLN
+ VSS cml_tlatch
Xcml_tlatch_78 VDD stub_bi_57/INN stub_bi_57/INP CKB2_N CKB2_P stub_bi_58/INP stub_bi_58/INN
+ POLN VSS cml_tlatch
Xcml_tlatch_45 VDD stub_bi_35/INN stub_bi_35/INP CKB3_N CKB3_P B3_2_P B3_2_N POLN
+ VSS cml_tlatch
Xcml_tlatch_67 VDD stub_bi_53/INN stub_bi_53/INP CKA3_N CKA3_P stub_bi_54/INP stub_bi_54/INN
+ POLN VSS cml_tlatch
Xcml_tlatch_89 VDD stub_bi_55/INN stub_bi_55/INP CKA2_P CKA2_N stub_bi_42/INP stub_bi_42/INN
+ POLN VSS cml_tlatch
Xcml_tlatch_24 VDD MOT2_N MOT2_P CKHA0_N CKHA0_P stub_bi_5/INP stub_bi_5/INN POLN
+ VSS cml_tlatch
Xcml_tlatch_35 VDD stub_bi_25/INN stub_bi_25/INP CKA0_N CKA0_P D0_P D0_N POLN VSS
+ cml_tlatch
Xcml_tlatch_13 VDD stub_bi_11/INN stub_bi_11/INP CKB1_N CKB1_P stub_bi_12/INP stub_bi_12/INN
+ POLN VSS cml_tlatch
Xcml_tlatch_79 VDD stub_bi_58/INN stub_bi_58/INP CKB2_P CKB2_N stub_bi_59/INP stub_bi_59/INN
+ POLN VSS cml_tlatch
Xcml_tlatch_57 VDD MOT26_N MOT26_P CKHA3_N CKHA3_P stub_bi_52/INP stub_bi_52/INN POLN
+ VSS cml_tlatch
Xcml_tlatch_68 VDD MOT25_N MOT25_P CKHB3_N CKHB3_P B3_8_P B3_8_N POLN VSS cml_tlatch
Xcml_tlatch_46 VDD B3_2_N B3_2_P CKB3_P CKB3_N stub_bi_37/INP stub_bi_37/INN POLN
+ VSS cml_tlatch
Xcml_tlatch_25 VDD MOT4_N MOT4_P CKHA0_N CKHA0_P stub_bi_7/INP stub_bi_7/INN POLN
+ VSS cml_tlatch
Xcml_tlatch_36 VDD stub_bi_29/INN stub_bi_29/INP CKA1_N CKA1_P A1_2_P A1_2_N POLN
+ VSS cml_tlatch
Xcml_tlatch_14 VDD stub_bi_12/INN stub_bi_12/INP CKB1_P CKB1_N stub_bi_13/INP stub_bi_13/INN
+ POLN VSS cml_tlatch
Xcml_tlatch_58 VDD MOT28_N MOT28_P CKHA3_N CKHA3_P stub_bi_54/INP stub_bi_54/INN POLN
+ VSS cml_tlatch
Xcml_tlatch_69 VDD MOT27_N MOT27_P CKHB3_N CKHB3_P stub_bi_46/INP stub_bi_46/INN POLN
+ VSS cml_tlatch
Xcml_tlatch_47 VDD stub_bi_37/INN stub_bi_37/INP CKB3_N CKB3_P D3_P D3_N POLN VSS
+ cml_tlatch
Xcml_tlatch_26 VDD MOT6_N MOT6_P CKHA0_N CKHA0_P A0_2_P A0_2_N POLN VSS cml_tlatch
Xcml_tlatch_37 VDD A1_2_N A1_2_P CKA1_P CKA1_N stub_bi_31/INP stub_bi_31/INN POLN
+ VSS cml_tlatch
Xcml_tlatch_15 VDD stub_bi_13/INN stub_bi_13/INP CKB1_N CKB1_P stub_bi_14/INP stub_bi_14/INN
+ POLN VSS cml_tlatch
Xcml_tlatch_48 VDD stub_bi_38/INN stub_bi_38/INP CKB2_N CKB2_P D2_P D2_N POLN VSS
+ cml_tlatch
Xcml_tlatch_59 VDD MOT30_N MOT30_P CKHA3_N CKHA3_P A3_2_P A3_2_N POLN VSS cml_tlatch
Xcml_tlatch_16 VDD stub_bi_5/TOPP stub_bi_5/TOPN CKB0_P CKB0_N stub_bi_1/INP stub_bi_1/INN
+ POLN VSS cml_tlatch
Xcml_tlatch_27 VDD stub_bi_20/INN stub_bi_20/INP CKB0_N CKB0_P B0_2_P B0_2_N POLN
+ VSS cml_tlatch
Xcml_tlatch_38 VDD stub_bi_31/INN stub_bi_31/INP CKA1_N CKA1_P D1_P D1_N POLN VSS
+ cml_tlatch
Xcml_tlatch_49 VDD MOT18_N MOT18_P CKHA2_N CKHA2_P stub_bi_63/INP stub_bi_63/INN POLN
+ VSS cml_tlatch
Xcml_tlatch_0 VDD stub_bi_19/INN stub_bi_19/INP CKA1_N CKA1_P stub_bi_0/INP stub_bi_0/INN
+ POLN VSS cml_tlatch
Xcml_tlatch_17 VDD MOT1_N MOT1_P CKHB0_N CKHB0_P B0_8_P B0_8_N POLN VSS cml_tlatch
Xcml_tlatch_28 VDD B0_2_N B0_2_P CKB0_P CKB0_N stub_bi_22/INP stub_bi_22/INN POLN
+ VSS cml_tlatch
Xcml_tlatch_39 VDD MOT10_N MOT10_P CKHA1_N CKHA1_P stub_bi_18/INP stub_bi_18/INN POLN
+ VSS cml_tlatch
Xcml_tlatch_1 VDD stub_bi_1/INN stub_bi_1/INP CKB0_N CKB0_P stub_bi_2/INP stub_bi_2/INN
+ POLN VSS cml_tlatch
Xcml_tlatch_18 VDD MOT3_N MOT3_P CKHB0_N CKHB0_P stub_bi_5/TOPN stub_bi_5/TOPP POLN
+ VSS cml_tlatch
Xcml_tlatch_29 VDD stub_bi_22/INN stub_bi_22/INP CKB0_N CKB0_P D0_P D0_N POLN VSS
+ cml_tlatch
Xcml_drvb_0 VDD GB1_P CKHB1_N CKHB1_P GB1_N VSS cml_drvb
Xcml_tlatch_2 VDD A0_8_N A0_8_P CKA0_P CKA0_N stub_bi_4/INP stub_bi_4/INN POLN VSS
+ cml_tlatch
.ends
