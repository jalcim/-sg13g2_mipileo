* NGSPICE file created from flatpost.ext - technology: ihp-sg13g2

.subckt sr16_rx4 VSS VDD CK_N CK_P D0_N D0_P D1_N D1_P D2_N D2_P D3_N D3_P POLN MOT0_N
+ MOT0_P MOT1_N MOT1_P MOT2_N MOT2_P MOT3_N MOT3_P MOT4_N MOT4_P MOT5_N MOT5_P MOT6_N
+ MOT6_P MOT7_N MOT7_P MOT8_N MOT8_P MOT9_N MOT9_P MOT10_N MOT10_P MOT11_N MOT11_P
+ MOT12_N MOT12_P MOT13_N MOT13_P MOT14_N MOT14_P MOT15_N MOT15_P MOT16_N MOT16_P
+ MOT17_N MOT17_P MOT18_N MOT18_P MOT19_N MOT19_P MOT20_N MOT20_P MOT21_N MOT21_P
+ MOT22_N MOT22_P MOT23_N MOT23_P MOT24_N MOT24_P MOT25_N MOT25_P MOT26_N MOT26_P
+ MOT27_N MOT27_P MOT28_N MOT28_P MOT29_N MOT29_P MOT30_N MOT30_P MOT31_N MOT31_P
+ CLK_W_N CLK_W_P
X0 cml_tlatch_89.xmux.xp.S1 cml_tlatch_89.OUTP cml_tlatch_89.OUTN VSS sg13_lv_nmos ad=56.9f pd=0.74u as=56.9f ps=0.74u w=0.17u l=0.17u
X1 cml_gate2_0.xrtail.R1 CKA1_N GB1_P VSS sg13_lv_nmos ad=0.1007p pd=0.91u as=0.1007p ps=0.91u w=0.53u l=0.13u
X2 cml_tlatch_52.xmux.xn.S1 A3_2_P cml_tlatch_52.OUTN VSS sg13_lv_nmos ad=63.19999f pd=0.74u as=63.19999f ps=0.74u w=0.26u l=0.38u
X3 cml_tlatch_17.xmux.xp.S1 MOT1_N MOT1_P VSS sg13_lv_nmos ad=56.9f pd=0.74u as=56.9f ps=0.74u w=0.17u l=0.17u
X4 cml_tlatch_19.xtail.S1 CKHB0_P cml_tlatch_19.xmux.xn.S1 VSS sg13_lv_nmos ad=89.3f pd=0.85u as=89.3f ps=0.85u w=0.47u l=0.16u
X5 J2_N J2_P cml_tlatch_92.xmux.xp.S1 VSS sg13_lv_nmos ad=56.9f pd=0.74u as=56.9f ps=0.74u w=0.17u l=0.17u
X6 J1_P J1_N cml_tlatch_93.xmux.xp.S1 VSS sg13_lv_nmos ad=56.9f pd=0.74u as=56.9f ps=0.74u w=0.17u l=0.17u
X7 A0_2_N A0_2_P cml_tlatch_31.xmux.xp.S1 VSS sg13_lv_nmos ad=56.9f pd=0.74u as=56.9f ps=0.74u w=0.17u l=0.17u
X8 cml_tlatch_29.xmux.xn.S1 CKB0_P cml_tlatch_29.xtail.S1 VSS sg13_lv_nmos ad=89.3f pd=0.85u as=89.3f ps=0.85u w=0.47u l=0.16u
X9 cml_tlatch_0.xtail.S1 CKA1_P cml_tlatch_0.xmux.xn.S1 VSS sg13_lv_nmos ad=89.3f pd=0.85u as=89.3f ps=0.85u w=0.47u l=0.16u
X10 MOT13_N MOT13_P cml_tlatch_6.xmux.xp.S1 VSS sg13_lv_nmos ad=56.9f pd=0.74u as=56.9f ps=0.74u w=0.17u l=0.17u
X11 VSS POLN cml_tlatch_65.xtail.S1 VSS sg13_lv_nmos ad=1.5637p pd=8.61u as=1.5637p ps=8.61u w=8.23u l=0.13u
X12 cml_tlatch_83.xmux.xp.S1 cml_tlatch_83.OUTP cml_tlatch_83.OUTN VSS sg13_lv_nmos ad=56.9f pd=0.74u as=56.9f ps=0.74u w=0.17u l=0.17u
X13 stub_bi_63.BOTN stub_bi_63.BOTP cml_tlatch_79.xmux.xp.S1 VSS sg13_lv_nmos ad=56.9f pd=0.74u as=56.9f ps=0.74u w=0.17u l=0.17u
X14 MOT21_P MOT21_N cml_tlatch_75.xmux.xp.S1 VSS sg13_lv_nmos ad=56.9f pd=0.74u as=56.9f ps=0.74u w=0.17u l=0.17u
X15 B2_8_P VDD VSS rppd l=5.17u w=1u
X16 cml_tlatch_16.xtail.S1 CKB0_P cml_tlatch_16.xmux.xp.S1 VSS sg13_lv_nmos ad=0.1598p pd=1.62u as=89.3f ps=0.85u w=0.47u l=0.16u
X17 cml_tlatch_48.xmux.xp.S1 CKB2_N cml_tlatch_48.xtail.S1 VSS sg13_lv_nmos ad=89.3f pd=0.85u as=89.3f ps=0.85u w=0.47u l=0.16u
X18 cml_tlatch_24.xmux.xp.S1 MOT2_P MOT2_N VSS sg13_lv_nmos ad=56.9f pd=0.74u as=56.9f ps=0.74u w=0.17u l=0.17u
X19 cml_tlatch_20.xmux.xp.S1 MOT7_N MOT7_P VSS sg13_lv_nmos ad=56.9f pd=0.74u as=56.9f ps=0.74u w=0.17u l=0.17u
X20 cml_tlatch_54.xmux.xp.S1 cml_tlatch_54.OUTN cml_tlatch_54.OUTP VSS sg13_lv_nmos ad=0.1019p pd=1.34u as=56.9f ps=0.74u w=0.17u l=0.17u
X21 cml_tlatch_51.xmux.xp.S1 MOT22_N MOT22_P VSS sg13_lv_nmos ad=56.9f pd=0.74u as=56.9f ps=0.74u w=0.17u l=0.17u
X22 cml_tlatch_54.xmux.xp.S1 CKA3_N cml_tlatch_54.xtail.S1 VSS sg13_lv_nmos ad=89.3f pd=0.85u as=89.3f ps=0.85u w=0.47u l=0.16u
X23 MOT30_P MOT30_N cml_tlatch_59.xmux.xp.S1 VSS sg13_lv_nmos ad=56.9f pd=0.74u as=56.9f ps=0.74u w=0.17u l=0.17u
X24 cml_tlatch_87.xmux.xp.S1 MOT16_P MOT16_N VSS sg13_lv_nmos ad=56.9f pd=0.74u as=56.9f ps=0.74u w=0.17u l=0.17u
X25 cml_tlatch_24.xmux.xn.S1 cml_tlatch_8.OUTN MOT2_P VSS sg13_lv_nmos ad=63.19999f pd=0.74u as=63.19999f ps=0.74u w=0.26u l=0.38u
X26 cml_tlatch_58.xmux.xn.S1 CKHA3_P cml_tlatch_58.xtail.S1 VSS sg13_lv_nmos ad=89.3f pd=0.85u as=89.3f ps=0.85u w=0.47u l=0.16u
X27 B1_8_P stub_bi_17.BOTP cml_tlatch_12.xmux.xn.S1 VSS sg13_lv_nmos ad=63.19999f pd=0.74u as=63.19999f ps=0.74u w=0.26u l=0.38u
X28 cml_tlatch_15.xtail.S1 CKB1_P cml_tlatch_15.xmux.xn.S1 VSS sg13_lv_nmos ad=89.3f pd=0.85u as=89.3f ps=0.85u w=0.47u l=0.16u
X29 hs_to_clk_2.D2 CK_P CKB1_N VSS sg13_lv_nmos ad=0.228p pd=1.58u as=0.408p ps=3.08u w=1.2u l=0.2u
X30 cml_tlatch_80.xmux.xp.S1 stub_bi_49.BOTN stub_bi_49.BOTP VSS sg13_lv_nmos ad=0.1019p pd=1.34u as=56.9f ps=0.74u w=0.17u l=0.17u
X31 cml_tlatch_30.xmux.xp.S1 CKA0_N cml_tlatch_30.xtail.S1 VSS sg13_lv_nmos ad=89.3f pd=0.85u as=89.3f ps=0.85u w=0.47u l=0.16u
X32 MOT11_P MOT11_N cml_tlatch_5.xmux.xp.S1 VSS sg13_lv_nmos ad=56.9f pd=0.74u as=56.9f ps=0.74u w=0.17u l=0.17u
X33 cml_tlatch_41.xmux.xp.S1 MOT14_N MOT14_P VSS sg13_lv_nmos ad=56.9f pd=0.74u as=56.9f ps=0.74u w=0.17u l=0.17u
X34 B2_2_P B2_2_N cml_tlatch_44.xmux.xp.S1 VSS sg13_lv_nmos ad=56.9f pd=0.74u as=56.9f ps=0.74u w=0.17u l=0.17u
X35 cml_tlatch_88.xmux.xp.S1 stub_bi_55.BOTP stub_bi_55.BOTN VSS sg13_lv_nmos ad=56.9f pd=0.74u as=56.9f ps=0.74u w=0.17u l=0.17u
X36 cml_tlatch_9.xmux.xp.S1 cml_tlatch_9.OUTN cml_tlatch_9.OUTP VSS sg13_lv_nmos ad=56.9f pd=0.74u as=56.9f ps=0.74u w=0.17u l=0.17u
X37 cml_tlatch_90.xmux.xp.S1 CKJ_P cml_tlatch_90.xtail.S1 VSS sg13_lv_nmos ad=89.3f pd=0.85u as=89.3f ps=0.85u w=0.47u l=0.16u
X38 MOT6_N MOT6_P cml_tlatch_26.xmux.xp.S1 VSS sg13_lv_nmos ad=56.9f pd=0.74u as=56.9f ps=0.74u w=0.17u l=0.17u
X39 cml_tlatch_94.xmux.xn.S1 stub_bi_29.BOTP cml_tlatch_6.INP VSS sg13_lv_nmos ad=63.19999f pd=0.74u as=63.19999f ps=0.74u w=0.26u l=0.38u
X40 cml_tlatch_68.xmux.xp.S1 MOT25_P MOT25_N VSS sg13_lv_nmos ad=56.9f pd=0.74u as=56.9f ps=0.74u w=0.17u l=0.17u
X41 cml_tlatch_10.xtail.S1 CKB0_P cml_tlatch_10.xmux.xp.S1 VSS sg13_lv_nmos ad=89.3f pd=0.85u as=0.1598p ps=1.62u w=0.47u l=0.16u
X42 MOT28_P MOT28_N cml_tlatch_58.xmux.xp.S1 VSS sg13_lv_nmos ad=56.9f pd=0.74u as=56.9f ps=0.74u w=0.17u l=0.17u
X43 A1_2_N A1_2_P cml_tlatch_37.xmux.xp.S1 VSS sg13_lv_nmos ad=56.9f pd=0.74u as=56.9f ps=0.74u w=0.17u l=0.17u
X44 cml_tlatch_94.xmux.xn.S1 stub_bi_29.BOTP cml_tlatch_6.INP VSS sg13_lv_nmos ad=63.19999f pd=0.74u as=63.19999f ps=0.74u w=0.26u l=0.38u
X45 VSS hs_to_clk_2.sg13_lv_nmos_2HGZLP_0.G VSS VSS sg13_lv_nmos ad=2.071p pd=11.28u as=4.99752n ps=0.02328 w=10.9u l=1.38u
X46 MOT0_N MOT0_P cml_tlatch_97.xmux.xp.S1 VSS sg13_lv_nmos ad=56.9f pd=0.74u as=56.9f ps=0.74u w=0.17u l=0.17u
X47 MOT9_N MOT9_P cml_tlatch_4.xmux.xp.S1 VSS sg13_lv_nmos ad=56.9f pd=0.74u as=56.9f ps=0.74u w=0.17u l=0.17u
X48 ENB_P NS1_N cml_gate2_8.xrtail.R1 VSS sg13_lv_nmos ad=0.1007p pd=0.91u as=0.1007p ps=0.91u w=0.53u l=0.13u
X49 cml_tlatch_52.xmux.xp.S1 cml_tlatch_52.OUTP cml_tlatch_52.OUTN VSS sg13_lv_nmos ad=56.9f pd=0.74u as=56.9f ps=0.74u w=0.17u l=0.17u
X50 cml_tlatch_6.xmux.xp.S1 CKHB1_N cml_tlatch_6.xtail.S1 VSS sg13_lv_nmos ad=89.3f pd=0.85u as=89.3f ps=0.85u w=0.47u l=0.16u
X51 cml_tlatch_36.xtail.S1 CKA1_P cml_tlatch_36.xmux.xn.S1 VSS sg13_lv_nmos ad=89.3f pd=0.85u as=89.3f ps=0.85u w=0.47u l=0.16u
X52 A2_8_P A2_8_N cml_tlatch_81.xmux.xp.S1 VSS sg13_lv_nmos ad=56.9f pd=0.74u as=56.9f ps=0.74u w=0.17u l=0.17u
X53 cml_tlatch_47.xmux.xp.S1 cml_tlatch_47.OUTN cml_tlatch_47.OUTP VSS sg13_lv_nmos ad=56.9f pd=0.74u as=56.9f ps=0.74u w=0.17u l=0.17u
X54 cml_tlatch_40.INN cml_tlatch_40.INP cml_tlatch_95.xmux.xp.S1 VSS sg13_lv_nmos ad=56.9f pd=0.74u as=56.9f ps=0.74u w=0.17u l=0.17u
X55 cml_tlatch_29.xmux.xp.S1 CKB0_N cml_tlatch_29.xtail.S1 VSS sg13_lv_nmos ad=89.3f pd=0.85u as=89.3f ps=0.85u w=0.47u l=0.16u
X56 cml_tlatch_28.xtail.S1 CKB0_P cml_tlatch_28.xmux.xp.S1 VSS sg13_lv_nmos ad=89.3f pd=0.85u as=89.3f ps=0.85u w=0.47u l=0.16u
X57 cml_tlatch_54.OUTN cml_tlatch_54.OUTP cml_tlatch_54.xmux.xp.S1 VSS sg13_lv_nmos ad=56.9f pd=0.74u as=56.9f ps=0.74u w=0.17u l=0.17u
X58 cml_tlatch_76.xmux.xn.S1 CKHB2_P cml_tlatch_76.xtail.S1 VSS sg13_lv_nmos ad=89.3f pd=0.85u as=0.1598p ps=1.62u w=0.47u l=0.16u
X59 cml_tlatch_77.xmux.xn.S1 stub_bi_62.BOTN B2_8_N VSS sg13_lv_nmos ad=63.19999f pd=0.74u as=0.1082p ps=1.34u w=0.26u l=0.38u
X60 cml_tlatch_97.xmux.xn.S1 CKHA0_P cml_tlatch_97.xtail.S1 VSS sg13_lv_nmos ad=0.1598p pd=1.62u as=89.3f ps=0.85u w=0.47u l=0.16u
X61 cml_tlatch_72.xmux.xn.S1 CKA2_P cml_tlatch_72.xtail.S1 VSS sg13_lv_nmos ad=89.3f pd=0.85u as=89.3f ps=0.85u w=0.47u l=0.16u
X62 MOT3_N MOT3_P cml_tlatch_18.xmux.xp.S1 VSS sg13_lv_nmos ad=56.9f pd=0.74u as=56.9f ps=0.74u w=0.17u l=0.17u
X63 cml_tlatch_12.xtail.S1 CKB1_N cml_tlatch_12.xmux.xn.S1 VSS sg13_lv_nmos ad=89.3f pd=0.85u as=89.3f ps=0.85u w=0.47u l=0.16u
X64 VDD MOT16_N VSS rppd l=5.17u w=1u
X65 cml_tlatch_28.xmux.xp.S1 B0_2_P B0_2_N VSS sg13_lv_nmos ad=56.9f pd=0.74u as=56.9f ps=0.74u w=0.17u l=0.17u
X66 MOT18_N MOT18_P cml_tlatch_49.xmux.xp.S1 VSS sg13_lv_nmos ad=56.9f pd=0.74u as=56.9f ps=0.74u w=0.17u l=0.17u
X67 B2_2_P VDD VSS rppd l=5.17u w=1u
X68 cml_tlatch_30.OUTN cml_tlatch_30.OUTP cml_tlatch_30.xmux.xp.S1 VSS sg13_lv_nmos ad=56.9f pd=0.74u as=56.9f ps=0.74u w=0.17u l=0.17u
X69 cml_tlatch_57.xmux.xp.S1 MOT26_P MOT26_N VSS sg13_lv_nmos ad=56.9f pd=0.74u as=56.9f ps=0.74u w=0.17u l=0.17u
X70 MOT25_N MOT25_P cml_tlatch_68.xmux.xp.S1 VSS sg13_lv_nmos ad=56.9f pd=0.74u as=56.9f ps=0.74u w=0.17u l=0.17u
X71 cml_tlatch_79.xtail.S1 CKB2_P cml_tlatch_79.xmux.xp.S1 VSS sg13_lv_nmos ad=89.3f pd=0.85u as=89.3f ps=0.85u w=0.47u l=0.16u
X72 cml_tlatch_5.INP stub_bi_19.BOTP cml_tlatch_14.xmux.xn.S1 VSS sg13_lv_nmos ad=63.19999f pd=0.74u as=63.19999f ps=0.74u w=0.26u l=0.38u
X73 cml_tlatch_88.xmux.xp.S1 stub_bi_55.BOTP stub_bi_55.BOTN VSS sg13_lv_nmos ad=56.9f pd=0.74u as=56.9f ps=0.74u w=0.17u l=0.17u
X74 cml_tlatch_87.xmux.xp.S1 MOT16_N MOT16_P VSS sg13_lv_nmos ad=56.9f pd=0.74u as=56.9f ps=0.74u w=0.17u l=0.17u
X75 cml_tlatch_6.xmux.xp.S1 MOT13_N MOT13_P VSS sg13_lv_nmos ad=56.9f pd=0.74u as=56.9f ps=0.74u w=0.17u l=0.17u
X76 cml_tlatch_77.xmux.xp.S1 B2_8_P B2_8_N VSS sg13_lv_nmos ad=56.9f pd=0.74u as=56.9f ps=0.74u w=0.17u l=0.17u
X77 A1_8_N A1_8_P cml_tlatch_21.xmux.xp.S1 VSS sg13_lv_nmos ad=56.9f pd=0.74u as=56.9f ps=0.74u w=0.17u l=0.17u
X78 MOT25_N B3_8_P cml_tlatch_68.xmux.xn.S1 VSS sg13_lv_nmos ad=63.19999f pd=0.74u as=63.19999f ps=0.74u w=0.26u l=0.38u
X79 cml_tlatch_71.xmux.xn.S1 CKHB3_P cml_tlatch_71.xtail.S1 VSS sg13_lv_nmos ad=89.3f pd=0.85u as=89.3f ps=0.85u w=0.47u l=0.16u
X80 cml_tlatch_69.xmux.xp.S1 MOT27_N MOT27_P VSS sg13_lv_nmos ad=56.9f pd=0.74u as=56.9f ps=0.74u w=0.17u l=0.17u
X81 cml_tlatch_17.xmux.xp.S1 MOT1_N MOT1_P VSS sg13_lv_nmos ad=56.9f pd=0.74u as=56.9f ps=0.74u w=0.17u l=0.17u
X82 MOT31_P MOT31_N cml_tlatch_71.xmux.xp.S1 VSS sg13_lv_nmos ad=56.9f pd=0.74u as=56.9f ps=0.74u w=0.17u l=0.17u
X83 MOT8_N MOT8_P cml_tlatch_96.xmux.xp.S1 VSS sg13_lv_nmos ad=56.9f pd=0.74u as=0.1019p ps=1.34u w=0.17u l=0.17u
X84 cml_tlatch_60.xmux.xp.S1 CKB3_P cml_tlatch_60.xtail.S1 VSS sg13_lv_nmos ad=89.3f pd=0.85u as=89.3f ps=0.85u w=0.47u l=0.16u
X85 cml_tlatch_59.xmux.xn.S1 A3_2_P MOT30_N VSS sg13_lv_nmos ad=0.1082p pd=1.34u as=63.19999f ps=0.74u w=0.26u l=0.38u
X86 cml_gate2_1.xrtail.R1 CKA0_N GB0_P VSS sg13_lv_nmos ad=0.1802p pd=1.74u as=0.1007p ps=0.91u w=0.53u l=0.13u
X87 MOT13_P VDD VSS rppd l=5.17u w=1u
X88 cml_tlatch_38.xmux.xp.S1 cml_tlatch_38.OUTP cml_tlatch_38.OUTN VSS sg13_lv_nmos ad=56.9f pd=0.74u as=56.9f ps=0.74u w=0.17u l=0.17u
X89 cml_tlatch_13.xmux.xn.S1 cml_tlatch_5.INN stub_bi_17.BOTN VSS sg13_lv_nmos ad=0.1082p pd=1.34u as=63.19999f ps=0.74u w=0.26u l=0.38u
X90 cml_tlatch_89.xmux.xn.S1 cml_tlatch_89.INP cml_tlatch_89.OUTN VSS sg13_lv_nmos ad=63.19999f pd=0.74u as=63.19999f ps=0.74u w=0.26u l=0.38u
X91 cml_drv_2.xrtail.R1 ENB_N ENB0_P VSS sg13_lv_nmos ad=56.2f pd=0.74u as=56.2f ps=0.74u w=0.16u l=0.19u
X92 cml_tlatch_50.xmux.xn.S1 cml_tlatch_89.OUTP MOT20_N VSS sg13_lv_nmos ad=63.19999f pd=0.74u as=63.19999f ps=0.74u w=0.26u l=0.38u
X93 cml_tlatch_95.INP cml_tlatch_95.INN cml_tlatch_36.xmux.xp.S1 VSS sg13_lv_nmos ad=56.9f pd=0.74u as=56.9f ps=0.74u w=0.17u l=0.17u
X94 cml_tlatch_88.xmux.xp.S1 CKB2_P cml_tlatch_88.xtail.S1 VSS sg13_lv_nmos ad=89.3f pd=0.85u as=89.3f ps=0.85u w=0.47u l=0.16u
X95 cml_tlatch_43.xmux.xp.S1 stub_bi_42.BOTP stub_bi_42.BOTN VSS sg13_lv_nmos ad=56.9f pd=0.74u as=56.9f ps=0.74u w=0.17u l=0.17u
X96 cml_tlatch_97.xmux.xp.S1 CKHA0_N cml_tlatch_97.xtail.S1 VSS sg13_lv_nmos ad=89.3f pd=0.85u as=89.3f ps=0.85u w=0.47u l=0.16u
X97 MOT10_P MOT10_N cml_tlatch_39.xmux.xp.S1 VSS sg13_lv_nmos ad=56.9f pd=0.74u as=56.9f ps=0.74u w=0.17u l=0.17u
X98 cml_tlatch_85.xmux.xp.S1 CKA3_P cml_tlatch_85.xtail.S1 VSS sg13_lv_nmos ad=89.3f pd=0.85u as=89.3f ps=0.85u w=0.47u l=0.16u
X99 cml_tlatch_78.xmux.xp.S1 stub_bi_62.BOTN stub_bi_62.BOTP VSS sg13_lv_nmos ad=56.9f pd=0.74u as=56.9f ps=0.74u w=0.17u l=0.17u
X100 cml_tlatch_8.OUTP cml_tlatch_9.OUTN cml_tlatch_8.xmux.xn.S1 VSS sg13_lv_nmos ad=0.1082p pd=1.34u as=63.19999f ps=0.74u w=0.26u l=0.38u
X101 cml_tlatch_67.xmux.xp.S1 cml_tlatch_67.OUTN cml_tlatch_67.OUTP VSS sg13_lv_nmos ad=56.9f pd=0.74u as=56.9f ps=0.74u w=0.17u l=0.17u
X102 GB2_N ENB0_P cml_gate2_7.sg13_lv_nmos_FTPY57_0.D0 VSS sg13_lv_nmos ad=0.1007p pd=0.91u as=0.1007p ps=0.91u w=0.53u l=0.13u
X103 B2_2_P stub_bi_32.BOTP cml_tlatch_44.xmux.xn.S1 VSS sg13_lv_nmos ad=63.19999f pd=0.74u as=63.19999f ps=0.74u w=0.26u l=0.38u
X104 cml_gate2_0.sg13_lv_nmos_FTPY57_0.D0 CKA1_P cml_gate2_0.xrtail.R1 VSS sg13_lv_nmos ad=0.1007p pd=0.91u as=0.1007p ps=0.91u w=0.53u l=0.13u
X105 cml_tlatch_64.xtail.S1 CKA3_N cml_tlatch_64.xmux.xn.S1 VSS sg13_lv_nmos ad=89.3f pd=0.85u as=89.3f ps=0.85u w=0.47u l=0.16u
X106 cml_tlatch_46.xmux.xp.S1 B3_2_P B3_2_N VSS sg13_lv_nmos ad=56.9f pd=0.74u as=56.9f ps=0.74u w=0.17u l=0.17u
X107 cml_tlatch_85.xmux.xp.S1 cml_tlatch_58.INP cml_tlatch_58.INN VSS sg13_lv_nmos ad=56.9f pd=0.74u as=56.9f ps=0.74u w=0.17u l=0.17u
X108 cml_tlatch_1.xtail.S1 CKB0_P cml_tlatch_1.xmux.xn.S1 VSS sg13_lv_nmos ad=89.3f pd=0.85u as=89.3f ps=0.85u w=0.47u l=0.16u
X109 cml_tlatch_35.xmux.xp.S1 cml_tlatch_35.OUTN cml_tlatch_35.OUTP VSS sg13_lv_nmos ad=56.9f pd=0.74u as=56.9f ps=0.74u w=0.17u l=0.17u
X110 cml_tlatch_8.OUTP cml_tlatch_9.OUTN cml_tlatch_8.xmux.xn.S1 VSS sg13_lv_nmos ad=63.19999f pd=0.74u as=63.19999f ps=0.74u w=0.26u l=0.38u
X111 cml_gate2_3.sg13_lv_nmos_FTPY57_0.D0 ENA0_P GA1_N VSS sg13_lv_nmos ad=0.1007p pd=0.91u as=0.1007p ps=0.91u w=0.53u l=0.13u
X112 cml_tlatch_8.xtail.S1 CKA0_N cml_tlatch_8.xmux.xn.S1 VSS sg13_lv_nmos ad=89.3f pd=0.85u as=89.3f ps=0.85u w=0.47u l=0.16u
X113 cml_tlatch_19.xmux.xn.S1 CKHB0_P cml_tlatch_19.xtail.S1 VSS sg13_lv_nmos ad=89.3f pd=0.85u as=0.1598p ps=1.62u w=0.47u l=0.16u
X114 cml_tlatch_94.xmux.xp.S1 cml_tlatch_6.INP cml_tlatch_6.INN VSS sg13_lv_nmos ad=56.9f pd=0.74u as=56.9f ps=0.74u w=0.17u l=0.17u
X115 cml_tlatch_44.xmux.xp.S1 CKB2_P cml_tlatch_44.xtail.S1 VSS sg13_lv_nmos ad=89.3f pd=0.85u as=89.3f ps=0.85u w=0.47u l=0.16u
X116 cml_tlatch_33.xtail.S1 CKB1_N cml_tlatch_33.xmux.xn.S1 VSS sg13_lv_nmos ad=89.3f pd=0.85u as=89.3f ps=0.85u w=0.47u l=0.16u
X117 VSS POLN cml_tlatch_81.xtail.S1 VSS sg13_lv_nmos ad=2.7982p pd=17.14u as=1.5637p ps=8.61u w=8.23u l=0.13u
X118 cml_tlatch_65.OUTN cml_tlatch_65.OUTP cml_tlatch_65.xmux.xp.S1 VSS sg13_lv_nmos ad=56.9f pd=0.74u as=0.1019p ps=1.34u w=0.17u l=0.17u
X119 VSS POLN cml_tlatch_48.xtail.S1 VSS sg13_lv_nmos ad=1.5637p pd=8.61u as=1.5637p ps=8.61u w=8.23u l=0.13u
X120 J2_N J1_P cml_tlatch_92.xmux.xn.S1 VSS sg13_lv_nmos ad=0.1082p pd=1.34u as=63.19999f ps=0.74u w=0.26u l=0.38u
X121 VDD CKHA2_P VSS rppd l=13.09u w=1u
X122 cml_tlatch_7.xmux.xp.S1 CKHB1_N cml_tlatch_7.xtail.S1 VSS sg13_lv_nmos ad=89.3f pd=0.85u as=89.3f ps=0.85u w=0.47u l=0.16u
X123 cml_tlatch_40.xmux.xp.S1 MOT12_N MOT12_P VSS sg13_lv_nmos ad=56.9f pd=0.74u as=56.9f ps=0.74u w=0.17u l=0.17u
X124 interco_bi_19.INP interco_bi_19.INN cml_tlatch_0.xmux.xp.S1 VSS sg13_lv_nmos ad=56.9f pd=0.74u as=56.9f ps=0.74u w=0.17u l=0.17u
X125 cml_tlatch_40.xmux.xp.S1 CKHA1_N cml_tlatch_40.xtail.S1 VSS sg13_lv_nmos ad=89.3f pd=0.85u as=89.3f ps=0.85u w=0.47u l=0.16u
X126 A2_8_P A2_8_N cml_tlatch_81.xmux.xp.S1 VSS sg13_lv_nmos ad=56.9f pd=0.74u as=56.9f ps=0.74u w=0.17u l=0.17u
X127 cml_tlatch_77.xmux.xp.S1 B2_8_N B2_8_P VSS sg13_lv_nmos ad=56.9f pd=0.74u as=56.9f ps=0.74u w=0.17u l=0.17u
X128 MOT18_N cml_tlatch_83.OUTP cml_tlatch_49.xmux.xn.S1 VSS sg13_lv_nmos ad=63.19999f pd=0.74u as=63.19999f ps=0.74u w=0.26u l=0.38u
X129 cml_tlatch_6.xmux.xn.S1 cml_tlatch_6.INP MOT13_N VSS sg13_lv_nmos ad=63.19999f pd=0.74u as=0.1082p ps=1.34u w=0.26u l=0.38u
X130 cml_gate2_8.sg13_lv_nmos_FTPY57_0.D0 NS1_P cml_gate2_8.xrtail.R1 VSS sg13_lv_nmos ad=0.1007p pd=0.91u as=0.1007p ps=0.91u w=0.53u l=0.13u
X131 cml_tlatch_3.OUTN cml_tlatch_3.OUTP cml_tlatch_3.xmux.xp.S1 VSS sg13_lv_nmos ad=56.9f pd=0.74u as=56.9f ps=0.74u w=0.17u l=0.17u
X132 MOT25_P MOT25_N cml_tlatch_68.xmux.xp.S1 VSS sg13_lv_nmos ad=56.9f pd=0.74u as=56.9f ps=0.74u w=0.17u l=0.17u
X133 cml_tlatch_75.xmux.xn.S1 CKHB2_P cml_tlatch_75.xtail.S1 VSS sg13_lv_nmos ad=89.3f pd=0.85u as=89.3f ps=0.85u w=0.47u l=0.16u
X134 cml_tlatch_1.xmux.xp.S1 cml_tlatch_1.OUTN cml_tlatch_1.OUTP VSS sg13_lv_nmos ad=56.9f pd=0.74u as=56.9f ps=0.74u w=0.17u l=0.17u
X135 cml_tlatch_38.xmux.xn.S1 D1_N cml_tlatch_38.OUTP VSS sg13_lv_nmos ad=63.19999f pd=0.74u as=63.19999f ps=0.74u w=0.26u l=0.38u
X136 cml_tlatch_90.xtail.S1 CKJ_P cml_tlatch_90.xmux.xp.S1 VSS sg13_lv_nmos ad=89.3f pd=0.85u as=89.3f ps=0.85u w=0.47u l=0.16u
X137 cml_tlatch_57.xmux.xp.S1 MOT26_N MOT26_P VSS sg13_lv_nmos ad=56.9f pd=0.74u as=56.9f ps=0.74u w=0.17u l=0.17u
X138 A3_2_N cml_tlatch_54.OUTP cml_tlatch_53.xmux.xn.S1 VSS sg13_lv_nmos ad=63.19999f pd=0.74u as=63.19999f ps=0.74u w=0.26u l=0.38u
X139 cml_tlatch_66.xmux.xp.S1 cml_tlatch_57.INN cml_tlatch_57.INP VSS sg13_lv_nmos ad=56.9f pd=0.74u as=56.9f ps=0.74u w=0.17u l=0.17u
X140 cml_tlatch_16.xmux.xp.S1 cml_tlatch_16.OUTN cml_tlatch_16.OUTP VSS sg13_lv_nmos ad=56.9f pd=0.74u as=56.9f ps=0.74u w=0.17u l=0.17u
X141 cml_gate2_2.xrtail.R1 CKB0_N GA0_P VSS sg13_lv_nmos ad=0.1007p pd=0.91u as=0.1007p ps=0.91u w=0.53u l=0.13u
X142 cml_tlatch_95.xtail.S1 CKA1_N cml_tlatch_95.xmux.xn.S1 VSS sg13_lv_nmos ad=89.3f pd=0.85u as=89.3f ps=0.85u w=0.47u l=0.16u
X143 cml_tlatch_82.xmux.xp.S1 CKA2_N cml_tlatch_82.xtail.S1 VSS sg13_lv_nmos ad=89.3f pd=0.85u as=89.3f ps=0.85u w=0.47u l=0.16u
X144 cml_tlatch_53.xtail.S1 CKA3_N cml_tlatch_53.xmux.xn.S1 VSS sg13_lv_nmos ad=89.3f pd=0.85u as=89.3f ps=0.85u w=0.47u l=0.16u
X145 A0_8_P A0_8_N cml_tlatch_2.xmux.xp.S1 VSS sg13_lv_nmos ad=56.9f pd=0.74u as=56.9f ps=0.74u w=0.17u l=0.17u
X146 cml_tlatch_30.xtail.S1 POLN VSS VSS sg13_lv_nmos ad=1.5637p pd=8.61u as=2.7982p ps=17.14u w=8.23u l=0.13u
X147 cml_tlatch_89.INN cml_tlatch_89.INP cml_tlatch_55.xmux.xp.S1 VSS sg13_lv_nmos ad=56.9f pd=0.74u as=56.9f ps=0.74u w=0.17u l=0.17u
X148 GA0_N ENA0_P cml_gate2_2.sg13_lv_nmos_FTPY57_0.D0 VSS sg13_lv_nmos ad=0.1007p pd=0.91u as=0.1007p ps=0.91u w=0.53u l=0.13u
X149 cml_tlatch_39.INN interco_bi_19.INP cml_tlatch_23.xmux.xn.S1 VSS sg13_lv_nmos ad=63.19999f pd=0.74u as=63.19999f ps=0.74u w=0.26u l=0.38u
X150 cml_tlatch_43.xmux.xp.S1 stub_bi_42.BOTN stub_bi_42.BOTP VSS sg13_lv_nmos ad=56.9f pd=0.74u as=56.9f ps=0.74u w=0.17u l=0.17u
X151 cml_tlatch_11.xtail.S1 CKB0_P cml_tlatch_11.xmux.xn.S1 VSS sg13_lv_nmos ad=89.3f pd=0.85u as=89.3f ps=0.85u w=0.47u l=0.16u
X152 cml_tlatch_23.xtail.S1 POLN VSS VSS sg13_lv_nmos ad=1.5637p pd=8.61u as=2.7982p ps=17.14u w=8.23u l=0.13u
X153 cml_tlatch_90.xmux.xp.S1 J4_P J4_N VSS sg13_lv_nmos ad=56.9f pd=0.74u as=56.9f ps=0.74u w=0.17u l=0.17u
X154 cml_tlatch_5.xmux.xn.S1 cml_tlatch_5.INN MOT11_P VSS sg13_lv_nmos ad=63.19999f pd=0.74u as=63.19999f ps=0.74u w=0.26u l=0.38u
X155 cml_tlatch_7.xmux.xp.S1 MOT15_N MOT15_P VSS sg13_lv_nmos ad=56.9f pd=0.74u as=56.9f ps=0.74u w=0.17u l=0.17u
X156 cml_tlatch_34.xtail.S1 CKB1_P cml_tlatch_34.xmux.xn.S1 VSS sg13_lv_nmos ad=0.1598p pd=1.62u as=89.3f ps=0.85u w=0.47u l=0.16u
X157 cml_tlatch_78.xmux.xp.S1 CKB2_N cml_tlatch_78.xtail.S1 VSS sg13_lv_nmos ad=89.3f pd=0.85u as=89.3f ps=0.85u w=0.47u l=0.16u
X158 cml_tlatch_94.xtail.S1 CKB1_N cml_tlatch_94.xmux.xn.S1 VSS sg13_lv_nmos ad=89.3f pd=0.85u as=89.3f ps=0.85u w=0.47u l=0.16u
X159 cml_tlatch_58.INP cml_tlatch_58.INN cml_tlatch_85.xmux.xp.S1 VSS sg13_lv_nmos ad=56.9f pd=0.74u as=56.9f ps=0.74u w=0.17u l=0.17u
X160 MOT22_N MOT22_P cml_tlatch_51.xmux.xp.S1 VSS sg13_lv_nmos ad=56.9f pd=0.74u as=56.9f ps=0.74u w=0.17u l=0.17u
X161 cml_tlatch_65.xmux.xp.S1 CKA3_N cml_tlatch_65.xtail.S1 VSS sg13_lv_nmos ad=89.3f pd=0.85u as=89.3f ps=0.85u w=0.47u l=0.16u
X162 MOT27_P cml_tlatch_69.INN cml_tlatch_69.xmux.xn.S1 VSS sg13_lv_nmos ad=63.19999f pd=0.74u as=63.19999f ps=0.74u w=0.26u l=0.38u
X163 cml_tlatch_12.xmux.xn.S1 CKB1_N cml_tlatch_12.xtail.S1 VSS sg13_lv_nmos ad=89.3f pd=0.85u as=89.3f ps=0.85u w=0.47u l=0.16u
X164 cml_tlatch_87.xmux.xn.S1 A2_8_P MOT16_N VSS sg13_lv_nmos ad=63.19999f pd=0.74u as=63.19999f ps=0.74u w=0.26u l=0.38u
X165 A2_2_N A2_2_P cml_tlatch_56.xmux.xp.S1 VSS sg13_lv_nmos ad=56.9f pd=0.74u as=56.9f ps=0.74u w=0.17u l=0.17u
X166 cml_tlatch_10.xmux.xn.S1 CKB0_N cml_tlatch_10.xtail.S1 VSS sg13_lv_nmos ad=89.3f pd=0.85u as=89.3f ps=0.85u w=0.47u l=0.16u
X167 MOT9_P VDD VSS rppd l=5.17u w=1u
X168 cml_tlatch_95.xmux.xp.S1 cml_tlatch_40.INN cml_tlatch_40.INP VSS sg13_lv_nmos ad=56.9f pd=0.74u as=56.9f ps=0.74u w=0.17u l=0.17u
X169 cml_tlatch_90.xmux.xp.S1 J4_P J4_N VSS sg13_lv_nmos ad=0.1019p pd=1.34u as=56.9f ps=0.74u w=0.17u l=0.17u
X170 cml_tlatch_6.INP cml_tlatch_6.INN cml_tlatch_94.xmux.xp.S1 VSS sg13_lv_nmos ad=56.9f pd=0.74u as=56.9f ps=0.74u w=0.17u l=0.17u
X171 hs_to_clk_7.D2 POLN VSS VSS sg13_lv_nmos ad=3.4p pd=20.68u as=1.9p ps=10.38u w=10u l=0.13u
X172 cml_tlatch_79.xmux.xn.S1 CKB2_N cml_tlatch_79.xtail.S1 VSS sg13_lv_nmos ad=89.3f pd=0.85u as=89.3f ps=0.85u w=0.47u l=0.16u
X173 cml_tlatch_27.OUTP cml_tlatch_27.OUTN cml_tlatch_27.xmux.xp.S1 VSS sg13_lv_nmos ad=56.9f pd=0.74u as=56.9f ps=0.74u w=0.17u l=0.17u
X174 MOT14_N MOT14_P cml_tlatch_41.xmux.xp.S1 VSS sg13_lv_nmos ad=56.9f pd=0.74u as=56.9f ps=0.74u w=0.17u l=0.17u
X175 cml_tlatch_17.xtail.S1 CKHB0_P cml_tlatch_17.xmux.xn.S1 VSS sg13_lv_nmos ad=89.3f pd=0.85u as=89.3f ps=0.85u w=0.47u l=0.16u
X176 cml_tlatch_66.xmux.xn.S1 CKA3_N cml_tlatch_66.xtail.S1 VSS sg13_lv_nmos ad=89.3f pd=0.85u as=89.3f ps=0.85u w=0.47u l=0.16u
X177 MOT1_N B0_8_P cml_tlatch_17.xmux.xn.S1 VSS sg13_lv_nmos ad=63.19999f pd=0.74u as=63.19999f ps=0.74u w=0.26u l=0.38u
X178 cml_tlatch_34.xtail.S1 POLN VSS VSS sg13_lv_nmos ad=1.5637p pd=8.61u as=1.5637p ps=8.61u w=8.23u l=0.13u
X179 cml_tlatch_27.xmux.xn.S1 CKB0_P cml_tlatch_27.xtail.S1 VSS sg13_lv_nmos ad=89.3f pd=0.85u as=89.3f ps=0.85u w=0.47u l=0.16u
X180 cml_tlatch_35.xmux.xp.S1 cml_tlatch_35.OUTP cml_tlatch_35.OUTN VSS sg13_lv_nmos ad=56.9f pd=0.74u as=56.9f ps=0.74u w=0.17u l=0.17u
X181 MOT5_N MOT5_P cml_tlatch_19.xmux.xp.S1 VSS sg13_lv_nmos ad=56.9f pd=0.74u as=56.9f ps=0.74u w=0.17u l=0.17u
X182 cml_drv_0.xrtail.R1 ENB_N ENB1_P VSS sg13_lv_nmos ad=56.2f pd=0.74u as=56.2f ps=0.74u w=0.16u l=0.19u
X183 cml_tlatch_72.xmux.xp.S1 cml_tlatch_83.INP cml_tlatch_83.INN VSS sg13_lv_nmos ad=56.9f pd=0.74u as=56.9f ps=0.74u w=0.17u l=0.17u
X184 cml_tlatch_69.INN cml_tlatch_63.OUTP cml_tlatch_62.xmux.xn.S1 VSS sg13_lv_nmos ad=63.19999f pd=0.74u as=63.19999f ps=0.74u w=0.26u l=0.38u
X185 cml_tlatch_63.OUTN cml_tlatch_63.OUTP cml_tlatch_63.xmux.xp.S1 VSS sg13_lv_nmos ad=56.9f pd=0.74u as=56.9f ps=0.74u w=0.17u l=0.17u
X186 cml_tlatch_40.xmux.xn.S1 CKHA1_P cml_tlatch_40.xtail.S1 VSS sg13_lv_nmos ad=89.3f pd=0.85u as=89.3f ps=0.85u w=0.47u l=0.16u
X187 A0_8_N A0_8_P cml_tlatch_2.xmux.xp.S1 VSS sg13_lv_nmos ad=56.9f pd=0.74u as=56.9f ps=0.74u w=0.17u l=0.17u
X188 cml_tlatch_73.xmux.xp.S1 MOT17_P MOT17_N VSS sg13_lv_nmos ad=56.9f pd=0.74u as=56.9f ps=0.74u w=0.17u l=0.17u
X189 MOT9_P B1_8_N cml_tlatch_4.xmux.xn.S1 VSS sg13_lv_nmos ad=63.19999f pd=0.74u as=63.19999f ps=0.74u w=0.26u l=0.38u
X190 cml_tlatch_89.xmux.xn.S1 CKA2_N cml_tlatch_89.xtail.S1 VSS sg13_lv_nmos ad=89.3f pd=0.85u as=89.3f ps=0.85u w=0.47u l=0.16u
X191 stub_bi_17.BOTP stub_bi_17.BOTN cml_tlatch_13.xmux.xp.S1 VSS sg13_lv_nmos ad=56.9f pd=0.74u as=56.9f ps=0.74u w=0.17u l=0.17u
X192 cml_tlatch_11.xmux.xp.S1 CKB0_N cml_tlatch_11.xtail.S1 VSS sg13_lv_nmos ad=89.3f pd=0.85u as=89.3f ps=0.85u w=0.47u l=0.16u
X193 cml_tlatch_3.OUTN cml_tlatch_3.OUTP cml_tlatch_3.xmux.xp.S1 VSS sg13_lv_nmos ad=56.9f pd=0.74u as=56.9f ps=0.74u w=0.17u l=0.17u
X194 cml_tlatch_60.xmux.xp.S1 B3_8_P B3_8_N VSS sg13_lv_nmos ad=56.9f pd=0.74u as=56.9f ps=0.74u w=0.17u l=0.17u
X195 cml_tlatch_26.xmux.xp.S1 MOT6_N MOT6_P VSS sg13_lv_nmos ad=56.9f pd=0.74u as=56.9f ps=0.74u w=0.17u l=0.17u
X196 cml_tlatch_97.xmux.xp.S1 MOT0_P MOT0_N VSS sg13_lv_nmos ad=56.9f pd=0.74u as=56.9f ps=0.74u w=0.17u l=0.17u
X197 cml_tlatch_72.xmux.xp.S1 CKA2_N cml_tlatch_72.xtail.S1 VSS sg13_lv_nmos ad=89.3f pd=0.85u as=89.3f ps=0.85u w=0.47u l=0.16u
X198 cml_tlatch_97.xmux.xn.S1 CKHA0_P cml_tlatch_97.xtail.S1 VSS sg13_lv_nmos ad=89.3f pd=0.85u as=89.3f ps=0.85u w=0.47u l=0.16u
X199 cml_tlatch_33.xmux.xn.S1 CKB1_N cml_tlatch_33.xtail.S1 VSS sg13_lv_nmos ad=89.3f pd=0.85u as=89.3f ps=0.85u w=0.47u l=0.16u
X200 cml_tlatch_30.OUTP A0_2_N cml_tlatch_30.xmux.xn.S1 VSS sg13_lv_nmos ad=63.19999f pd=0.74u as=63.19999f ps=0.74u w=0.26u l=0.38u
X201 cml_tlatch_4.xmux.xp.S1 MOT9_N MOT9_P VSS sg13_lv_nmos ad=56.9f pd=0.74u as=56.9f ps=0.74u w=0.17u l=0.17u
X202 cml_tlatch_4.xmux.xp.S1 CKHB1_N cml_tlatch_4.xtail.S1 VSS sg13_lv_nmos ad=89.3f pd=0.85u as=89.3f ps=0.85u w=0.47u l=0.16u
X203 J4_P J4_N cml_tlatch_90.xmux.xp.S1 VSS sg13_lv_nmos ad=56.9f pd=0.74u as=56.9f ps=0.74u w=0.17u l=0.17u
X204 MOT20_N MOT20_P cml_tlatch_50.xmux.xp.S1 VSS sg13_lv_nmos ad=56.9f pd=0.74u as=56.9f ps=0.74u w=0.17u l=0.17u
X205 B2_2_N B2_2_P cml_tlatch_44.xmux.xp.S1 VSS sg13_lv_nmos ad=56.9f pd=0.74u as=56.9f ps=0.74u w=0.17u l=0.17u
X206 MOT1_N MOT1_P cml_tlatch_17.xmux.xp.S1 VSS sg13_lv_nmos ad=56.9f pd=0.74u as=56.9f ps=0.74u w=0.17u l=0.17u
X207 cml_tlatch_45.xmux.xp.S1 cml_tlatch_45.OUTN cml_tlatch_45.OUTP VSS sg13_lv_nmos ad=56.9f pd=0.74u as=56.9f ps=0.74u w=0.17u l=0.17u
X208 cml_tlatch_83.OUTN cml_tlatch_83.INP cml_tlatch_83.xmux.xn.S1 VSS sg13_lv_nmos ad=0.1082p pd=1.34u as=63.19999f ps=0.74u w=0.26u l=0.38u
X209 cml_tlatch_24.xmux.xp.S1 CKHA0_N cml_tlatch_24.xtail.S1 VSS sg13_lv_nmos ad=89.3f pd=0.85u as=89.3f ps=0.85u w=0.47u l=0.16u
X210 cml_tlatch_87.xtail.S1 CKHA2_N cml_tlatch_87.xmux.xp.S1 VSS sg13_lv_nmos ad=89.3f pd=0.85u as=89.3f ps=0.85u w=0.47u l=0.16u
X211 ENA_N J1_P cml_gate2_9.sg13_lv_nmos_FTPY57_0.D0 VSS sg13_lv_nmos ad=0.1007p pd=0.91u as=0.1802p ps=1.74u w=0.53u l=0.13u
X212 cml_tlatch_36.xtail.S1 CKA1_N cml_tlatch_36.xmux.xp.S1 VSS sg13_lv_nmos ad=89.3f pd=0.85u as=89.3f ps=0.85u w=0.47u l=0.16u
X213 cml_tlatch_21.xmux.xp.S1 CKA1_P cml_tlatch_21.xtail.S1 VSS sg13_lv_nmos ad=89.3f pd=0.85u as=89.3f ps=0.85u w=0.47u l=0.16u
X214 cml_tlatch_1.OUTP cml_tlatch_98.OUTN cml_tlatch_1.xmux.xn.S1 VSS sg13_lv_nmos ad=63.19999f pd=0.74u as=63.19999f ps=0.74u w=0.26u l=0.38u
X215 cml_tlatch_75.xmux.xp.S1 MOT21_P MOT21_N VSS sg13_lv_nmos ad=56.9f pd=0.74u as=56.9f ps=0.74u w=0.17u l=0.17u
X216 cml_tlatch_84.xmux.xp.S1 cml_tlatch_70.INN cml_tlatch_70.INP VSS sg13_lv_nmos ad=56.9f pd=0.74u as=56.9f ps=0.74u w=0.17u l=0.17u
X217 cml_tlatch_36.xmux.xp.S1 cml_tlatch_95.INP cml_tlatch_95.INN VSS sg13_lv_nmos ad=56.9f pd=0.74u as=56.9f ps=0.74u w=0.17u l=0.17u
X218 MOT29_N MOT29_P cml_tlatch_70.xmux.xp.S1 VSS sg13_lv_nmos ad=56.9f pd=0.74u as=56.9f ps=0.74u w=0.17u l=0.17u
X219 cml_tlatch_37.xmux.xp.S1 CKA1_P cml_tlatch_37.xtail.S1 VSS sg13_lv_nmos ad=89.3f pd=0.85u as=89.3f ps=0.85u w=0.47u l=0.16u
X220 cml_tlatch_70.INN cml_tlatch_45.OUTP cml_tlatch_84.xmux.xn.S1 VSS sg13_lv_nmos ad=63.19999f pd=0.74u as=63.19999f ps=0.74u w=0.26u l=0.38u
X221 cml_tlatch_88.xmux.xp.S1 CKB2_P cml_tlatch_88.xtail.S1 VSS sg13_lv_nmos ad=89.3f pd=0.85u as=89.3f ps=0.85u w=0.47u l=0.16u
X222 cml_tlatch_93.xmux.xp.S1 J1_N J1_P VSS sg13_lv_nmos ad=56.9f pd=0.74u as=56.9f ps=0.74u w=0.17u l=0.17u
X223 cml_tlatch_89.OUTN cml_tlatch_89.OUTP cml_tlatch_89.xmux.xp.S1 VSS sg13_lv_nmos ad=56.9f pd=0.74u as=56.9f ps=0.74u w=0.17u l=0.17u
X224 cml_tlatch_31.xmux.xp.S1 A0_2_P A0_2_N VSS sg13_lv_nmos ad=56.9f pd=0.74u as=56.9f ps=0.74u w=0.17u l=0.17u
X225 cml_tlatch_75.xtail.S1 CKHB2_P cml_tlatch_75.xmux.xn.S1 VSS sg13_lv_nmos ad=89.3f pd=0.85u as=89.3f ps=0.85u w=0.47u l=0.16u
X226 cml_tlatch_58.INP cml_tlatch_52.OUTN cml_tlatch_85.xmux.xn.S1 VSS sg13_lv_nmos ad=63.19999f pd=0.74u as=63.19999f ps=0.74u w=0.26u l=0.38u
X227 MOT26_P cml_tlatch_57.INN cml_tlatch_57.xmux.xn.S1 VSS sg13_lv_nmos ad=63.19999f pd=0.74u as=63.19999f ps=0.74u w=0.26u l=0.38u
X228 cml_tlatch_6.INP cml_tlatch_6.INN cml_tlatch_94.xmux.xp.S1 VSS sg13_lv_nmos ad=56.9f pd=0.74u as=56.9f ps=0.74u w=0.17u l=0.17u
X229 cml_tlatch_56.xmux.xp.S1 CKA2_P cml_tlatch_56.xtail.S1 VSS sg13_lv_nmos ad=0.1598p pd=1.62u as=89.3f ps=0.85u w=0.47u l=0.16u
X230 cml_tlatch_6.xmux.xp.S1 MOT13_P MOT13_N VSS sg13_lv_nmos ad=56.9f pd=0.74u as=56.9f ps=0.74u w=0.17u l=0.17u
X231 VDD interco_bi_19.INP VSS rppd l=5.17u w=1u
X232 MOT14_N MOT14_P cml_tlatch_41.xmux.xp.S1 VSS sg13_lv_nmos ad=56.9f pd=0.74u as=56.9f ps=0.74u w=0.17u l=0.17u
X233 cml_tlatch_12.xmux.xp.S1 CKB1_P cml_tlatch_12.xtail.S1 VSS sg13_lv_nmos ad=89.3f pd=0.85u as=89.3f ps=0.85u w=0.47u l=0.16u
X234 MOT12_P cml_tlatch_40.INN cml_tlatch_40.xmux.xn.S1 VSS sg13_lv_nmos ad=63.19999f pd=0.74u as=63.19999f ps=0.74u w=0.26u l=0.38u
X235 cml_tlatch_3.OUTP cml_tlatch_8.OUTN cml_tlatch_3.xmux.xn.S1 VSS sg13_lv_nmos ad=63.19999f pd=0.74u as=0.1082p ps=1.34u w=0.26u l=0.38u
X236 MOT2_N MOT2_P cml_tlatch_24.xmux.xp.S1 VSS sg13_lv_nmos ad=56.9f pd=0.74u as=56.9f ps=0.74u w=0.17u l=0.17u
X237 cml_tlatch_10.xtail.S1 POLN VSS VSS sg13_lv_nmos ad=1.5637p pd=8.61u as=2.7982p ps=17.14u w=8.23u l=0.13u
X238 cml_tlatch_41.xtail.S1 CKHA1_N cml_tlatch_41.xmux.xp.S1 VSS sg13_lv_nmos ad=89.3f pd=0.85u as=0.1598p ps=1.62u w=0.47u l=0.16u
X239 A3_8_P A3_8_N cml_tlatch_64.xmux.xp.S1 VSS sg13_lv_nmos ad=56.9f pd=0.74u as=56.9f ps=0.74u w=0.17u l=0.17u
X240 MOT22_P MOT22_N cml_tlatch_51.xmux.xp.S1 VSS sg13_lv_nmos ad=56.9f pd=0.74u as=0.1019p ps=1.34u w=0.17u l=0.17u
X241 cml_tlatch_82.xmux.xp.S1 cml_tlatch_82.OUTP cml_tlatch_82.OUTN VSS sg13_lv_nmos ad=56.9f pd=0.74u as=56.9f ps=0.74u w=0.17u l=0.17u
X242 cml_tlatch_70.xtail.S1 CKHB3_P cml_tlatch_70.xmux.xn.S1 VSS sg13_lv_nmos ad=89.3f pd=0.85u as=89.3f ps=0.85u w=0.47u l=0.16u
X243 B1_2_N stub_bi_31.BOTN cml_tlatch_33.xmux.xn.S1 VSS sg13_lv_nmos ad=63.19999f pd=0.74u as=63.19999f ps=0.74u w=0.26u l=0.38u
X244 cml_tlatch_67.xmux.xn.S1 cml_tlatch_58.INN cml_tlatch_67.OUTP VSS sg13_lv_nmos ad=63.19999f pd=0.74u as=63.19999f ps=0.74u w=0.26u l=0.38u
X245 stub_bi_32.BOTN VDD VSS rppd l=5.17u w=1u
X246 cml_tlatch_72.xmux.xp.S1 cml_tlatch_83.INP cml_tlatch_83.INN VSS sg13_lv_nmos ad=56.9f pd=0.74u as=56.9f ps=0.74u w=0.17u l=0.17u
X247 cml_gate2_1.xrtail.R1 CKA0_P cml_gate2_1.sg13_lv_nmos_FTPY57_0.D0 VSS sg13_lv_nmos ad=0.1007p pd=0.91u as=0.1007p ps=0.91u w=0.53u l=0.13u
X248 cml_tlatch_13.xmux.xp.S1 stub_bi_17.BOTP stub_bi_17.BOTN VSS sg13_lv_nmos ad=56.9f pd=0.74u as=56.9f ps=0.74u w=0.17u l=0.17u
X249 A1_2_P cml_tlatch_38.OUTN cml_tlatch_37.xmux.xn.S1 VSS sg13_lv_nmos ad=63.19999f pd=0.74u as=63.19999f ps=0.74u w=0.26u l=0.38u
X250 cml_tlatch_62.xmux.xp.S1 cml_tlatch_69.INP cml_tlatch_69.INN VSS sg13_lv_nmos ad=56.9f pd=0.74u as=56.9f ps=0.74u w=0.17u l=0.17u
X251 cml_tlatch_91.xmux.xp.S1 CLK_W_P CLK_W_N VSS sg13_lv_nmos ad=56.9f pd=0.74u as=56.9f ps=0.74u w=0.17u l=0.17u
X252 MOT23_P B2_2_N cml_tlatch_76.xmux.xn.S1 VSS sg13_lv_nmos ad=63.19999f pd=0.74u as=63.19999f ps=0.74u w=0.26u l=0.38u
X253 cml_tlatch_13.xmux.xn.S1 CKB1_P cml_tlatch_13.xtail.S1 VSS sg13_lv_nmos ad=89.3f pd=0.85u as=89.3f ps=0.85u w=0.47u l=0.16u
X254 cml_tlatch_82.xtail.S1 POLN VSS VSS sg13_lv_nmos ad=1.5637p pd=8.61u as=2.7982p ps=17.14u w=8.23u l=0.13u
X255 cml_tlatch_44.xmux.xp.S1 B2_2_N B2_2_P VSS sg13_lv_nmos ad=56.9f pd=0.74u as=56.9f ps=0.74u w=0.17u l=0.17u
X256 cml_tlatch_16.xmux.xp.S1 CKB0_P cml_tlatch_16.xtail.S1 VSS sg13_lv_nmos ad=89.3f pd=0.85u as=89.3f ps=0.85u w=0.47u l=0.16u
X257 VSS hs_to_clk_5.sg13_lv_nmos_2HGZLP_0.G VSS VSS sg13_lv_nmos ad=2.071p pd=11.28u as=0 ps=0 w=10.9u l=1.38u
X258 cml_tlatch_73.xmux.xp.S1 MOT17_P MOT17_N VSS sg13_lv_nmos ad=56.9f pd=0.74u as=56.9f ps=0.74u w=0.17u l=0.17u
X259 cml_tlatch_30.xmux.xn.S1 CKA0_P cml_tlatch_30.xtail.S1 VSS sg13_lv_nmos ad=89.3f pd=0.85u as=0.1598p ps=1.62u w=0.47u l=0.16u
X260 cml_tlatch_9.OUTP cml_tlatch_9.OUTN cml_tlatch_9.xmux.xp.S1 VSS sg13_lv_nmos ad=56.9f pd=0.74u as=56.9f ps=0.74u w=0.17u l=0.17u
X261 cml_tlatch_82.xmux.xn.S1 CKA2_P cml_tlatch_82.xtail.S1 VSS sg13_lv_nmos ad=89.3f pd=0.85u as=89.3f ps=0.85u w=0.47u l=0.16u
X262 MOT21_N stub_bi_55.BOTN cml_tlatch_75.xmux.xn.S1 VSS sg13_lv_nmos ad=0.1082p pd=1.34u as=63.19999f ps=0.74u w=0.26u l=0.38u
X263 cml_tlatch_23.xmux.xp.S1 CKA1_P cml_tlatch_23.xtail.S1 VSS sg13_lv_nmos ad=89.3f pd=0.85u as=89.3f ps=0.85u w=0.47u l=0.16u
X264 MOT20_P MOT20_N cml_tlatch_50.xmux.xp.S1 VSS sg13_lv_nmos ad=56.9f pd=0.74u as=56.9f ps=0.74u w=0.17u l=0.17u
X265 VSS hs_to_clk_2.sg13_lv_nmos_2HGZLP_0.G VSS VSS sg13_lv_nmos ad=2.071p pd=11.28u as=0 ps=0 w=10.9u l=1.38u
X266 cml_gate2_9.xrtail.R1 VSS VSS rppd l=4.86u w=1u
X267 cml_tlatch_58.xmux.xp.S1 MOT28_N MOT28_P VSS sg13_lv_nmos ad=56.9f pd=0.74u as=56.9f ps=0.74u w=0.17u l=0.17u
X268 cml_tlatch_40.xmux.xp.S1 MOT12_P MOT12_N VSS sg13_lv_nmos ad=56.9f pd=0.74u as=56.9f ps=0.74u w=0.17u l=0.17u
X269 cml_tlatch_17.xmux.xn.S1 CKHB0_P cml_tlatch_17.xtail.S1 VSS sg13_lv_nmos ad=89.3f pd=0.85u as=89.3f ps=0.85u w=0.47u l=0.16u
X270 cml_tlatch_67.OUTN cml_tlatch_58.INP cml_tlatch_67.xmux.xn.S1 VSS sg13_lv_nmos ad=63.19999f pd=0.74u as=0.1082p ps=1.34u w=0.26u l=0.38u
X271 cml_tlatch_97.xmux.xp.S1 MOT0_P MOT0_N VSS sg13_lv_nmos ad=56.9f pd=0.74u as=56.9f ps=0.74u w=0.17u l=0.17u
X272 cml_tlatch_4.xmux.xp.S1 MOT9_P MOT9_N VSS sg13_lv_nmos ad=56.9f pd=0.74u as=56.9f ps=0.74u w=0.17u l=0.17u
X273 cml_tlatch_52.OUTN cml_tlatch_52.OUTP cml_tlatch_52.xmux.xp.S1 VSS sg13_lv_nmos ad=56.9f pd=0.74u as=56.9f ps=0.74u w=0.17u l=0.17u
X274 cml_tlatch_52.xmux.xn.S1 CKA3_P cml_tlatch_52.xtail.S1 VSS sg13_lv_nmos ad=89.3f pd=0.85u as=89.3f ps=0.85u w=0.47u l=0.16u
X275 cml_tlatch_59.xmux.xn.S1 A3_2_N MOT30_P VSS sg13_lv_nmos ad=63.19999f pd=0.74u as=63.19999f ps=0.74u w=0.26u l=0.38u
X276 cml_tlatch_70.xtail.S1 CKHB3_N cml_tlatch_70.xmux.xp.S1 VSS sg13_lv_nmos ad=89.3f pd=0.85u as=0.1598p ps=1.62u w=0.47u l=0.16u
X277 cml_tlatch_43.xmux.xn.S1 B2_2_P stub_bi_42.BOTP VSS sg13_lv_nmos ad=63.19999f pd=0.74u as=63.19999f ps=0.74u w=0.26u l=0.38u
X278 cml_tlatch_20.xmux.xp.S1 MOT7_P MOT7_N VSS sg13_lv_nmos ad=56.9f pd=0.74u as=56.9f ps=0.74u w=0.17u l=0.17u
X279 GB0_P CKA0_N cml_gate2_1.xrtail.R1 VSS sg13_lv_nmos ad=0.1007p pd=0.91u as=0.1007p ps=0.91u w=0.53u l=0.13u
X280 stub_bi_49.BOTN stub_bi_49.BOTP cml_tlatch_80.xmux.xp.S1 VSS sg13_lv_nmos ad=56.9f pd=0.74u as=56.9f ps=0.74u w=0.17u l=0.17u
X281 B3_8_P B3_8_N cml_tlatch_60.xmux.xp.S1 VSS sg13_lv_nmos ad=56.9f pd=0.74u as=0.1019p ps=1.34u w=0.17u l=0.17u
X282 cml_tlatch_74.xmux.xp.S1 MOT19_N MOT19_P VSS sg13_lv_nmos ad=56.9f pd=0.74u as=56.9f ps=0.74u w=0.17u l=0.17u
X283 cml_tlatch_3.xmux.xp.S1 CKA0_N cml_tlatch_3.xtail.S1 VSS sg13_lv_nmos ad=89.3f pd=0.85u as=0.1598p ps=1.62u w=0.47u l=0.16u
X284 MOT22_P MOT22_N cml_tlatch_51.xmux.xp.S1 VSS sg13_lv_nmos ad=56.9f pd=0.74u as=56.9f ps=0.74u w=0.17u l=0.17u
X285 cml_tlatch_29.xmux.xp.S1 cml_tlatch_29.OUTP cml_tlatch_29.OUTN VSS sg13_lv_nmos ad=56.9f pd=0.74u as=56.9f ps=0.74u w=0.17u l=0.17u
X286 stub_bi_32.BOTN D2_N cml_tlatch_48.xmux.xn.S1 VSS sg13_lv_nmos ad=63.19999f pd=0.74u as=63.19999f ps=0.74u w=0.26u l=0.38u
X287 cml_tlatch_96.xmux.xp.S1 CKHA1_N cml_tlatch_96.xtail.S1 VSS sg13_lv_nmos ad=89.3f pd=0.85u as=89.3f ps=0.85u w=0.47u l=0.16u
X288 cml_tlatch_45.xmux.xn.S1 CKB3_P cml_tlatch_45.xtail.S1 VSS sg13_lv_nmos ad=89.3f pd=0.85u as=89.3f ps=0.85u w=0.47u l=0.16u
X289 cml_tlatch_49.xmux.xp.S1 MOT18_P MOT18_N VSS sg13_lv_nmos ad=56.9f pd=0.74u as=56.9f ps=0.74u w=0.17u l=0.17u
X290 cml_tlatch_91.xmux.xn.S1 CKJ_P cml_tlatch_91.xtail.S1 VSS sg13_lv_nmos ad=0.1598p pd=1.62u as=89.3f ps=0.85u w=0.47u l=0.16u
X291 cml_tlatch_30.xmux.xp.S1 cml_tlatch_30.OUTP cml_tlatch_30.OUTN VSS sg13_lv_nmos ad=56.9f pd=0.74u as=56.9f ps=0.74u w=0.17u l=0.17u
X292 cml_tlatch_89.xmux.xp.S1 cml_tlatch_89.OUTN cml_tlatch_89.OUTP VSS sg13_lv_nmos ad=56.9f pd=0.74u as=56.9f ps=0.74u w=0.17u l=0.17u
X293 CLK_W_P CLK_W_N cml_tlatch_91.xmux.xp.S1 VSS sg13_lv_nmos ad=56.9f pd=0.74u as=56.9f ps=0.74u w=0.17u l=0.17u
X294 cml_tlatch_18.xmux.xn.S1 cml_tlatch_16.OUTP MOT3_N VSS sg13_lv_nmos ad=63.19999f pd=0.74u as=63.19999f ps=0.74u w=0.26u l=0.38u
X295 cml_drv_2.xrtail.R1 ENB_N ENB0_P VSS sg13_lv_nmos ad=56.2f pd=0.74u as=56.2f ps=0.74u w=0.16u l=0.19u
X296 cml_tlatch_34.xtail.S1 CKB1_P cml_tlatch_34.xmux.xn.S1 VSS sg13_lv_nmos ad=89.3f pd=0.85u as=89.3f ps=0.85u w=0.47u l=0.16u
X297 MOT16_P MOT16_N cml_tlatch_87.xmux.xp.S1 VSS sg13_lv_nmos ad=56.9f pd=0.74u as=56.9f ps=0.74u w=0.17u l=0.17u
X298 VSS POLN cml_tlatch_98.xtail.S1 VSS sg13_lv_nmos ad=1.5637p pd=8.61u as=1.5637p ps=8.61u w=8.23u l=0.13u
X299 MOT13_P MOT13_N cml_tlatch_6.xmux.xp.S1 VSS sg13_lv_nmos ad=56.9f pd=0.74u as=56.9f ps=0.74u w=0.17u l=0.17u
X300 cml_tlatch_52.xmux.xn.S1 A3_2_N cml_tlatch_52.OUTP VSS sg13_lv_nmos ad=63.19999f pd=0.74u as=63.19999f ps=0.74u w=0.26u l=0.38u
X301 MOT23_P MOT23_N cml_tlatch_76.xmux.xp.S1 VSS sg13_lv_nmos ad=56.9f pd=0.74u as=56.9f ps=0.74u w=0.17u l=0.17u
X302 B2_8_N B2_8_P cml_tlatch_77.xmux.xp.S1 VSS sg13_lv_nmos ad=56.9f pd=0.74u as=56.9f ps=0.74u w=0.17u l=0.17u
X303 cml_tlatch_71.xmux.xp.S1 MOT31_N MOT31_P VSS sg13_lv_nmos ad=56.9f pd=0.74u as=56.9f ps=0.74u w=0.17u l=0.17u
X304 cml_tlatch_34.xmux.xp.S1 stub_bi_31.BOTP stub_bi_31.BOTN VSS sg13_lv_nmos ad=56.9f pd=0.74u as=56.9f ps=0.74u w=0.17u l=0.17u
X305 cml_tlatch_31.xmux.xp.S1 A0_2_P A0_2_N VSS sg13_lv_nmos ad=56.9f pd=0.74u as=56.9f ps=0.74u w=0.17u l=0.17u
X306 hs_to_clk_1.sg13_lv_nmos_2HGZLP_0.G VDD VSS rppd l=0.68u w=1u
X307 cml_tlatch_97.xtail.S1 CKHA0_P cml_tlatch_97.xmux.xn.S1 VSS sg13_lv_nmos ad=89.3f pd=0.85u as=89.3f ps=0.85u w=0.47u l=0.16u
X308 cml_tlatch_7.xmux.xn.S1 B1_2_P MOT15_N VSS sg13_lv_nmos ad=63.19999f pd=0.74u as=63.19999f ps=0.74u w=0.26u l=0.38u
X309 cml_tlatch_82.OUTN cml_tlatch_83.OUTP cml_tlatch_82.xmux.xn.S1 VSS sg13_lv_nmos ad=63.19999f pd=0.74u as=63.19999f ps=0.74u w=0.26u l=0.38u
X310 cml_tlatch_26.xtail.S1 CKHA0_P cml_tlatch_26.xmux.xn.S1 VSS sg13_lv_nmos ad=89.3f pd=0.85u as=89.3f ps=0.85u w=0.47u l=0.16u
X311 cml_tlatch_38.OUTN cml_tlatch_38.OUTP cml_tlatch_38.xmux.xp.S1 VSS sg13_lv_nmos ad=56.9f pd=0.74u as=56.9f ps=0.74u w=0.17u l=0.17u
X312 cml_tlatch_48.xmux.xp.S1 stub_bi_32.BOTN stub_bi_32.BOTP VSS sg13_lv_nmos ad=56.9f pd=0.74u as=56.9f ps=0.74u w=0.17u l=0.17u
X313 cml_tlatch_8.xmux.xp.S1 cml_tlatch_8.OUTN cml_tlatch_8.OUTP VSS sg13_lv_nmos ad=56.9f pd=0.74u as=56.9f ps=0.74u w=0.17u l=0.17u
X314 cml_tlatch_47.xmux.xp.S1 CKB3_N cml_tlatch_47.xtail.S1 VSS sg13_lv_nmos ad=89.3f pd=0.85u as=89.3f ps=0.85u w=0.47u l=0.16u
X315 cml_tlatch_79.xmux.xn.S1 CKB2_N cml_tlatch_79.xtail.S1 VSS sg13_lv_nmos ad=89.3f pd=0.85u as=89.3f ps=0.85u w=0.47u l=0.16u
X316 VDD A1_8_N VSS rppd l=5.17u w=1u
X317 cml_tlatch_52.OUTN A3_2_P cml_tlatch_52.xmux.xn.S1 VSS sg13_lv_nmos ad=63.19999f pd=0.74u as=63.19999f ps=0.74u w=0.26u l=0.38u
X318 MOT2_N MOT2_P cml_tlatch_24.xmux.xp.S1 VSS sg13_lv_nmos ad=56.9f pd=0.74u as=56.9f ps=0.74u w=0.17u l=0.17u
X319 stub_bi_42.BOTN stub_bi_42.BOTP cml_tlatch_43.xmux.xp.S1 VSS sg13_lv_nmos ad=56.9f pd=0.74u as=56.9f ps=0.74u w=0.17u l=0.17u
X320 cml_tlatch_87.xmux.xp.S1 CKHA2_N cml_tlatch_87.xtail.S1 VSS sg13_lv_nmos ad=89.3f pd=0.85u as=89.3f ps=0.85u w=0.47u l=0.16u
X321 cml_tlatch_82.xmux.xp.S1 cml_tlatch_82.OUTP cml_tlatch_82.OUTN VSS sg13_lv_nmos ad=56.9f pd=0.74u as=56.9f ps=0.74u w=0.17u l=0.17u
X322 VSS POLN cml_tlatch_22.xtail.S1 VSS sg13_lv_nmos ad=1.5637p pd=8.61u as=1.5637p ps=8.61u w=8.23u l=0.13u
X323 cml_tlatch_80.xtail.S1 CKB2_P cml_tlatch_80.xmux.xn.S1 VSS sg13_lv_nmos ad=89.3f pd=0.85u as=89.3f ps=0.85u w=0.47u l=0.16u
X324 cml_gate2_8.xrtail.R1 NS1_P cml_gate2_8.sg13_lv_nmos_FTPY57_0.D0 VSS sg13_lv_nmos ad=0.1007p pd=0.91u as=0.1007p ps=0.91u w=0.53u l=0.13u
X325 stub_bi_62.BOTP stub_bi_62.BOTN cml_tlatch_78.xmux.xp.S1 VSS sg13_lv_nmos ad=56.9f pd=0.74u as=56.9f ps=0.74u w=0.17u l=0.17u
X326 cml_tlatch_27.xmux.xn.S1 CKB0_P cml_tlatch_27.xtail.S1 VSS sg13_lv_nmos ad=89.3f pd=0.85u as=89.3f ps=0.85u w=0.47u l=0.16u
X327 MOT24_N MOT24_P cml_tlatch_86.xmux.xp.S1 VSS sg13_lv_nmos ad=56.9f pd=0.74u as=56.9f ps=0.74u w=0.17u l=0.17u
X328 A1_2_P A1_2_N cml_tlatch_37.xmux.xp.S1 VSS sg13_lv_nmos ad=56.9f pd=0.74u as=0.1019p ps=1.34u w=0.17u l=0.17u
X329 cml_tlatch_9.OUTP cml_tlatch_9.OUTN cml_tlatch_9.xmux.xp.S1 VSS sg13_lv_nmos ad=56.9f pd=0.74u as=56.9f ps=0.74u w=0.17u l=0.17u
X330 cml_gate2_8.sg13_lv_nmos_FTPY57_0.D0 J2_P ENB_N VSS sg13_lv_nmos ad=0.1007p pd=0.91u as=0.1007p ps=0.91u w=0.53u l=0.13u
X331 cml_tlatch_87.xtail.S1 CKHA2_P cml_tlatch_87.xmux.xn.S1 VSS sg13_lv_nmos ad=89.3f pd=0.85u as=89.3f ps=0.85u w=0.47u l=0.16u
X332 cml_tlatch_24.xmux.xn.S1 CKHA0_P cml_tlatch_24.xtail.S1 VSS sg13_lv_nmos ad=0.1598p pd=1.62u as=89.3f ps=0.85u w=0.47u l=0.16u
X333 cml_tlatch_54.xtail.S1 CKA3_P cml_tlatch_54.xmux.xn.S1 VSS sg13_lv_nmos ad=89.3f pd=0.85u as=89.3f ps=0.85u w=0.47u l=0.16u
X334 cml_tlatch_88.xtail.S1 CKB2_P cml_tlatch_88.xmux.xp.S1 VSS sg13_lv_nmos ad=89.3f pd=0.85u as=0.1598p ps=1.62u w=0.47u l=0.16u
X335 cml_tlatch_86.xmux.xp.S1 CKHA3_N cml_tlatch_86.xtail.S1 VSS sg13_lv_nmos ad=89.3f pd=0.85u as=89.3f ps=0.85u w=0.47u l=0.16u
X336 cml_tlatch_58.xmux.xp.S1 MOT28_N MOT28_P VSS sg13_lv_nmos ad=56.9f pd=0.74u as=56.9f ps=0.74u w=0.17u l=0.17u
X337 cml_tlatch_66.xmux.xn.S1 cml_tlatch_67.OUTN cml_tlatch_57.INP VSS sg13_lv_nmos ad=63.19999f pd=0.74u as=63.19999f ps=0.74u w=0.26u l=0.38u
X338 cml_tlatch_99.OUTN cml_tlatch_99.OUTP cml_tlatch_99.xmux.xp.S1 VSS sg13_lv_nmos ad=56.9f pd=0.74u as=56.9f ps=0.74u w=0.17u l=0.17u
X339 cml_tlatch_7.xtail.S1 CKHB1_P cml_tlatch_7.xmux.xn.S1 VSS sg13_lv_nmos ad=89.3f pd=0.85u as=89.3f ps=0.85u w=0.47u l=0.16u
X340 cml_tlatch_32.xtail.S1 CKB1_P cml_tlatch_32.xmux.xn.S1 VSS sg13_lv_nmos ad=89.3f pd=0.85u as=89.3f ps=0.85u w=0.47u l=0.16u
X341 cml_tlatch_49.xmux.xp.S1 MOT18_N MOT18_P VSS sg13_lv_nmos ad=56.9f pd=0.74u as=56.9f ps=0.74u w=0.17u l=0.17u
X342 cml_tlatch_28.xmux.xn.S1 CKB0_N cml_tlatch_28.xtail.S1 VSS sg13_lv_nmos ad=89.3f pd=0.85u as=89.3f ps=0.85u w=0.47u l=0.16u
X343 cml_tlatch_11.xmux.xp.S1 CKB0_N cml_tlatch_11.xtail.S1 VSS sg13_lv_nmos ad=89.3f pd=0.85u as=89.3f ps=0.85u w=0.47u l=0.16u
X344 cml_tlatch_45.xtail.S1 POLN VSS VSS sg13_lv_nmos ad=1.5637p pd=8.61u as=1.5637p ps=8.61u w=8.23u l=0.13u
X345 cml_tlatch_58.xtail.S1 CKHA3_N cml_tlatch_58.xmux.xp.S1 VSS sg13_lv_nmos ad=89.3f pd=0.85u as=89.3f ps=0.85u w=0.47u l=0.16u
X346 cml_tlatch_70.xmux.xp.S1 MOT29_N MOT29_P VSS sg13_lv_nmos ad=56.9f pd=0.74u as=56.9f ps=0.74u w=0.17u l=0.17u
X347 stub_bi_49.BOTN stub_bi_49.BOTP cml_tlatch_80.xmux.xp.S1 VSS sg13_lv_nmos ad=56.9f pd=0.74u as=56.9f ps=0.74u w=0.17u l=0.17u
X348 MOT12_P MOT12_N cml_tlatch_40.xmux.xp.S1 VSS sg13_lv_nmos ad=56.9f pd=0.74u as=56.9f ps=0.74u w=0.17u l=0.17u
X349 cml_tlatch_0.xmux.xp.S1 interco_bi_19.INN interco_bi_19.INP VSS sg13_lv_nmos ad=56.9f pd=0.74u as=56.9f ps=0.74u w=0.17u l=0.17u
X350 cml_tlatch_72.xmux.xp.S1 CKA2_N cml_tlatch_72.xtail.S1 VSS sg13_lv_nmos ad=89.3f pd=0.85u as=89.3f ps=0.85u w=0.47u l=0.16u
X351 VDD A3_2_N VSS rppd l=5.17u w=1u
X352 MOT10_N MOT10_P cml_tlatch_39.xmux.xp.S1 VSS sg13_lv_nmos ad=56.9f pd=0.74u as=0.1019p ps=1.34u w=0.17u l=0.17u
X353 cml_tlatch_81.xmux.xp.S1 A2_8_N A2_8_P VSS sg13_lv_nmos ad=56.9f pd=0.74u as=56.9f ps=0.74u w=0.17u l=0.17u
X354 cml_tlatch_95.xmux.xp.S1 cml_tlatch_40.INP cml_tlatch_40.INN VSS sg13_lv_nmos ad=56.9f pd=0.74u as=56.9f ps=0.74u w=0.17u l=0.17u
X355 cml_tlatch_33.xmux.xp.S1 B1_2_P B1_2_N VSS sg13_lv_nmos ad=56.9f pd=0.74u as=56.9f ps=0.74u w=0.17u l=0.17u
X356 cml_tlatch_6.INP stub_bi_29.BOTP cml_tlatch_94.xmux.xn.S1 VSS sg13_lv_nmos ad=63.19999f pd=0.74u as=63.19999f ps=0.74u w=0.26u l=0.38u
X357 VSS POLN cml_tlatch_42.xtail.S1 VSS sg13_lv_nmos ad=2.7982p pd=17.14u as=1.5637p ps=8.61u w=8.23u l=0.13u
X358 cml_tlatch_84.xtail.S1 CKB3_P cml_tlatch_84.xmux.xp.S1 VSS sg13_lv_nmos ad=89.3f pd=0.85u as=89.3f ps=0.85u w=0.47u l=0.16u
X359 cml_tlatch_95.xmux.xp.S1 CKA1_P cml_tlatch_95.xtail.S1 VSS sg13_lv_nmos ad=0.1598p pd=1.62u as=89.3f ps=0.85u w=0.47u l=0.16u
X360 VSS POLN cml_tlatch_75.xtail.S1 VSS sg13_lv_nmos ad=1.5637p pd=8.61u as=1.5637p ps=8.61u w=8.23u l=0.13u
X361 MOT17_P MOT17_N cml_tlatch_73.xmux.xp.S1 VSS sg13_lv_nmos ad=56.9f pd=0.74u as=56.9f ps=0.74u w=0.17u l=0.17u
X362 cml_tlatch_68.xmux.xp.S1 MOT25_N MOT25_P VSS sg13_lv_nmos ad=56.9f pd=0.74u as=56.9f ps=0.74u w=0.17u l=0.17u
X363 cml_tlatch_18.xmux.xp.S1 MOT3_P MOT3_N VSS sg13_lv_nmos ad=56.9f pd=0.74u as=56.9f ps=0.74u w=0.17u l=0.17u
X364 GA1_P CKB1_N cml_gate2_3.xrtail.R1 VSS sg13_lv_nmos ad=0.1007p pd=0.91u as=0.1007p ps=0.91u w=0.53u l=0.13u
X365 ENA1_P ENA_N cml_drv_1.xrtail.R1 VSS sg13_lv_nmos ad=56.2f pd=0.74u as=56.2f ps=0.74u w=0.16u l=0.19u
X366 cml_tlatch_24.xmux.xp.S1 CKHA0_N cml_tlatch_24.xtail.S1 VSS sg13_lv_nmos ad=89.3f pd=0.85u as=89.3f ps=0.85u w=0.47u l=0.16u
X367 cml_tlatch_59.xtail.S1 POLN VSS VSS sg13_lv_nmos ad=1.5637p pd=8.61u as=1.5637p ps=8.61u w=8.23u l=0.13u
X368 stub_bi_55.BOTN stub_bi_55.BOTP cml_tlatch_88.xmux.xp.S1 VSS sg13_lv_nmos ad=56.9f pd=0.74u as=56.9f ps=0.74u w=0.17u l=0.17u
X369 cml_tlatch_62.xmux.xn.S1 cml_tlatch_63.OUTP cml_tlatch_69.INN VSS sg13_lv_nmos ad=63.19999f pd=0.74u as=63.19999f ps=0.74u w=0.26u l=0.38u
X370 cml_tlatch_3.xmux.xp.S1 cml_tlatch_3.OUTN cml_tlatch_3.OUTP VSS sg13_lv_nmos ad=56.9f pd=0.74u as=56.9f ps=0.74u w=0.17u l=0.17u
X371 cml_tlatch_96.xtail.S1 CKHA1_P cml_tlatch_96.xmux.xn.S1 VSS sg13_lv_nmos ad=89.3f pd=0.85u as=89.3f ps=0.85u w=0.47u l=0.16u
X372 hs_to_clk_8.sg13_lv_nmos_2HGZLP_0.G CKJ_N VSS rppd l=4.25u w=1u
X373 cml_tlatch_57.INP cml_tlatch_57.INN cml_tlatch_66.xmux.xp.S1 VSS sg13_lv_nmos ad=56.9f pd=0.74u as=56.9f ps=0.74u w=0.17u l=0.17u
X374 cml_tlatch_86.xmux.xp.S1 MOT24_N MOT24_P VSS sg13_lv_nmos ad=56.9f pd=0.74u as=56.9f ps=0.74u w=0.17u l=0.17u
X375 cml_tlatch_2.xmux.xp.S1 A0_8_N A0_8_P VSS sg13_lv_nmos ad=56.9f pd=0.74u as=56.9f ps=0.74u w=0.17u l=0.17u
X376 cml_tlatch_71.xmux.xp.S1 MOT31_N MOT31_P VSS sg13_lv_nmos ad=56.9f pd=0.74u as=56.9f ps=0.74u w=0.17u l=0.17u
X377 cml_tlatch_98.OUTP cml_tlatch_98.OUTN cml_tlatch_98.xmux.xp.S1 VSS sg13_lv_nmos ad=56.9f pd=0.74u as=56.9f ps=0.74u w=0.17u l=0.17u
X378 A0_2_P cml_tlatch_35.OUTN cml_tlatch_31.xmux.xn.S1 VSS sg13_lv_nmos ad=63.19999f pd=0.74u as=63.19999f ps=0.74u w=0.26u l=0.38u
X379 cml_tlatch_45.OUTN cml_tlatch_45.OUTP cml_tlatch_45.xmux.xp.S1 VSS sg13_lv_nmos ad=56.9f pd=0.74u as=56.9f ps=0.74u w=0.17u l=0.17u
X380 MOT16_P A2_8_N cml_tlatch_87.xmux.xn.S1 VSS sg13_lv_nmos ad=63.19999f pd=0.74u as=63.19999f ps=0.74u w=0.26u l=0.38u
X381 MOT8_P MOT8_N cml_tlatch_96.xmux.xp.S1 VSS sg13_lv_nmos ad=56.9f pd=0.74u as=56.9f ps=0.74u w=0.17u l=0.17u
X382 cml_tlatch_67.xmux.xp.S1 cml_tlatch_67.OUTP cml_tlatch_67.OUTN VSS sg13_lv_nmos ad=0.1019p pd=1.34u as=56.9f ps=0.74u w=0.17u l=0.17u
X383 cml_tlatch_14.xmux.xn.S1 stub_bi_19.BOTP cml_tlatch_5.INP VSS sg13_lv_nmos ad=63.19999f pd=0.74u as=0.1082p ps=1.34u w=0.26u l=0.38u
X384 MOT15_P MOT15_N cml_tlatch_7.xmux.xp.S1 VSS sg13_lv_nmos ad=56.9f pd=0.74u as=56.9f ps=0.74u w=0.17u l=0.17u
X385 MOT15_N MOT15_P cml_tlatch_7.xmux.xp.S1 VSS sg13_lv_nmos ad=56.9f pd=0.74u as=56.9f ps=0.74u w=0.17u l=0.17u
X386 cml_tlatch_12.xmux.xp.S1 CKB1_P cml_tlatch_12.xtail.S1 VSS sg13_lv_nmos ad=89.3f pd=0.85u as=89.3f ps=0.85u w=0.47u l=0.16u
X387 cml_tlatch_50.xmux.xn.S1 cml_tlatch_89.OUTN MOT20_P VSS sg13_lv_nmos ad=63.19999f pd=0.74u as=63.19999f ps=0.74u w=0.26u l=0.38u
X388 cml_tlatch_93.xmux.xp.S1 J1_P J1_N VSS sg13_lv_nmos ad=56.9f pd=0.74u as=56.9f ps=0.74u w=0.17u l=0.17u
X389 A3_2_P A3_2_N cml_tlatch_53.xmux.xp.S1 VSS sg13_lv_nmos ad=56.9f pd=0.74u as=56.9f ps=0.74u w=0.17u l=0.17u
X390 cml_tlatch_68.xmux.xn.S1 B3_8_P MOT25_N VSS sg13_lv_nmos ad=63.19999f pd=0.74u as=63.19999f ps=0.74u w=0.26u l=0.38u
X391 GA2_N ENA1_P cml_gate2_4.sg13_lv_nmos_FTPY57_0.D0 VSS sg13_lv_nmos ad=0.1007p pd=0.91u as=0.1007p ps=0.91u w=0.53u l=0.13u
X392 cml_tlatch_85.xmux.xp.S1 cml_tlatch_58.INN cml_tlatch_58.INP VSS sg13_lv_nmos ad=56.9f pd=0.74u as=56.9f ps=0.74u w=0.17u l=0.17u
X393 cml_tlatch_60.xtail.S1 CKB3_N cml_tlatch_60.xmux.xn.S1 VSS sg13_lv_nmos ad=89.3f pd=0.85u as=0.1598p ps=1.62u w=0.47u l=0.16u
X394 cml_tlatch_51.xmux.xp.S1 MOT22_P MOT22_N VSS sg13_lv_nmos ad=56.9f pd=0.74u as=56.9f ps=0.74u w=0.17u l=0.17u
X395 J1_N J4_N cml_tlatch_93.xmux.xn.S1 VSS sg13_lv_nmos ad=0.1082p pd=1.34u as=63.19999f ps=0.74u w=0.26u l=0.38u
X396 cml_tlatch_68.xmux.xn.S1 B3_8_P MOT25_N VSS sg13_lv_nmos ad=63.19999f pd=0.74u as=63.19999f ps=0.74u w=0.26u l=0.38u
X397 GB3_P ENB0_N cml_gate2_6.sg13_lv_nmos_FTPY57_0.D0 VSS sg13_lv_nmos ad=0.1007p pd=0.91u as=0.1007p ps=0.91u w=0.53u l=0.13u
X398 stub_bi_63.BOTP stub_bi_63.BOTN cml_tlatch_79.xmux.xp.S1 VSS sg13_lv_nmos ad=56.9f pd=0.74u as=56.9f ps=0.74u w=0.17u l=0.17u
X399 cml_tlatch_23.xmux.xp.S1 cml_tlatch_39.INN cml_tlatch_39.INP VSS sg13_lv_nmos ad=56.9f pd=0.74u as=56.9f ps=0.74u w=0.17u l=0.17u
X400 cml_drv_0.xrtail.R1 ENB_N ENB1_P VSS sg13_lv_nmos ad=56.2f pd=0.74u as=56.2f ps=0.74u w=0.16u l=0.19u
X401 MOT30_N A3_2_P cml_tlatch_59.xmux.xn.S1 VSS sg13_lv_nmos ad=63.19999f pd=0.74u as=63.19999f ps=0.74u w=0.26u l=0.38u
X402 cml_tlatch_70.xtail.S1 CKHB3_P cml_tlatch_70.xmux.xn.S1 VSS sg13_lv_nmos ad=89.3f pd=0.85u as=89.3f ps=0.85u w=0.47u l=0.16u
X403 B3_2_N B3_2_P cml_tlatch_46.xmux.xp.S1 VSS sg13_lv_nmos ad=56.9f pd=0.74u as=56.9f ps=0.74u w=0.17u l=0.17u
X404 MOT20_N cml_tlatch_89.OUTP cml_tlatch_50.xmux.xn.S1 VSS sg13_lv_nmos ad=63.19999f pd=0.74u as=63.19999f ps=0.74u w=0.26u l=0.38u
X405 cml_tlatch_41.xmux.xp.S1 MOT14_P MOT14_N VSS sg13_lv_nmos ad=56.9f pd=0.74u as=56.9f ps=0.74u w=0.17u l=0.17u
X406 cml_tlatch_73.xtail.S1 CKHB2_P cml_tlatch_73.xmux.xn.S1 VSS sg13_lv_nmos ad=89.3f pd=0.85u as=89.3f ps=0.85u w=0.47u l=0.16u
X407 stub_bi_17.BOTN cml_tlatch_5.INN cml_tlatch_13.xmux.xn.S1 VSS sg13_lv_nmos ad=63.19999f pd=0.74u as=63.19999f ps=0.74u w=0.26u l=0.38u
X408 cml_tlatch_34.xmux.xn.S1 CKB1_P cml_tlatch_34.xtail.S1 VSS sg13_lv_nmos ad=89.3f pd=0.85u as=89.3f ps=0.85u w=0.47u l=0.16u
X409 MOT24_P MOT24_N cml_tlatch_86.xmux.xp.S1 VSS sg13_lv_nmos ad=56.9f pd=0.74u as=56.9f ps=0.74u w=0.17u l=0.17u
X410 cml_tlatch_89.OUTN cml_tlatch_89.INP cml_tlatch_89.xmux.xn.S1 VSS sg13_lv_nmos ad=63.19999f pd=0.74u as=0.1082p ps=1.34u w=0.26u l=0.38u
X411 MOT31_N MOT31_P cml_tlatch_71.xmux.xp.S1 VSS sg13_lv_nmos ad=56.9f pd=0.74u as=56.9f ps=0.74u w=0.17u l=0.17u
X412 cml_tlatch_44.xmux.xn.S1 stub_bi_32.BOTP B2_2_P VSS sg13_lv_nmos ad=63.19999f pd=0.74u as=0.1082p ps=1.34u w=0.26u l=0.38u
X413 VSS POLN cml_tlatch_43.xtail.S1 VSS sg13_lv_nmos ad=2.7982p pd=17.14u as=1.5637p ps=8.61u w=8.23u l=0.13u
X414 stub_bi_49.BOTP stub_bi_55.BOTN cml_tlatch_80.xmux.xn.S1 VSS sg13_lv_nmos ad=63.19999f pd=0.74u as=63.19999f ps=0.74u w=0.26u l=0.38u
X415 B2_2_N stub_bi_32.BOTN cml_tlatch_44.xmux.xn.S1 VSS sg13_lv_nmos ad=63.19999f pd=0.74u as=63.19999f ps=0.74u w=0.26u l=0.38u
X416 cml_tlatch_8.xmux.xn.S1 cml_tlatch_9.OUTN cml_tlatch_8.OUTP VSS sg13_lv_nmos ad=63.19999f pd=0.74u as=63.19999f ps=0.74u w=0.26u l=0.38u
X417 cml_tlatch_96.xmux.xp.S1 MOT8_P MOT8_N VSS sg13_lv_nmos ad=56.9f pd=0.74u as=56.9f ps=0.74u w=0.17u l=0.17u
X418 cml_tlatch_35.OUTN cml_tlatch_35.OUTP cml_tlatch_35.xmux.xp.S1 VSS sg13_lv_nmos ad=56.9f pd=0.74u as=56.9f ps=0.74u w=0.17u l=0.17u
X419 cml_tlatch_56.INN D2_P cml_tlatch_42.xmux.xn.S1 VSS sg13_lv_nmos ad=63.19999f pd=0.74u as=63.19999f ps=0.74u w=0.26u l=0.38u
X420 cml_tlatch_19.xmux.xp.S1 MOT5_P MOT5_N VSS sg13_lv_nmos ad=56.9f pd=0.74u as=56.9f ps=0.74u w=0.17u l=0.17u
X421 cml_tlatch_81.xtail.S1 CKA2_N cml_tlatch_81.xmux.xn.S1 VSS sg13_lv_nmos ad=89.3f pd=0.85u as=89.3f ps=0.85u w=0.47u l=0.16u
X422 cml_tlatch_63.xmux.xp.S1 cml_tlatch_63.OUTP cml_tlatch_63.OUTN VSS sg13_lv_nmos ad=56.9f pd=0.74u as=56.9f ps=0.74u w=0.17u l=0.17u
X423 cml_tlatch_79.xtail.S1 CKB2_N cml_tlatch_79.xmux.xn.S1 VSS sg13_lv_nmos ad=89.3f pd=0.85u as=0.1598p ps=1.62u w=0.47u l=0.16u
X424 J1_N J1_P cml_tlatch_93.xmux.xp.S1 VSS sg13_lv_nmos ad=56.9f pd=0.74u as=0.1019p ps=1.34u w=0.17u l=0.17u
X425 cml_tlatch_32.xtail.S1 CKB1_N cml_tlatch_32.xmux.xp.S1 VSS sg13_lv_nmos ad=0.1598p pd=1.62u as=89.3f ps=0.85u w=0.47u l=0.16u
X426 ENA0_N ENA_P cml_drv_3.xrtail.R1 VSS sg13_lv_nmos ad=56.2f pd=0.74u as=56.2f ps=0.74u w=0.16u l=0.19u
X427 cml_tlatch_85.xmux.xp.S1 cml_tlatch_58.INN cml_tlatch_58.INP VSS sg13_lv_nmos ad=56.9f pd=0.74u as=56.9f ps=0.74u w=0.17u l=0.17u
X428 cml_tlatch_78.xmux.xn.S1 CKB2_P cml_tlatch_78.xtail.S1 VSS sg13_lv_nmos ad=89.3f pd=0.85u as=89.3f ps=0.85u w=0.47u l=0.16u
X429 VDD A0_8_P VSS rppd l=5.17u w=1u
X430 cml_gate2_2.sg13_lv_nmos_FTPY57_0.D0 ENA0_N GA0_P VSS sg13_lv_nmos ad=0.1802p pd=1.74u as=0.1007p ps=0.91u w=0.53u l=0.13u
X431 cml_tlatch_10.xmux.xn.S1 cml_tlatch_11.OUTN B0_8_P VSS sg13_lv_nmos ad=0.1082p pd=1.34u as=63.19999f ps=0.74u w=0.26u l=0.38u
X432 cml_tlatch_27.xtail.S1 CKB0_P cml_tlatch_27.xmux.xn.S1 VSS sg13_lv_nmos ad=89.3f pd=0.85u as=0.1598p ps=1.62u w=0.47u l=0.16u
X433 cml_tlatch_31.xmux.xn.S1 CKA0_N cml_tlatch_31.xtail.S1 VSS sg13_lv_nmos ad=89.3f pd=0.85u as=0.1598p ps=1.62u w=0.47u l=0.16u
X434 cml_tlatch_64.xmux.xp.S1 A3_8_P A3_8_N VSS sg13_lv_nmos ad=56.9f pd=0.74u as=56.9f ps=0.74u w=0.17u l=0.17u
X435 A1_8_P A1_8_N cml_tlatch_21.xmux.xp.S1 VSS sg13_lv_nmos ad=56.9f pd=0.74u as=56.9f ps=0.74u w=0.17u l=0.17u
X436 B3_8_N B3_8_P cml_tlatch_60.xmux.xp.S1 VSS sg13_lv_nmos ad=56.9f pd=0.74u as=56.9f ps=0.74u w=0.17u l=0.17u
X437 cml_tlatch_68.xmux.xp.S1 MOT25_N MOT25_P VSS sg13_lv_nmos ad=56.9f pd=0.74u as=56.9f ps=0.74u w=0.17u l=0.17u
X438 hs_to_clk_0.sg13_lv_nmos_2HGZLP_0.G CKA0_P VSS rppd l=4.25u w=1u
X439 cml_tlatch_62.xtail.S1 CKB3_N cml_tlatch_62.xmux.xn.S1 VSS sg13_lv_nmos ad=89.3f pd=0.85u as=89.3f ps=0.85u w=0.47u l=0.16u
X440 cml_tlatch_87.xmux.xn.S1 CKHA2_P cml_tlatch_87.xtail.S1 VSS sg13_lv_nmos ad=89.3f pd=0.85u as=89.3f ps=0.85u w=0.47u l=0.16u
X441 cml_tlatch_23.xmux.xn.S1 CKA1_N cml_tlatch_23.xtail.S1 VSS sg13_lv_nmos ad=0.1598p pd=1.62u as=89.3f ps=0.85u w=0.47u l=0.16u
X442 cml_tlatch_49.xmux.xn.S1 cml_tlatch_83.OUTP MOT18_N VSS sg13_lv_nmos ad=63.19999f pd=0.74u as=63.19999f ps=0.74u w=0.26u l=0.38u
X443 cml_tlatch_87.xtail.S1 POLN VSS VSS sg13_lv_nmos ad=1.5637p pd=8.61u as=2.7982p ps=17.14u w=8.23u l=0.13u
X444 cml_tlatch_46.xtail.S1 CKB3_N cml_tlatch_46.xmux.xn.S1 VSS sg13_lv_nmos ad=89.3f pd=0.85u as=0.1598p ps=1.62u w=0.47u l=0.16u
X445 cml_tlatch_3.xmux.xp.S1 cml_tlatch_3.OUTN cml_tlatch_3.OUTP VSS sg13_lv_nmos ad=0.1019p pd=1.34u as=56.9f ps=0.74u w=0.17u l=0.17u
X446 cml_tlatch_47.xmux.xp.S1 cml_tlatch_47.OUTP cml_tlatch_47.OUTN VSS sg13_lv_nmos ad=56.9f pd=0.74u as=56.9f ps=0.74u w=0.17u l=0.17u
X447 cml_tlatch_51.xmux.xn.S1 CKHA2_P cml_tlatch_51.xtail.S1 VSS sg13_lv_nmos ad=89.3f pd=0.85u as=89.3f ps=0.85u w=0.47u l=0.16u
X448 cml_tlatch_68.xtail.S1 CKHB3_N cml_tlatch_68.xmux.xp.S1 VSS sg13_lv_nmos ad=89.3f pd=0.85u as=89.3f ps=0.85u w=0.47u l=0.16u
X449 cml_tlatch_76.xmux.xn.S1 B2_2_N MOT23_P VSS sg13_lv_nmos ad=63.19999f pd=0.74u as=63.19999f ps=0.74u w=0.26u l=0.38u
X450 MOT11_P VDD VSS rppd l=5.17u w=1u
X451 MOT9_P MOT9_N cml_tlatch_4.xmux.xp.S1 VSS sg13_lv_nmos ad=56.9f pd=0.74u as=56.9f ps=0.74u w=0.17u l=0.17u
X452 cml_tlatch_83.xmux.xp.S1 CKA2_P cml_tlatch_83.xtail.S1 VSS sg13_lv_nmos ad=89.3f pd=0.85u as=0.1598p ps=1.62u w=0.47u l=0.16u
X453 cml_tlatch_99.xmux.xn.S1 cml_tlatch_30.OUTP cml_tlatch_99.OUTN VSS sg13_lv_nmos ad=63.19999f pd=0.74u as=63.19999f ps=0.74u w=0.26u l=0.38u
X454 cml_tlatch_28.xmux.xp.S1 B0_2_P B0_2_N VSS sg13_lv_nmos ad=0.1019p pd=1.34u as=56.9f ps=0.74u w=0.17u l=0.17u
X455 cml_tlatch_29.xtail.S1 CKB0_N cml_tlatch_29.xmux.xp.S1 VSS sg13_lv_nmos ad=89.3f pd=0.85u as=89.3f ps=0.85u w=0.47u l=0.16u
X456 cml_tlatch_18.xtail.S1 CKHB0_P cml_tlatch_18.xmux.xn.S1 VSS sg13_lv_nmos ad=89.3f pd=0.85u as=89.3f ps=0.85u w=0.47u l=0.16u
X457 cml_tlatch_52.xmux.xp.S1 cml_tlatch_52.OUTN cml_tlatch_52.OUTP VSS sg13_lv_nmos ad=56.9f pd=0.74u as=56.9f ps=0.74u w=0.17u l=0.17u
X458 cml_tlatch_44.xmux.xp.S1 B2_2_P B2_2_N VSS sg13_lv_nmos ad=56.9f pd=0.74u as=56.9f ps=0.74u w=0.17u l=0.17u
X459 cml_tlatch_11.xtail.S1 CKB0_N cml_tlatch_11.xmux.xp.S1 VSS sg13_lv_nmos ad=89.3f pd=0.85u as=0.1598p ps=1.62u w=0.47u l=0.16u
X460 cml_tlatch_45.OUTP cml_tlatch_45.OUTN cml_tlatch_45.xmux.xp.S1 VSS sg13_lv_nmos ad=56.9f pd=0.74u as=56.9f ps=0.74u w=0.17u l=0.17u
X461 B0_8_P B0_8_N cml_tlatch_10.xmux.xp.S1 VSS sg13_lv_nmos ad=56.9f pd=0.74u as=0.1019p ps=1.34u w=0.17u l=0.17u
X462 cml_tlatch_17.xmux.xp.S1 MOT1_P MOT1_N VSS sg13_lv_nmos ad=56.9f pd=0.74u as=56.9f ps=0.74u w=0.17u l=0.17u
X463 cml_tlatch_38.OUTP D1_N cml_tlatch_38.xmux.xn.S1 VSS sg13_lv_nmos ad=63.19999f pd=0.74u as=63.19999f ps=0.74u w=0.26u l=0.38u
X464 J4_N CLK_W_N cml_tlatch_90.xmux.xn.S1 VSS sg13_lv_nmos ad=0.1082p pd=1.34u as=63.19999f ps=0.74u w=0.26u l=0.38u
X465 cml_tlatch_65.xmux.xp.S1 cml_tlatch_65.OUTP cml_tlatch_65.OUTN VSS sg13_lv_nmos ad=56.9f pd=0.74u as=56.9f ps=0.74u w=0.17u l=0.17u
X466 cml_tlatch_98.xtail.S1 CKB0_P cml_tlatch_98.xmux.xp.S1 VSS sg13_lv_nmos ad=89.3f pd=0.85u as=89.3f ps=0.85u w=0.47u l=0.16u
X467 cml_tlatch_61.xmux.xn.S1 cml_tlatch_69.INP cml_tlatch_61.OUTN VSS sg13_lv_nmos ad=0.1082p pd=1.34u as=63.19999f ps=0.74u w=0.26u l=0.38u
X468 cml_tlatch_86.xmux.xn.S1 CKHA3_P cml_tlatch_86.xtail.S1 VSS sg13_lv_nmos ad=89.3f pd=0.85u as=89.3f ps=0.85u w=0.47u l=0.16u
X469 cml_drv_2.xrtail.R1 ENB_P ENB0_N VSS sg13_lv_nmos ad=56.2f pd=0.74u as=56.2f ps=0.74u w=0.16u l=0.19u
X470 cml_tlatch_61.xmux.xp.S1 CKB3_N cml_tlatch_61.xtail.S1 VSS sg13_lv_nmos ad=89.3f pd=0.85u as=89.3f ps=0.85u w=0.47u l=0.16u
X471 cml_tlatch_88.xtail.S1 CKB2_N cml_tlatch_88.xmux.xn.S1 VSS sg13_lv_nmos ad=89.3f pd=0.85u as=89.3f ps=0.85u w=0.47u l=0.16u
X472 cml_gate2_6.sg13_lv_nmos_FTPY57_0.D0 ENB0_N GB3_P VSS sg13_lv_nmos ad=0.1007p pd=0.91u as=0.1007p ps=0.91u w=0.53u l=0.13u
X473 cml_tlatch_61.xmux.xn.S1 cml_tlatch_69.INP cml_tlatch_61.OUTN VSS sg13_lv_nmos ad=63.19999f pd=0.74u as=63.19999f ps=0.74u w=0.26u l=0.38u
X474 MOT21_N MOT21_P cml_tlatch_75.xmux.xp.S1 VSS sg13_lv_nmos ad=56.9f pd=0.74u as=0.1019p ps=1.34u w=0.17u l=0.17u
X475 MOT30_N MOT30_P cml_tlatch_59.xmux.xp.S1 VSS sg13_lv_nmos ad=56.9f pd=0.74u as=56.9f ps=0.74u w=0.17u l=0.17u
X476 cml_tlatch_56.xtail.S1 CKA2_N cml_tlatch_56.xmux.xn.S1 VSS sg13_lv_nmos ad=89.3f pd=0.85u as=89.3f ps=0.85u w=0.47u l=0.16u
X477 VSS POLN cml_tlatch_67.xtail.S1 VSS sg13_lv_nmos ad=1.5637p pd=8.61u as=1.5637p ps=8.61u w=8.23u l=0.13u
X478 cml_tlatch_22.xmux.xn.S1 cml_tlatch_39.INP cml_tlatch_22.OUTN VSS sg13_lv_nmos ad=63.19999f pd=0.74u as=63.19999f ps=0.74u w=0.26u l=0.38u
X479 cml_tlatch_38.xmux.xp.S1 CKA1_N cml_tlatch_38.xtail.S1 VSS sg13_lv_nmos ad=89.3f pd=0.85u as=89.3f ps=0.85u w=0.47u l=0.16u
X480 cml_gate2_9.sg13_lv_nmos_FTPY57_0.D0 NM1_P cml_gate2_9.xrtail.R1 VSS sg13_lv_nmos ad=0.1007p pd=0.91u as=0.1007p ps=0.91u w=0.53u l=0.13u
X481 cml_tlatch_89.xmux.xp.S1 cml_tlatch_89.OUTP cml_tlatch_89.OUTN VSS sg13_lv_nmos ad=56.9f pd=0.74u as=56.9f ps=0.74u w=0.17u l=0.17u
X482 cml_gate2_5.xrtail.R1 CKB3_N GA3_P VSS sg13_lv_nmos ad=0.1007p pd=0.91u as=0.1007p ps=0.91u w=0.53u l=0.13u
X483 A0_2_N cml_tlatch_35.OUTP cml_tlatch_31.xmux.xn.S1 VSS sg13_lv_nmos ad=63.19999f pd=0.74u as=0.1082p ps=1.34u w=0.26u l=0.38u
X484 MOT11_P cml_tlatch_5.INN cml_tlatch_5.xmux.xn.S1 VSS sg13_lv_nmos ad=63.19999f pd=0.74u as=63.19999f ps=0.74u w=0.26u l=0.38u
X485 cml_tlatch_71.xtail.S1 CKHB3_P cml_tlatch_71.xmux.xn.S1 VSS sg13_lv_nmos ad=0.1598p pd=1.62u as=89.3f ps=0.85u w=0.47u l=0.16u
X486 cml_tlatch_60.xtail.S1 CKB3_P cml_tlatch_60.xmux.xp.S1 VSS sg13_lv_nmos ad=89.3f pd=0.85u as=89.3f ps=0.85u w=0.47u l=0.16u
X487 MOT11_N MOT11_P cml_tlatch_5.xmux.xp.S1 VSS sg13_lv_nmos ad=56.9f pd=0.74u as=56.9f ps=0.74u w=0.17u l=0.17u
X488 cml_tlatch_94.xmux.xp.S1 cml_tlatch_6.INN cml_tlatch_6.INP VSS sg13_lv_nmos ad=56.9f pd=0.74u as=56.9f ps=0.74u w=0.17u l=0.17u
X489 cml_tlatch_41.xmux.xp.S1 MOT14_P MOT14_N VSS sg13_lv_nmos ad=56.9f pd=0.74u as=56.9f ps=0.74u w=0.17u l=0.17u
X490 A0_2_P A0_2_N cml_tlatch_31.xmux.xp.S1 VSS sg13_lv_nmos ad=56.9f pd=0.74u as=56.9f ps=0.74u w=0.17u l=0.17u
X491 cml_tlatch_63.OUTP cml_tlatch_63.OUTN cml_tlatch_63.xmux.xp.S1 VSS sg13_lv_nmos ad=56.9f pd=0.74u as=56.9f ps=0.74u w=0.17u l=0.17u
X492 cml_tlatch_31.xtail.S1 CKA0_P cml_tlatch_31.xmux.xp.S1 VSS sg13_lv_nmos ad=89.3f pd=0.85u as=89.3f ps=0.85u w=0.47u l=0.16u
X493 cml_tlatch_24.xmux.xp.S1 MOT2_P MOT2_N VSS sg13_lv_nmos ad=56.9f pd=0.74u as=56.9f ps=0.74u w=0.17u l=0.17u
X494 cml_tlatch_64.xmux.xp.S1 A3_8_N A3_8_P VSS sg13_lv_nmos ad=56.9f pd=0.74u as=56.9f ps=0.74u w=0.17u l=0.17u
X495 cml_gate2_0.sg13_lv_nmos_FTPY57_0.D0 CKA1_P cml_gate2_0.xrtail.R1 VSS sg13_lv_nmos ad=0.1007p pd=0.91u as=0.1007p ps=0.91u w=0.53u l=0.13u
X496 A3_8_P cml_tlatch_65.OUTN cml_tlatch_64.xmux.xn.S1 VSS sg13_lv_nmos ad=63.19999f pd=0.74u as=63.19999f ps=0.74u w=0.26u l=0.38u
X497 cml_tlatch_44.xmux.xp.S1 B2_2_P B2_2_N VSS sg13_lv_nmos ad=56.9f pd=0.74u as=56.9f ps=0.74u w=0.17u l=0.17u
X498 cml_tlatch_24.xmux.xn.S1 CKHA0_P cml_tlatch_24.xtail.S1 VSS sg13_lv_nmos ad=89.3f pd=0.85u as=89.3f ps=0.85u w=0.47u l=0.16u
X499 cml_tlatch_34.xmux.xp.S1 CKB1_N cml_tlatch_34.xtail.S1 VSS sg13_lv_nmos ad=89.3f pd=0.85u as=89.3f ps=0.85u w=0.47u l=0.16u
X500 B0_8_P B0_8_N cml_tlatch_10.xmux.xp.S1 VSS sg13_lv_nmos ad=56.9f pd=0.74u as=56.9f ps=0.74u w=0.17u l=0.17u
X501 B1_8_N B1_8_P cml_tlatch_12.xmux.xp.S1 VSS sg13_lv_nmos ad=56.9f pd=0.74u as=56.9f ps=0.74u w=0.17u l=0.17u
X502 cml_tlatch_35.OUTN cml_tlatch_35.OUTP cml_tlatch_35.xmux.xp.S1 VSS sg13_lv_nmos ad=56.9f pd=0.74u as=56.9f ps=0.74u w=0.17u l=0.17u
X503 cml_tlatch_15.xmux.xp.S1 stub_bi_19.BOTP stub_bi_19.BOTN VSS sg13_lv_nmos ad=56.9f pd=0.74u as=56.9f ps=0.74u w=0.17u l=0.17u
X504 cml_tlatch_7.xtail.S1 CKHB1_P cml_tlatch_7.xmux.xn.S1 VSS sg13_lv_nmos ad=89.3f pd=0.85u as=89.3f ps=0.85u w=0.47u l=0.16u
X505 stub_bi_17.BOTN stub_bi_17.BOTP cml_tlatch_13.xmux.xp.S1 VSS sg13_lv_nmos ad=56.9f pd=0.74u as=0.1019p ps=1.34u w=0.17u l=0.17u
X506 cml_tlatch_56.xtail.S1 CKA2_P cml_tlatch_56.xmux.xp.S1 VSS sg13_lv_nmos ad=89.3f pd=0.85u as=89.3f ps=0.85u w=0.47u l=0.16u
X507 cml_tlatch_12.xtail.S1 CKB1_P cml_tlatch_12.xmux.xp.S1 VSS sg13_lv_nmos ad=89.3f pd=0.85u as=0.1598p ps=1.62u w=0.47u l=0.16u
X508 CLK_W_N CLK_W_P cml_tlatch_91.xmux.xp.S1 VSS sg13_lv_nmos ad=56.9f pd=0.74u as=56.9f ps=0.74u w=0.17u l=0.17u
X509 cml_tlatch_28.xmux.xn.S1 CKB0_N cml_tlatch_28.xtail.S1 VSS sg13_lv_nmos ad=89.3f pd=0.85u as=89.3f ps=0.85u w=0.47u l=0.16u
X510 B2_2_P B2_2_N cml_tlatch_44.xmux.xp.S1 VSS sg13_lv_nmos ad=56.9f pd=0.74u as=56.9f ps=0.74u w=0.17u l=0.17u
X511 MOT27_N MOT27_P cml_tlatch_69.xmux.xp.S1 VSS sg13_lv_nmos ad=56.9f pd=0.74u as=56.9f ps=0.74u w=0.17u l=0.17u
X512 cml_tlatch_66.xtail.S1 CKA3_P cml_tlatch_66.xmux.xp.S1 VSS sg13_lv_nmos ad=89.3f pd=0.85u as=89.3f ps=0.85u w=0.47u l=0.16u
X513 cml_tlatch_49.xtail.S1 CKHA2_N cml_tlatch_49.xmux.xp.S1 VSS sg13_lv_nmos ad=89.3f pd=0.85u as=89.3f ps=0.85u w=0.47u l=0.16u
X514 MOT21_N MOT21_P cml_tlatch_75.xmux.xp.S1 VSS sg13_lv_nmos ad=56.9f pd=0.74u as=56.9f ps=0.74u w=0.17u l=0.17u
X515 cml_tlatch_8.xmux.xn.S1 CKA0_N cml_tlatch_8.xtail.S1 VSS sg13_lv_nmos ad=89.3f pd=0.85u as=89.3f ps=0.85u w=0.47u l=0.16u
X516 cml_tlatch_92.xmux.xp.S1 CKJ_P cml_tlatch_92.xtail.S1 VSS sg13_lv_nmos ad=89.3f pd=0.85u as=89.3f ps=0.85u w=0.47u l=0.16u
X517 stub_bi_29.BOTN stub_bi_29.BOTP cml_tlatch_32.xmux.xp.S1 VSS sg13_lv_nmos ad=56.9f pd=0.74u as=56.9f ps=0.74u w=0.17u l=0.17u
X518 cml_gate2_7.sg13_lv_nmos_FTPY57_0.D0 ENB0_N GB2_P VSS sg13_lv_nmos ad=0.1007p pd=0.91u as=0.1007p ps=0.91u w=0.53u l=0.13u
X519 MOT12_N MOT12_P cml_tlatch_40.xmux.xp.S1 VSS sg13_lv_nmos ad=56.9f pd=0.74u as=56.9f ps=0.74u w=0.17u l=0.17u
X520 cml_tlatch_44.xtail.S1 CKB2_P cml_tlatch_44.xmux.xp.S1 VSS sg13_lv_nmos ad=89.3f pd=0.85u as=89.3f ps=0.85u w=0.47u l=0.16u
X521 cml_tlatch_95.xtail.S1 CKA1_P cml_tlatch_95.xmux.xp.S1 VSS sg13_lv_nmos ad=89.3f pd=0.85u as=89.3f ps=0.85u w=0.47u l=0.16u
X522 cml_tlatch_52.xmux.xp.S1 cml_tlatch_52.OUTP cml_tlatch_52.OUTN VSS sg13_lv_nmos ad=56.9f pd=0.74u as=56.9f ps=0.74u w=0.17u l=0.17u
X523 stub_bi_55.BOTN stub_bi_42.BOTP cml_tlatch_88.xmux.xn.S1 VSS sg13_lv_nmos ad=63.19999f pd=0.74u as=63.19999f ps=0.74u w=0.26u l=0.38u
X524 cml_tlatch_4.xmux.xn.S1 B1_8_N MOT9_P VSS sg13_lv_nmos ad=63.19999f pd=0.74u as=0.1082p ps=1.34u w=0.26u l=0.38u
X525 MOT19_P MOT19_N cml_tlatch_74.xmux.xp.S1 VSS sg13_lv_nmos ad=56.9f pd=0.74u as=56.9f ps=0.74u w=0.17u l=0.17u
X526 cml_tlatch_9.OUTN cml_tlatch_99.OUTP cml_tlatch_9.xmux.xn.S1 VSS sg13_lv_nmos ad=63.19999f pd=0.74u as=0.1082p ps=1.34u w=0.26u l=0.38u
X527 cml_tlatch_9.xtail.S1 CKA0_N cml_tlatch_9.xmux.xp.S1 VSS sg13_lv_nmos ad=89.3f pd=0.85u as=89.3f ps=0.85u w=0.47u l=0.16u
X528 VSS POLN cml_tlatch_84.xtail.S1 VSS sg13_lv_nmos ad=2.7982p pd=17.14u as=1.5637p ps=8.61u w=8.23u l=0.13u
X529 cml_tlatch_9.xtail.S1 CKA0_P cml_tlatch_9.xmux.xn.S1 VSS sg13_lv_nmos ad=89.3f pd=0.85u as=89.3f ps=0.85u w=0.47u l=0.16u
X530 cml_tlatch_17.xmux.xp.S1 MOT1_P MOT1_N VSS sg13_lv_nmos ad=0.1019p pd=1.34u as=56.9f ps=0.74u w=0.17u l=0.17u
X531 ENA1_N ENA_P cml_drv_1.xrtail.R1 VSS sg13_lv_nmos ad=56.2f pd=0.74u as=56.2f ps=0.74u w=0.16u l=0.19u
X532 MOT4_P MOT4_N cml_tlatch_25.xmux.xp.S1 VSS sg13_lv_nmos ad=56.9f pd=0.74u as=56.9f ps=0.74u w=0.17u l=0.17u
X533 stub_bi_17.BOTN stub_bi_17.BOTP cml_tlatch_13.xmux.xp.S1 VSS sg13_lv_nmos ad=56.9f pd=0.74u as=56.9f ps=0.74u w=0.17u l=0.17u
X534 cml_tlatch_12.xmux.xn.S1 stub_bi_17.BOTN B1_8_N VSS sg13_lv_nmos ad=0.1082p pd=1.34u as=63.19999f ps=0.74u w=0.26u l=0.38u
X535 cml_tlatch_57.INP cml_tlatch_67.OUTN cml_tlatch_66.xmux.xn.S1 VSS sg13_lv_nmos ad=0.1082p pd=1.34u as=63.19999f ps=0.74u w=0.26u l=0.38u
X536 cml_tlatch_78.xtail.S1 CKB2_P cml_tlatch_78.xmux.xn.S1 VSS sg13_lv_nmos ad=89.3f pd=0.85u as=89.3f ps=0.85u w=0.47u l=0.16u
X537 cml_tlatch_89.OUTP cml_tlatch_89.OUTN cml_tlatch_89.xmux.xp.S1 VSS sg13_lv_nmos ad=56.9f pd=0.74u as=56.9f ps=0.74u w=0.17u l=0.17u
X538 cml_tlatch_91.xmux.xp.S1 CLK_W_N CLK_W_P VSS sg13_lv_nmos ad=56.9f pd=0.74u as=56.9f ps=0.74u w=0.17u l=0.17u
X539 cml_tlatch_87.xmux.xp.S1 MOT16_N MOT16_P VSS sg13_lv_nmos ad=56.9f pd=0.74u as=56.9f ps=0.74u w=0.17u l=0.17u
X540 cml_tlatch_30.xtail.S1 POLN VSS VSS sg13_lv_nmos ad=1.5637p pd=8.61u as=1.5637p ps=8.61u w=8.23u l=0.13u
X541 cml_tlatch_83.xmux.xn.S1 cml_tlatch_83.INP cml_tlatch_83.OUTN VSS sg13_lv_nmos ad=63.19999f pd=0.74u as=63.19999f ps=0.74u w=0.26u l=0.38u
X542 cml_drvb_0.xrtail.R1 GB1_P CKHB1_N VSS sg13_lv_nmos ad=0.1463p pd=1.15u as=0.2618p ps=2.22u w=0.77u l=0.21u
X543 cml_tlatch_95.INN cml_tlatch_95.INP cml_tlatch_36.xmux.xp.S1 VSS sg13_lv_nmos ad=56.9f pd=0.74u as=56.9f ps=0.74u w=0.17u l=0.17u
X544 B1_8_P B1_8_N cml_tlatch_12.xmux.xp.S1 VSS sg13_lv_nmos ad=56.9f pd=0.74u as=56.9f ps=0.74u w=0.17u l=0.17u
X545 stub_bi_31.BOTN stub_bi_31.BOTP cml_tlatch_34.xmux.xp.S1 VSS sg13_lv_nmos ad=56.9f pd=0.74u as=0.1019p ps=1.34u w=0.17u l=0.17u
X546 cml_tlatch_83.xmux.xn.S1 cml_tlatch_83.INP cml_tlatch_83.OUTN VSS sg13_lv_nmos ad=63.19999f pd=0.74u as=63.19999f ps=0.74u w=0.26u l=0.38u
X547 cml_tlatch_20.xmux.xp.S1 CKHB0_N cml_tlatch_20.xtail.S1 VSS sg13_lv_nmos ad=0.1598p pd=1.62u as=89.3f ps=0.85u w=0.47u l=0.16u
X548 cml_gate2_1.sg13_lv_nmos_FTPY57_0.D0 ENB1_P GB0_N VSS sg13_lv_nmos ad=0.1802p pd=1.74u as=0.1007p ps=0.91u w=0.53u l=0.13u
X549 cml_tlatch_6.INN stub_bi_29.BOTN cml_tlatch_94.xmux.xn.S1 VSS sg13_lv_nmos ad=63.19999f pd=0.74u as=63.19999f ps=0.74u w=0.26u l=0.38u
X550 cml_tlatch_80.xtail.S1 CKB2_N cml_tlatch_80.xmux.xp.S1 VSS sg13_lv_nmos ad=89.3f pd=0.85u as=89.3f ps=0.85u w=0.47u l=0.16u
X551 cml_tlatch_1.xmux.xn.S1 cml_tlatch_98.OUTN cml_tlatch_1.OUTP VSS sg13_lv_nmos ad=63.19999f pd=0.74u as=63.19999f ps=0.74u w=0.26u l=0.38u
X552 cml_tlatch_61.OUTP cml_tlatch_61.OUTN cml_tlatch_61.xmux.xp.S1 VSS sg13_lv_nmos ad=56.9f pd=0.74u as=56.9f ps=0.74u w=0.17u l=0.17u
X553 stub_bi_32.BOTP stub_bi_32.BOTN cml_tlatch_48.xmux.xp.S1 VSS sg13_lv_nmos ad=56.9f pd=0.74u as=56.9f ps=0.74u w=0.17u l=0.17u
X554 MOT7_N MOT7_P cml_tlatch_20.xmux.xp.S1 VSS sg13_lv_nmos ad=56.9f pd=0.74u as=56.9f ps=0.74u w=0.17u l=0.17u
X555 cml_tlatch_1.xmux.xn.S1 cml_tlatch_98.OUTN cml_tlatch_1.OUTP VSS sg13_lv_nmos ad=63.19999f pd=0.74u as=63.19999f ps=0.74u w=0.26u l=0.38u
X556 cml_tlatch_84.xmux.xn.S1 cml_tlatch_45.OUTP cml_tlatch_70.INN VSS sg13_lv_nmos ad=63.19999f pd=0.74u as=63.19999f ps=0.74u w=0.26u l=0.38u
X557 cml_tlatch_58.xmux.xp.S1 MOT28_P MOT28_N VSS sg13_lv_nmos ad=56.9f pd=0.74u as=56.9f ps=0.74u w=0.17u l=0.17u
X558 VDD MOT21_N VSS rppd l=5.17u w=1u
X559 cml_tlatch_18.xmux.xn.S1 CKHB0_P cml_tlatch_18.xtail.S1 VSS sg13_lv_nmos ad=89.3f pd=0.85u as=89.3f ps=0.85u w=0.47u l=0.16u
X560 cml_tlatch_24.xmux.xp.S1 MOT2_P MOT2_N VSS sg13_lv_nmos ad=56.9f pd=0.74u as=56.9f ps=0.74u w=0.17u l=0.17u
X561 cml_drv_0.xrtail.R1 ENB_P ENB1_N VSS sg13_lv_nmos ad=56.2f pd=0.74u as=56.2f ps=0.74u w=0.16u l=0.19u
X562 cml_tlatch_57.xmux.xn.S1 cml_tlatch_57.INN MOT26_P VSS sg13_lv_nmos ad=63.19999f pd=0.74u as=63.19999f ps=0.74u w=0.26u l=0.38u
X563 cml_tlatch_82.OUTN cml_tlatch_82.OUTP cml_tlatch_82.xmux.xp.S1 VSS sg13_lv_nmos ad=56.9f pd=0.74u as=56.9f ps=0.74u w=0.17u l=0.17u
X564 cml_tlatch_78.xmux.xp.S1 stub_bi_62.BOTN stub_bi_62.BOTP VSS sg13_lv_nmos ad=56.9f pd=0.74u as=56.9f ps=0.74u w=0.17u l=0.17u
X565 MOT0_P MOT0_N cml_tlatch_97.xmux.xp.S1 VSS sg13_lv_nmos ad=56.9f pd=0.74u as=56.9f ps=0.74u w=0.17u l=0.17u
X566 VDD cml_tlatch_38.OUTN VSS rppd l=5.17u w=1u
X567 cml_tlatch_75.xmux.xp.S1 MOT21_N MOT21_P VSS sg13_lv_nmos ad=56.9f pd=0.74u as=56.9f ps=0.74u w=0.17u l=0.17u
X568 cml_tlatch_47.xmux.xn.S1 D3_P cml_tlatch_47.OUTN VSS sg13_lv_nmos ad=0.1082p pd=1.34u as=63.19999f ps=0.74u w=0.26u l=0.38u
X569 MOT7_P MOT7_N cml_tlatch_20.xmux.xp.S1 VSS sg13_lv_nmos ad=56.9f pd=0.74u as=56.9f ps=0.74u w=0.17u l=0.17u
X570 MOT6_P A0_2_N cml_tlatch_26.xmux.xn.S1 VSS sg13_lv_nmos ad=63.19999f pd=0.74u as=0.1082p ps=1.34u w=0.26u l=0.38u
X571 cml_tlatch_39.xmux.xp.S1 CKHA1_N cml_tlatch_39.xtail.S1 VSS sg13_lv_nmos ad=89.3f pd=0.85u as=89.3f ps=0.85u w=0.47u l=0.16u
X572 cml_tlatch_81.xtail.S1 CKA2_N cml_tlatch_81.xmux.xn.S1 VSS sg13_lv_nmos ad=89.3f pd=0.85u as=89.3f ps=0.85u w=0.47u l=0.16u
X573 cml_tlatch_59.xmux.xp.S1 MOT30_N MOT30_P VSS sg13_lv_nmos ad=56.9f pd=0.74u as=56.9f ps=0.74u w=0.17u l=0.17u
X574 MOT16_N MOT16_P cml_tlatch_87.xmux.xp.S1 VSS sg13_lv_nmos ad=56.9f pd=0.74u as=56.9f ps=0.74u w=0.17u l=0.17u
X575 cml_drvb_4.xrtail.R1 GA2_P CKHA2_N VSS sg13_lv_nmos ad=0.1463p pd=1.15u as=0.2618p ps=2.22u w=0.77u l=0.21u
X576 cml_tlatch_86.xmux.xp.S1 MOT24_P MOT24_N VSS sg13_lv_nmos ad=56.9f pd=0.74u as=56.9f ps=0.74u w=0.17u l=0.17u
X577 cml_tlatch_87.xmux.xn.S1 A2_8_N MOT16_P VSS sg13_lv_nmos ad=63.19999f pd=0.74u as=63.19999f ps=0.74u w=0.26u l=0.38u
X578 cml_tlatch_47.xmux.xn.S1 D3_P cml_tlatch_47.OUTN VSS sg13_lv_nmos ad=63.19999f pd=0.74u as=63.19999f ps=0.74u w=0.26u l=0.38u
X579 cml_tlatch_68.xtail.S1 CKHB3_P cml_tlatch_68.xmux.xn.S1 VSS sg13_lv_nmos ad=89.3f pd=0.85u as=89.3f ps=0.85u w=0.47u l=0.16u
X580 cml_tlatch_92.xmux.xn.S1 CKJ_N cml_tlatch_92.xtail.S1 VSS sg13_lv_nmos ad=89.3f pd=0.85u as=89.3f ps=0.85u w=0.47u l=0.16u
X581 cml_tlatch_97.xmux.xn.S1 A0_8_P MOT0_N VSS sg13_lv_nmos ad=63.19999f pd=0.74u as=63.19999f ps=0.74u w=0.26u l=0.38u
X582 cml_tlatch_32.xtail.S1 CKB1_N cml_tlatch_32.xmux.xp.S1 VSS sg13_lv_nmos ad=89.3f pd=0.85u as=89.3f ps=0.85u w=0.47u l=0.16u
X583 cml_tlatch_50.xmux.xp.S1 MOT20_N MOT20_P VSS sg13_lv_nmos ad=56.9f pd=0.74u as=56.9f ps=0.74u w=0.17u l=0.17u
X584 cml_tlatch_11.xmux.xp.S1 cml_tlatch_11.OUTP cml_tlatch_11.OUTN VSS sg13_lv_nmos ad=56.9f pd=0.74u as=56.9f ps=0.74u w=0.17u l=0.17u
X585 cml_tlatch_38.xmux.xn.S1 D1_P cml_tlatch_38.OUTN VSS sg13_lv_nmos ad=63.19999f pd=0.74u as=63.19999f ps=0.74u w=0.26u l=0.38u
X586 MOT28_P MOT28_N cml_tlatch_58.xmux.xp.S1 VSS sg13_lv_nmos ad=56.9f pd=0.74u as=56.9f ps=0.74u w=0.17u l=0.17u
X587 cml_gate2_3.sg13_lv_nmos_FTPY57_0.D0 ENA0_N GA1_P VSS sg13_lv_nmos ad=0.1007p pd=0.91u as=0.1007p ps=0.91u w=0.53u l=0.13u
X588 stub_bi_31.BOTN stub_bi_31.BOTP cml_tlatch_34.xmux.xp.S1 VSS sg13_lv_nmos ad=56.9f pd=0.74u as=56.9f ps=0.74u w=0.17u l=0.17u
X589 cml_tlatch_61.xtail.S1 POLN VSS VSS sg13_lv_nmos ad=1.5637p pd=8.61u as=2.7982p ps=17.14u w=8.23u l=0.13u
X590 J2_N J2_P cml_tlatch_92.xmux.xp.S1 VSS sg13_lv_nmos ad=56.9f pd=0.74u as=56.9f ps=0.74u w=0.17u l=0.17u
X591 A3_2_N A3_2_P cml_tlatch_53.xmux.xp.S1 VSS sg13_lv_nmos ad=56.9f pd=0.74u as=56.9f ps=0.74u w=0.17u l=0.17u
X592 cml_tlatch_16.OUTN cml_tlatch_16.OUTP cml_tlatch_16.xmux.xp.S1 VSS sg13_lv_nmos ad=56.9f pd=0.74u as=56.9f ps=0.74u w=0.17u l=0.17u
X593 cml_tlatch_35.xmux.xn.S1 CKA0_P cml_tlatch_35.xtail.S1 VSS sg13_lv_nmos ad=89.3f pd=0.85u as=89.3f ps=0.85u w=0.47u l=0.16u
X594 VSS hs_to_clk_2.sg13_lv_nmos_2HGZLP_0.G VSS VSS sg13_lv_nmos ad=2.071p pd=11.28u as=0 ps=0 w=10.9u l=1.38u
X595 cml_tlatch_67.OUTP cml_tlatch_58.INN cml_tlatch_67.xmux.xn.S1 VSS sg13_lv_nmos ad=63.19999f pd=0.74u as=0.1082p ps=1.34u w=0.26u l=0.38u
X596 MOT18_P MOT18_N cml_tlatch_49.xmux.xp.S1 VSS sg13_lv_nmos ad=56.9f pd=0.74u as=56.9f ps=0.74u w=0.17u l=0.17u
X597 cml_tlatch_10.xmux.xn.S1 cml_tlatch_11.OUTP B0_8_N VSS sg13_lv_nmos ad=63.19999f pd=0.74u as=0.1082p ps=1.34u w=0.26u l=0.38u
X598 cml_tlatch_77.xtail.S1 CKB2_N cml_tlatch_77.xmux.xn.S1 VSS sg13_lv_nmos ad=0.1598p pd=1.62u as=89.3f ps=0.85u w=0.47u l=0.16u
X599 cml_tlatch_43.xmux.xn.S1 B2_2_N stub_bi_42.BOTN VSS sg13_lv_nmos ad=63.19999f pd=0.74u as=63.19999f ps=0.74u w=0.26u l=0.38u
X600 cml_tlatch_40.xmux.xp.S1 MOT12_N MOT12_P VSS sg13_lv_nmos ad=56.9f pd=0.74u as=56.9f ps=0.74u w=0.17u l=0.17u
X601 interco_bi_19.INN cml_tlatch_40.INP cml_tlatch_0.xmux.xn.S1 VSS sg13_lv_nmos ad=63.19999f pd=0.74u as=63.19999f ps=0.74u w=0.26u l=0.38u
X602 cml_tlatch_80.xmux.xp.S1 stub_bi_49.BOTP stub_bi_49.BOTN VSS sg13_lv_nmos ad=56.9f pd=0.74u as=56.9f ps=0.74u w=0.17u l=0.17u
X603 cml_tlatch_8.OUTP cml_tlatch_8.OUTN cml_tlatch_8.xmux.xp.S1 VSS sg13_lv_nmos ad=56.9f pd=0.74u as=56.9f ps=0.74u w=0.17u l=0.17u
X604 cml_gate2_6.xrtail.R1 CKA3_P cml_gate2_6.sg13_lv_nmos_FTPY57_0.D0 VSS sg13_lv_nmos ad=0.1007p pd=0.91u as=0.1007p ps=0.91u w=0.53u l=0.13u
X605 cml_tlatch_24.xtail.S1 CKHA0_P cml_tlatch_24.xmux.xn.S1 VSS sg13_lv_nmos ad=89.3f pd=0.85u as=89.3f ps=0.85u w=0.47u l=0.16u
X606 cml_tlatch_41.xmux.xn.S1 A1_2_N MOT14_P VSS sg13_lv_nmos ad=0.1082p pd=1.34u as=63.19999f ps=0.74u w=0.26u l=0.38u
X607 cml_tlatch_37.xmux.xp.S1 A1_2_P A1_2_N VSS sg13_lv_nmos ad=56.9f pd=0.74u as=56.9f ps=0.74u w=0.17u l=0.17u
X608 B1_2_N B1_2_P cml_tlatch_33.xmux.xp.S1 VSS sg13_lv_nmos ad=56.9f pd=0.74u as=56.9f ps=0.74u w=0.17u l=0.17u
X609 cml_tlatch_69.xmux.xp.S1 MOT27_N MOT27_P VSS sg13_lv_nmos ad=56.9f pd=0.74u as=56.9f ps=0.74u w=0.17u l=0.17u
X610 cml_tlatch_23.xtail.S1 CKA1_N cml_tlatch_23.xmux.xn.S1 VSS sg13_lv_nmos ad=89.3f pd=0.85u as=89.3f ps=0.85u w=0.47u l=0.16u
X611 cml_tlatch_89.xmux.xn.S1 cml_tlatch_89.INP cml_tlatch_89.OUTN VSS sg13_lv_nmos ad=63.19999f pd=0.74u as=63.19999f ps=0.74u w=0.26u l=0.38u
X612 cml_tlatch_18.xtail.S1 CKHB0_N cml_tlatch_18.xmux.xp.S1 VSS sg13_lv_nmos ad=89.3f pd=0.85u as=89.3f ps=0.85u w=0.47u l=0.16u
X613 VSS cml_drvb_8.xrtail.R1 VSS rppd l=2.72u w=1u
X614 cml_tlatch_47.OUTP cml_tlatch_47.OUTN cml_tlatch_47.xmux.xp.S1 VSS sg13_lv_nmos ad=56.9f pd=0.74u as=56.9f ps=0.74u w=0.17u l=0.17u
X615 cml_tlatch_28.xtail.S1 CKB0_N cml_tlatch_28.xmux.xn.S1 VSS sg13_lv_nmos ad=89.3f pd=0.85u as=0.1598p ps=1.62u w=0.47u l=0.16u
X616 cml_tlatch_44.xmux.xn.S1 stub_bi_32.BOTN B2_2_N VSS sg13_lv_nmos ad=63.19999f pd=0.74u as=63.19999f ps=0.74u w=0.26u l=0.38u
X617 MOT11_P MOT11_N cml_tlatch_5.xmux.xp.S1 VSS sg13_lv_nmos ad=56.9f pd=0.74u as=56.9f ps=0.74u w=0.17u l=0.17u
X618 cml_tlatch_49.xmux.xp.S1 CKHA2_N cml_tlatch_49.xtail.S1 VSS sg13_lv_nmos ad=89.3f pd=0.85u as=89.3f ps=0.85u w=0.47u l=0.16u
X619 cml_tlatch_89.OUTP cml_tlatch_89.OUTN cml_tlatch_89.xmux.xp.S1 VSS sg13_lv_nmos ad=56.9f pd=0.74u as=56.9f ps=0.74u w=0.17u l=0.17u
X620 cml_tlatch_98.xtail.S1 CKB0_P cml_tlatch_98.xmux.xp.S1 VSS sg13_lv_nmos ad=89.3f pd=0.85u as=89.3f ps=0.85u w=0.47u l=0.16u
X621 VSS POLN cml_tlatch_26.xtail.S1 VSS sg13_lv_nmos ad=2.7982p pd=17.14u as=1.5637p ps=8.61u w=8.23u l=0.13u
X622 cml_tlatch_86.xmux.xn.S1 CKHA3_P cml_tlatch_86.xtail.S1 VSS sg13_lv_nmos ad=89.3f pd=0.85u as=89.3f ps=0.85u w=0.47u l=0.16u
X623 cml_tlatch_48.xmux.xn.S1 D2_N stub_bi_32.BOTN VSS sg13_lv_nmos ad=63.19999f pd=0.74u as=0.1082p ps=1.34u w=0.26u l=0.38u
X624 cml_tlatch_88.xmux.xp.S1 stub_bi_55.BOTP stub_bi_55.BOTN VSS sg13_lv_nmos ad=56.9f pd=0.74u as=56.9f ps=0.74u w=0.17u l=0.17u
X625 cml_tlatch_3.OUTP cml_tlatch_3.OUTN cml_tlatch_3.xmux.xp.S1 VSS sg13_lv_nmos ad=56.9f pd=0.74u as=56.9f ps=0.74u w=0.17u l=0.17u
X626 GB3_P CKA3_N cml_gate2_6.xrtail.R1 VSS sg13_lv_nmos ad=0.1007p pd=0.91u as=0.1007p ps=0.91u w=0.53u l=0.13u
X627 cml_tlatch_52.xtail.S1 CKA3_N cml_tlatch_52.xmux.xp.S1 VSS sg13_lv_nmos ad=89.3f pd=0.85u as=89.3f ps=0.85u w=0.47u l=0.16u
X628 cml_tlatch_87.xmux.xp.S1 MOT16_N MOT16_P VSS sg13_lv_nmos ad=56.9f pd=0.74u as=56.9f ps=0.74u w=0.17u l=0.17u
X629 B0_2_N B0_2_P cml_tlatch_28.xmux.xp.S1 VSS sg13_lv_nmos ad=56.9f pd=0.74u as=56.9f ps=0.74u w=0.17u l=0.17u
X630 A0_8_P A0_8_N cml_tlatch_2.xmux.xp.S1 VSS sg13_lv_nmos ad=56.9f pd=0.74u as=0.1019p ps=1.34u w=0.17u l=0.17u
X631 MOT26_N MOT26_P cml_tlatch_57.xmux.xp.S1 VSS sg13_lv_nmos ad=56.9f pd=0.74u as=56.9f ps=0.74u w=0.17u l=0.17u
X632 cml_tlatch_76.xmux.xp.S1 MOT23_N MOT23_P VSS sg13_lv_nmos ad=56.9f pd=0.74u as=56.9f ps=0.74u w=0.17u l=0.17u
X633 cml_tlatch_22.xmux.xp.S1 CKA1_N cml_tlatch_22.xtail.S1 VSS sg13_lv_nmos ad=89.3f pd=0.85u as=89.3f ps=0.85u w=0.47u l=0.16u
X634 MOT31_P MOT31_N cml_tlatch_71.xmux.xp.S1 VSS sg13_lv_nmos ad=56.9f pd=0.74u as=56.9f ps=0.74u w=0.17u l=0.17u
X635 VDD cml_tlatch_89.OUTP VSS rppd l=5.17u w=1u
X636 cml_tlatch_25.xmux.xn.S1 CKHA0_P cml_tlatch_25.xtail.S1 VSS sg13_lv_nmos ad=0.1598p pd=1.62u as=89.3f ps=0.85u w=0.47u l=0.16u
X637 cml_tlatch_56.xtail.S1 CKA2_N cml_tlatch_56.xmux.xn.S1 VSS sg13_lv_nmos ad=89.3f pd=0.85u as=89.3f ps=0.85u w=0.47u l=0.16u
X638 cml_tlatch_49.xtail.S1 CKHA2_P cml_tlatch_49.xmux.xn.S1 VSS sg13_lv_nmos ad=89.3f pd=0.85u as=89.3f ps=0.85u w=0.47u l=0.16u
X639 cml_tlatch_30.xmux.xp.S1 cml_tlatch_30.OUTN cml_tlatch_30.OUTP VSS sg13_lv_nmos ad=56.9f pd=0.74u as=56.9f ps=0.74u w=0.17u l=0.17u
X640 cml_tlatch_57.xmux.xp.S1 CKHA3_N cml_tlatch_57.xtail.S1 VSS sg13_lv_nmos ad=89.3f pd=0.85u as=89.3f ps=0.85u w=0.47u l=0.16u
X641 cml_tlatch_96.xmux.xp.S1 MOT8_N MOT8_P VSS sg13_lv_nmos ad=56.9f pd=0.74u as=56.9f ps=0.74u w=0.17u l=0.17u
X642 cml_tlatch_82.xmux.xp.S1 cml_tlatch_82.OUTN cml_tlatch_82.OUTP VSS sg13_lv_nmos ad=56.9f pd=0.74u as=56.9f ps=0.74u w=0.17u l=0.17u
X643 MOT27_P MOT27_N cml_tlatch_69.xmux.xp.S1 VSS sg13_lv_nmos ad=56.9f pd=0.74u as=56.9f ps=0.74u w=0.17u l=0.17u
X644 MOT1_P MOT1_N cml_tlatch_17.xmux.xp.S1 VSS sg13_lv_nmos ad=56.9f pd=0.74u as=56.9f ps=0.74u w=0.17u l=0.17u
X645 cml_tlatch_7.xmux.xp.S1 MOT15_N MOT15_P VSS sg13_lv_nmos ad=56.9f pd=0.74u as=56.9f ps=0.74u w=0.17u l=0.17u
X646 cml_tlatch_7.xmux.xp.S1 MOT15_P MOT15_N VSS sg13_lv_nmos ad=56.9f pd=0.74u as=56.9f ps=0.74u w=0.17u l=0.17u
X647 cml_tlatch_53.xmux.xp.S1 A3_2_N A3_2_P VSS sg13_lv_nmos ad=56.9f pd=0.74u as=56.9f ps=0.74u w=0.17u l=0.17u
X648 cml_tlatch_52.OUTP A3_2_N cml_tlatch_52.xmux.xn.S1 VSS sg13_lv_nmos ad=63.19999f pd=0.74u as=63.19999f ps=0.74u w=0.26u l=0.38u
X649 cml_tlatch_27.xtail.S1 CKB0_N cml_tlatch_27.xmux.xp.S1 VSS sg13_lv_nmos ad=89.3f pd=0.85u as=89.3f ps=0.85u w=0.47u l=0.16u
X650 GA0_P ENA0_N cml_gate2_2.sg13_lv_nmos_FTPY57_0.D0 VSS sg13_lv_nmos ad=0.1007p pd=0.91u as=0.1007p ps=0.91u w=0.53u l=0.13u
X651 cml_tlatch_13.xmux.xp.S1 CKB1_N cml_tlatch_13.xtail.S1 VSS sg13_lv_nmos ad=89.3f pd=0.85u as=89.3f ps=0.85u w=0.47u l=0.16u
X652 cml_tlatch_82.xmux.xn.S1 cml_tlatch_83.OUTP cml_tlatch_82.OUTN VSS sg13_lv_nmos ad=63.19999f pd=0.74u as=63.19999f ps=0.74u w=0.26u l=0.38u
X653 cml_tlatch_44.xtail.S1 CKB2_N cml_tlatch_44.xmux.xn.S1 VSS sg13_lv_nmos ad=0.1598p pd=1.62u as=89.3f ps=0.85u w=0.47u l=0.16u
X654 cml_tlatch_34.xmux.xp.S1 CKB1_N cml_tlatch_34.xtail.S1 VSS sg13_lv_nmos ad=89.3f pd=0.85u as=89.3f ps=0.85u w=0.47u l=0.16u
X655 cml_tlatch_79.xmux.xp.S1 stub_bi_63.BOTP stub_bi_63.BOTN VSS sg13_lv_nmos ad=56.9f pd=0.74u as=56.9f ps=0.74u w=0.17u l=0.17u
X656 cml_tlatch_79.xmux.xp.S1 stub_bi_63.BOTN stub_bi_63.BOTP VSS sg13_lv_nmos ad=56.9f pd=0.74u as=56.9f ps=0.74u w=0.17u l=0.17u
X657 cml_tlatch_39.INP cml_tlatch_39.INN cml_tlatch_23.xmux.xp.S1 VSS sg13_lv_nmos ad=56.9f pd=0.74u as=56.9f ps=0.74u w=0.17u l=0.17u
X658 MOT3_N MOT3_P cml_tlatch_18.xmux.xp.S1 VSS sg13_lv_nmos ad=56.9f pd=0.74u as=56.9f ps=0.74u w=0.17u l=0.17u
X659 cml_gate2_4.sg13_lv_nmos_FTPY57_0.D0 CKB2_P cml_gate2_4.xrtail.R1 VSS sg13_lv_nmos ad=0.1007p pd=0.91u as=0.1007p ps=0.91u w=0.53u l=0.13u
X660 cml_tlatch_47.xtail.S1 CKB3_P cml_tlatch_47.xmux.xn.S1 VSS sg13_lv_nmos ad=89.3f pd=0.85u as=0.1598p ps=1.62u w=0.47u l=0.16u
X661 VSS POLN cml_tlatch_76.xtail.S1 VSS sg13_lv_nmos ad=1.5637p pd=8.61u as=1.5637p ps=8.61u w=8.23u l=0.13u
X662 cml_tlatch_10.xtail.S1 POLN VSS VSS sg13_lv_nmos ad=1.5637p pd=8.61u as=1.5637p ps=8.61u w=8.23u l=0.13u
X663 cml_tlatch_59.xtail.S1 CKHA3_P cml_tlatch_59.xmux.xn.S1 VSS sg13_lv_nmos ad=89.3f pd=0.85u as=89.3f ps=0.85u w=0.47u l=0.16u
X664 cml_tlatch_86.xmux.xp.S1 MOT24_P MOT24_N VSS sg13_lv_nmos ad=56.9f pd=0.74u as=56.9f ps=0.74u w=0.17u l=0.17u
X665 cml_tlatch_22.xmux.xp.S1 cml_tlatch_22.OUTP cml_tlatch_22.OUTN VSS sg13_lv_nmos ad=56.9f pd=0.74u as=56.9f ps=0.74u w=0.17u l=0.17u
X666 cml_tlatch_67.OUTP cml_tlatch_67.OUTN cml_tlatch_67.xmux.xp.S1 VSS sg13_lv_nmos ad=56.9f pd=0.74u as=56.9f ps=0.74u w=0.17u l=0.17u
X667 cml_tlatch_71.xmux.xp.S1 MOT31_P MOT31_N VSS sg13_lv_nmos ad=56.9f pd=0.74u as=56.9f ps=0.74u w=0.17u l=0.17u
X668 cml_tlatch_5.xmux.xn.S1 cml_tlatch_5.INP MOT11_N VSS sg13_lv_nmos ad=63.19999f pd=0.74u as=63.19999f ps=0.74u w=0.26u l=0.38u
X669 A1_8_N A1_8_P cml_tlatch_21.xmux.xp.S1 VSS sg13_lv_nmos ad=56.9f pd=0.74u as=56.9f ps=0.74u w=0.17u l=0.17u
X670 cml_tlatch_35.OUTP cml_tlatch_35.OUTN cml_tlatch_35.xmux.xp.S1 VSS sg13_lv_nmos ad=56.9f pd=0.74u as=56.9f ps=0.74u w=0.17u l=0.17u
X671 MOT8_N MOT8_P cml_tlatch_96.xmux.xp.S1 VSS sg13_lv_nmos ad=56.9f pd=0.74u as=56.9f ps=0.74u w=0.17u l=0.17u
X672 cml_tlatch_80.xmux.xp.S1 CKB2_N cml_tlatch_80.xtail.S1 VSS sg13_lv_nmos ad=89.3f pd=0.85u as=89.3f ps=0.85u w=0.47u l=0.16u
X673 cml_tlatch_98.xmux.xp.S1 cml_tlatch_98.OUTN cml_tlatch_98.OUTP VSS sg13_lv_nmos ad=56.9f pd=0.74u as=56.9f ps=0.74u w=0.17u l=0.17u
X674 cml_tlatch_39.xtail.S1 CKHA1_P cml_tlatch_39.xmux.xn.S1 VSS sg13_lv_nmos ad=89.3f pd=0.85u as=89.3f ps=0.85u w=0.47u l=0.16u
X675 cml_tlatch_46.xmux.xp.S1 B3_2_P B3_2_N VSS sg13_lv_nmos ad=56.9f pd=0.74u as=56.9f ps=0.74u w=0.17u l=0.17u
X676 cml_tlatch_26.xmux.xp.S1 MOT6_P MOT6_N VSS sg13_lv_nmos ad=56.9f pd=0.74u as=56.9f ps=0.74u w=0.17u l=0.17u
X677 cml_tlatch_67.xmux.xp.S1 CKA3_N cml_tlatch_67.xtail.S1 VSS sg13_lv_nmos ad=89.3f pd=0.85u as=0.1598p ps=1.62u w=0.47u l=0.16u
X678 cml_tlatch_57.xmux.xp.S1 MOT26_N MOT26_P VSS sg13_lv_nmos ad=56.9f pd=0.74u as=56.9f ps=0.74u w=0.17u l=0.17u
X679 cml_tlatch_90.xmux.xn.S1 CKJ_N cml_tlatch_90.xtail.S1 VSS sg13_lv_nmos ad=89.3f pd=0.85u as=89.3f ps=0.85u w=0.47u l=0.16u
X680 VDD MOT23_P VSS rppd l=5.17u w=1u
X681 MOT17_P B2_8_N cml_tlatch_73.xmux.xn.S1 VSS sg13_lv_nmos ad=0.1082p pd=1.34u as=63.19999f ps=0.74u w=0.26u l=0.38u
X682 B1_2_N B1_2_P cml_tlatch_33.xmux.xp.S1 VSS sg13_lv_nmos ad=56.9f pd=0.74u as=56.9f ps=0.74u w=0.17u l=0.17u
X683 cml_tlatch_62.xtail.S1 CKB3_P cml_tlatch_62.xmux.xp.S1 VSS sg13_lv_nmos ad=89.3f pd=0.85u as=89.3f ps=0.85u w=0.47u l=0.16u
X684 cml_tlatch_42.xtail.S1 CKA2_P cml_tlatch_42.xmux.xn.S1 VSS sg13_lv_nmos ad=89.3f pd=0.85u as=89.3f ps=0.85u w=0.47u l=0.16u
X685 cml_tlatch_16.xtail.S1 CKB0_P cml_tlatch_16.xmux.xp.S1 VSS sg13_lv_nmos ad=89.3f pd=0.85u as=89.3f ps=0.85u w=0.47u l=0.16u
X686 MOT10_P MOT10_N cml_tlatch_39.xmux.xp.S1 VSS sg13_lv_nmos ad=56.9f pd=0.74u as=56.9f ps=0.74u w=0.17u l=0.17u
X687 cml_tlatch_95.INP cml_tlatch_95.INN cml_tlatch_36.xmux.xp.S1 VSS sg13_lv_nmos ad=56.9f pd=0.74u as=56.9f ps=0.74u w=0.17u l=0.17u
X688 cml_tlatch_16.xtail.S1 CKB0_N cml_tlatch_16.xmux.xn.S1 VSS sg13_lv_nmos ad=89.3f pd=0.85u as=89.3f ps=0.85u w=0.47u l=0.16u
X689 A3_8_N A3_8_P cml_tlatch_64.xmux.xp.S1 VSS sg13_lv_nmos ad=56.9f pd=0.74u as=56.9f ps=0.74u w=0.17u l=0.17u
X690 cml_tlatch_73.xmux.xp.S1 MOT17_N MOT17_P VSS sg13_lv_nmos ad=56.9f pd=0.74u as=56.9f ps=0.74u w=0.17u l=0.17u
X691 B2_8_P B2_8_N cml_tlatch_77.xmux.xp.S1 VSS sg13_lv_nmos ad=56.9f pd=0.74u as=56.9f ps=0.74u w=0.17u l=0.17u
X692 cml_tlatch_42.xmux.xp.S1 cml_tlatch_56.INN cml_tlatch_56.INP VSS sg13_lv_nmos ad=56.9f pd=0.74u as=56.9f ps=0.74u w=0.17u l=0.17u
X693 cml_tlatch_21.xmux.xp.S1 A1_8_N A1_8_P VSS sg13_lv_nmos ad=56.9f pd=0.74u as=56.9f ps=0.74u w=0.17u l=0.17u
X694 MOT25_P MOT25_N cml_tlatch_68.xmux.xp.S1 VSS sg13_lv_nmos ad=56.9f pd=0.74u as=56.9f ps=0.74u w=0.17u l=0.17u
X695 cml_tlatch_99.OUTP cml_tlatch_30.OUTN cml_tlatch_99.xmux.xn.S1 VSS sg13_lv_nmos ad=0.1082p pd=1.34u as=63.19999f ps=0.74u w=0.26u l=0.38u
X696 cml_tlatch_32.xmux.xp.S1 CKB1_N cml_tlatch_32.xtail.S1 VSS sg13_lv_nmos ad=89.3f pd=0.85u as=89.3f ps=0.85u w=0.47u l=0.16u
X697 cml_tlatch_54.xmux.xp.S1 cml_tlatch_54.OUTP cml_tlatch_54.OUTN VSS sg13_lv_nmos ad=56.9f pd=0.74u as=56.9f ps=0.74u w=0.17u l=0.17u
X698 cml_tlatch_3.OUTP cml_tlatch_3.OUTN cml_tlatch_3.xmux.xp.S1 VSS sg13_lv_nmos ad=56.9f pd=0.74u as=56.9f ps=0.74u w=0.17u l=0.17u
X699 cml_tlatch_15.xmux.xp.S1 stub_bi_19.BOTN stub_bi_19.BOTP VSS sg13_lv_nmos ad=56.9f pd=0.74u as=56.9f ps=0.74u w=0.17u l=0.17u
X700 cml_tlatch_47.OUTN cml_tlatch_47.OUTP cml_tlatch_47.xmux.xp.S1 VSS sg13_lv_nmos ad=56.9f pd=0.74u as=56.9f ps=0.74u w=0.17u l=0.17u
X701 cml_tlatch_4.xmux.xp.S1 MOT9_N MOT9_P VSS sg13_lv_nmos ad=56.9f pd=0.74u as=56.9f ps=0.74u w=0.17u l=0.17u
X702 B0_2_N B0_2_P cml_tlatch_28.xmux.xp.S1 VSS sg13_lv_nmos ad=56.9f pd=0.74u as=56.9f ps=0.74u w=0.17u l=0.17u
X703 cml_tlatch_99.OUTP cml_tlatch_30.OUTN cml_tlatch_99.xmux.xn.S1 VSS sg13_lv_nmos ad=63.19999f pd=0.74u as=63.19999f ps=0.74u w=0.26u l=0.38u
X704 cml_tlatch_52.OUTP cml_tlatch_52.OUTN cml_tlatch_52.xmux.xp.S1 VSS sg13_lv_nmos ad=56.9f pd=0.74u as=56.9f ps=0.74u w=0.17u l=0.17u
X705 MOT26_P MOT26_N cml_tlatch_57.xmux.xp.S1 VSS sg13_lv_nmos ad=56.9f pd=0.74u as=56.9f ps=0.74u w=0.17u l=0.17u
X706 cml_tlatch_74.xtail.S1 CKHB2_P cml_tlatch_74.xmux.xn.S1 VSS sg13_lv_nmos ad=89.3f pd=0.85u as=89.3f ps=0.85u w=0.47u l=0.16u
X707 MOT1_N MOT1_P cml_tlatch_17.xmux.xp.S1 VSS sg13_lv_nmos ad=56.9f pd=0.74u as=56.9f ps=0.74u w=0.17u l=0.17u
X708 cml_gate2_9.xrtail.R1 NM1_N ENA_P VSS sg13_lv_nmos ad=0.1007p pd=0.91u as=0.1007p ps=0.91u w=0.53u l=0.13u
X709 cml_tlatch_96.xtail.S1 CKHA1_N cml_tlatch_96.xmux.xp.S1 VSS sg13_lv_nmos ad=89.3f pd=0.85u as=89.3f ps=0.85u w=0.47u l=0.16u
X710 GA1_N ENA0_P cml_gate2_3.sg13_lv_nmos_FTPY57_0.D0 VSS sg13_lv_nmos ad=0.1007p pd=0.91u as=0.1802p ps=1.74u w=0.53u l=0.13u
X711 cml_tlatch_92.xmux.xp.S1 J2_N J2_P VSS sg13_lv_nmos ad=56.9f pd=0.74u as=56.9f ps=0.74u w=0.17u l=0.17u
X712 cml_tlatch_65.OUTN cml_tlatch_65.OUTP cml_tlatch_65.xmux.xp.S1 VSS sg13_lv_nmos ad=56.9f pd=0.74u as=56.9f ps=0.74u w=0.17u l=0.17u
X713 cml_tlatch_20.xmux.xp.S1 CKHB0_N cml_tlatch_20.xtail.S1 VSS sg13_lv_nmos ad=89.3f pd=0.85u as=89.3f ps=0.85u w=0.47u l=0.16u
X714 cml_tlatch_21.xmux.xp.S1 A1_8_P A1_8_N VSS sg13_lv_nmos ad=0.1019p pd=1.34u as=56.9f ps=0.74u w=0.17u l=0.17u
X715 stub_bi_62.BOTN stub_bi_62.BOTP cml_tlatch_78.xmux.xp.S1 VSS sg13_lv_nmos ad=56.9f pd=0.74u as=56.9f ps=0.74u w=0.17u l=0.17u
X716 VSS POLN cml_tlatch_98.xtail.S1 VSS sg13_lv_nmos ad=2.7982p pd=17.14u as=1.5637p ps=8.61u w=8.23u l=0.13u
X717 cml_gate2_0.sg13_lv_nmos_FTPY57_0.D0 ENB1_P GB1_N VSS sg13_lv_nmos ad=0.1007p pd=0.91u as=0.1007p ps=0.91u w=0.53u l=0.13u
X718 cml_tlatch_39.xmux.xp.S1 MOT10_P MOT10_N VSS sg13_lv_nmos ad=56.9f pd=0.74u as=56.9f ps=0.74u w=0.17u l=0.17u
X719 cml_tlatch_69.INN cml_tlatch_63.OUTP cml_tlatch_62.xmux.xn.S1 VSS sg13_lv_nmos ad=63.19999f pd=0.74u as=63.19999f ps=0.74u w=0.26u l=0.38u
X720 VSS POLN cml_tlatch_73.xtail.S1 VSS sg13_lv_nmos ad=1.5637p pd=8.61u as=1.5637p ps=8.61u w=8.23u l=0.13u
X721 cml_tlatch_70.xmux.xn.S1 cml_tlatch_70.INN MOT29_P VSS sg13_lv_nmos ad=0.1082p pd=1.34u as=63.19999f ps=0.74u w=0.26u l=0.38u
X722 stub_bi_42.BOTP stub_bi_42.BOTN cml_tlatch_43.xmux.xp.S1 VSS sg13_lv_nmos ad=56.9f pd=0.74u as=56.9f ps=0.74u w=0.17u l=0.17u
X723 cml_tlatch_88.xmux.xn.S1 stub_bi_42.BOTP stub_bi_55.BOTN VSS sg13_lv_nmos ad=63.19999f pd=0.74u as=63.19999f ps=0.74u w=0.26u l=0.38u
X724 cml_tlatch_39.INN cml_tlatch_39.INP cml_tlatch_23.xmux.xp.S1 VSS sg13_lv_nmos ad=56.9f pd=0.74u as=0.1019p ps=1.34u w=0.17u l=0.17u
X725 cml_tlatch_4.xmux.xn.S1 B1_8_P MOT9_N VSS sg13_lv_nmos ad=63.19999f pd=0.74u as=63.19999f ps=0.74u w=0.26u l=0.38u
X726 hs_to_clk_5.D2 CK_N CKB3_P VSS sg13_lv_nmos ad=0.228p pd=1.58u as=0.408p ps=3.08u w=1.2u l=0.2u
X727 MOT20_P cml_tlatch_89.OUTN cml_tlatch_50.xmux.xn.S1 VSS sg13_lv_nmos ad=63.19999f pd=0.74u as=63.19999f ps=0.74u w=0.26u l=0.38u
X728 cml_tlatch_36.xmux.xp.S1 cml_tlatch_95.INN cml_tlatch_95.INP VSS sg13_lv_nmos ad=0.1019p pd=1.34u as=56.9f ps=0.74u w=0.17u l=0.17u
X729 cml_tlatch_72.xmux.xn.S1 CKA2_P cml_tlatch_72.xtail.S1 VSS sg13_lv_nmos ad=89.3f pd=0.85u as=89.3f ps=0.85u w=0.47u l=0.16u
X730 cml_tlatch_1.xmux.xp.S1 cml_tlatch_1.OUTN cml_tlatch_1.OUTP VSS sg13_lv_nmos ad=56.9f pd=0.74u as=56.9f ps=0.74u w=0.17u l=0.17u
X731 cml_tlatch_5.xmux.xp.S1 MOT11_P MOT11_N VSS sg13_lv_nmos ad=56.9f pd=0.74u as=56.9f ps=0.74u w=0.17u l=0.17u
X732 cml_tlatch_3.OUTN cml_tlatch_8.OUTP cml_tlatch_3.xmux.xn.S1 VSS sg13_lv_nmos ad=63.19999f pd=0.74u as=63.19999f ps=0.74u w=0.26u l=0.38u
X733 CKHA0_N GA0_P cml_drvb_2.xrtail.R1 VSS sg13_lv_nmos ad=0.2618p pd=2.22u as=0.1463p ps=1.15u w=0.77u l=0.21u
X734 MOT14_N MOT14_P cml_tlatch_41.xmux.xp.S1 VSS sg13_lv_nmos ad=56.9f pd=0.74u as=56.9f ps=0.74u w=0.17u l=0.17u
X735 cml_tlatch_26.xmux.xn.S1 CKHA0_P cml_tlatch_26.xtail.S1 VSS sg13_lv_nmos ad=89.3f pd=0.85u as=89.3f ps=0.85u w=0.47u l=0.16u
X736 GB1_P ENB1_N cml_gate2_0.sg13_lv_nmos_FTPY57_0.D0 VSS sg13_lv_nmos ad=0.1007p pd=0.91u as=0.1007p ps=0.91u w=0.53u l=0.13u
X737 cml_tlatch_67.OUTP cml_tlatch_67.OUTN cml_tlatch_67.xmux.xp.S1 VSS sg13_lv_nmos ad=56.9f pd=0.74u as=56.9f ps=0.74u w=0.17u l=0.17u
X738 MOT25_N B3_8_P cml_tlatch_68.xmux.xn.S1 VSS sg13_lv_nmos ad=63.19999f pd=0.74u as=63.19999f ps=0.74u w=0.26u l=0.38u
X739 VSS POLN cml_tlatch_22.xtail.S1 VSS sg13_lv_nmos ad=2.7982p pd=17.14u as=1.5637p ps=8.61u w=8.23u l=0.13u
X740 cml_tlatch_63.xmux.xp.S1 cml_tlatch_63.OUTN cml_tlatch_63.OUTP VSS sg13_lv_nmos ad=56.9f pd=0.74u as=56.9f ps=0.74u w=0.17u l=0.17u
X741 cml_tlatch_47.xtail.S1 CKB3_N cml_tlatch_47.xmux.xp.S1 VSS sg13_lv_nmos ad=89.3f pd=0.85u as=89.3f ps=0.85u w=0.47u l=0.16u
X742 stub_bi_49.BOTN stub_bi_55.BOTP cml_tlatch_80.xmux.xn.S1 VSS sg13_lv_nmos ad=63.19999f pd=0.74u as=63.19999f ps=0.74u w=0.26u l=0.38u
X743 cml_tlatch_56.xmux.xp.S1 A2_2_P A2_2_N VSS sg13_lv_nmos ad=56.9f pd=0.74u as=56.9f ps=0.74u w=0.17u l=0.17u
X744 cml_tlatch_84.xmux.xp.S1 cml_tlatch_70.INP cml_tlatch_70.INN VSS sg13_lv_nmos ad=56.9f pd=0.74u as=56.9f ps=0.74u w=0.17u l=0.17u
X745 cml_tlatch_49.xmux.xn.S1 CKHA2_P cml_tlatch_49.xtail.S1 VSS sg13_lv_nmos ad=89.3f pd=0.85u as=89.3f ps=0.85u w=0.47u l=0.16u
X746 cml_tlatch_27.xmux.xp.S1 cml_tlatch_27.OUTN cml_tlatch_27.OUTP VSS sg13_lv_nmos ad=56.9f pd=0.74u as=56.9f ps=0.74u w=0.17u l=0.17u
X747 cml_tlatch_10.xmux.xp.S1 B0_8_N B0_8_P VSS sg13_lv_nmos ad=56.9f pd=0.74u as=56.9f ps=0.74u w=0.17u l=0.17u
X748 cml_tlatch_72.xtail.S1 POLN VSS VSS sg13_lv_nmos ad=1.5637p pd=8.61u as=2.7982p ps=17.14u w=8.23u l=0.13u
X749 cml_tlatch_50.xmux.xn.S1 cml_tlatch_89.OUTP MOT20_N VSS sg13_lv_nmos ad=63.19999f pd=0.74u as=63.19999f ps=0.74u w=0.26u l=0.38u
X750 cml_tlatch_71.xmux.xn.S1 CKHB3_P cml_tlatch_71.xtail.S1 VSS sg13_lv_nmos ad=89.3f pd=0.85u as=89.3f ps=0.85u w=0.47u l=0.16u
X751 cml_tlatch_80.xmux.xn.S1 CKB2_P cml_tlatch_80.xtail.S1 VSS sg13_lv_nmos ad=89.3f pd=0.85u as=89.3f ps=0.85u w=0.47u l=0.16u
X752 cml_tlatch_3.xtail.S1 CKA0_P cml_tlatch_3.xmux.xn.S1 VSS sg13_lv_nmos ad=89.3f pd=0.85u as=89.3f ps=0.85u w=0.47u l=0.16u
X753 stub_bi_19.BOTN stub_bi_19.BOTP cml_tlatch_15.xmux.xp.S1 VSS sg13_lv_nmos ad=56.9f pd=0.74u as=56.9f ps=0.74u w=0.17u l=0.17u
X754 cml_tlatch_74.xmux.xp.S1 CKHB2_N cml_tlatch_74.xtail.S1 VSS sg13_lv_nmos ad=0.1598p pd=1.62u as=89.3f ps=0.85u w=0.47u l=0.16u
X755 cml_tlatch_21.xmux.xp.S1 A1_8_N A1_8_P VSS sg13_lv_nmos ad=56.9f pd=0.74u as=56.9f ps=0.74u w=0.17u l=0.17u
X756 cml_gate2_8.sg13_lv_nmos_FTPY57_0.D0 J2_P ENB_N VSS sg13_lv_nmos ad=0.1802p pd=1.74u as=0.1007p ps=0.91u w=0.53u l=0.13u
X757 cml_tlatch_67.xmux.xn.S1 CKA3_P cml_tlatch_67.xtail.S1 VSS sg13_lv_nmos ad=89.3f pd=0.85u as=89.3f ps=0.85u w=0.47u l=0.16u
X758 stub_bi_31.BOTP stub_bi_31.BOTN cml_tlatch_34.xmux.xp.S1 VSS sg13_lv_nmos ad=56.9f pd=0.74u as=56.9f ps=0.74u w=0.17u l=0.17u
X759 cml_tlatch_69.xmux.xp.S1 MOT27_P MOT27_N VSS sg13_lv_nmos ad=56.9f pd=0.74u as=56.9f ps=0.74u w=0.17u l=0.17u
X760 cml_tlatch_58.INP cml_tlatch_58.INN cml_tlatch_85.xmux.xp.S1 VSS sg13_lv_nmos ad=56.9f pd=0.74u as=56.9f ps=0.74u w=0.17u l=0.17u
X761 MOT5_N cml_tlatch_98.OUTP cml_tlatch_19.xmux.xn.S1 VSS sg13_lv_nmos ad=63.19999f pd=0.74u as=63.19999f ps=0.74u w=0.26u l=0.38u
X762 cml_tlatch_57.xmux.xn.S1 CKHA3_P cml_tlatch_57.xtail.S1 VSS sg13_lv_nmos ad=89.3f pd=0.85u as=89.3f ps=0.85u w=0.47u l=0.16u
X763 cml_tlatch_42.xmux.xn.S1 D2_P cml_tlatch_56.INN VSS sg13_lv_nmos ad=63.19999f pd=0.74u as=63.19999f ps=0.74u w=0.26u l=0.38u
X764 cml_tlatch_22.xmux.xn.S1 CKA1_P cml_tlatch_22.xtail.S1 VSS sg13_lv_nmos ad=89.3f pd=0.85u as=89.3f ps=0.85u w=0.47u l=0.16u
X765 cml_tlatch_4.xtail.S1 CKHB1_P cml_tlatch_4.xmux.xn.S1 VSS sg13_lv_nmos ad=0.1598p pd=1.62u as=89.3f ps=0.85u w=0.47u l=0.16u
X766 cml_tlatch_34.xtail.S1 CKB1_N cml_tlatch_34.xmux.xp.S1 VSS sg13_lv_nmos ad=89.3f pd=0.85u as=0.1598p ps=1.62u w=0.47u l=0.16u
X767 B0_2_N VDD VSS rppd l=5.17u w=1u
X768 cml_tlatch_2.xmux.xp.S1 A0_8_P A0_8_N VSS sg13_lv_nmos ad=56.9f pd=0.74u as=56.9f ps=0.74u w=0.17u l=0.17u
X769 ENA1_N ENA_P cml_drv_1.xrtail.R1 VSS sg13_lv_nmos ad=56.2f pd=0.74u as=0.1012p ps=1.34u w=0.16u l=0.19u
X770 cml_tlatch_85.xmux.xp.S1 CKA3_P cml_tlatch_85.xtail.S1 VSS sg13_lv_nmos ad=89.3f pd=0.85u as=89.3f ps=0.85u w=0.47u l=0.16u
X771 cml_tlatch_1.OUTP VDD VSS rppd l=5.17u w=1u
X772 cml_tlatch_21.xmux.xp.S1 A1_8_N A1_8_P VSS sg13_lv_nmos ad=56.9f pd=0.74u as=56.9f ps=0.74u w=0.17u l=0.17u
X773 stub_bi_32.BOTN stub_bi_32.BOTP cml_tlatch_48.xmux.xp.S1 VSS sg13_lv_nmos ad=56.9f pd=0.74u as=56.9f ps=0.74u w=0.17u l=0.17u
X774 GB0_N ENB1_P cml_gate2_1.sg13_lv_nmos_FTPY57_0.D0 VSS sg13_lv_nmos ad=0.1007p pd=0.91u as=0.1007p ps=0.91u w=0.53u l=0.13u
X775 cml_tlatch_32.xmux.xn.S1 CKB1_P cml_tlatch_32.xtail.S1 VSS sg13_lv_nmos ad=89.3f pd=0.85u as=89.3f ps=0.85u w=0.47u l=0.16u
X776 cml_tlatch_1.OUTN cml_tlatch_1.OUTP cml_tlatch_1.xmux.xp.S1 VSS sg13_lv_nmos ad=56.9f pd=0.74u as=56.9f ps=0.74u w=0.17u l=0.17u
X777 cml_tlatch_81.xmux.xp.S1 CKA2_P cml_tlatch_81.xtail.S1 VSS sg13_lv_nmos ad=89.3f pd=0.85u as=89.3f ps=0.85u w=0.47u l=0.16u
X778 cml_tlatch_55.xmux.xn.S1 CKA2_P cml_tlatch_55.xtail.S1 VSS sg13_lv_nmos ad=89.3f pd=0.85u as=89.3f ps=0.85u w=0.47u l=0.16u
X779 cml_tlatch_3.xmux.xp.S1 cml_tlatch_3.OUTP cml_tlatch_3.OUTN VSS sg13_lv_nmos ad=56.9f pd=0.74u as=56.9f ps=0.74u w=0.17u l=0.17u
X780 cml_tlatch_11.xtail.S1 POLN VSS VSS sg13_lv_nmos ad=1.5637p pd=8.61u as=2.7982p ps=17.14u w=8.23u l=0.13u
X781 VSS POLN cml_tlatch_75.xtail.S1 VSS sg13_lv_nmos ad=2.7982p pd=17.14u as=1.5637p ps=8.61u w=8.23u l=0.13u
X782 cml_tlatch_74.xmux.xp.S1 MOT19_N MOT19_P VSS sg13_lv_nmos ad=56.9f pd=0.74u as=56.9f ps=0.74u w=0.17u l=0.17u
X783 cml_gate2_8.sg13_lv_nmos_FTPY57_0.D0 J2_N ENB_P VSS sg13_lv_nmos ad=0.1007p pd=0.91u as=0.1007p ps=0.91u w=0.53u l=0.13u
X784 cml_tlatch_84.xmux.xp.S1 CKB3_P cml_tlatch_84.xtail.S1 VSS sg13_lv_nmos ad=89.3f pd=0.85u as=89.3f ps=0.85u w=0.47u l=0.16u
X785 cml_drvb_5.xrtail.R1 GA3_N CKHA3_P VSS sg13_lv_nmos ad=0.1463p pd=1.15u as=0.2618p ps=2.22u w=0.77u l=0.21u
X786 cml_tlatch_25.xmux.xp.S1 MOT4_N MOT4_P VSS sg13_lv_nmos ad=56.9f pd=0.74u as=56.9f ps=0.74u w=0.17u l=0.17u
X787 cml_tlatch_57.INN cml_tlatch_57.INP cml_tlatch_66.xmux.xp.S1 VSS sg13_lv_nmos ad=56.9f pd=0.74u as=56.9f ps=0.74u w=0.17u l=0.17u
X788 cml_tlatch_25.xmux.xn.S1 CKHA0_P cml_tlatch_25.xtail.S1 VSS sg13_lv_nmos ad=89.3f pd=0.85u as=89.3f ps=0.85u w=0.47u l=0.16u
X789 cml_tlatch_62.xmux.xp.S1 cml_tlatch_69.INN cml_tlatch_69.INP VSS sg13_lv_nmos ad=56.9f pd=0.74u as=56.9f ps=0.74u w=0.17u l=0.17u
X790 cml_tlatch_50.xmux.xp.S1 MOT20_P MOT20_N VSS sg13_lv_nmos ad=56.9f pd=0.74u as=56.9f ps=0.74u w=0.17u l=0.17u
X791 cml_tlatch_99.OUTN cml_tlatch_30.OUTP cml_tlatch_99.xmux.xn.S1 VSS sg13_lv_nmos ad=63.19999f pd=0.74u as=63.19999f ps=0.74u w=0.26u l=0.38u
X792 cml_tlatch_62.xmux.xp.S1 CKB3_P cml_tlatch_62.xtail.S1 VSS sg13_lv_nmos ad=89.3f pd=0.85u as=89.3f ps=0.85u w=0.47u l=0.16u
X793 cml_tlatch_70.INP cml_tlatch_70.INN cml_tlatch_84.xmux.xp.S1 VSS sg13_lv_nmos ad=56.9f pd=0.74u as=0.1019p ps=1.34u w=0.17u l=0.17u
X794 MOT23_P B2_2_N cml_tlatch_76.xmux.xn.S1 VSS sg13_lv_nmos ad=63.19999f pd=0.74u as=63.19999f ps=0.74u w=0.26u l=0.38u
X795 stub_bi_42.BOTP stub_bi_42.BOTN cml_tlatch_43.xmux.xp.S1 VSS sg13_lv_nmos ad=56.9f pd=0.74u as=56.9f ps=0.74u w=0.17u l=0.17u
X796 cml_tlatch_27.xtail.S1 CKB0_N cml_tlatch_27.xmux.xp.S1 VSS sg13_lv_nmos ad=89.3f pd=0.85u as=89.3f ps=0.85u w=0.47u l=0.16u
X797 cml_tlatch_37.xmux.xn.S1 cml_tlatch_38.OUTP A1_2_N VSS sg13_lv_nmos ad=63.19999f pd=0.74u as=63.19999f ps=0.74u w=0.26u l=0.38u
X798 cml_tlatch_36.xmux.xp.S1 cml_tlatch_95.INP cml_tlatch_95.INN VSS sg13_lv_nmos ad=56.9f pd=0.74u as=56.9f ps=0.74u w=0.17u l=0.17u
X799 MOT14_N A1_2_P cml_tlatch_41.xmux.xn.S1 VSS sg13_lv_nmos ad=63.19999f pd=0.74u as=63.19999f ps=0.74u w=0.26u l=0.38u
X800 cml_tlatch_96.xmux.xn.S1 CKHA1_P cml_tlatch_96.xtail.S1 VSS sg13_lv_nmos ad=89.3f pd=0.85u as=89.3f ps=0.85u w=0.47u l=0.16u
X801 MOT3_P MOT3_N cml_tlatch_18.xmux.xp.S1 VSS sg13_lv_nmos ad=56.9f pd=0.74u as=56.9f ps=0.74u w=0.17u l=0.17u
X802 cml_tlatch_13.xmux.xp.S1 CKB1_N cml_tlatch_13.xtail.S1 VSS sg13_lv_nmos ad=89.3f pd=0.85u as=89.3f ps=0.85u w=0.47u l=0.16u
X803 CKA2_N CK_N hs_to_clk_4.D2 VSS sg13_lv_nmos ad=0.228p pd=1.58u as=0.408p ps=3.08u w=1.2u l=0.2u
X804 cml_tlatch_26.xmux.xp.S1 MOT6_N MOT6_P VSS sg13_lv_nmos ad=56.9f pd=0.74u as=56.9f ps=0.74u w=0.17u l=0.17u
X805 cml_tlatch_93.xmux.xp.S1 CKJ_N cml_tlatch_93.xtail.S1 VSS sg13_lv_nmos ad=89.3f pd=0.85u as=89.3f ps=0.85u w=0.47u l=0.16u
X806 cml_tlatch_61.OUTN cml_tlatch_69.INP cml_tlatch_61.xmux.xn.S1 VSS sg13_lv_nmos ad=63.19999f pd=0.74u as=63.19999f ps=0.74u w=0.26u l=0.38u
X807 cml_tlatch_61.xmux.xp.S1 cml_tlatch_61.OUTN cml_tlatch_61.OUTP VSS sg13_lv_nmos ad=56.9f pd=0.74u as=56.9f ps=0.74u w=0.17u l=0.17u
X808 cml_tlatch_70.xmux.xp.S1 MOT29_P MOT29_N VSS sg13_lv_nmos ad=56.9f pd=0.74u as=56.9f ps=0.74u w=0.17u l=0.17u
X809 cml_tlatch_30.OUTN A0_2_P cml_tlatch_30.xmux.xn.S1 VSS sg13_lv_nmos ad=0.1082p pd=1.34u as=63.19999f ps=0.74u w=0.26u l=0.38u
X810 VSS POLN cml_tlatch_0.xtail.S1 VSS sg13_lv_nmos ad=1.5637p pd=8.61u as=1.5637p ps=8.61u w=8.23u l=0.13u
X811 cml_tlatch_59.xmux.xn.S1 A3_2_N MOT30_P VSS sg13_lv_nmos ad=63.19999f pd=0.74u as=0.1082p ps=1.34u w=0.26u l=0.38u
X812 cml_tlatch_30.OUTN A0_2_P cml_tlatch_30.xmux.xn.S1 VSS sg13_lv_nmos ad=63.19999f pd=0.74u as=63.19999f ps=0.74u w=0.26u l=0.38u
X813 B2_2_N B2_2_P cml_tlatch_44.xmux.xp.S1 VSS sg13_lv_nmos ad=56.9f pd=0.74u as=56.9f ps=0.74u w=0.17u l=0.17u
X814 cml_tlatch_61.OUTN cml_tlatch_61.OUTP cml_tlatch_61.xmux.xp.S1 VSS sg13_lv_nmos ad=56.9f pd=0.74u as=56.9f ps=0.74u w=0.17u l=0.17u
X815 MOT24_N A3_8_P cml_tlatch_86.xmux.xn.S1 VSS sg13_lv_nmos ad=63.19999f pd=0.74u as=63.19999f ps=0.74u w=0.26u l=0.38u
X816 cml_tlatch_10.xmux.xp.S1 B0_8_N B0_8_P VSS sg13_lv_nmos ad=56.9f pd=0.74u as=56.9f ps=0.74u w=0.17u l=0.17u
X817 cml_tlatch_97.xmux.xp.S1 MOT0_N MOT0_P VSS sg13_lv_nmos ad=56.9f pd=0.74u as=56.9f ps=0.74u w=0.17u l=0.17u
X818 cml_tlatch_89.INN A2_2_P cml_tlatch_55.xmux.xn.S1 VSS sg13_lv_nmos ad=63.19999f pd=0.74u as=63.19999f ps=0.74u w=0.26u l=0.38u
X819 cml_tlatch_5.xmux.xn.S1 cml_tlatch_5.INN MOT11_P VSS sg13_lv_nmos ad=63.19999f pd=0.74u as=0.1082p ps=1.34u w=0.26u l=0.38u
X820 MOT21_P MOT21_N cml_tlatch_75.xmux.xp.S1 VSS sg13_lv_nmos ad=56.9f pd=0.74u as=56.9f ps=0.74u w=0.17u l=0.17u
X821 cml_tlatch_20.xtail.S1 CKHB0_N cml_tlatch_20.xmux.xp.S1 VSS sg13_lv_nmos ad=89.3f pd=0.85u as=89.3f ps=0.85u w=0.47u l=0.16u
X822 cml_tlatch_20.xmux.xp.S1 MOT7_N MOT7_P VSS sg13_lv_nmos ad=56.9f pd=0.74u as=56.9f ps=0.74u w=0.17u l=0.17u
X823 cml_tlatch_51.xmux.xp.S1 MOT22_N MOT22_P VSS sg13_lv_nmos ad=56.9f pd=0.74u as=56.9f ps=0.74u w=0.17u l=0.17u
X824 cml_tlatch_64.xmux.xn.S1 cml_tlatch_65.OUTN A3_8_P VSS sg13_lv_nmos ad=63.19999f pd=0.74u as=63.19999f ps=0.74u w=0.26u l=0.38u
X825 cml_tlatch_73.xmux.xn.S1 CKHB2_P cml_tlatch_73.xtail.S1 VSS sg13_lv_nmos ad=89.3f pd=0.85u as=89.3f ps=0.85u w=0.47u l=0.16u
X826 NM1_N CLK_W_P cml_drvb_9.xrtail.R1 VSS sg13_lv_nmos ad=0.2618p pd=2.22u as=0.1463p ps=1.15u w=0.77u l=0.21u
X827 MOT20_P MOT20_N cml_tlatch_50.xmux.xp.S1 VSS sg13_lv_nmos ad=56.9f pd=0.74u as=0.1019p ps=1.34u w=0.17u l=0.17u
X828 cml_tlatch_11.OUTN cml_tlatch_11.OUTP cml_tlatch_11.xmux.xp.S1 VSS sg13_lv_nmos ad=56.9f pd=0.74u as=56.9f ps=0.74u w=0.17u l=0.17u
X829 cml_tlatch_61.OUTP cml_tlatch_61.OUTN cml_tlatch_61.xmux.xp.S1 VSS sg13_lv_nmos ad=56.9f pd=0.74u as=56.9f ps=0.74u w=0.17u l=0.17u
X830 cml_tlatch_2.xmux.xp.S1 A0_8_P A0_8_N VSS sg13_lv_nmos ad=0.1019p pd=1.34u as=56.9f ps=0.74u w=0.17u l=0.17u
X831 cml_tlatch_94.xtail.S1 CKB1_P cml_tlatch_94.xmux.xp.S1 VSS sg13_lv_nmos ad=89.3f pd=0.85u as=89.3f ps=0.85u w=0.47u l=0.16u
X832 cml_tlatch_42.xtail.S1 CKA2_P cml_tlatch_42.xmux.xn.S1 VSS sg13_lv_nmos ad=89.3f pd=0.85u as=89.3f ps=0.85u w=0.47u l=0.16u
X833 cml_tlatch_46.xtail.S1 CKB3_P cml_tlatch_46.xmux.xp.S1 VSS sg13_lv_nmos ad=89.3f pd=0.85u as=89.3f ps=0.85u w=0.47u l=0.16u
X834 cml_tlatch_92.xmux.xp.S1 J2_P J2_N VSS sg13_lv_nmos ad=56.9f pd=0.74u as=56.9f ps=0.74u w=0.17u l=0.17u
X835 cml_tlatch_53.xmux.xp.S1 A3_2_P A3_2_N VSS sg13_lv_nmos ad=56.9f pd=0.74u as=56.9f ps=0.74u w=0.17u l=0.17u
X836 MOT17_N MOT17_P cml_tlatch_73.xmux.xp.S1 VSS sg13_lv_nmos ad=56.9f pd=0.74u as=56.9f ps=0.74u w=0.17u l=0.17u
X837 cml_tlatch_16.xtail.S1 CKB0_N cml_tlatch_16.xmux.xn.S1 VSS sg13_lv_nmos ad=89.3f pd=0.85u as=89.3f ps=0.85u w=0.47u l=0.16u
X838 cml_tlatch_49.xmux.xp.S1 MOT18_N MOT18_P VSS sg13_lv_nmos ad=56.9f pd=0.74u as=56.9f ps=0.74u w=0.17u l=0.17u
X839 cml_tlatch_14.xmux.xn.S1 stub_bi_19.BOTN cml_tlatch_5.INN VSS sg13_lv_nmos ad=63.19999f pd=0.74u as=63.19999f ps=0.74u w=0.26u l=0.38u
X840 cml_tlatch_0.xmux.xp.S1 CKA1_N cml_tlatch_0.xtail.S1 VSS sg13_lv_nmos ad=89.3f pd=0.85u as=89.3f ps=0.85u w=0.47u l=0.16u
X841 cml_tlatch_66.xmux.xn.S1 CKA3_N cml_tlatch_66.xtail.S1 VSS sg13_lv_nmos ad=89.3f pd=0.85u as=89.3f ps=0.85u w=0.47u l=0.16u
X842 cml_tlatch_74.xmux.xp.S1 MOT19_N MOT19_P VSS sg13_lv_nmos ad=56.9f pd=0.74u as=56.9f ps=0.74u w=0.17u l=0.17u
X843 cml_tlatch_76.xtail.S1 CKHB2_N cml_tlatch_76.xmux.xp.S1 VSS sg13_lv_nmos ad=89.3f pd=0.85u as=89.3f ps=0.85u w=0.47u l=0.16u
X844 cml_tlatch_48.xtail.S1 CKB2_P cml_tlatch_48.xmux.xn.S1 VSS sg13_lv_nmos ad=0.1598p pd=1.62u as=89.3f ps=0.85u w=0.47u l=0.16u
X845 MOT0_N MOT0_P cml_tlatch_97.xmux.xp.S1 VSS sg13_lv_nmos ad=56.9f pd=0.74u as=56.9f ps=0.74u w=0.17u l=0.17u
X846 MOT9_N MOT9_P cml_tlatch_4.xmux.xp.S1 VSS sg13_lv_nmos ad=56.9f pd=0.74u as=56.9f ps=0.74u w=0.17u l=0.17u
X847 VSS POLN cml_tlatch_6.xtail.S1 VSS sg13_lv_nmos ad=1.5637p pd=8.61u as=1.5637p ps=8.61u w=8.23u l=0.13u
X848 ENA0_P ENA_N cml_drv_3.xrtail.R1 VSS sg13_lv_nmos ad=56.2f pd=0.74u as=56.2f ps=0.74u w=0.16u l=0.19u
X849 cml_tlatch_47.xmux.xp.S1 cml_tlatch_47.OUTN cml_tlatch_47.OUTP VSS sg13_lv_nmos ad=56.9f pd=0.74u as=56.9f ps=0.74u w=0.17u l=0.17u
X850 cml_tlatch_13.xmux.xp.S1 stub_bi_17.BOTP stub_bi_17.BOTN VSS sg13_lv_nmos ad=56.9f pd=0.74u as=56.9f ps=0.74u w=0.17u l=0.17u
X851 cml_tlatch_87.xtail.S1 POLN VSS VSS sg13_lv_nmos ad=1.5637p pd=8.61u as=1.5637p ps=8.61u w=8.23u l=0.13u
X852 cml_tlatch_5.xmux.xp.S1 MOT11_N MOT11_P VSS sg13_lv_nmos ad=56.9f pd=0.74u as=56.9f ps=0.74u w=0.17u l=0.17u
X853 cml_gate2_4.xrtail.R1 CKB2_P cml_gate2_4.sg13_lv_nmos_FTPY57_0.D0 VSS sg13_lv_nmos ad=0.1007p pd=0.91u as=0.1007p ps=0.91u w=0.53u l=0.13u
X854 cml_tlatch_89.xmux.xp.S1 cml_tlatch_89.OUTN cml_tlatch_89.OUTP VSS sg13_lv_nmos ad=56.9f pd=0.74u as=56.9f ps=0.74u w=0.17u l=0.17u
X855 cml_tlatch_62.xmux.xn.S1 CKB3_N cml_tlatch_62.xtail.S1 VSS sg13_lv_nmos ad=89.3f pd=0.85u as=89.3f ps=0.85u w=0.47u l=0.16u
X856 MOT2_P MOT2_N cml_tlatch_24.xmux.xp.S1 VSS sg13_lv_nmos ad=56.9f pd=0.74u as=56.9f ps=0.74u w=0.17u l=0.17u
X857 cml_tlatch_4.xmux.xn.S1 CKHB1_P cml_tlatch_4.xtail.S1 VSS sg13_lv_nmos ad=89.3f pd=0.85u as=89.3f ps=0.85u w=0.47u l=0.16u
X858 MOT20_P MOT20_N cml_tlatch_50.xmux.xp.S1 VSS sg13_lv_nmos ad=56.9f pd=0.74u as=56.9f ps=0.74u w=0.17u l=0.17u
X859 cml_tlatch_51.xtail.S1 CKHA2_P cml_tlatch_51.xmux.xn.S1 VSS sg13_lv_nmos ad=89.3f pd=0.85u as=89.3f ps=0.85u w=0.47u l=0.16u
X860 MOT18_N MOT18_P cml_tlatch_49.xmux.xp.S1 VSS sg13_lv_nmos ad=56.9f pd=0.74u as=56.9f ps=0.74u w=0.17u l=0.17u
X861 VDD cml_tlatch_35.OUTN VSS rppd l=5.17u w=1u
X862 MOT2_P cml_tlatch_8.OUTN cml_tlatch_24.xmux.xn.S1 VSS sg13_lv_nmos ad=63.19999f pd=0.74u as=0.1082p ps=1.34u w=0.26u l=0.38u
X863 cml_tlatch_89.xmux.xn.S1 CKA2_N cml_tlatch_89.xtail.S1 VSS sg13_lv_nmos ad=89.3f pd=0.85u as=89.3f ps=0.85u w=0.47u l=0.16u
X864 cml_tlatch_57.xmux.xp.S1 MOT26_P MOT26_N VSS sg13_lv_nmos ad=56.9f pd=0.74u as=56.9f ps=0.74u w=0.17u l=0.17u
X865 MOT23_P MOT23_N cml_tlatch_76.xmux.xp.S1 VSS sg13_lv_nmos ad=56.9f pd=0.74u as=0.1019p ps=1.34u w=0.17u l=0.17u
X866 cml_tlatch_30.OUTN cml_tlatch_30.OUTP cml_tlatch_30.xmux.xp.S1 VSS sg13_lv_nmos ad=56.9f pd=0.74u as=56.9f ps=0.74u w=0.17u l=0.17u
X867 cml_tlatch_11.xmux.xn.S1 cml_tlatch_16.OUTN cml_tlatch_11.OUTP VSS sg13_lv_nmos ad=0.1082p pd=1.34u as=63.19999f ps=0.74u w=0.26u l=0.38u
X868 cml_tlatch_93.xmux.xn.S1 CKJ_P cml_tlatch_93.xtail.S1 VSS sg13_lv_nmos ad=89.3f pd=0.85u as=89.3f ps=0.85u w=0.47u l=0.16u
X869 cml_tlatch_53.xmux.xp.S1 A3_2_P A3_2_N VSS sg13_lv_nmos ad=56.9f pd=0.74u as=56.9f ps=0.74u w=0.17u l=0.17u
X870 cml_tlatch_69.xtail.S1 CKHB3_P cml_tlatch_69.xmux.xn.S1 VSS sg13_lv_nmos ad=89.3f pd=0.85u as=89.3f ps=0.85u w=0.47u l=0.16u
X871 cml_tlatch_16.xmux.xp.S1 cml_tlatch_16.OUTP cml_tlatch_16.OUTN VSS sg13_lv_nmos ad=56.9f pd=0.74u as=56.9f ps=0.74u w=0.17u l=0.17u
X872 cml_tlatch_24.xmux.xn.S1 cml_tlatch_8.OUTP MOT2_N VSS sg13_lv_nmos ad=63.19999f pd=0.74u as=63.19999f ps=0.74u w=0.26u l=0.38u
X873 A2_8_N A2_8_P cml_tlatch_81.xmux.xp.S1 VSS sg13_lv_nmos ad=56.9f pd=0.74u as=56.9f ps=0.74u w=0.17u l=0.17u
X874 cml_tlatch_30.OUTP cml_tlatch_30.OUTN cml_tlatch_30.xmux.xp.S1 VSS sg13_lv_nmos ad=56.9f pd=0.74u as=56.9f ps=0.74u w=0.17u l=0.17u
X875 B1_8_N stub_bi_17.BOTN cml_tlatch_12.xmux.xn.S1 VSS sg13_lv_nmos ad=63.19999f pd=0.74u as=63.19999f ps=0.74u w=0.26u l=0.38u
X876 cml_tlatch_66.xmux.xn.S1 cml_tlatch_67.OUTN cml_tlatch_57.INP VSS sg13_lv_nmos ad=63.19999f pd=0.74u as=63.19999f ps=0.74u w=0.26u l=0.38u
X877 cml_tlatch_6.xtail.S1 CKHB1_P cml_tlatch_6.xmux.xn.S1 VSS sg13_lv_nmos ad=89.3f pd=0.85u as=0.1598p ps=1.62u w=0.47u l=0.16u
X878 cml_gate2_6.sg13_lv_nmos_FTPY57_0.D0 ENB0_N GB3_P VSS sg13_lv_nmos ad=0.1007p pd=0.91u as=0.1007p ps=0.91u w=0.53u l=0.13u
X879 cml_tlatch_72.xmux.xp.S1 cml_tlatch_83.INN cml_tlatch_83.INP VSS sg13_lv_nmos ad=56.9f pd=0.74u as=56.9f ps=0.74u w=0.17u l=0.17u
X880 cml_tlatch_82.OUTP cml_tlatch_82.OUTN cml_tlatch_82.xmux.xp.S1 VSS sg13_lv_nmos ad=56.9f pd=0.74u as=0.1019p ps=1.34u w=0.17u l=0.17u
X881 cml_tlatch_17.xmux.xp.S1 MOT1_N MOT1_P VSS sg13_lv_nmos ad=56.9f pd=0.74u as=56.9f ps=0.74u w=0.17u l=0.17u
X882 cml_tlatch_47.OUTP cml_tlatch_47.OUTN cml_tlatch_47.xmux.xp.S1 VSS sg13_lv_nmos ad=56.9f pd=0.74u as=56.9f ps=0.74u w=0.17u l=0.17u
X883 A3_2_P A3_2_N cml_tlatch_53.xmux.xp.S1 VSS sg13_lv_nmos ad=56.9f pd=0.74u as=56.9f ps=0.74u w=0.17u l=0.17u
X884 stub_bi_55.BOTP stub_bi_55.BOTN cml_tlatch_88.xmux.xp.S1 VSS sg13_lv_nmos ad=56.9f pd=0.74u as=56.9f ps=0.74u w=0.17u l=0.17u
X885 cml_gate2_9.sg13_lv_nmos_FTPY57_0.D0 NM1_P cml_gate2_9.xrtail.R1 VSS sg13_lv_nmos ad=0.1007p pd=0.91u as=0.1007p ps=0.91u w=0.53u l=0.13u
X886 cml_tlatch_2.xmux.xp.S1 CKA0_P cml_tlatch_2.xtail.S1 VSS sg13_lv_nmos ad=89.3f pd=0.85u as=89.3f ps=0.85u w=0.47u l=0.16u
X887 cml_tlatch_7.xtail.S1 CKHB1_N cml_tlatch_7.xmux.xp.S1 VSS sg13_lv_nmos ad=89.3f pd=0.85u as=89.3f ps=0.85u w=0.47u l=0.16u
X888 cml_tlatch_61.xtail.S1 CKB3_N cml_tlatch_61.xmux.xp.S1 VSS sg13_lv_nmos ad=89.3f pd=0.85u as=89.3f ps=0.85u w=0.47u l=0.16u
X889 cml_tlatch_88.xmux.xn.S1 CKB2_N cml_tlatch_88.xtail.S1 VSS sg13_lv_nmos ad=89.3f pd=0.85u as=89.3f ps=0.85u w=0.47u l=0.16u
X890 cml_tlatch_29.xmux.xp.S1 cml_tlatch_29.OUTP cml_tlatch_29.OUTN VSS sg13_lv_nmos ad=56.9f pd=0.74u as=56.9f ps=0.74u w=0.17u l=0.17u
X891 cml_tlatch_0.xmux.xn.S1 cml_tlatch_40.INP interco_bi_19.INN VSS sg13_lv_nmos ad=63.19999f pd=0.74u as=63.19999f ps=0.74u w=0.26u l=0.38u
X892 cml_tlatch_83.OUTN cml_tlatch_83.INP cml_tlatch_83.xmux.xn.S1 VSS sg13_lv_nmos ad=63.19999f pd=0.74u as=63.19999f ps=0.74u w=0.26u l=0.38u
X893 cml_tlatch_94.xmux.xn.S1 stub_bi_29.BOTN cml_tlatch_6.INN VSS sg13_lv_nmos ad=63.19999f pd=0.74u as=63.19999f ps=0.74u w=0.26u l=0.38u
X894 cml_tlatch_85.xmux.xn.S1 CKA3_N cml_tlatch_85.xtail.S1 VSS sg13_lv_nmos ad=89.3f pd=0.85u as=89.3f ps=0.85u w=0.47u l=0.16u
X895 CKB2_N CK_P hs_to_clk_6.D2 VSS sg13_lv_nmos ad=0.228p pd=1.58u as=0.228p ps=1.58u w=1.2u l=0.2u
X896 cml_tlatch_89.INP cml_tlatch_89.INN cml_tlatch_55.xmux.xp.S1 VSS sg13_lv_nmos ad=56.9f pd=0.74u as=56.9f ps=0.74u w=0.17u l=0.17u
X897 stub_bi_63.BOTP stub_bi_63.BOTN cml_tlatch_79.xmux.xp.S1 VSS sg13_lv_nmos ad=56.9f pd=0.74u as=56.9f ps=0.74u w=0.17u l=0.17u
X898 cml_tlatch_25.xtail.S1 CKHA0_P cml_tlatch_25.xmux.xn.S1 VSS sg13_lv_nmos ad=89.3f pd=0.85u as=89.3f ps=0.85u w=0.47u l=0.16u
X899 cml_tlatch_97.xmux.xp.S1 MOT0_N MOT0_P VSS sg13_lv_nmos ad=0.1019p pd=1.34u as=56.9f ps=0.74u w=0.17u l=0.17u
X900 cml_tlatch_39.xmux.xn.S1 cml_tlatch_39.INN MOT10_P VSS sg13_lv_nmos ad=0.1082p pd=1.34u as=63.19999f ps=0.74u w=0.26u l=0.38u
X901 stub_bi_63.BOTN stub_bi_63.BOTP cml_tlatch_79.xmux.xp.S1 VSS sg13_lv_nmos ad=56.9f pd=0.74u as=56.9f ps=0.74u w=0.17u l=0.17u
X902 cml_tlatch_94.xmux.xn.S1 stub_bi_29.BOTN cml_tlatch_6.INN VSS sg13_lv_nmos ad=63.19999f pd=0.74u as=63.19999f ps=0.74u w=0.26u l=0.38u
X903 GA2_P ENA1_N cml_gate2_4.sg13_lv_nmos_FTPY57_0.D0 VSS sg13_lv_nmos ad=0.1007p pd=0.91u as=0.1007p ps=0.91u w=0.53u l=0.13u
X904 cml_tlatch_65.OUTP cml_tlatch_57.INN cml_tlatch_65.xmux.xn.S1 VSS sg13_lv_nmos ad=63.19999f pd=0.74u as=63.19999f ps=0.74u w=0.26u l=0.38u
X905 cml_tlatch_70.xmux.xp.S1 MOT29_N MOT29_P VSS sg13_lv_nmos ad=56.9f pd=0.74u as=56.9f ps=0.74u w=0.17u l=0.17u
X906 cml_tlatch_1.OUTP cml_tlatch_98.OUTN cml_tlatch_1.xmux.xn.S1 VSS sg13_lv_nmos ad=63.19999f pd=0.74u as=63.19999f ps=0.74u w=0.26u l=0.38u
X907 MOT30_P MOT30_N cml_tlatch_59.xmux.xp.S1 VSS sg13_lv_nmos ad=56.9f pd=0.74u as=56.9f ps=0.74u w=0.17u l=0.17u
X908 cml_tlatch_87.xmux.xp.S1 MOT16_P MOT16_N VSS sg13_lv_nmos ad=56.9f pd=0.74u as=56.9f ps=0.74u w=0.17u l=0.17u
X909 cml_tlatch_19.xtail.S1 CKHB0_N cml_tlatch_19.xmux.xp.S1 VSS sg13_lv_nmos ad=89.3f pd=0.85u as=89.3f ps=0.85u w=0.47u l=0.16u
X910 cml_tlatch_95.xmux.xn.S1 cml_tlatch_95.INN cml_tlatch_40.INP VSS sg13_lv_nmos ad=63.19999f pd=0.74u as=63.19999f ps=0.74u w=0.26u l=0.38u
X911 MOT24_N MOT24_P cml_tlatch_86.xmux.xp.S1 VSS sg13_lv_nmos ad=56.9f pd=0.74u as=56.9f ps=0.74u w=0.17u l=0.17u
X912 MOT13_P MOT13_N cml_tlatch_6.xmux.xp.S1 VSS sg13_lv_nmos ad=56.9f pd=0.74u as=56.9f ps=0.74u w=0.17u l=0.17u
X913 cml_tlatch_13.xtail.S1 CKB1_N cml_tlatch_13.xmux.xp.S1 VSS sg13_lv_nmos ad=89.3f pd=0.85u as=0.1598p ps=1.62u w=0.47u l=0.16u
X914 cml_tlatch_31.xmux.xp.S1 CKA0_P cml_tlatch_31.xtail.S1 VSS sg13_lv_nmos ad=89.3f pd=0.85u as=89.3f ps=0.85u w=0.47u l=0.16u
X915 MOT23_P MOT23_N cml_tlatch_76.xmux.xp.S1 VSS sg13_lv_nmos ad=56.9f pd=0.74u as=56.9f ps=0.74u w=0.17u l=0.17u
X916 cml_tlatch_33.xmux.xn.S1 stub_bi_31.BOTP B1_2_P VSS sg13_lv_nmos ad=0.1082p pd=1.34u as=63.19999f ps=0.74u w=0.26u l=0.38u
X917 cml_tlatch_57.xmux.xn.S1 CKHA3_P cml_tlatch_57.xtail.S1 VSS sg13_lv_nmos ad=89.3f pd=0.85u as=89.3f ps=0.85u w=0.47u l=0.16u
X918 cml_tlatch_96.xmux.xp.S1 MOT8_P MOT8_N VSS sg13_lv_nmos ad=56.9f pd=0.74u as=56.9f ps=0.74u w=0.17u l=0.17u
X919 cml_tlatch_37.xmux.xp.S1 A1_2_N A1_2_P VSS sg13_lv_nmos ad=56.9f pd=0.74u as=56.9f ps=0.74u w=0.17u l=0.17u
X920 cml_tlatch_34.xmux.xp.S1 stub_bi_31.BOTP stub_bi_31.BOTN VSS sg13_lv_nmos ad=56.9f pd=0.74u as=56.9f ps=0.74u w=0.17u l=0.17u
X921 cml_tlatch_9.xmux.xp.S1 cml_tlatch_9.OUTN cml_tlatch_9.OUTP VSS sg13_lv_nmos ad=56.9f pd=0.74u as=56.9f ps=0.74u w=0.17u l=0.17u
X922 cml_tlatch_49.xmux.xp.S1 MOT18_N MOT18_P VSS sg13_lv_nmos ad=56.9f pd=0.74u as=56.9f ps=0.74u w=0.17u l=0.17u
X923 MOT6_N MOT6_P cml_tlatch_26.xmux.xp.S1 VSS sg13_lv_nmos ad=56.9f pd=0.74u as=56.9f ps=0.74u w=0.17u l=0.17u
X924 ENA_P NM1_N cml_gate2_9.xrtail.R1 VSS sg13_lv_nmos ad=0.1007p pd=0.91u as=0.1802p ps=1.74u w=0.53u l=0.13u
X925 cml_tlatch_47.OUTN D3_P cml_tlatch_47.xmux.xn.S1 VSS sg13_lv_nmos ad=63.19999f pd=0.74u as=63.19999f ps=0.74u w=0.26u l=0.38u
X926 interco_bi_19.INP cml_tlatch_40.INN cml_tlatch_0.xmux.xn.S1 VSS sg13_lv_nmos ad=63.19999f pd=0.74u as=63.19999f ps=0.74u w=0.26u l=0.38u
X927 cml_tlatch_82.OUTP cml_tlatch_82.OUTN cml_tlatch_82.xmux.xp.S1 VSS sg13_lv_nmos ad=56.9f pd=0.74u as=56.9f ps=0.74u w=0.17u l=0.17u
X928 cml_tlatch_38.OUTN cml_tlatch_38.OUTP cml_tlatch_38.xmux.xp.S1 VSS sg13_lv_nmos ad=56.9f pd=0.74u as=56.9f ps=0.74u w=0.17u l=0.17u
X929 MOT16_P A2_8_N cml_tlatch_87.xmux.xn.S1 VSS sg13_lv_nmos ad=63.19999f pd=0.74u as=63.19999f ps=0.74u w=0.26u l=0.38u
X930 cml_tlatch_8.xmux.xp.S1 cml_tlatch_8.OUTN cml_tlatch_8.OUTP VSS sg13_lv_nmos ad=56.9f pd=0.74u as=56.9f ps=0.74u w=0.17u l=0.17u
X931 VSS POLN cml_tlatch_19.xtail.S1 VSS sg13_lv_nmos ad=2.7982p pd=17.14u as=1.5637p ps=8.61u w=8.23u l=0.13u
X932 cml_tlatch_14.xtail.S1 CKB1_N cml_tlatch_14.xmux.xn.S1 VSS sg13_lv_nmos ad=89.3f pd=0.85u as=89.3f ps=0.85u w=0.47u l=0.16u
X933 VDD cml_tlatch_83.INN VSS rppd l=5.17u w=1u
X934 cml_tlatch_50.xtail.S1 CKHA2_P cml_tlatch_50.xmux.xn.S1 VSS sg13_lv_nmos ad=89.3f pd=0.85u as=89.3f ps=0.85u w=0.47u l=0.16u
X935 cml_tlatch_33.xmux.xp.S1 B1_2_P B1_2_N VSS sg13_lv_nmos ad=56.9f pd=0.74u as=56.9f ps=0.74u w=0.17u l=0.17u
X936 MOT9_N MOT9_P cml_tlatch_4.xmux.xp.S1 VSS sg13_lv_nmos ad=56.9f pd=0.74u as=56.9f ps=0.74u w=0.17u l=0.17u
X937 cml_tlatch_81.xmux.xp.S1 CKA2_P cml_tlatch_81.xtail.S1 VSS sg13_lv_nmos ad=89.3f pd=0.85u as=89.3f ps=0.85u w=0.47u l=0.16u
X938 cml_tlatch_98.xmux.xn.S1 CKB0_N cml_tlatch_98.xtail.S1 VSS sg13_lv_nmos ad=89.3f pd=0.85u as=89.3f ps=0.85u w=0.47u l=0.16u
X939 cml_tlatch_39.xmux.xp.S1 MOT10_N MOT10_P VSS sg13_lv_nmos ad=56.9f pd=0.74u as=56.9f ps=0.74u w=0.17u l=0.17u
X940 cml_tlatch_92.xtail.S1 CKJ_P cml_tlatch_92.xmux.xp.S1 VSS sg13_lv_nmos ad=89.3f pd=0.85u as=89.3f ps=0.85u w=0.47u l=0.16u
X941 MOT29_P MOT29_N cml_tlatch_70.xmux.xp.S1 VSS sg13_lv_nmos ad=56.9f pd=0.74u as=56.9f ps=0.74u w=0.17u l=0.17u
X942 interco_bi_19.INP interco_bi_19.INN cml_tlatch_0.xmux.xp.S1 VSS sg13_lv_nmos ad=56.9f pd=0.74u as=56.9f ps=0.74u w=0.17u l=0.17u
X943 cml_tlatch_45.OUTN cml_tlatch_45.OUTP cml_tlatch_45.xmux.xp.S1 VSS sg13_lv_nmos ad=56.9f pd=0.74u as=56.9f ps=0.74u w=0.17u l=0.17u
X944 A2_8_P A2_8_N cml_tlatch_81.xmux.xp.S1 VSS sg13_lv_nmos ad=56.9f pd=0.74u as=56.9f ps=0.74u w=0.17u l=0.17u
X945 MOT17_P MOT17_N cml_tlatch_73.xmux.xp.S1 VSS sg13_lv_nmos ad=56.9f pd=0.74u as=0.1019p ps=1.34u w=0.17u l=0.17u
X946 cml_tlatch_77.xmux.xp.S1 B2_8_N B2_8_P VSS sg13_lv_nmos ad=56.9f pd=0.74u as=56.9f ps=0.74u w=0.17u l=0.17u
X947 cml_tlatch_56.INP cml_tlatch_56.INN cml_tlatch_42.xmux.xp.S1 VSS sg13_lv_nmos ad=56.9f pd=0.74u as=0.1019p ps=1.34u w=0.17u l=0.17u
X948 cml_tlatch_67.xtail.S1 CKA3_N cml_tlatch_67.xmux.xp.S1 VSS sg13_lv_nmos ad=89.3f pd=0.85u as=89.3f ps=0.85u w=0.47u l=0.16u
X949 MOT14_P A1_2_N cml_tlatch_41.xmux.xn.S1 VSS sg13_lv_nmos ad=63.19999f pd=0.74u as=63.19999f ps=0.74u w=0.26u l=0.38u
X950 cml_tlatch_96.xtail.S1 POLN VSS VSS sg13_lv_nmos ad=1.5637p pd=8.61u as=2.7982p ps=17.14u w=8.23u l=0.13u
X951 cml_tlatch_45.xtail.S1 CKB3_N cml_tlatch_45.xmux.xp.S1 VSS sg13_lv_nmos ad=89.3f pd=0.85u as=0.1598p ps=1.62u w=0.47u l=0.16u
X952 VDD MOT2_N VSS rppd l=5.17u w=1u
X953 cml_tlatch_32.xmux.xp.S1 stub_bi_29.BOTN stub_bi_29.BOTP VSS sg13_lv_nmos ad=56.9f pd=0.74u as=56.9f ps=0.74u w=0.17u l=0.17u
X954 cml_tlatch_54.OUTN cml_tlatch_54.OUTP cml_tlatch_54.xmux.xp.S1 VSS sg13_lv_nmos ad=56.9f pd=0.74u as=56.9f ps=0.74u w=0.17u l=0.17u
X955 cml_tlatch_3.xmux.xp.S1 cml_tlatch_3.OUTN cml_tlatch_3.OUTP VSS sg13_lv_nmos ad=56.9f pd=0.74u as=56.9f ps=0.74u w=0.17u l=0.17u
X956 MOT14_P A1_2_N cml_tlatch_41.xmux.xn.S1 VSS sg13_lv_nmos ad=63.19999f pd=0.74u as=63.19999f ps=0.74u w=0.26u l=0.38u
X957 cml_tlatch_43.xmux.xn.S1 CKB2_P cml_tlatch_43.xtail.S1 VSS sg13_lv_nmos ad=89.3f pd=0.85u as=89.3f ps=0.85u w=0.47u l=0.16u
X958 stub_bi_19.BOTP stub_bi_19.BOTN cml_tlatch_15.xmux.xp.S1 VSS sg13_lv_nmos ad=56.9f pd=0.74u as=0.1019p ps=1.34u w=0.17u l=0.17u
X959 cml_tlatch_82.xmux.xn.S1 CKA2_P cml_tlatch_82.xtail.S1 VSS sg13_lv_nmos ad=89.3f pd=0.85u as=0.1598p ps=1.62u w=0.47u l=0.16u
X960 cml_tlatch_28.xmux.xp.S1 B0_2_P B0_2_N VSS sg13_lv_nmos ad=56.9f pd=0.74u as=56.9f ps=0.74u w=0.17u l=0.17u
X961 cml_tlatch_23.xmux.xp.S1 CKA1_P cml_tlatch_23.xtail.S1 VSS sg13_lv_nmos ad=89.3f pd=0.85u as=89.3f ps=0.85u w=0.47u l=0.16u
X962 cml_tlatch_57.xmux.xp.S1 MOT26_P MOT26_N VSS sg13_lv_nmos ad=56.9f pd=0.74u as=56.9f ps=0.74u w=0.17u l=0.17u
X963 cml_tlatch_51.xmux.xn.S1 A2_2_P MOT22_N VSS sg13_lv_nmos ad=63.19999f pd=0.74u as=63.19999f ps=0.74u w=0.26u l=0.38u
X964 cml_tlatch_99.OUTN cml_tlatch_99.OUTP cml_tlatch_99.xmux.xp.S1 VSS sg13_lv_nmos ad=56.9f pd=0.74u as=56.9f ps=0.74u w=0.17u l=0.17u
X965 cml_tlatch_40.INP cml_tlatch_40.INN cml_tlatch_95.xmux.xp.S1 VSS sg13_lv_nmos ad=56.9f pd=0.74u as=56.9f ps=0.74u w=0.17u l=0.17u
X966 cml_tlatch_65.xmux.xp.S1 cml_tlatch_65.OUTP cml_tlatch_65.OUTN VSS sg13_lv_nmos ad=56.9f pd=0.74u as=56.9f ps=0.74u w=0.17u l=0.17u
X967 cml_tlatch_30.OUTP cml_tlatch_30.OUTN cml_tlatch_30.xmux.xp.S1 VSS sg13_lv_nmos ad=56.9f pd=0.74u as=56.9f ps=0.74u w=0.17u l=0.17u
X968 cml_tlatch_9.xmux.xn.S1 CKA0_P cml_tlatch_9.xtail.S1 VSS sg13_lv_nmos ad=0.1598p pd=1.62u as=89.3f ps=0.85u w=0.47u l=0.16u
X969 B2_2_N stub_bi_32.BOTN cml_tlatch_44.xmux.xn.S1 VSS sg13_lv_nmos ad=63.19999f pd=0.74u as=63.19999f ps=0.74u w=0.26u l=0.38u
X970 MOT10_N MOT10_P cml_tlatch_39.xmux.xp.S1 VSS sg13_lv_nmos ad=56.9f pd=0.74u as=56.9f ps=0.74u w=0.17u l=0.17u
X971 A1_8_N A1_8_P cml_tlatch_21.xmux.xp.S1 VSS sg13_lv_nmos ad=56.9f pd=0.74u as=56.9f ps=0.74u w=0.17u l=0.17u
X972 cml_tlatch_76.xmux.xp.S1 CKHB2_N cml_tlatch_76.xtail.S1 VSS sg13_lv_nmos ad=89.3f pd=0.85u as=89.3f ps=0.85u w=0.47u l=0.16u
X973 cml_tlatch_40.xtail.S1 CKHA1_P cml_tlatch_40.xmux.xn.S1 VSS sg13_lv_nmos ad=89.3f pd=0.85u as=89.3f ps=0.85u w=0.47u l=0.16u
X974 VSS POLN cml_tlatch_60.xtail.S1 VSS sg13_lv_nmos ad=2.7982p pd=17.14u as=1.5637p ps=8.61u w=8.23u l=0.13u
X975 cml_tlatch_55.xtail.S1 CKA2_N cml_tlatch_55.xmux.xp.S1 VSS sg13_lv_nmos ad=89.3f pd=0.85u as=89.3f ps=0.85u w=0.47u l=0.16u
X976 cml_tlatch_14.xmux.xp.S1 CKB1_P cml_tlatch_14.xtail.S1 VSS sg13_lv_nmos ad=89.3f pd=0.85u as=89.3f ps=0.85u w=0.47u l=0.16u
X977 MOT19_P stub_bi_63.BOTP cml_tlatch_74.xmux.xn.S1 VSS sg13_lv_nmos ad=0.1082p pd=1.34u as=63.19999f ps=0.74u w=0.26u l=0.38u
X978 cml_tlatch_38.xmux.xp.S1 cml_tlatch_38.OUTP cml_tlatch_38.OUTN VSS sg13_lv_nmos ad=0.1019p pd=1.34u as=56.9f ps=0.74u w=0.17u l=0.17u
X979 MOT17_P MOT17_N cml_tlatch_73.xmux.xp.S1 VSS sg13_lv_nmos ad=56.9f pd=0.74u as=56.9f ps=0.74u w=0.17u l=0.17u
X980 cml_tlatch_56.INP cml_tlatch_56.INN cml_tlatch_42.xmux.xp.S1 VSS sg13_lv_nmos ad=56.9f pd=0.74u as=56.9f ps=0.74u w=0.17u l=0.17u
X981 VSS POLN cml_tlatch_90.xtail.S1 VSS sg13_lv_nmos ad=2.7982p pd=17.14u as=1.5637p ps=8.61u w=8.23u l=0.13u
X982 J1_N J1_P cml_tlatch_93.xmux.xp.S1 VSS sg13_lv_nmos ad=56.9f pd=0.74u as=56.9f ps=0.74u w=0.17u l=0.17u
X983 cml_tlatch_5.xtail.S1 CKHB1_N cml_tlatch_5.xmux.xp.S1 VSS sg13_lv_nmos ad=89.3f pd=0.85u as=89.3f ps=0.85u w=0.47u l=0.16u
X984 cml_tlatch_45.xmux.xn.S1 B3_2_P cml_tlatch_45.OUTN VSS sg13_lv_nmos ad=0.1082p pd=1.34u as=63.19999f ps=0.74u w=0.26u l=0.38u
X985 cml_tlatch_1.OUTP cml_tlatch_1.OUTN cml_tlatch_1.xmux.xp.S1 VSS sg13_lv_nmos ad=56.9f pd=0.74u as=56.9f ps=0.74u w=0.17u l=0.17u
X986 cml_tlatch_95.INP cml_tlatch_95.INN cml_tlatch_36.xmux.xp.S1 VSS sg13_lv_nmos ad=56.9f pd=0.74u as=56.9f ps=0.74u w=0.17u l=0.17u
X987 CKA3_N CK_N hs_to_clk_7.D2 VSS sg13_lv_nmos ad=0.228p pd=1.58u as=0.408p ps=3.08u w=1.2u l=0.2u
X988 cml_tlatch_71.xmux.xp.S1 CKHB3_N cml_tlatch_71.xtail.S1 VSS sg13_lv_nmos ad=89.3f pd=0.85u as=89.3f ps=0.85u w=0.47u l=0.16u
X989 cml_tlatch_25.xtail.S1 CKHA0_N cml_tlatch_25.xmux.xp.S1 VSS sg13_lv_nmos ad=89.3f pd=0.85u as=89.3f ps=0.85u w=0.47u l=0.16u
X990 cml_tlatch_16.OUTP cml_tlatch_1.OUTN cml_tlatch_16.xmux.xn.S1 VSS sg13_lv_nmos ad=63.19999f pd=0.74u as=63.19999f ps=0.74u w=0.26u l=0.38u
X991 cml_tlatch_22.OUTN cml_tlatch_22.OUTP cml_tlatch_22.xmux.xp.S1 VSS sg13_lv_nmos ad=56.9f pd=0.74u as=56.9f ps=0.74u w=0.17u l=0.17u
X992 stub_bi_19.BOTP stub_bi_19.BOTN cml_tlatch_15.xmux.xp.S1 VSS sg13_lv_nmos ad=56.9f pd=0.74u as=56.9f ps=0.74u w=0.17u l=0.17u
X993 cml_tlatch_45.xmux.xn.S1 B3_2_P cml_tlatch_45.OUTN VSS sg13_lv_nmos ad=63.19999f pd=0.74u as=63.19999f ps=0.74u w=0.26u l=0.38u
X994 cml_tlatch_67.xmux.xp.S1 cml_tlatch_67.OUTN cml_tlatch_67.OUTP VSS sg13_lv_nmos ad=56.9f pd=0.74u as=56.9f ps=0.74u w=0.17u l=0.17u
X995 cml_tlatch_36.xmux.xn.S1 A1_2_P cml_tlatch_95.INN VSS sg13_lv_nmos ad=63.19999f pd=0.74u as=63.19999f ps=0.74u w=0.26u l=0.38u
X996 A2_2_N A2_2_P cml_tlatch_56.xmux.xp.S1 VSS sg13_lv_nmos ad=56.9f pd=0.74u as=56.9f ps=0.74u w=0.17u l=0.17u
X997 cml_tlatch_29.xmux.xn.S1 D0_P cml_tlatch_29.OUTN VSS sg13_lv_nmos ad=63.19999f pd=0.74u as=0.1082p ps=1.34u w=0.26u l=0.38u
X998 cml_tlatch_82.OUTN cml_tlatch_83.OUTP cml_tlatch_82.xmux.xn.S1 VSS sg13_lv_nmos ad=63.19999f pd=0.74u as=0.1082p ps=1.34u w=0.26u l=0.38u
X999 GB3_P VDD VSS rppd l=7.42u w=1u
X1000 cml_tlatch_51.xmux.xp.S1 CKHA2_N cml_tlatch_51.xtail.S1 VSS sg13_lv_nmos ad=89.3f pd=0.85u as=0.1598p ps=1.62u w=0.47u l=0.16u
X1001 GB0_P ENB1_N cml_gate2_1.sg13_lv_nmos_FTPY57_0.D0 VSS sg13_lv_nmos ad=0.1007p pd=0.91u as=0.1007p ps=0.91u w=0.53u l=0.13u
X1002 cml_tlatch_98.OUTP cml_tlatch_98.OUTN cml_tlatch_98.xmux.xp.S1 VSS sg13_lv_nmos ad=56.9f pd=0.74u as=56.9f ps=0.74u w=0.17u l=0.17u
X1003 cml_tlatch_15.xmux.xp.S1 stub_bi_19.BOTP stub_bi_19.BOTN VSS sg13_lv_nmos ad=56.9f pd=0.74u as=56.9f ps=0.74u w=0.17u l=0.17u
X1004 VSS POLN cml_tlatch_66.xtail.S1 VSS sg13_lv_nmos ad=2.7982p pd=17.14u as=1.5637p ps=8.61u w=8.23u l=0.13u
X1005 cml_tlatch_37.xtail.S1 CKA1_P cml_tlatch_37.xmux.xp.S1 VSS sg13_lv_nmos ad=89.3f pd=0.85u as=89.3f ps=0.85u w=0.47u l=0.16u
X1006 cml_tlatch_61.OUTP VDD VSS rppd l=5.17u w=1u
X1007 cml_tlatch_39.xtail.S1 CKHA1_N cml_tlatch_39.xmux.xp.S1 VSS sg13_lv_nmos ad=89.3f pd=0.85u as=89.3f ps=0.85u w=0.47u l=0.16u
X1008 cml_tlatch_85.xmux.xp.S1 cml_tlatch_58.INN cml_tlatch_58.INP VSS sg13_lv_nmos ad=56.9f pd=0.74u as=56.9f ps=0.74u w=0.17u l=0.17u
X1009 cml_tlatch_65.xtail.S1 CKA3_P cml_tlatch_65.xmux.xn.S1 VSS sg13_lv_nmos ad=89.3f pd=0.85u as=89.3f ps=0.85u w=0.47u l=0.16u
X1010 cml_tlatch_63.OUTN cml_tlatch_63.OUTP cml_tlatch_63.xmux.xp.S1 VSS sg13_lv_nmos ad=56.9f pd=0.74u as=56.9f ps=0.74u w=0.17u l=0.17u
X1011 cml_tlatch_51.xmux.xp.S1 MOT22_P MOT22_N VSS sg13_lv_nmos ad=56.9f pd=0.74u as=56.9f ps=0.74u w=0.17u l=0.17u
X1012 cml_tlatch_79.xtail.S1 POLN VSS VSS sg13_lv_nmos ad=1.5637p pd=8.61u as=2.7982p ps=17.14u w=8.23u l=0.13u
X1013 cml_tlatch_59.xmux.xp.S1 CKHA3_N cml_tlatch_59.xtail.S1 VSS sg13_lv_nmos ad=89.3f pd=0.85u as=89.3f ps=0.85u w=0.47u l=0.16u
X1014 A0_8_N A0_8_P cml_tlatch_2.xmux.xp.S1 VSS sg13_lv_nmos ad=56.9f pd=0.74u as=56.9f ps=0.74u w=0.17u l=0.17u
X1015 VSS POLN cml_tlatch_18.xtail.S1 VSS sg13_lv_nmos ad=2.7982p pd=17.14u as=1.5637p ps=8.61u w=8.23u l=0.13u
X1016 VSS POLN cml_tlatch_74.xtail.S1 VSS sg13_lv_nmos ad=1.5637p pd=8.61u as=1.5637p ps=8.61u w=8.23u l=0.13u
X1017 cml_tlatch_77.xmux.xp.S1 B2_8_N B2_8_P VSS sg13_lv_nmos ad=56.9f pd=0.74u as=56.9f ps=0.74u w=0.17u l=0.17u
X1018 cml_tlatch_74.xtail.S1 CKHB2_N cml_tlatch_74.xmux.xp.S1 VSS sg13_lv_nmos ad=89.3f pd=0.85u as=89.3f ps=0.85u w=0.47u l=0.16u
X1019 cml_tlatch_35.xtail.S1 CKA0_P cml_tlatch_35.xmux.xn.S1 VSS sg13_lv_nmos ad=89.3f pd=0.85u as=89.3f ps=0.85u w=0.47u l=0.16u
X1020 cml_tlatch_33.xtail.S1 CKB1_P cml_tlatch_33.xmux.xp.S1 VSS sg13_lv_nmos ad=89.3f pd=0.85u as=89.3f ps=0.85u w=0.47u l=0.16u
X1021 cml_tlatch_56.xtail.S1 CKA2_P cml_tlatch_56.xmux.xp.S1 VSS sg13_lv_nmos ad=89.3f pd=0.85u as=89.3f ps=0.85u w=0.47u l=0.16u
X1022 cml_tlatch_99.xmux.xn.S1 CKA0_N cml_tlatch_99.xtail.S1 VSS sg13_lv_nmos ad=89.3f pd=0.85u as=0.1598p ps=1.62u w=0.47u l=0.16u
X1023 cml_tlatch_3.OUTN cml_tlatch_3.OUTP cml_tlatch_3.xmux.xp.S1 VSS sg13_lv_nmos ad=56.9f pd=0.74u as=56.9f ps=0.74u w=0.17u l=0.17u
X1024 GB2_N ENB0_P cml_gate2_7.sg13_lv_nmos_FTPY57_0.D0 VSS sg13_lv_nmos ad=0.1007p pd=0.91u as=0.1007p ps=0.91u w=0.53u l=0.13u
X1025 cml_tlatch_4.xmux.xn.S1 CKHB1_P cml_tlatch_4.xtail.S1 VSS sg13_lv_nmos ad=89.3f pd=0.85u as=89.3f ps=0.85u w=0.47u l=0.16u
X1026 cml_tlatch_21.xtail.S1 CKA1_N cml_tlatch_21.xmux.xn.S1 VSS sg13_lv_nmos ad=89.3f pd=0.85u as=89.3f ps=0.85u w=0.47u l=0.16u
X1027 cml_tlatch_42.xmux.xp.S1 CKA2_N cml_tlatch_42.xtail.S1 VSS sg13_lv_nmos ad=89.3f pd=0.85u as=89.3f ps=0.85u w=0.47u l=0.16u
X1028 cml_tlatch_19.xmux.xp.S1 MOT5_P MOT5_N VSS sg13_lv_nmos ad=56.9f pd=0.74u as=56.9f ps=0.74u w=0.17u l=0.17u
X1029 cml_tlatch_22.xmux.xp.S1 cml_tlatch_22.OUTN cml_tlatch_22.OUTP VSS sg13_lv_nmos ad=56.9f pd=0.74u as=56.9f ps=0.74u w=0.17u l=0.17u
X1030 stub_bi_55.BOTN VDD VSS rppd l=5.17u w=1u
X1031 cml_tlatch_66.xmux.xp.S1 cml_tlatch_57.INN cml_tlatch_57.INP VSS sg13_lv_nmos ad=56.9f pd=0.74u as=56.9f ps=0.74u w=0.17u l=0.17u
X1032 cml_tlatch_66.xmux.xp.S1 cml_tlatch_57.INP cml_tlatch_57.INN VSS sg13_lv_nmos ad=56.9f pd=0.74u as=56.9f ps=0.74u w=0.17u l=0.17u
X1033 J1_N J1_P cml_tlatch_93.xmux.xp.S1 VSS sg13_lv_nmos ad=56.9f pd=0.74u as=56.9f ps=0.74u w=0.17u l=0.17u
X1034 GB3_P CKA3_N cml_gate2_6.xrtail.R1 VSS sg13_lv_nmos ad=0.1007p pd=0.91u as=0.1007p ps=0.91u w=0.53u l=0.13u
X1035 cml_gate2_9.sg13_lv_nmos_FTPY57_0.D0 J1_N ENA_P VSS sg13_lv_nmos ad=0.1802p pd=1.74u as=0.1007p ps=0.91u w=0.53u l=0.13u
X1036 cml_tlatch_69.INP cml_tlatch_69.INN cml_tlatch_62.xmux.xp.S1 VSS sg13_lv_nmos ad=56.9f pd=0.74u as=56.9f ps=0.74u w=0.17u l=0.17u
X1037 MOT20_N MOT20_P cml_tlatch_50.xmux.xp.S1 VSS sg13_lv_nmos ad=56.9f pd=0.74u as=56.9f ps=0.74u w=0.17u l=0.17u
X1038 cml_tlatch_50.xmux.xn.S1 CKHA2_P cml_tlatch_50.xtail.S1 VSS sg13_lv_nmos ad=89.3f pd=0.85u as=89.3f ps=0.85u w=0.47u l=0.16u
X1039 hs_to_clk_3.sg13_lv_nmos_2HGZLP_0.G CKA1_P VSS rppd l=4.25u w=1u
X1040 cml_tlatch_99.xtail.S1 POLN VSS VSS sg13_lv_nmos ad=1.5637p pd=8.61u as=2.7982p ps=17.14u w=8.23u l=0.13u
X1041 cml_tlatch_99.xmux.xn.S1 cml_tlatch_30.OUTN cml_tlatch_99.OUTP VSS sg13_lv_nmos ad=63.19999f pd=0.74u as=63.19999f ps=0.74u w=0.26u l=0.38u
X1042 cml_tlatch_75.xmux.xp.S1 CKHB2_N cml_tlatch_75.xtail.S1 VSS sg13_lv_nmos ad=0.1598p pd=1.62u as=89.3f ps=0.85u w=0.47u l=0.16u
X1043 cml_tlatch_43.xmux.xp.S1 stub_bi_42.BOTN stub_bi_42.BOTP VSS sg13_lv_nmos ad=56.9f pd=0.74u as=56.9f ps=0.74u w=0.17u l=0.17u
X1044 cml_tlatch_2.xmux.xp.S1 CKA0_P cml_tlatch_2.xtail.S1 VSS sg13_lv_nmos ad=89.3f pd=0.85u as=89.3f ps=0.85u w=0.47u l=0.16u
X1045 ENA1_P VDD VSS rppd l=8.13u w=1u
X1046 cml_tlatch_18.xmux.xp.S1 MOT3_N MOT3_P VSS sg13_lv_nmos ad=56.9f pd=0.74u as=56.9f ps=0.74u w=0.17u l=0.17u
X1047 cml_gate2_3.xrtail.R1 CKB1_P cml_gate2_3.sg13_lv_nmos_FTPY57_0.D0 VSS sg13_lv_nmos ad=0.1802p pd=1.74u as=0.1007p ps=0.91u w=0.53u l=0.13u
X1048 B3_8_N B3_8_P cml_tlatch_60.xmux.xp.S1 VSS sg13_lv_nmos ad=56.9f pd=0.74u as=56.9f ps=0.74u w=0.17u l=0.17u
X1049 MOT6_P MOT6_N cml_tlatch_26.xmux.xp.S1 VSS sg13_lv_nmos ad=56.9f pd=0.74u as=56.9f ps=0.74u w=0.17u l=0.17u
X1050 cml_tlatch_62.xmux.xn.S1 cml_tlatch_63.OUTP cml_tlatch_69.INN VSS sg13_lv_nmos ad=63.19999f pd=0.74u as=0.1082p ps=1.34u w=0.26u l=0.38u
X1051 cml_tlatch_58.xmux.xn.S1 CKHA3_P cml_tlatch_58.xtail.S1 VSS sg13_lv_nmos ad=89.3f pd=0.85u as=89.3f ps=0.85u w=0.47u l=0.16u
X1052 cml_tlatch_75.xmux.xp.S1 MOT21_P MOT21_N VSS sg13_lv_nmos ad=56.9f pd=0.74u as=56.9f ps=0.74u w=0.17u l=0.17u
X1053 cml_tlatch_43.xtail.S1 CKB2_P cml_tlatch_43.xmux.xn.S1 VSS sg13_lv_nmos ad=89.3f pd=0.85u as=89.3f ps=0.85u w=0.47u l=0.16u
X1054 cml_tlatch_5.xtail.S1 CKHB1_P cml_tlatch_5.xmux.xn.S1 VSS sg13_lv_nmos ad=0.1598p pd=1.62u as=89.3f ps=0.85u w=0.47u l=0.16u
X1055 cml_tlatch_59.xmux.xp.S1 MOT30_P MOT30_N VSS sg13_lv_nmos ad=56.9f pd=0.74u as=56.9f ps=0.74u w=0.17u l=0.17u
X1056 cml_tlatch_1.xmux.xp.S1 cml_tlatch_1.OUTP cml_tlatch_1.OUTN VSS sg13_lv_nmos ad=56.9f pd=0.74u as=56.9f ps=0.74u w=0.17u l=0.17u
X1057 cml_tlatch_93.xmux.xp.S1 J1_N J1_P VSS sg13_lv_nmos ad=56.9f pd=0.74u as=56.9f ps=0.74u w=0.17u l=0.17u
X1058 MOT29_P cml_tlatch_70.INN cml_tlatch_70.xmux.xn.S1 VSS sg13_lv_nmos ad=63.19999f pd=0.74u as=63.19999f ps=0.74u w=0.26u l=0.38u
X1059 hs_to_clk_2.D2 CK_N CKB1_P VSS sg13_lv_nmos ad=0.228p pd=1.58u as=0.408p ps=3.08u w=1.2u l=0.2u
X1060 A2_2_N A2_2_P cml_tlatch_56.xmux.xp.S1 VSS sg13_lv_nmos ad=56.9f pd=0.74u as=56.9f ps=0.74u w=0.17u l=0.17u
X1061 cml_tlatch_35.xtail.S1 CKA0_N cml_tlatch_35.xmux.xp.S1 VSS sg13_lv_nmos ad=89.3f pd=0.85u as=89.3f ps=0.85u w=0.47u l=0.16u
X1062 MOT9_N B1_8_P cml_tlatch_4.xmux.xn.S1 VSS sg13_lv_nmos ad=63.19999f pd=0.74u as=63.19999f ps=0.74u w=0.26u l=0.38u
X1063 cml_tlatch_6.INP cml_tlatch_6.INN cml_tlatch_94.xmux.xp.S1 VSS sg13_lv_nmos ad=56.9f pd=0.74u as=56.9f ps=0.74u w=0.17u l=0.17u
X1064 cml_tlatch_90.xmux.xp.S1 J4_N J4_P VSS sg13_lv_nmos ad=56.9f pd=0.74u as=56.9f ps=0.74u w=0.17u l=0.17u
X1065 cml_tlatch_44.xmux.xp.S1 B2_2_P B2_2_N VSS sg13_lv_nmos ad=56.9f pd=0.74u as=56.9f ps=0.74u w=0.17u l=0.17u
X1066 stub_bi_55.BOTN stub_bi_42.BOTP cml_tlatch_88.xmux.xn.S1 VSS sg13_lv_nmos ad=63.19999f pd=0.74u as=63.19999f ps=0.74u w=0.26u l=0.38u
X1067 cml_tlatch_50.xmux.xn.S1 cml_tlatch_89.OUTN MOT20_P VSS sg13_lv_nmos ad=63.19999f pd=0.74u as=63.19999f ps=0.74u w=0.26u l=0.38u
X1068 cml_tlatch_63.xmux.xn.S1 CKB3_P cml_tlatch_63.xtail.S1 VSS sg13_lv_nmos ad=89.3f pd=0.85u as=89.3f ps=0.85u w=0.47u l=0.16u
X1069 cml_tlatch_45.OUTP cml_tlatch_45.OUTN cml_tlatch_45.xmux.xp.S1 VSS sg13_lv_nmos ad=56.9f pd=0.74u as=56.9f ps=0.74u w=0.17u l=0.17u
X1070 MOT0_P MOT0_N cml_tlatch_97.xmux.xp.S1 VSS sg13_lv_nmos ad=56.9f pd=0.74u as=56.9f ps=0.74u w=0.17u l=0.17u
X1071 cml_tlatch_75.xmux.xp.S1 MOT21_N MOT21_P VSS sg13_lv_nmos ad=56.9f pd=0.74u as=56.9f ps=0.74u w=0.17u l=0.17u
X1072 VSS POLN cml_tlatch_76.xtail.S1 VSS sg13_lv_nmos ad=2.7982p pd=17.14u as=1.5637p ps=8.61u w=8.23u l=0.13u
X1073 cml_tlatch_99.xtail.S1 CKA0_P cml_tlatch_99.xmux.xp.S1 VSS sg13_lv_nmos ad=89.3f pd=0.85u as=89.3f ps=0.85u w=0.47u l=0.16u
X1074 A3_8_P A3_8_N cml_tlatch_64.xmux.xp.S1 VSS sg13_lv_nmos ad=56.9f pd=0.74u as=56.9f ps=0.74u w=0.17u l=0.17u
X1075 VSS POLN cml_tlatch_14.xtail.S1 VSS sg13_lv_nmos ad=1.5637p pd=8.61u as=1.5637p ps=8.61u w=8.23u l=0.13u
X1076 cml_tlatch_63.xtail.S1 POLN VSS VSS sg13_lv_nmos ad=1.5637p pd=8.61u as=2.7982p ps=17.14u w=8.23u l=0.13u
X1077 cml_tlatch_21.xtail.S1 CKA1_N cml_tlatch_21.xmux.xn.S1 VSS sg13_lv_nmos ad=89.3f pd=0.85u as=89.3f ps=0.85u w=0.47u l=0.16u
X1078 cml_tlatch_12.xmux.xp.S1 B1_8_P B1_8_N VSS sg13_lv_nmos ad=0.1019p pd=1.34u as=56.9f ps=0.74u w=0.17u l=0.17u
X1079 cml_tlatch_35.xmux.xp.S1 cml_tlatch_35.OUTP cml_tlatch_35.OUTN VSS sg13_lv_nmos ad=56.9f pd=0.74u as=56.9f ps=0.74u w=0.17u l=0.17u
X1080 cml_tlatch_37.xtail.S1 CKA1_N cml_tlatch_37.xmux.xn.S1 VSS sg13_lv_nmos ad=89.3f pd=0.85u as=89.3f ps=0.85u w=0.47u l=0.16u
X1081 cml_tlatch_72.xmux.xp.S1 cml_tlatch_83.INP cml_tlatch_83.INN VSS sg13_lv_nmos ad=56.9f pd=0.74u as=56.9f ps=0.74u w=0.17u l=0.17u
X1082 cml_tlatch_17.xtail.S1 CKHB0_N cml_tlatch_17.xmux.xp.S1 VSS sg13_lv_nmos ad=89.3f pd=0.85u as=89.3f ps=0.85u w=0.47u l=0.16u
X1083 cml_tlatch_11.xmux.xp.S1 cml_tlatch_11.OUTP cml_tlatch_11.OUTN VSS sg13_lv_nmos ad=56.9f pd=0.74u as=56.9f ps=0.74u w=0.17u l=0.17u
X1084 GA0_N ENA0_P cml_gate2_2.sg13_lv_nmos_FTPY57_0.D0 VSS sg13_lv_nmos ad=0.1007p pd=0.91u as=0.1007p ps=0.91u w=0.53u l=0.13u
X1085 cml_tlatch_38.xmux.xp.S1 cml_tlatch_38.OUTN cml_tlatch_38.OUTP VSS sg13_lv_nmos ad=56.9f pd=0.74u as=56.9f ps=0.74u w=0.17u l=0.17u
X1086 A0_8_N A0_8_P cml_tlatch_2.xmux.xp.S1 VSS sg13_lv_nmos ad=56.9f pd=0.74u as=56.9f ps=0.74u w=0.17u l=0.17u
X1087 CKB0_N hs_to_clk_1.sg13_lv_nmos_2HGZLP_0.G VSS rppd l=4.25u w=1u
X1088 cml_tlatch_98.xmux.xn.S1 CKB0_N cml_tlatch_98.xtail.S1 VSS sg13_lv_nmos ad=89.3f pd=0.85u as=89.3f ps=0.85u w=0.47u l=0.16u
X1089 cml_tlatch_28.xtail.S1 CKB0_P cml_tlatch_28.xmux.xp.S1 VSS sg13_lv_nmos ad=89.3f pd=0.85u as=89.3f ps=0.85u w=0.47u l=0.16u
X1090 cml_tlatch_73.xmux.xp.S1 MOT17_P MOT17_N VSS sg13_lv_nmos ad=56.9f pd=0.74u as=56.9f ps=0.74u w=0.17u l=0.17u
X1091 cml_tlatch_5.INP cml_tlatch_5.INN cml_tlatch_14.xmux.xp.S1 VSS sg13_lv_nmos ad=56.9f pd=0.74u as=56.9f ps=0.74u w=0.17u l=0.17u
X1092 cml_tlatch_39.xmux.xn.S1 CKHA1_P cml_tlatch_39.xtail.S1 VSS sg13_lv_nmos ad=89.3f pd=0.85u as=89.3f ps=0.85u w=0.47u l=0.16u
X1093 cml_tlatch_67.xtail.S1 CKA3_N cml_tlatch_67.xmux.xp.S1 VSS sg13_lv_nmos ad=89.3f pd=0.85u as=89.3f ps=0.85u w=0.47u l=0.16u
X1094 cml_tlatch_32.xmux.xp.S1 stub_bi_29.BOTP stub_bi_29.BOTN VSS sg13_lv_nmos ad=0.1019p pd=1.34u as=56.9f ps=0.74u w=0.17u l=0.17u
X1095 A0_2_P A0_2_N cml_tlatch_31.xmux.xp.S1 VSS sg13_lv_nmos ad=56.9f pd=0.74u as=56.9f ps=0.74u w=0.17u l=0.17u
X1096 MOT5_P MOT5_N cml_tlatch_19.xmux.xp.S1 VSS sg13_lv_nmos ad=56.9f pd=0.74u as=56.9f ps=0.74u w=0.17u l=0.17u
X1097 cml_tlatch_65.OUTP cml_tlatch_65.OUTN cml_tlatch_65.xmux.xp.S1 VSS sg13_lv_nmos ad=56.9f pd=0.74u as=56.9f ps=0.74u w=0.17u l=0.17u
X1098 cml_tlatch_97.xmux.xp.S1 MOT0_P MOT0_N VSS sg13_lv_nmos ad=56.9f pd=0.74u as=56.9f ps=0.74u w=0.17u l=0.17u
X1099 cml_tlatch_4.xmux.xp.S1 MOT9_P MOT9_N VSS sg13_lv_nmos ad=56.9f pd=0.74u as=56.9f ps=0.74u w=0.17u l=0.17u
X1100 VDD cml_tlatch_8.OUTN VSS rppd l=5.17u w=1u
X1101 cml_tlatch_41.xmux.xn.S1 CKHA1_P cml_tlatch_41.xtail.S1 VSS sg13_lv_nmos ad=89.3f pd=0.85u as=89.3f ps=0.85u w=0.47u l=0.16u
X1102 cml_tlatch_56.INN D2_P cml_tlatch_42.xmux.xn.S1 VSS sg13_lv_nmos ad=63.19999f pd=0.74u as=0.1082p ps=1.34u w=0.26u l=0.38u
X1103 cml_tlatch_52.OUTN cml_tlatch_52.OUTP cml_tlatch_52.xmux.xp.S1 VSS sg13_lv_nmos ad=56.9f pd=0.74u as=56.9f ps=0.74u w=0.17u l=0.17u
X1104 cml_tlatch_57.xmux.xn.S1 cml_tlatch_57.INN MOT26_P VSS sg13_lv_nmos ad=63.19999f pd=0.74u as=0.1082p ps=1.34u w=0.26u l=0.38u
X1105 stub_bi_17.BOTN stub_bi_17.BOTP cml_tlatch_13.xmux.xp.S1 VSS sg13_lv_nmos ad=56.9f pd=0.74u as=56.9f ps=0.74u w=0.17u l=0.17u
X1106 cml_tlatch_63.xtail.S1 CKB3_N cml_tlatch_63.xmux.xp.S1 VSS sg13_lv_nmos ad=0.1598p pd=1.62u as=89.3f ps=0.85u w=0.47u l=0.16u
X1107 cml_tlatch_58.INN cml_tlatch_52.OUTP cml_tlatch_85.xmux.xn.S1 VSS sg13_lv_nmos ad=63.19999f pd=0.74u as=63.19999f ps=0.74u w=0.26u l=0.38u
X1108 MOT26_N cml_tlatch_57.INP cml_tlatch_57.xmux.xn.S1 VSS sg13_lv_nmos ad=63.19999f pd=0.74u as=63.19999f ps=0.74u w=0.26u l=0.38u
X1109 cml_tlatch_58.xmux.xp.S1 MOT28_P MOT28_N VSS sg13_lv_nmos ad=56.9f pd=0.74u as=56.9f ps=0.74u w=0.17u l=0.17u
X1110 cml_tlatch_28.xmux.xn.S1 cml_tlatch_29.OUTP B0_2_N VSS sg13_lv_nmos ad=0.1082p pd=1.34u as=63.19999f ps=0.74u w=0.26u l=0.38u
X1111 cml_tlatch_24.xmux.xp.S1 MOT2_N MOT2_P VSS sg13_lv_nmos ad=56.9f pd=0.74u as=56.9f ps=0.74u w=0.17u l=0.17u
X1112 cml_tlatch_34.xmux.xn.S1 D1_N stub_bi_31.BOTN VSS sg13_lv_nmos ad=0.1082p pd=1.34u as=63.19999f ps=0.74u w=0.26u l=0.38u
X1113 cml_tlatch_20.xtail.S1 POLN VSS VSS sg13_lv_nmos ad=1.5637p pd=8.61u as=2.7982p ps=17.14u w=8.23u l=0.13u
X1114 cml_gate2_9.xrtail.R1 NM1_N ENA_P VSS sg13_lv_nmos ad=0.1802p pd=1.74u as=0.1007p ps=0.91u w=0.53u l=0.13u
X1115 cml_tlatch_55.xtail.S1 CKA2_N cml_tlatch_55.xmux.xp.S1 VSS sg13_lv_nmos ad=89.3f pd=0.85u as=89.3f ps=0.85u w=0.47u l=0.16u
X1116 MOT12_N MOT12_P cml_tlatch_40.xmux.xp.S1 VSS sg13_lv_nmos ad=56.9f pd=0.74u as=56.9f ps=0.74u w=0.17u l=0.17u
X1117 cml_tlatch_18.xmux.xp.S1 MOT3_N MOT3_P VSS sg13_lv_nmos ad=0.1019p pd=1.34u as=56.9f ps=0.74u w=0.17u l=0.17u
X1118 cml_gate2_5.sg13_lv_nmos_FTPY57_0.D0 CKB3_P cml_gate2_5.xrtail.R1 VSS sg13_lv_nmos ad=0.1007p pd=0.91u as=0.1802p ps=1.74u w=0.53u l=0.13u
X1119 cml_tlatch_74.xmux.xn.S1 CKHB2_P cml_tlatch_74.xtail.S1 VSS sg13_lv_nmos ad=89.3f pd=0.85u as=89.3f ps=0.85u w=0.47u l=0.16u
X1120 cml_tlatch_37.xtail.S1 CKA1_N cml_tlatch_37.xmux.xn.S1 VSS sg13_lv_nmos ad=89.3f pd=0.85u as=89.3f ps=0.85u w=0.47u l=0.16u
X1121 cml_tlatch_83.INP cml_tlatch_83.INN cml_tlatch_72.xmux.xp.S1 VSS sg13_lv_nmos ad=56.9f pd=0.74u as=56.9f ps=0.74u w=0.17u l=0.17u
X1122 MOT29_N MOT29_P cml_tlatch_70.xmux.xp.S1 VSS sg13_lv_nmos ad=56.9f pd=0.74u as=56.9f ps=0.74u w=0.17u l=0.17u
X1123 cml_tlatch_76.xmux.xn.S1 B2_2_N MOT23_P VSS sg13_lv_nmos ad=63.19999f pd=0.74u as=63.19999f ps=0.74u w=0.26u l=0.38u
X1124 VSS POLN cml_tlatch_73.xtail.S1 VSS sg13_lv_nmos ad=2.7982p pd=17.14u as=1.5637p ps=8.61u w=8.23u l=0.13u
X1125 cml_tlatch_99.xmux.xn.S1 cml_tlatch_30.OUTP cml_tlatch_99.OUTN VSS sg13_lv_nmos ad=63.19999f pd=0.74u as=63.19999f ps=0.74u w=0.26u l=0.38u
X1126 A1_2_N cml_tlatch_38.OUTP cml_tlatch_37.xmux.xn.S1 VSS sg13_lv_nmos ad=63.19999f pd=0.74u as=63.19999f ps=0.74u w=0.26u l=0.38u
X1127 cml_tlatch_60.xmux.xp.S1 B3_8_N B3_8_P VSS sg13_lv_nmos ad=56.9f pd=0.74u as=56.9f ps=0.74u w=0.17u l=0.17u
X1128 stub_bi_17.BOTP cml_tlatch_5.INP cml_tlatch_13.xmux.xn.S1 VSS sg13_lv_nmos ad=63.19999f pd=0.74u as=63.19999f ps=0.74u w=0.26u l=0.38u
X1129 cml_tlatch_71.xmux.xp.S1 CKHB3_N cml_tlatch_71.xtail.S1 VSS sg13_lv_nmos ad=89.3f pd=0.85u as=89.3f ps=0.85u w=0.47u l=0.16u
X1130 MOT23_N B2_2_P cml_tlatch_76.xmux.xn.S1 VSS sg13_lv_nmos ad=63.19999f pd=0.74u as=63.19999f ps=0.74u w=0.26u l=0.38u
X1131 cml_tlatch_77.xtail.S1 CKB2_P cml_tlatch_77.xmux.xp.S1 VSS sg13_lv_nmos ad=89.3f pd=0.85u as=89.3f ps=0.85u w=0.47u l=0.16u
X1132 cml_tlatch_88.xmux.xp.S1 stub_bi_55.BOTN stub_bi_55.BOTP VSS sg13_lv_nmos ad=56.9f pd=0.74u as=56.9f ps=0.74u w=0.17u l=0.17u
X1133 cml_tlatch_31.xmux.xp.S1 A0_2_P A0_2_N VSS sg13_lv_nmos ad=56.9f pd=0.74u as=56.9f ps=0.74u w=0.17u l=0.17u
X1134 cml_tlatch_56.INN cml_tlatch_56.INP cml_tlatch_42.xmux.xp.S1 VSS sg13_lv_nmos ad=56.9f pd=0.74u as=56.9f ps=0.74u w=0.17u l=0.17u
X1135 cml_tlatch_25.xtail.S1 CKHA0_N cml_tlatch_25.xmux.xp.S1 VSS sg13_lv_nmos ad=89.3f pd=0.85u as=89.3f ps=0.85u w=0.47u l=0.16u
X1136 cml_tlatch_43.xtail.S1 CKB2_N cml_tlatch_43.xmux.xp.S1 VSS sg13_lv_nmos ad=0.1598p pd=1.62u as=89.3f ps=0.85u w=0.47u l=0.16u
X1137 GA3_N ENA1_P cml_gate2_5.sg13_lv_nmos_FTPY57_0.D0 VSS sg13_lv_nmos ad=0.1007p pd=0.91u as=0.1007p ps=0.91u w=0.53u l=0.13u
X1138 cml_tlatch_29.OUTN cml_tlatch_29.OUTP cml_tlatch_29.xmux.xp.S1 VSS sg13_lv_nmos ad=56.9f pd=0.74u as=56.9f ps=0.74u w=0.17u l=0.17u
X1139 cml_tlatch_61.xmux.xn.S1 cml_tlatch_69.INP cml_tlatch_61.OUTN VSS sg13_lv_nmos ad=63.19999f pd=0.74u as=63.19999f ps=0.74u w=0.26u l=0.38u
X1140 VDD MOT6_P VSS rppd l=5.17u w=1u
X1141 cml_tlatch_89.INP A2_2_N cml_tlatch_55.xmux.xn.S1 VSS sg13_lv_nmos ad=63.19999f pd=0.74u as=63.19999f ps=0.74u w=0.26u l=0.38u
X1142 MOT28_N MOT28_P cml_tlatch_58.xmux.xp.S1 VSS sg13_lv_nmos ad=56.9f pd=0.74u as=56.9f ps=0.74u w=0.17u l=0.17u
X1143 cml_tlatch_75.xmux.xp.S1 MOT21_N MOT21_P VSS sg13_lv_nmos ad=56.9f pd=0.74u as=56.9f ps=0.74u w=0.17u l=0.17u
X1144 MOT2_N MOT2_P cml_tlatch_24.xmux.xp.S1 VSS sg13_lv_nmos ad=56.9f pd=0.74u as=56.9f ps=0.74u w=0.17u l=0.17u
X1145 GB1_P ENB1_N cml_gate2_0.sg13_lv_nmos_FTPY57_0.D0 VSS sg13_lv_nmos ad=0.1007p pd=0.91u as=0.1007p ps=0.91u w=0.53u l=0.13u
X1146 VSS POLN cml_tlatch_7.xtail.S1 VSS sg13_lv_nmos ad=1.5637p pd=8.61u as=1.5637p ps=8.61u w=8.23u l=0.13u
X1147 cml_tlatch_30.xmux.xn.S1 A0_2_P cml_tlatch_30.OUTN VSS sg13_lv_nmos ad=63.19999f pd=0.74u as=63.19999f ps=0.74u w=0.26u l=0.38u
X1148 cml_tlatch_39.xtail.S1 POLN VSS VSS sg13_lv_nmos ad=1.5637p pd=8.61u as=1.5637p ps=8.61u w=8.23u l=0.13u
X1149 cml_tlatch_60.xmux.xp.S1 B3_8_N B3_8_P VSS sg13_lv_nmos ad=0.1019p pd=1.34u as=56.9f ps=0.74u w=0.17u l=0.17u
X1150 cml_tlatch_54.OUTP cml_tlatch_54.OUTN cml_tlatch_54.xmux.xp.S1 VSS sg13_lv_nmos ad=56.9f pd=0.74u as=56.9f ps=0.74u w=0.17u l=0.17u
X1151 MOT16_N MOT16_P cml_tlatch_87.xmux.xp.S1 VSS sg13_lv_nmos ad=56.9f pd=0.74u as=0.1019p ps=1.34u w=0.17u l=0.17u
X1152 stub_bi_62.BOTP stub_bi_62.BOTN cml_tlatch_78.xmux.xp.S1 VSS sg13_lv_nmos ad=56.9f pd=0.74u as=56.9f ps=0.74u w=0.17u l=0.17u
X1153 CKB2_N hs_to_clk_6.sg13_lv_nmos_2HGZLP_0.G VSS rppd l=4.25u w=1u
X1154 hs_to_clk_8.D2 CK_N CKJ_N VSS sg13_lv_nmos ad=0.228p pd=1.58u as=0.228p ps=1.58u w=1.2u l=0.2u
X1155 cml_tlatch_86.xmux.xn.S1 A3_8_P MOT24_N VSS sg13_lv_nmos ad=63.19999f pd=0.74u as=63.19999f ps=0.74u w=0.26u l=0.38u
X1156 cml_tlatch_6.xmux.xp.S1 MOT13_N MOT13_P VSS sg13_lv_nmos ad=56.9f pd=0.74u as=56.9f ps=0.74u w=0.17u l=0.17u
X1157 stub_bi_49.BOTP stub_bi_49.BOTN cml_tlatch_80.xmux.xp.S1 VSS sg13_lv_nmos ad=56.9f pd=0.74u as=56.9f ps=0.74u w=0.17u l=0.17u
X1158 cml_tlatch_55.xmux.xn.S1 A2_2_P cml_tlatch_89.INN VSS sg13_lv_nmos ad=63.19999f pd=0.74u as=63.19999f ps=0.74u w=0.26u l=0.38u
X1159 cml_gate2_7.xrtail.R1 VSS VSS rppd l=4.86u w=1u
X1160 B1_8_P B1_8_N cml_tlatch_12.xmux.xp.S1 VSS sg13_lv_nmos ad=56.9f pd=0.74u as=56.9f ps=0.74u w=0.17u l=0.17u
X1161 GA2_P CKB2_N cml_gate2_4.xrtail.R1 VSS sg13_lv_nmos ad=0.1007p pd=0.91u as=0.1007p ps=0.91u w=0.53u l=0.13u
X1162 stub_bi_31.BOTN stub_bi_31.BOTP cml_tlatch_34.xmux.xp.S1 VSS sg13_lv_nmos ad=56.9f pd=0.74u as=56.9f ps=0.74u w=0.17u l=0.17u
X1163 cml_tlatch_44.xmux.xp.S1 B2_2_N B2_2_P VSS sg13_lv_nmos ad=56.9f pd=0.74u as=56.9f ps=0.74u w=0.17u l=0.17u
X1164 A1_2_P A1_2_N cml_tlatch_37.xmux.xp.S1 VSS sg13_lv_nmos ad=56.9f pd=0.74u as=56.9f ps=0.74u w=0.17u l=0.17u
X1165 VSS hs_to_clk_0.sg13_lv_nmos_2HGZLP_0.G VSS VSS sg13_lv_nmos ad=2.071p pd=11.28u as=0 ps=0 w=10.9u l=1.38u
X1166 cml_tlatch_5.xmux.xn.S1 CKHB1_P cml_tlatch_5.xtail.S1 VSS sg13_lv_nmos ad=89.3f pd=0.85u as=89.3f ps=0.85u w=0.47u l=0.16u
X1167 cml_tlatch_9.OUTP cml_tlatch_9.OUTN cml_tlatch_9.xmux.xp.S1 VSS sg13_lv_nmos ad=56.9f pd=0.74u as=56.9f ps=0.74u w=0.17u l=0.17u
X1168 cml_tlatch_64.xmux.xn.S1 CKA3_N cml_tlatch_64.xtail.S1 VSS sg13_lv_nmos ad=0.1598p pd=1.62u as=89.3f ps=0.85u w=0.47u l=0.16u
X1169 cml_tlatch_1.xmux.xn.S1 cml_tlatch_98.OUTP cml_tlatch_1.OUTN VSS sg13_lv_nmos ad=0.1082p pd=1.34u as=63.19999f ps=0.74u w=0.26u l=0.38u
X1170 cml_drv_1.xrtail.R1 ENA_P ENA1_N VSS sg13_lv_nmos ad=56.2f pd=0.74u as=56.2f ps=0.74u w=0.16u l=0.19u
X1171 MOT25_N MOT25_P cml_tlatch_68.xmux.xp.S1 VSS sg13_lv_nmos ad=56.9f pd=0.74u as=56.9f ps=0.74u w=0.17u l=0.17u
X1172 cml_tlatch_58.xmux.xp.S1 MOT28_N MOT28_P VSS sg13_lv_nmos ad=56.9f pd=0.74u as=56.9f ps=0.74u w=0.17u l=0.17u
X1173 MOT1_P B0_8_N cml_tlatch_17.xmux.xn.S1 VSS sg13_lv_nmos ad=63.19999f pd=0.74u as=63.19999f ps=0.74u w=0.26u l=0.38u
X1174 A3_8_P cml_tlatch_65.OUTN cml_tlatch_64.xmux.xn.S1 VSS sg13_lv_nmos ad=63.19999f pd=0.74u as=0.1082p ps=1.34u w=0.26u l=0.38u
X1175 cml_tlatch_53.xtail.S1 POLN VSS VSS sg13_lv_nmos ad=1.5637p pd=8.61u as=1.5637p ps=8.61u w=8.23u l=0.13u
X1176 cml_tlatch_8.OUTP cml_tlatch_8.OUTN cml_tlatch_8.xmux.xp.S1 VSS sg13_lv_nmos ad=56.9f pd=0.74u as=56.9f ps=0.74u w=0.17u l=0.17u
X1177 cml_tlatch_33.xtail.S1 CKB1_P cml_tlatch_33.xmux.xp.S1 VSS sg13_lv_nmos ad=89.3f pd=0.85u as=89.3f ps=0.85u w=0.47u l=0.16u
X1178 cml_tlatch_25.xmux.xn.S1 cml_tlatch_99.OUTP MOT4_N VSS sg13_lv_nmos ad=63.19999f pd=0.74u as=63.19999f ps=0.74u w=0.26u l=0.38u
X1179 cml_tlatch_79.xmux.xn.S1 stub_bi_49.BOTP stub_bi_63.BOTN VSS sg13_lv_nmos ad=63.19999f pd=0.74u as=63.19999f ps=0.74u w=0.26u l=0.38u
X1180 cml_tlatch_61.xtail.S1 CKB3_P cml_tlatch_61.xmux.xn.S1 VSS sg13_lv_nmos ad=89.3f pd=0.85u as=89.3f ps=0.85u w=0.47u l=0.16u
X1181 cml_tlatch_4.xmux.xp.S1 MOT9_P MOT9_N VSS sg13_lv_nmos ad=56.9f pd=0.74u as=56.9f ps=0.74u w=0.17u l=0.17u
X1182 cml_tlatch_99.OUTP cml_tlatch_99.OUTN cml_tlatch_99.xmux.xp.S1 VSS sg13_lv_nmos ad=56.9f pd=0.74u as=56.9f ps=0.74u w=0.17u l=0.17u
X1183 cml_tlatch_52.OUTN cml_tlatch_52.OUTP cml_tlatch_52.xmux.xp.S1 VSS sg13_lv_nmos ad=56.9f pd=0.74u as=56.9f ps=0.74u w=0.17u l=0.17u
X1184 cml_tlatch_82.xmux.xp.S1 CKA2_N cml_tlatch_82.xtail.S1 VSS sg13_lv_nmos ad=89.3f pd=0.85u as=89.3f ps=0.85u w=0.47u l=0.16u
X1185 cml_tlatch_45.xmux.xp.S1 cml_tlatch_45.OUTP cml_tlatch_45.OUTN VSS sg13_lv_nmos ad=56.9f pd=0.74u as=56.9f ps=0.74u w=0.17u l=0.17u
X1186 cml_tlatch_82.xmux.xn.S1 cml_tlatch_83.OUTP cml_tlatch_82.OUTN VSS sg13_lv_nmos ad=63.19999f pd=0.74u as=63.19999f ps=0.74u w=0.26u l=0.38u
X1187 cml_tlatch_11.xtail.S1 POLN VSS VSS sg13_lv_nmos ad=1.5637p pd=8.61u as=1.5637p ps=8.61u w=8.23u l=0.13u
X1188 cml_tlatch_42.xmux.xp.S1 CKA2_N cml_tlatch_42.xtail.S1 VSS sg13_lv_nmos ad=89.3f pd=0.85u as=89.3f ps=0.85u w=0.47u l=0.16u
X1189 MOT22_P MOT22_N cml_tlatch_51.xmux.xp.S1 VSS sg13_lv_nmos ad=56.9f pd=0.74u as=56.9f ps=0.74u w=0.17u l=0.17u
X1190 cml_gate2_7.xrtail.R1 CKA2_N GB2_P VSS sg13_lv_nmos ad=0.1007p pd=0.91u as=0.1007p ps=0.91u w=0.53u l=0.13u
X1191 cml_tlatch_59.xmux.xp.S1 MOT30_N MOT30_P VSS sg13_lv_nmos ad=56.9f pd=0.74u as=56.9f ps=0.74u w=0.17u l=0.17u
X1192 MOT16_N MOT16_P cml_tlatch_87.xmux.xp.S1 VSS sg13_lv_nmos ad=56.9f pd=0.74u as=56.9f ps=0.74u w=0.17u l=0.17u
X1193 VSS POLN cml_tlatch_78.xtail.S1 VSS sg13_lv_nmos ad=1.5637p pd=8.61u as=1.5637p ps=8.61u w=8.23u l=0.13u
X1194 stub_bi_29.BOTP stub_bi_29.BOTN cml_tlatch_32.xmux.xp.S1 VSS sg13_lv_nmos ad=56.9f pd=0.74u as=56.9f ps=0.74u w=0.17u l=0.17u
X1195 cml_gate2_8.sg13_lv_nmos_FTPY57_0.D0 J2_N ENB_P VSS sg13_lv_nmos ad=0.1007p pd=0.91u as=0.1007p ps=0.91u w=0.53u l=0.13u
X1196 cml_tlatch_24.xmux.xp.S1 MOT2_N MOT2_P VSS sg13_lv_nmos ad=0.1019p pd=1.34u as=56.9f ps=0.74u w=0.17u l=0.17u
X1197 cml_tlatch_98.xtail.S1 CKB0_N cml_tlatch_98.xmux.xn.S1 VSS sg13_lv_nmos ad=89.3f pd=0.85u as=0.1598p ps=1.62u w=0.47u l=0.16u
X1198 cml_tlatch_66.xtail.S1 CKA3_P cml_tlatch_66.xmux.xp.S1 VSS sg13_lv_nmos ad=89.3f pd=0.85u as=89.3f ps=0.85u w=0.47u l=0.16u
X1199 cml_tlatch_49.xmux.xp.S1 MOT18_P MOT18_N VSS sg13_lv_nmos ad=56.9f pd=0.74u as=56.9f ps=0.74u w=0.17u l=0.17u
X1200 MOT26_N MOT26_P cml_tlatch_57.xmux.xp.S1 VSS sg13_lv_nmos ad=56.9f pd=0.74u as=56.9f ps=0.74u w=0.17u l=0.17u
X1201 VSS hs_to_clk_4.sg13_lv_nmos_2HGZLP_0.G VSS VSS sg13_lv_nmos ad=2.071p pd=11.28u as=0 ps=0 w=10.9u l=1.38u
X1202 cml_tlatch_99.xmux.xp.S1 cml_tlatch_99.OUTP cml_tlatch_99.OUTN VSS sg13_lv_nmos ad=56.9f pd=0.74u as=56.9f ps=0.74u w=0.17u l=0.17u
X1203 A3_2_N A3_2_P cml_tlatch_53.xmux.xp.S1 VSS sg13_lv_nmos ad=56.9f pd=0.74u as=56.9f ps=0.74u w=0.17u l=0.17u
X1204 stub_bi_55.BOTN stub_bi_55.BOTP cml_tlatch_88.xmux.xp.S1 VSS sg13_lv_nmos ad=56.9f pd=0.74u as=56.9f ps=0.74u w=0.17u l=0.17u
X1205 cml_tlatch_16.OUTN cml_tlatch_16.OUTP cml_tlatch_16.xmux.xp.S1 VSS sg13_lv_nmos ad=56.9f pd=0.74u as=56.9f ps=0.74u w=0.17u l=0.17u
X1206 cml_gate2_1.sg13_lv_nmos_FTPY57_0.D0 ENB1_N GB0_P VSS sg13_lv_nmos ad=0.1007p pd=0.91u as=0.1007p ps=0.91u w=0.53u l=0.13u
X1207 cml_tlatch_95.xmux.xp.S1 cml_tlatch_40.INN cml_tlatch_40.INP VSS sg13_lv_nmos ad=56.9f pd=0.74u as=56.9f ps=0.74u w=0.17u l=0.17u
X1208 ENB_P J2_N cml_gate2_8.sg13_lv_nmos_FTPY57_0.D0 VSS sg13_lv_nmos ad=0.1007p pd=0.91u as=0.1802p ps=1.74u w=0.53u l=0.13u
X1209 MOT16_P MOT16_N cml_tlatch_87.xmux.xp.S1 VSS sg13_lv_nmos ad=56.9f pd=0.74u as=56.9f ps=0.74u w=0.17u l=0.17u
X1210 cml_tlatch_10.xmux.xn.S1 CKB0_N cml_tlatch_10.xtail.S1 VSS sg13_lv_nmos ad=89.3f pd=0.85u as=89.3f ps=0.85u w=0.47u l=0.16u
X1211 cml_tlatch_39.xmux.xp.S1 MOT10_P MOT10_N VSS sg13_lv_nmos ad=56.9f pd=0.74u as=56.9f ps=0.74u w=0.17u l=0.17u
X1212 cml_tlatch_58.xmux.xn.S1 CKHA3_P cml_tlatch_58.xtail.S1 VSS sg13_lv_nmos ad=89.3f pd=0.85u as=89.3f ps=0.85u w=0.47u l=0.16u
X1213 cml_tlatch_2.xmux.xp.S1 A0_8_N A0_8_P VSS sg13_lv_nmos ad=56.9f pd=0.74u as=56.9f ps=0.74u w=0.17u l=0.17u
X1214 VSS POLN cml_tlatch_4.xtail.S1 VSS sg13_lv_nmos ad=1.5637p pd=8.61u as=1.5637p ps=8.61u w=8.23u l=0.13u
X1215 cml_tlatch_71.xmux.xp.S1 MOT31_N MOT31_P VSS sg13_lv_nmos ad=56.9f pd=0.74u as=56.9f ps=0.74u w=0.17u l=0.17u
X1216 cml_tlatch_84.xmux.xn.S1 CKB3_N cml_tlatch_84.xtail.S1 VSS sg13_lv_nmos ad=89.3f pd=0.85u as=89.3f ps=0.85u w=0.47u l=0.16u
X1217 cml_tlatch_40.INN cml_tlatch_40.INP cml_tlatch_95.xmux.xp.S1 VSS sg13_lv_nmos ad=56.9f pd=0.74u as=0.1019p ps=1.34u w=0.17u l=0.17u
X1218 GA1_P ENA0_N cml_gate2_3.sg13_lv_nmos_FTPY57_0.D0 VSS sg13_lv_nmos ad=0.1007p pd=0.91u as=0.1802p ps=1.74u w=0.53u l=0.13u
X1219 cml_tlatch_0.xmux.xn.S1 cml_tlatch_40.INN interco_bi_19.INP VSS sg13_lv_nmos ad=63.19999f pd=0.74u as=63.19999f ps=0.74u w=0.26u l=0.38u
X1220 hs_to_clk_6.sg13_lv_nmos_2HGZLP_0.G VDD VSS rppd l=0.68u w=1u
X1221 cml_tlatch_16.xmux.xn.S1 cml_tlatch_1.OUTP cml_tlatch_16.OUTN VSS sg13_lv_nmos ad=63.19999f pd=0.74u as=0.1082p ps=1.34u w=0.26u l=0.38u
X1222 MOT8_P MOT8_N cml_tlatch_96.xmux.xp.S1 VSS sg13_lv_nmos ad=56.9f pd=0.74u as=56.9f ps=0.74u w=0.17u l=0.17u
X1223 cml_tlatch_38.OUTN cml_tlatch_38.OUTP cml_tlatch_38.xmux.xp.S1 VSS sg13_lv_nmos ad=56.9f pd=0.74u as=56.9f ps=0.74u w=0.17u l=0.17u
X1224 cml_tlatch_53.xmux.xn.S1 CKA3_N cml_tlatch_53.xtail.S1 VSS sg13_lv_nmos ad=0.1598p pd=1.62u as=89.3f ps=0.85u w=0.47u l=0.16u
X1225 cml_tlatch_57.INP cml_tlatch_67.OUTN cml_tlatch_66.xmux.xn.S1 VSS sg13_lv_nmos ad=63.19999f pd=0.74u as=63.19999f ps=0.74u w=0.26u l=0.38u
X1226 MOT7_P B0_2_N cml_tlatch_20.xmux.xn.S1 VSS sg13_lv_nmos ad=0.1082p pd=1.34u as=63.19999f ps=0.74u w=0.26u l=0.38u
X1227 cml_tlatch_90.xmux.xp.S1 CKJ_P cml_tlatch_90.xtail.S1 VSS sg13_lv_nmos ad=89.3f pd=0.85u as=89.3f ps=0.85u w=0.47u l=0.16u
X1228 cml_tlatch_69.xmux.xp.S1 CKHB3_N cml_tlatch_69.xtail.S1 VSS sg13_lv_nmos ad=89.3f pd=0.85u as=89.3f ps=0.85u w=0.47u l=0.16u
X1229 cml_tlatch_9.xtail.S1 CKA0_P cml_tlatch_9.xmux.xn.S1 VSS sg13_lv_nmos ad=89.3f pd=0.85u as=89.3f ps=0.85u w=0.47u l=0.16u
X1230 VSS POLN cml_tlatch_0.xtail.S1 VSS sg13_lv_nmos ad=2.7982p pd=17.14u as=1.5637p ps=8.61u w=8.23u l=0.13u
X1231 cml_tlatch_5.INP VDD VSS rppd l=5.17u w=1u
X1232 VSS POLN cml_tlatch_47.xtail.S1 VSS sg13_lv_nmos ad=2.7982p pd=17.14u as=1.5637p ps=8.61u w=8.23u l=0.13u
X1233 cml_tlatch_1.xmux.xp.S1 cml_tlatch_1.OUTN cml_tlatch_1.OUTP VSS sg13_lv_nmos ad=56.9f pd=0.74u as=56.9f ps=0.74u w=0.17u l=0.17u
X1234 cml_tlatch_29.xtail.S1 CKB0_P cml_tlatch_29.xmux.xn.S1 VSS sg13_lv_nmos ad=0.1598p pd=1.62u as=89.3f ps=0.85u w=0.47u l=0.16u
X1235 cml_tlatch_93.xtail.S1 CKJ_N cml_tlatch_93.xmux.xp.S1 VSS sg13_lv_nmos ad=89.3f pd=0.85u as=89.3f ps=0.85u w=0.47u l=0.16u
X1236 cml_tlatch_0.xmux.xn.S1 CKA1_P cml_tlatch_0.xtail.S1 VSS sg13_lv_nmos ad=89.3f pd=0.85u as=89.3f ps=0.85u w=0.47u l=0.16u
X1237 interco_bi_19.INN cml_tlatch_40.INP cml_tlatch_0.xmux.xn.S1 VSS sg13_lv_nmos ad=63.19999f pd=0.74u as=63.19999f ps=0.74u w=0.26u l=0.38u
X1238 cml_tlatch_22.xmux.xp.S1 cml_tlatch_22.OUTP cml_tlatch_22.OUTN VSS sg13_lv_nmos ad=56.9f pd=0.74u as=56.9f ps=0.74u w=0.17u l=0.17u
X1239 stub_bi_62.BOTP stub_bi_62.BOTN cml_tlatch_78.xmux.xp.S1 VSS sg13_lv_nmos ad=56.9f pd=0.74u as=56.9f ps=0.74u w=0.17u l=0.17u
X1240 MOT10_P cml_tlatch_39.INN cml_tlatch_39.xmux.xn.S1 VSS sg13_lv_nmos ad=63.19999f pd=0.74u as=63.19999f ps=0.74u w=0.26u l=0.38u
X1241 B3_2_N B3_2_P cml_tlatch_46.xmux.xp.S1 VSS sg13_lv_nmos ad=56.9f pd=0.74u as=0.1019p ps=1.34u w=0.17u l=0.17u
X1242 cml_tlatch_6.INN stub_bi_29.BOTN cml_tlatch_94.xmux.xn.S1 VSS sg13_lv_nmos ad=63.19999f pd=0.74u as=63.19999f ps=0.74u w=0.26u l=0.38u
X1243 VDD MOT4_N VSS rppd l=5.17u w=1u
X1244 cml_tlatch_65.xmux.xn.S1 cml_tlatch_57.INN cml_tlatch_65.OUTP VSS sg13_lv_nmos ad=63.19999f pd=0.74u as=63.19999f ps=0.74u w=0.26u l=0.38u
X1245 cml_tlatch_17.xtail.S1 CKHB0_N cml_tlatch_17.xmux.xp.S1 VSS sg13_lv_nmos ad=89.3f pd=0.85u as=89.3f ps=0.85u w=0.47u l=0.16u
X1246 cml_tlatch_98.xmux.xp.S1 cml_tlatch_98.OUTN cml_tlatch_98.OUTP VSS sg13_lv_nmos ad=56.9f pd=0.74u as=56.9f ps=0.74u w=0.17u l=0.17u
X1247 MOT10_P cml_tlatch_39.INN cml_tlatch_39.xmux.xn.S1 VSS sg13_lv_nmos ad=63.19999f pd=0.74u as=63.19999f ps=0.74u w=0.26u l=0.38u
X1248 cml_tlatch_40.INP cml_tlatch_95.INN cml_tlatch_95.xmux.xn.S1 VSS sg13_lv_nmos ad=63.19999f pd=0.74u as=63.19999f ps=0.74u w=0.26u l=0.38u
X1249 cml_tlatch_53.xmux.xp.S1 CKA3_P cml_tlatch_53.xtail.S1 VSS sg13_lv_nmos ad=89.3f pd=0.85u as=89.3f ps=0.85u w=0.47u l=0.16u
X1250 cml_tlatch_28.xtail.S1 CKB0_P cml_tlatch_28.xmux.xp.S1 VSS sg13_lv_nmos ad=89.3f pd=0.85u as=89.3f ps=0.85u w=0.47u l=0.16u
X1251 cml_tlatch_15.xmux.xn.S1 CKB1_P cml_tlatch_15.xtail.S1 VSS sg13_lv_nmos ad=89.3f pd=0.85u as=89.3f ps=0.85u w=0.47u l=0.16u
X1252 cml_tlatch_77.xmux.xp.S1 CKB2_P cml_tlatch_77.xtail.S1 VSS sg13_lv_nmos ad=89.3f pd=0.85u as=89.3f ps=0.85u w=0.47u l=0.16u
X1253 cml_tlatch_82.xmux.xp.S1 cml_tlatch_82.OUTN cml_tlatch_82.OUTP VSS sg13_lv_nmos ad=56.9f pd=0.74u as=56.9f ps=0.74u w=0.17u l=0.17u
X1254 cml_tlatch_25.xmux.xp.S1 CKHA0_N cml_tlatch_25.xtail.S1 VSS sg13_lv_nmos ad=89.3f pd=0.85u as=0.1598p ps=1.62u w=0.47u l=0.16u
X1255 cml_tlatch_7.xmux.xp.S1 MOT15_P MOT15_N VSS sg13_lv_nmos ad=56.9f pd=0.74u as=56.9f ps=0.74u w=0.17u l=0.17u
X1256 stub_bi_31.BOTP D1_P cml_tlatch_34.xmux.xn.S1 VSS sg13_lv_nmos ad=63.19999f pd=0.74u as=63.19999f ps=0.74u w=0.26u l=0.38u
X1257 cml_tlatch_30.xtail.S1 CKA0_N cml_tlatch_30.xmux.xp.S1 VSS sg13_lv_nmos ad=89.3f pd=0.85u as=89.3f ps=0.85u w=0.47u l=0.16u
X1258 cml_tlatch_64.xmux.xp.S1 CKA3_P cml_tlatch_64.xtail.S1 VSS sg13_lv_nmos ad=89.3f pd=0.85u as=0.1598p ps=1.62u w=0.47u l=0.16u
X1259 cml_tlatch_33.xtail.S1 POLN VSS VSS sg13_lv_nmos ad=1.5637p pd=8.61u as=2.7982p ps=17.14u w=8.23u l=0.13u
X1260 cml_tlatch_63.xmux.xp.S1 cml_tlatch_63.OUTP cml_tlatch_63.OUTN VSS sg13_lv_nmos ad=56.9f pd=0.74u as=56.9f ps=0.74u w=0.17u l=0.17u
X1261 MOT22_N MOT22_P cml_tlatch_51.xmux.xp.S1 VSS sg13_lv_nmos ad=56.9f pd=0.74u as=56.9f ps=0.74u w=0.17u l=0.17u
X1262 B1_2_P stub_bi_31.BOTP cml_tlatch_33.xmux.xn.S1 VSS sg13_lv_nmos ad=63.19999f pd=0.74u as=63.19999f ps=0.74u w=0.26u l=0.38u
X1263 cml_tlatch_47.xmux.xn.S1 D3_P cml_tlatch_47.OUTN VSS sg13_lv_nmos ad=63.19999f pd=0.74u as=63.19999f ps=0.74u w=0.26u l=0.38u
X1264 cml_tlatch_0.xmux.xp.S1 interco_bi_19.INN interco_bi_19.INP VSS sg13_lv_nmos ad=56.9f pd=0.74u as=56.9f ps=0.74u w=0.17u l=0.17u
X1265 cml_tlatch_13.xtail.S1 POLN VSS VSS sg13_lv_nmos ad=1.5637p pd=8.61u as=1.5637p ps=8.61u w=8.23u l=0.13u
X1266 cml_tlatch_39.INP cml_tlatch_39.INN cml_tlatch_23.xmux.xp.S1 VSS sg13_lv_nmos ad=56.9f pd=0.74u as=56.9f ps=0.74u w=0.17u l=0.17u
X1267 cml_tlatch_94.xmux.xp.S1 CKB1_P cml_tlatch_94.xtail.S1 VSS sg13_lv_nmos ad=89.3f pd=0.85u as=89.3f ps=0.85u w=0.47u l=0.16u
X1268 cml_tlatch_87.xmux.xn.S1 A2_8_N MOT16_P VSS sg13_lv_nmos ad=63.19999f pd=0.74u as=63.19999f ps=0.74u w=0.26u l=0.38u
X1269 B2_8_P B2_8_N cml_tlatch_77.xmux.xp.S1 VSS sg13_lv_nmos ad=56.9f pd=0.74u as=56.9f ps=0.74u w=0.17u l=0.17u
X1270 cml_gate2_3.sg13_lv_nmos_FTPY57_0.D0 CKB1_P cml_gate2_3.xrtail.R1 VSS sg13_lv_nmos ad=0.1007p pd=0.91u as=0.1007p ps=0.91u w=0.53u l=0.13u
X1271 cml_tlatch_95.xmux.xp.S1 cml_tlatch_40.INN cml_tlatch_40.INP VSS sg13_lv_nmos ad=56.9f pd=0.74u as=56.9f ps=0.74u w=0.17u l=0.17u
X1272 cml_tlatch_46.xmux.xp.S1 CKB3_P cml_tlatch_46.xtail.S1 VSS sg13_lv_nmos ad=89.3f pd=0.85u as=89.3f ps=0.85u w=0.47u l=0.16u
X1273 cml_tlatch_83.xtail.S1 POLN VSS VSS sg13_lv_nmos ad=1.5637p pd=8.61u as=1.5637p ps=8.61u w=8.23u l=0.13u
X1274 cml_tlatch_89.xmux.xp.S1 CKA2_P cml_tlatch_89.xtail.S1 VSS sg13_lv_nmos ad=89.3f pd=0.85u as=89.3f ps=0.85u w=0.47u l=0.16u
X1275 cml_tlatch_63.OUTN cml_tlatch_70.INP cml_tlatch_63.xmux.xn.S1 VSS sg13_lv_nmos ad=63.19999f pd=0.74u as=63.19999f ps=0.74u w=0.26u l=0.38u
X1276 cml_tlatch_3.xmux.xp.S1 cml_tlatch_3.OUTP cml_tlatch_3.OUTN VSS sg13_lv_nmos ad=56.9f pd=0.74u as=56.9f ps=0.74u w=0.17u l=0.17u
X1277 VSS POLN cml_tlatch_24.xtail.S1 VSS sg13_lv_nmos ad=1.5637p pd=8.61u as=1.5637p ps=8.61u w=8.23u l=0.13u
X1278 cml_tlatch_68.xtail.S1 CKHB3_P cml_tlatch_68.xmux.xn.S1 VSS sg13_lv_nmos ad=89.3f pd=0.85u as=0.1598p ps=1.62u w=0.47u l=0.16u
X1279 cml_tlatch_6.xtail.S1 CKHB1_N cml_tlatch_6.xmux.xp.S1 VSS sg13_lv_nmos ad=89.3f pd=0.85u as=89.3f ps=0.85u w=0.47u l=0.16u
X1280 cml_tlatch_36.xmux.xn.S1 CKA1_P cml_tlatch_36.xtail.S1 VSS sg13_lv_nmos ad=89.3f pd=0.85u as=89.3f ps=0.85u w=0.47u l=0.16u
X1281 cml_tlatch_58.INN cml_tlatch_58.INP cml_tlatch_85.xmux.xp.S1 VSS sg13_lv_nmos ad=56.9f pd=0.74u as=56.9f ps=0.74u w=0.17u l=0.17u
X1282 cml_tlatch_68.xmux.xp.S1 MOT25_N MOT25_P VSS sg13_lv_nmos ad=56.9f pd=0.74u as=56.9f ps=0.74u w=0.17u l=0.17u
X1283 cml_tlatch_35.OUTP cml_tlatch_35.OUTN cml_tlatch_35.xmux.xp.S1 VSS sg13_lv_nmos ad=56.9f pd=0.74u as=56.9f ps=0.74u w=0.17u l=0.17u
X1284 cml_tlatch_50.xmux.xp.S1 CKHA2_N cml_tlatch_50.xtail.S1 VSS sg13_lv_nmos ad=89.3f pd=0.85u as=89.3f ps=0.85u w=0.47u l=0.16u
X1285 MOT5_N MOT5_P cml_tlatch_19.xmux.xp.S1 VSS sg13_lv_nmos ad=56.9f pd=0.74u as=56.9f ps=0.74u w=0.17u l=0.17u
X1286 cml_tlatch_95.xmux.xp.S1 cml_tlatch_40.INN cml_tlatch_40.INP VSS sg13_lv_nmos ad=56.9f pd=0.74u as=56.9f ps=0.74u w=0.17u l=0.17u
X1287 cml_gate2_4.xrtail.R1 CKB2_P cml_gate2_4.sg13_lv_nmos_FTPY57_0.D0 VSS sg13_lv_nmos ad=0.1007p pd=0.91u as=0.1007p ps=0.91u w=0.53u l=0.13u
X1288 cml_tlatch_98.OUTN cml_tlatch_98.OUTP cml_tlatch_98.xmux.xp.S1 VSS sg13_lv_nmos ad=56.9f pd=0.74u as=0.1019p ps=1.34u w=0.17u l=0.17u
X1289 cml_tlatch_63.OUTN cml_tlatch_63.OUTP cml_tlatch_63.xmux.xp.S1 VSS sg13_lv_nmos ad=56.9f pd=0.74u as=56.9f ps=0.74u w=0.17u l=0.17u
X1290 cml_tlatch_57.INN cml_tlatch_57.INP cml_tlatch_66.xmux.xp.S1 VSS sg13_lv_nmos ad=56.9f pd=0.74u as=56.9f ps=0.74u w=0.17u l=0.17u
X1291 cml_tlatch_41.xmux.xn.S1 A1_2_N MOT14_P VSS sg13_lv_nmos ad=63.19999f pd=0.74u as=63.19999f ps=0.74u w=0.26u l=0.38u
X1292 cml_tlatch_93.xmux.xp.S1 J1_P J1_N VSS sg13_lv_nmos ad=56.9f pd=0.74u as=56.9f ps=0.74u w=0.17u l=0.17u
X1293 cml_tlatch_57.INP cml_tlatch_57.INN cml_tlatch_66.xmux.xp.S1 VSS sg13_lv_nmos ad=56.9f pd=0.74u as=56.9f ps=0.74u w=0.17u l=0.17u
X1294 cml_gate2_7.sg13_lv_nmos_FTPY57_0.D0 CKA2_P cml_gate2_7.xrtail.R1 VSS sg13_lv_nmos ad=0.1007p pd=0.91u as=0.1007p ps=0.91u w=0.53u l=0.13u
X1295 cml_tlatch_50.xmux.xp.S1 MOT20_P MOT20_N VSS sg13_lv_nmos ad=56.9f pd=0.74u as=56.9f ps=0.74u w=0.17u l=0.17u
X1296 cml_tlatch_38.xtail.S1 CKA1_P cml_tlatch_38.xmux.xn.S1 VSS sg13_lv_nmos ad=89.3f pd=0.85u as=89.3f ps=0.85u w=0.47u l=0.16u
X1297 cml_tlatch_61.xmux.xn.S1 CKB3_P cml_tlatch_61.xtail.S1 VSS sg13_lv_nmos ad=89.3f pd=0.85u as=89.3f ps=0.85u w=0.47u l=0.16u
X1298 MOT22_N A2_2_P cml_tlatch_51.xmux.xn.S1 VSS sg13_lv_nmos ad=63.19999f pd=0.74u as=63.19999f ps=0.74u w=0.26u l=0.38u
X1299 J2_P J2_N cml_tlatch_92.xmux.xp.S1 VSS sg13_lv_nmos ad=56.9f pd=0.74u as=56.9f ps=0.74u w=0.17u l=0.17u
X1300 cml_tlatch_8.xtail.S1 CKA0_P cml_tlatch_8.xmux.xp.S1 VSS sg13_lv_nmos ad=89.3f pd=0.85u as=89.3f ps=0.85u w=0.47u l=0.16u
X1301 cml_tlatch_8.xtail.S1 CKA0_N cml_tlatch_8.xmux.xn.S1 VSS sg13_lv_nmos ad=89.3f pd=0.85u as=89.3f ps=0.85u w=0.47u l=0.16u
X1302 MOT8_P MOT8_N cml_tlatch_96.xmux.xp.S1 VSS sg13_lv_nmos ad=56.9f pd=0.74u as=56.9f ps=0.74u w=0.17u l=0.17u
X1303 cml_tlatch_44.xmux.xn.S1 stub_bi_32.BOTN B2_2_N VSS sg13_lv_nmos ad=63.19999f pd=0.74u as=0.1082p ps=1.34u w=0.26u l=0.38u
X1304 cml_tlatch_41.xtail.S1 CKHA1_N cml_tlatch_41.xmux.xp.S1 VSS sg13_lv_nmos ad=89.3f pd=0.85u as=89.3f ps=0.85u w=0.47u l=0.16u
X1305 ENB0_P ENB_N cml_drv_2.xrtail.R1 VSS sg13_lv_nmos ad=0.1012p pd=1.34u as=56.2f ps=0.74u w=0.16u l=0.19u
X1306 MOT3_P MOT3_N cml_tlatch_18.xmux.xp.S1 VSS sg13_lv_nmos ad=56.9f pd=0.74u as=56.9f ps=0.74u w=0.17u l=0.17u
X1307 cml_tlatch_42.xmux.xn.S1 D2_P cml_tlatch_56.INN VSS sg13_lv_nmos ad=63.19999f pd=0.74u as=63.19999f ps=0.74u w=0.26u l=0.38u
X1308 cml_tlatch_42.xmux.xp.S1 cml_tlatch_56.INN cml_tlatch_56.INP VSS sg13_lv_nmos ad=56.9f pd=0.74u as=56.9f ps=0.74u w=0.17u l=0.17u
X1309 cml_tlatch_2.xmux.xn.S1 CKA0_N cml_tlatch_2.xtail.S1 VSS sg13_lv_nmos ad=89.3f pd=0.85u as=0.1598p ps=1.62u w=0.47u l=0.16u
X1310 cml_tlatch_93.xmux.xp.S1 J1_P J1_N VSS sg13_lv_nmos ad=0.1019p pd=1.34u as=56.9f ps=0.74u w=0.17u l=0.17u
X1311 cml_tlatch_45.xmux.xn.S1 B3_2_N cml_tlatch_45.OUTP VSS sg13_lv_nmos ad=0.1082p pd=1.34u as=63.19999f ps=0.74u w=0.26u l=0.38u
X1312 cml_tlatch_46.xmux.xp.S1 B3_2_N B3_2_P VSS sg13_lv_nmos ad=56.9f pd=0.74u as=56.9f ps=0.74u w=0.17u l=0.17u
X1313 cml_tlatch_83.INN cml_tlatch_89.OUTP cml_tlatch_72.xmux.xn.S1 VSS sg13_lv_nmos ad=0.1082p pd=1.34u as=63.19999f ps=0.74u w=0.26u l=0.38u
X1314 MOT30_N MOT30_P cml_tlatch_59.xmux.xp.S1 VSS sg13_lv_nmos ad=56.9f pd=0.74u as=56.9f ps=0.74u w=0.17u l=0.17u
X1315 cml_tlatch_45.xmux.xn.S1 B3_2_N cml_tlatch_45.OUTP VSS sg13_lv_nmos ad=63.19999f pd=0.74u as=63.19999f ps=0.74u w=0.26u l=0.38u
X1316 cml_tlatch_15.xmux.xp.S1 stub_bi_19.BOTN stub_bi_19.BOTP VSS sg13_lv_nmos ad=56.9f pd=0.74u as=56.9f ps=0.74u w=0.17u l=0.17u
X1317 cml_tlatch_23.xmux.xp.S1 cml_tlatch_39.INP cml_tlatch_39.INN VSS sg13_lv_nmos ad=56.9f pd=0.74u as=56.9f ps=0.74u w=0.17u l=0.17u
X1318 cml_tlatch_23.xmux.xp.S1 cml_tlatch_39.INN cml_tlatch_39.INP VSS sg13_lv_nmos ad=0.1019p pd=1.34u as=56.9f ps=0.74u w=0.17u l=0.17u
X1319 cml_tlatch_47.OUTN cml_tlatch_47.OUTP cml_tlatch_47.xmux.xp.S1 VSS sg13_lv_nmos ad=56.9f pd=0.74u as=56.9f ps=0.74u w=0.17u l=0.17u
X1320 cml_tlatch_75.xtail.S1 CKHB2_N cml_tlatch_75.xmux.xp.S1 VSS sg13_lv_nmos ad=89.3f pd=0.85u as=89.3f ps=0.85u w=0.47u l=0.16u
X1321 MOT4_N MOT4_P cml_tlatch_25.xmux.xp.S1 VSS sg13_lv_nmos ad=56.9f pd=0.74u as=56.9f ps=0.74u w=0.17u l=0.17u
X1322 cml_tlatch_36.xmux.xn.S1 A1_2_N cml_tlatch_95.INP VSS sg13_lv_nmos ad=63.19999f pd=0.74u as=63.19999f ps=0.74u w=0.26u l=0.38u
X1323 cml_tlatch_30.xmux.xn.S1 CKA0_P cml_tlatch_30.xtail.S1 VSS sg13_lv_nmos ad=89.3f pd=0.85u as=89.3f ps=0.85u w=0.47u l=0.16u
X1324 cml_tlatch_56.xmux.xp.S1 A2_2_P A2_2_N VSS sg13_lv_nmos ad=56.9f pd=0.74u as=56.9f ps=0.74u w=0.17u l=0.17u
X1325 cml_tlatch_7.xmux.xp.S1 CKHB1_N cml_tlatch_7.xtail.S1 VSS sg13_lv_nmos ad=89.3f pd=0.85u as=89.3f ps=0.85u w=0.47u l=0.16u
X1326 cml_tlatch_41.xmux.xp.S1 MOT14_P MOT14_N VSS sg13_lv_nmos ad=56.9f pd=0.74u as=56.9f ps=0.74u w=0.17u l=0.17u
X1327 cml_tlatch_97.xtail.S1 CKHA0_N cml_tlatch_97.xmux.xp.S1 VSS sg13_lv_nmos ad=89.3f pd=0.85u as=89.3f ps=0.85u w=0.47u l=0.16u
X1328 cml_tlatch_98.OUTN cml_tlatch_98.OUTP cml_tlatch_98.xmux.xp.S1 VSS sg13_lv_nmos ad=56.9f pd=0.74u as=56.9f ps=0.74u w=0.17u l=0.17u
X1329 B2_8_P stub_bi_62.BOTP cml_tlatch_77.xmux.xn.S1 VSS sg13_lv_nmos ad=63.19999f pd=0.74u as=63.19999f ps=0.74u w=0.26u l=0.38u
X1330 cml_tlatch_16.xmux.xn.S1 cml_tlatch_1.OUTN cml_tlatch_16.OUTP VSS sg13_lv_nmos ad=63.19999f pd=0.74u as=63.19999f ps=0.74u w=0.26u l=0.38u
X1331 cml_tlatch_45.OUTN B3_2_P cml_tlatch_45.xmux.xn.S1 VSS sg13_lv_nmos ad=63.19999f pd=0.74u as=63.19999f ps=0.74u w=0.26u l=0.38u
X1332 cml_tlatch_1.xmux.xp.S1 CKB0_N cml_tlatch_1.xtail.S1 VSS sg13_lv_nmos ad=89.3f pd=0.85u as=89.3f ps=0.85u w=0.47u l=0.16u
X1333 cml_tlatch_5.xmux.xn.S1 CKHB1_P cml_tlatch_5.xtail.S1 VSS sg13_lv_nmos ad=89.3f pd=0.85u as=89.3f ps=0.85u w=0.47u l=0.16u
X1334 cml_tlatch_64.xmux.xp.S1 A3_8_N A3_8_P VSS sg13_lv_nmos ad=56.9f pd=0.74u as=56.9f ps=0.74u w=0.17u l=0.17u
X1335 cml_tlatch_64.xmux.xn.S1 CKA3_N cml_tlatch_64.xtail.S1 VSS sg13_lv_nmos ad=89.3f pd=0.85u as=89.3f ps=0.85u w=0.47u l=0.16u
X1336 cml_tlatch_16.xmux.xn.S1 cml_tlatch_1.OUTN cml_tlatch_16.OUTP VSS sg13_lv_nmos ad=63.19999f pd=0.74u as=63.19999f ps=0.74u w=0.26u l=0.38u
X1337 B1_8_N B1_8_P cml_tlatch_12.xmux.xp.S1 VSS sg13_lv_nmos ad=56.9f pd=0.74u as=56.9f ps=0.74u w=0.17u l=0.17u
X1338 cml_tlatch_35.OUTN cml_tlatch_35.OUTP cml_tlatch_35.xmux.xp.S1 VSS sg13_lv_nmos ad=56.9f pd=0.74u as=56.9f ps=0.74u w=0.17u l=0.17u
X1339 stub_bi_49.BOTP VDD VSS rppd l=5.17u w=1u
X1340 cml_tlatch_55.xmux.xp.S1 cml_tlatch_89.INP cml_tlatch_89.INN VSS sg13_lv_nmos ad=56.9f pd=0.74u as=56.9f ps=0.74u w=0.17u l=0.17u
X1341 cml_tlatch_90.xtail.S1 CKJ_P cml_tlatch_90.xmux.xp.S1 VSS sg13_lv_nmos ad=89.3f pd=0.85u as=89.3f ps=0.85u w=0.47u l=0.16u
X1342 cml_tlatch_83.INN cml_tlatch_83.INP cml_tlatch_72.xmux.xp.S1 VSS sg13_lv_nmos ad=56.9f pd=0.74u as=0.1019p ps=1.34u w=0.17u l=0.17u
X1343 A1_8_P A1_8_N cml_tlatch_21.xmux.xp.S1 VSS sg13_lv_nmos ad=56.9f pd=0.74u as=56.9f ps=0.74u w=0.17u l=0.17u
X1344 ENA_P NM1_N cml_gate2_9.xrtail.R1 VSS sg13_lv_nmos ad=0.1007p pd=0.91u as=0.1007p ps=0.91u w=0.53u l=0.13u
X1345 cml_tlatch_76.xmux.xn.S1 B2_2_P MOT23_N VSS sg13_lv_nmos ad=63.19999f pd=0.74u as=63.19999f ps=0.74u w=0.26u l=0.38u
X1346 cml_tlatch_2.xmux.xp.S1 A0_8_P A0_8_N VSS sg13_lv_nmos ad=56.9f pd=0.74u as=56.9f ps=0.74u w=0.17u l=0.17u
X1347 cml_tlatch_3.xmux.xp.S1 CKA0_N cml_tlatch_3.xtail.S1 VSS sg13_lv_nmos ad=89.3f pd=0.85u as=89.3f ps=0.85u w=0.47u l=0.16u
X1348 cml_tlatch_38.xtail.S1 CKA1_P cml_tlatch_38.xmux.xn.S1 VSS sg13_lv_nmos ad=89.3f pd=0.85u as=89.3f ps=0.85u w=0.47u l=0.16u
X1349 cml_tlatch_34.xmux.xp.S1 stub_bi_31.BOTN stub_bi_31.BOTP VSS sg13_lv_nmos ad=0.1019p pd=1.34u as=56.9f ps=0.74u w=0.17u l=0.17u
X1350 ENA_N J1_P cml_gate2_9.sg13_lv_nmos_FTPY57_0.D0 VSS sg13_lv_nmos ad=0.1007p pd=0.91u as=0.1007p ps=0.91u w=0.53u l=0.13u
X1351 cml_tlatch_82.xmux.xp.S1 CKA2_N cml_tlatch_82.xtail.S1 VSS sg13_lv_nmos ad=89.3f pd=0.85u as=89.3f ps=0.85u w=0.47u l=0.16u
X1352 GB1_N ENB1_P cml_gate2_0.sg13_lv_nmos_FTPY57_0.D0 VSS sg13_lv_nmos ad=0.1007p pd=0.91u as=0.1802p ps=1.74u w=0.53u l=0.13u
X1353 VDD cml_tlatch_58.INN VSS rppd l=5.17u w=1u
X1354 cml_tlatch_5.xmux.xp.S1 MOT11_P MOT11_N VSS sg13_lv_nmos ad=56.9f pd=0.74u as=56.9f ps=0.74u w=0.17u l=0.17u
X1355 stub_bi_29.BOTN stub_bi_29.BOTP cml_tlatch_32.xmux.xp.S1 VSS sg13_lv_nmos ad=56.9f pd=0.74u as=56.9f ps=0.74u w=0.17u l=0.17u
X1356 cml_tlatch_31.xmux.xp.S1 A0_2_N A0_2_P VSS sg13_lv_nmos ad=56.9f pd=0.74u as=56.9f ps=0.74u w=0.17u l=0.17u
X1357 cml_tlatch_19.xmux.xp.S1 MOT5_N MOT5_P VSS sg13_lv_nmos ad=56.9f pd=0.74u as=56.9f ps=0.74u w=0.17u l=0.17u
X1358 cml_gate2_2.sg13_lv_nmos_FTPY57_0.D0 CKB0_P cml_gate2_2.xrtail.R1 VSS sg13_lv_nmos ad=0.1007p pd=0.91u as=0.1007p ps=0.91u w=0.53u l=0.13u
X1359 cml_tlatch_3.xmux.xp.S1 cml_tlatch_3.OUTP cml_tlatch_3.OUTN VSS sg13_lv_nmos ad=56.9f pd=0.74u as=56.9f ps=0.74u w=0.17u l=0.17u
X1360 A1_8_P A1_8_N cml_tlatch_21.xmux.xp.S1 VSS sg13_lv_nmos ad=56.9f pd=0.74u as=56.9f ps=0.74u w=0.17u l=0.17u
X1361 cml_tlatch_14.xmux.xn.S1 CKB1_N cml_tlatch_14.xtail.S1 VSS sg13_lv_nmos ad=89.3f pd=0.85u as=89.3f ps=0.85u w=0.47u l=0.16u
X1362 B3_8_N B3_8_P cml_tlatch_60.xmux.xp.S1 VSS sg13_lv_nmos ad=56.9f pd=0.74u as=56.9f ps=0.74u w=0.17u l=0.17u
X1363 cml_tlatch_59.xtail.S1 CKHA3_P cml_tlatch_59.xmux.xn.S1 VSS sg13_lv_nmos ad=89.3f pd=0.85u as=89.3f ps=0.85u w=0.47u l=0.16u
X1364 cml_tlatch_17.xmux.xp.S1 CKHB0_N cml_tlatch_17.xtail.S1 VSS sg13_lv_nmos ad=89.3f pd=0.85u as=0.1598p ps=1.62u w=0.47u l=0.16u
X1365 MOT0_P A0_8_N cml_tlatch_97.xmux.xn.S1 VSS sg13_lv_nmos ad=0.1082p pd=1.34u as=63.19999f ps=0.74u w=0.26u l=0.38u
X1366 cml_tlatch_83.xmux.xn.S1 CKA2_N cml_tlatch_83.xtail.S1 VSS sg13_lv_nmos ad=89.3f pd=0.85u as=89.3f ps=0.85u w=0.47u l=0.16u
X1367 cml_tlatch_27.xmux.xp.S1 cml_tlatch_27.OUTN cml_tlatch_27.OUTP VSS sg13_lv_nmos ad=56.9f pd=0.74u as=56.9f ps=0.74u w=0.17u l=0.17u
X1368 cml_tlatch_22.OUTP cml_tlatch_22.OUTN cml_tlatch_22.xmux.xp.S1 VSS sg13_lv_nmos ad=56.9f pd=0.74u as=56.9f ps=0.74u w=0.17u l=0.17u
X1369 stub_bi_29.BOTP VDD VSS rppd l=5.17u w=1u
X1370 cml_tlatch_91.xmux.xp.S1 CLK_W_P CLK_W_N VSS sg13_lv_nmos ad=56.9f pd=0.74u as=56.9f ps=0.74u w=0.17u l=0.17u
X1371 cml_tlatch_12.xmux.xn.S1 CKB1_N cml_tlatch_12.xtail.S1 VSS sg13_lv_nmos ad=89.3f pd=0.85u as=89.3f ps=0.85u w=0.47u l=0.16u
X1372 cml_tlatch_50.xmux.xp.S1 MOT20_P MOT20_N VSS sg13_lv_nmos ad=56.9f pd=0.74u as=56.9f ps=0.74u w=0.17u l=0.17u
X1373 cml_tlatch_45.OUTP cml_tlatch_45.OUTN cml_tlatch_45.xmux.xp.S1 VSS sg13_lv_nmos ad=56.9f pd=0.74u as=56.9f ps=0.74u w=0.17u l=0.17u
X1374 cml_tlatch_17.xmux.xp.S1 MOT1_P MOT1_N VSS sg13_lv_nmos ad=56.9f pd=0.74u as=56.9f ps=0.74u w=0.17u l=0.17u
X1375 MOT2_P MOT2_N cml_tlatch_24.xmux.xp.S1 VSS sg13_lv_nmos ad=56.9f pd=0.74u as=56.9f ps=0.74u w=0.17u l=0.17u
X1376 MOT30_N MOT30_P cml_tlatch_59.xmux.xp.S1 VSS sg13_lv_nmos ad=56.9f pd=0.74u as=0.1019p ps=1.34u w=0.17u l=0.17u
X1377 cml_tlatch_10.xmux.xn.S1 CKB0_N cml_tlatch_10.xtail.S1 VSS sg13_lv_nmos ad=89.3f pd=0.85u as=89.3f ps=0.85u w=0.47u l=0.16u
X1378 cml_tlatch_83.INN cml_tlatch_83.INP cml_tlatch_72.xmux.xp.S1 VSS sg13_lv_nmos ad=56.9f pd=0.74u as=56.9f ps=0.74u w=0.17u l=0.17u
X1379 cml_tlatch_61.OUTN cml_tlatch_61.OUTP cml_tlatch_61.xmux.xp.S1 VSS sg13_lv_nmos ad=56.9f pd=0.74u as=56.9f ps=0.74u w=0.17u l=0.17u
X1380 A3_8_N cml_tlatch_65.OUTP cml_tlatch_64.xmux.xn.S1 VSS sg13_lv_nmos ad=63.19999f pd=0.74u as=63.19999f ps=0.74u w=0.26u l=0.38u
X1381 cml_gate2_4.xrtail.R1 CKB2_N GA2_P VSS sg13_lv_nmos ad=0.1007p pd=0.91u as=0.1007p ps=0.91u w=0.53u l=0.13u
X1382 cml_tlatch_40.xmux.xp.S1 MOT12_P MOT12_N VSS sg13_lv_nmos ad=56.9f pd=0.74u as=56.9f ps=0.74u w=0.17u l=0.17u
X1383 cml_tlatch_95.xmux.xn.S1 CKA1_N cml_tlatch_95.xtail.S1 VSS sg13_lv_nmos ad=89.3f pd=0.85u as=89.3f ps=0.85u w=0.47u l=0.16u
X1384 cml_tlatch_91.xmux.xp.S1 CLK_W_N CLK_W_P VSS sg13_lv_nmos ad=56.9f pd=0.74u as=56.9f ps=0.74u w=0.17u l=0.17u
X1385 cml_tlatch_60.xmux.xp.S1 B3_8_P B3_8_N VSS sg13_lv_nmos ad=56.9f pd=0.74u as=56.9f ps=0.74u w=0.17u l=0.17u
X1386 cml_tlatch_53.xmux.xn.S1 CKA3_N cml_tlatch_53.xtail.S1 VSS sg13_lv_nmos ad=89.3f pd=0.85u as=89.3f ps=0.85u w=0.47u l=0.16u
X1387 cml_tlatch_20.xmux.xn.S1 CKHB0_P cml_tlatch_20.xtail.S1 VSS sg13_lv_nmos ad=89.3f pd=0.85u as=89.3f ps=0.85u w=0.47u l=0.16u
X1388 cml_tlatch_63.xmux.xp.S1 CKB3_N cml_tlatch_63.xtail.S1 VSS sg13_lv_nmos ad=89.3f pd=0.85u as=89.3f ps=0.85u w=0.47u l=0.16u
X1389 cml_tlatch_73.xmux.xp.S1 CKHB2_N cml_tlatch_73.xtail.S1 VSS sg13_lv_nmos ad=89.3f pd=0.85u as=89.3f ps=0.85u w=0.47u l=0.16u
X1390 cml_tlatch_95.INN cml_tlatch_95.INP cml_tlatch_36.xmux.xp.S1 VSS sg13_lv_nmos ad=56.9f pd=0.74u as=56.9f ps=0.74u w=0.17u l=0.17u
X1391 cml_tlatch_13.xmux.xp.S1 stub_bi_17.BOTN stub_bi_17.BOTP VSS sg13_lv_nmos ad=56.9f pd=0.74u as=56.9f ps=0.74u w=0.17u l=0.17u
X1392 cml_tlatch_72.xmux.xp.S1 cml_tlatch_83.INN cml_tlatch_83.INP VSS sg13_lv_nmos ad=56.9f pd=0.74u as=56.9f ps=0.74u w=0.17u l=0.17u
X1393 cml_tlatch_1.OUTN cml_tlatch_1.OUTP cml_tlatch_1.xmux.xp.S1 VSS sg13_lv_nmos ad=56.9f pd=0.74u as=56.9f ps=0.74u w=0.17u l=0.17u
X1394 stub_bi_55.BOTP stub_bi_55.BOTN cml_tlatch_88.xmux.xp.S1 VSS sg13_lv_nmos ad=56.9f pd=0.74u as=56.9f ps=0.74u w=0.17u l=0.17u
X1395 cml_tlatch_50.xtail.S1 CKHA2_N cml_tlatch_50.xmux.xp.S1 VSS sg13_lv_nmos ad=89.3f pd=0.85u as=89.3f ps=0.85u w=0.47u l=0.16u
X1396 cml_tlatch_29.xmux.xp.S1 cml_tlatch_29.OUTP cml_tlatch_29.OUTN VSS sg13_lv_nmos ad=56.9f pd=0.74u as=56.9f ps=0.74u w=0.17u l=0.17u
X1397 cml_tlatch_40.xmux.xn.S1 CKHA1_P cml_tlatch_40.xtail.S1 VSS sg13_lv_nmos ad=89.3f pd=0.85u as=89.3f ps=0.85u w=0.47u l=0.16u
X1398 cml_tlatch_8.OUTN cml_tlatch_8.OUTP cml_tlatch_8.xmux.xp.S1 VSS sg13_lv_nmos ad=56.9f pd=0.74u as=56.9f ps=0.74u w=0.17u l=0.17u
X1399 cml_tlatch_94.xmux.xn.S1 CKB1_N cml_tlatch_94.xtail.S1 VSS sg13_lv_nmos ad=89.3f pd=0.85u as=89.3f ps=0.85u w=0.47u l=0.16u
X1400 cml_tlatch_45.xmux.xp.S1 cml_tlatch_45.OUTN cml_tlatch_45.OUTP VSS sg13_lv_nmos ad=56.9f pd=0.74u as=56.9f ps=0.74u w=0.17u l=0.17u
X1401 cml_tlatch_48.xtail.S1 CKB2_N cml_tlatch_48.xmux.xp.S1 VSS sg13_lv_nmos ad=89.3f pd=0.85u as=89.3f ps=0.85u w=0.47u l=0.16u
X1402 cml_tlatch_25.xmux.xp.S1 MOT4_N MOT4_P VSS sg13_lv_nmos ad=56.9f pd=0.74u as=56.9f ps=0.74u w=0.17u l=0.17u
X1403 cml_drvb_5.xrtail.R1 GA3_P CKHA3_N VSS sg13_lv_nmos ad=0.1463p pd=1.15u as=0.2618p ps=2.22u w=0.77u l=0.21u
X1404 cml_tlatch_24.xmux.xp.S1 MOT2_P MOT2_N VSS sg13_lv_nmos ad=56.9f pd=0.74u as=56.9f ps=0.74u w=0.17u l=0.17u
X1405 cml_tlatch_64.xmux.xp.S1 A3_8_N A3_8_P VSS sg13_lv_nmos ad=56.9f pd=0.74u as=56.9f ps=0.74u w=0.17u l=0.17u
X1406 B3_8_P B3_8_N cml_tlatch_60.xmux.xp.S1 VSS sg13_lv_nmos ad=56.9f pd=0.74u as=56.9f ps=0.74u w=0.17u l=0.17u
X1407 cml_tlatch_5.xmux.xp.S1 CKHB1_N cml_tlatch_5.xtail.S1 VSS sg13_lv_nmos ad=89.3f pd=0.85u as=89.3f ps=0.85u w=0.47u l=0.16u
X1408 A1_2_N A1_2_P cml_tlatch_37.xmux.xp.S1 VSS sg13_lv_nmos ad=56.9f pd=0.74u as=56.9f ps=0.74u w=0.17u l=0.17u
X1409 ENB1_P ENB_N cml_drv_0.xrtail.R1 VSS sg13_lv_nmos ad=0.1012p pd=1.34u as=56.2f ps=0.74u w=0.16u l=0.19u
X1410 B0_8_P B0_8_N cml_tlatch_10.xmux.xp.S1 VSS sg13_lv_nmos ad=56.9f pd=0.74u as=56.9f ps=0.74u w=0.17u l=0.17u
X1411 cml_tlatch_15.xmux.xn.S1 CKB1_P cml_tlatch_15.xtail.S1 VSS sg13_lv_nmos ad=89.3f pd=0.85u as=89.3f ps=0.85u w=0.47u l=0.16u
X1412 cml_tlatch_58.xtail.S1 CKHA3_N cml_tlatch_58.xmux.xp.S1 VSS sg13_lv_nmos ad=89.3f pd=0.85u as=89.3f ps=0.85u w=0.47u l=0.16u
X1413 cml_tlatch_88.xmux.xn.S1 stub_bi_42.BOTP stub_bi_55.BOTN VSS sg13_lv_nmos ad=63.19999f pd=0.74u as=0.1082p ps=1.34u w=0.26u l=0.38u
X1414 cml_tlatch_66.xmux.xn.S1 cml_tlatch_67.OUTP cml_tlatch_57.INN VSS sg13_lv_nmos ad=63.19999f pd=0.74u as=63.19999f ps=0.74u w=0.26u l=0.38u
X1415 cml_gate2_9.sg13_lv_nmos_FTPY57_0.D0 J1_P ENA_N VSS sg13_lv_nmos ad=0.1007p pd=0.91u as=0.1007p ps=0.91u w=0.53u l=0.13u
X1416 cml_tlatch_91.xtail.S1 CKJ_N cml_tlatch_91.xmux.xp.S1 VSS sg13_lv_nmos ad=89.3f pd=0.85u as=89.3f ps=0.85u w=0.47u l=0.16u
X1417 stub_bi_55.BOTP stub_bi_42.BOTN cml_tlatch_88.xmux.xn.S1 VSS sg13_lv_nmos ad=63.19999f pd=0.74u as=63.19999f ps=0.74u w=0.26u l=0.38u
X1418 cml_tlatch_4.xmux.xn.S1 B1_8_P MOT9_N VSS sg13_lv_nmos ad=63.19999f pd=0.74u as=0.1082p ps=1.34u w=0.26u l=0.38u
X1419 cml_tlatch_38.OUTP cml_tlatch_38.OUTN cml_tlatch_38.xmux.xp.S1 VSS sg13_lv_nmos ad=56.9f pd=0.74u as=56.9f ps=0.74u w=0.17u l=0.17u
X1420 cml_tlatch_12.xmux.xp.S1 B1_8_N B1_8_P VSS sg13_lv_nmos ad=56.9f pd=0.74u as=56.9f ps=0.74u w=0.17u l=0.17u
X1421 MOT28_N cml_tlatch_58.INP cml_tlatch_58.xmux.xn.S1 VSS sg13_lv_nmos ad=63.19999f pd=0.74u as=63.19999f ps=0.74u w=0.26u l=0.38u
X1422 B2_2_P B2_2_N cml_tlatch_44.xmux.xp.S1 VSS sg13_lv_nmos ad=56.9f pd=0.74u as=56.9f ps=0.74u w=0.17u l=0.17u
X1423 cml_tlatch_9.xmux.xp.S1 cml_tlatch_9.OUTN cml_tlatch_9.OUTP VSS sg13_lv_nmos ad=56.9f pd=0.74u as=56.9f ps=0.74u w=0.17u l=0.17u
X1424 cml_tlatch_33.xmux.xn.S1 CKB1_N cml_tlatch_33.xtail.S1 VSS sg13_lv_nmos ad=89.3f pd=0.85u as=89.3f ps=0.85u w=0.47u l=0.16u
X1425 MOT21_N MOT21_P cml_tlatch_75.xmux.xp.S1 VSS sg13_lv_nmos ad=56.9f pd=0.74u as=56.9f ps=0.74u w=0.17u l=0.17u
X1426 cml_tlatch_70.xmux.xp.S1 MOT29_P MOT29_N VSS sg13_lv_nmos ad=56.9f pd=0.74u as=56.9f ps=0.74u w=0.17u l=0.17u
X1427 hs_to_clk_3.D2 CK_N CKA1_N VSS sg13_lv_nmos ad=0.228p pd=1.58u as=0.228p ps=1.58u w=1.2u l=0.2u
X1428 cml_tlatch_61.xmux.xp.S1 cml_tlatch_61.OUTN cml_tlatch_61.OUTP VSS sg13_lv_nmos ad=56.9f pd=0.74u as=56.9f ps=0.74u w=0.17u l=0.17u
X1429 cml_tlatch_50.xmux.xp.S1 MOT20_N MOT20_P VSS sg13_lv_nmos ad=56.9f pd=0.74u as=56.9f ps=0.74u w=0.17u l=0.17u
X1430 cml_tlatch_19.xmux.xp.S1 MOT5_N MOT5_P VSS sg13_lv_nmos ad=0.1019p pd=1.34u as=56.9f ps=0.74u w=0.17u l=0.17u
X1431 A0_2_N A0_2_P cml_tlatch_31.xmux.xp.S1 VSS sg13_lv_nmos ad=56.9f pd=0.74u as=56.9f ps=0.74u w=0.17u l=0.17u
X1432 B0_2_P B0_2_N cml_tlatch_28.xmux.xp.S1 VSS sg13_lv_nmos ad=56.9f pd=0.74u as=0.1019p ps=1.34u w=0.17u l=0.17u
X1433 cml_tlatch_54.xmux.xn.S1 CKA3_P cml_tlatch_54.xtail.S1 VSS sg13_lv_nmos ad=0.1598p pd=1.62u as=89.3f ps=0.85u w=0.47u l=0.16u
X1434 MOT9_N MOT9_P cml_tlatch_4.xmux.xp.S1 VSS sg13_lv_nmos ad=56.9f pd=0.74u as=56.9f ps=0.74u w=0.17u l=0.17u
X1435 cml_tlatch_99.xmux.xp.S1 cml_tlatch_99.OUTN cml_tlatch_99.OUTP VSS sg13_lv_nmos ad=56.9f pd=0.74u as=56.9f ps=0.74u w=0.17u l=0.17u
X1436 cml_tlatch_97.xmux.xp.S1 CKHA0_N cml_tlatch_97.xtail.S1 VSS sg13_lv_nmos ad=89.3f pd=0.85u as=89.3f ps=0.85u w=0.47u l=0.16u
X1437 VSS POLN cml_tlatch_74.xtail.S1 VSS sg13_lv_nmos ad=2.7982p pd=17.14u as=1.5637p ps=8.61u w=8.23u l=0.13u
X1438 cml_tlatch_21.xmux.xp.S1 CKA1_P cml_tlatch_21.xtail.S1 VSS sg13_lv_nmos ad=89.3f pd=0.85u as=89.3f ps=0.85u w=0.47u l=0.16u
X1439 cml_tlatch_52.xmux.xp.S1 cml_tlatch_52.OUTP cml_tlatch_52.OUTN VSS sg13_lv_nmos ad=56.9f pd=0.74u as=56.9f ps=0.74u w=0.17u l=0.17u
X1440 cml_tlatch_59.xtail.S1 CKHA3_N cml_tlatch_59.xmux.xp.S1 VSS sg13_lv_nmos ad=0.1598p pd=1.62u as=89.3f ps=0.85u w=0.47u l=0.16u
X1441 MOT19_P MOT19_N cml_tlatch_74.xmux.xp.S1 VSS sg13_lv_nmos ad=56.9f pd=0.74u as=56.9f ps=0.74u w=0.17u l=0.17u
X1442 cml_tlatch_20.xmux.xp.S1 MOT7_N MOT7_P VSS sg13_lv_nmos ad=56.9f pd=0.74u as=56.9f ps=0.74u w=0.17u l=0.17u
X1443 cml_tlatch_51.xmux.xp.S1 MOT22_N MOT22_P VSS sg13_lv_nmos ad=56.9f pd=0.74u as=56.9f ps=0.74u w=0.17u l=0.17u
X1444 cml_tlatch_88.xmux.xp.S1 CKB2_P cml_tlatch_88.xtail.S1 VSS sg13_lv_nmos ad=89.3f pd=0.85u as=89.3f ps=0.85u w=0.47u l=0.16u
X1445 cml_tlatch_32.xmux.xp.S1 stub_bi_29.BOTN stub_bi_29.BOTP VSS sg13_lv_nmos ad=56.9f pd=0.74u as=56.9f ps=0.74u w=0.17u l=0.17u
X1446 VSS POLN cml_tlatch_56.xtail.S1 VSS sg13_lv_nmos ad=1.5637p pd=8.61u as=1.5637p ps=8.61u w=8.23u l=0.13u
X1447 VSS hs_to_clk_4.sg13_lv_nmos_2HGZLP_0.G VSS VSS sg13_lv_nmos ad=2.071p pd=11.28u as=0 ps=0 w=10.9u l=1.38u
X1448 cml_tlatch_8.xtail.S1 POLN VSS VSS sg13_lv_nmos ad=1.5637p pd=8.61u as=2.7982p ps=17.14u w=8.23u l=0.13u
X1449 MOT11_P MOT11_N cml_tlatch_5.xmux.xp.S1 VSS sg13_lv_nmos ad=56.9f pd=0.74u as=56.9f ps=0.74u w=0.17u l=0.17u
X1450 cml_tlatch_40.xtail.S1 POLN VSS VSS sg13_lv_nmos ad=1.5637p pd=8.61u as=1.5637p ps=8.61u w=8.23u l=0.13u
X1451 MOT18_N MOT18_P cml_tlatch_49.xmux.xp.S1 VSS sg13_lv_nmos ad=56.9f pd=0.74u as=0.1019p ps=1.34u w=0.17u l=0.17u
X1452 cml_tlatch_22.xmux.xn.S1 CKA1_P cml_tlatch_22.xtail.S1 VSS sg13_lv_nmos ad=89.3f pd=0.85u as=89.3f ps=0.85u w=0.47u l=0.16u
X1453 VSS POLN cml_tlatch_82.xtail.S1 VSS sg13_lv_nmos ad=2.7982p pd=17.14u as=1.5637p ps=8.61u w=8.23u l=0.13u
X1454 cml_tlatch_27.xmux.xn.S1 B0_2_N cml_tlatch_27.OUTP VSS sg13_lv_nmos ad=63.19999f pd=0.74u as=0.1082p ps=1.34u w=0.26u l=0.38u
X1455 cml_tlatch_89.OUTP cml_tlatch_89.OUTN cml_tlatch_89.xmux.xp.S1 VSS sg13_lv_nmos ad=56.9f pd=0.74u as=56.9f ps=0.74u w=0.17u l=0.17u
X1456 cml_tlatch_53.xmux.xp.S1 A3_2_P A3_2_N VSS sg13_lv_nmos ad=56.9f pd=0.74u as=56.9f ps=0.74u w=0.17u l=0.17u
X1457 cml_tlatch_88.xmux.xp.S1 stub_bi_55.BOTP stub_bi_55.BOTN VSS sg13_lv_nmos ad=56.9f pd=0.74u as=56.9f ps=0.74u w=0.17u l=0.17u
X1458 cml_tlatch_16.xmux.xp.S1 cml_tlatch_16.OUTP cml_tlatch_16.OUTN VSS sg13_lv_nmos ad=56.9f pd=0.74u as=56.9f ps=0.74u w=0.17u l=0.17u
X1459 cml_tlatch_99.OUTN cml_tlatch_99.OUTP cml_tlatch_99.xmux.xp.S1 VSS sg13_lv_nmos ad=56.9f pd=0.74u as=0.1019p ps=1.34u w=0.17u l=0.17u
X1460 cml_tlatch_57.xmux.xn.S1 cml_tlatch_57.INP MOT26_N VSS sg13_lv_nmos ad=63.19999f pd=0.74u as=63.19999f ps=0.74u w=0.26u l=0.38u
X1461 cml_tlatch_41.xtail.S1 CKHA1_N cml_tlatch_41.xmux.xp.S1 VSS sg13_lv_nmos ad=89.3f pd=0.85u as=89.3f ps=0.85u w=0.47u l=0.16u
X1462 cml_tlatch_99.xtail.S1 POLN VSS VSS sg13_lv_nmos ad=1.5637p pd=8.61u as=1.5637p ps=8.61u w=8.23u l=0.13u
X1463 cml_tlatch_87.xmux.xp.S1 MOT16_N MOT16_P VSS sg13_lv_nmos ad=56.9f pd=0.74u as=56.9f ps=0.74u w=0.17u l=0.17u
X1464 MOT13_P cml_tlatch_6.INN cml_tlatch_6.xmux.xn.S1 VSS sg13_lv_nmos ad=63.19999f pd=0.74u as=63.19999f ps=0.74u w=0.26u l=0.38u
X1465 cml_tlatch_76.xmux.xp.S1 MOT23_N MOT23_P VSS sg13_lv_nmos ad=56.9f pd=0.74u as=56.9f ps=0.74u w=0.17u l=0.17u
X1466 cml_gate2_7.sg13_lv_nmos_FTPY57_0.D0 ENB0_N GB2_P VSS sg13_lv_nmos ad=0.1007p pd=0.91u as=0.1007p ps=0.91u w=0.53u l=0.13u
X1467 B0_2_P B0_2_N cml_tlatch_28.xmux.xp.S1 VSS sg13_lv_nmos ad=56.9f pd=0.74u as=56.9f ps=0.74u w=0.17u l=0.17u
X1468 MOT0_N A0_8_P cml_tlatch_97.xmux.xn.S1 VSS sg13_lv_nmos ad=63.19999f pd=0.74u as=0.1082p ps=1.34u w=0.26u l=0.38u
X1469 cml_tlatch_81.xmux.xp.S1 A2_8_P A2_8_N VSS sg13_lv_nmos ad=0.1019p pd=1.34u as=56.9f ps=0.74u w=0.17u l=0.17u
X1470 stub_bi_31.BOTN D1_N cml_tlatch_34.xmux.xn.S1 VSS sg13_lv_nmos ad=63.19999f pd=0.74u as=63.19999f ps=0.74u w=0.26u l=0.38u
X1471 cml_tlatch_55.xmux.xn.S1 CKA2_P cml_tlatch_55.xtail.S1 VSS sg13_lv_nmos ad=89.3f pd=0.85u as=0.1598p ps=1.62u w=0.47u l=0.16u
X1472 cml_tlatch_63.xmux.xn.S1 cml_tlatch_70.INP cml_tlatch_63.OUTN VSS sg13_lv_nmos ad=63.19999f pd=0.74u as=63.19999f ps=0.74u w=0.26u l=0.38u
X1473 cml_tlatch_13.xmux.xn.S1 CKB1_P cml_tlatch_13.xtail.S1 VSS sg13_lv_nmos ad=89.3f pd=0.85u as=89.3f ps=0.85u w=0.47u l=0.16u
X1474 cml_tlatch_96.xmux.xp.S1 MOT8_N MOT8_P VSS sg13_lv_nmos ad=56.9f pd=0.74u as=56.9f ps=0.74u w=0.17u l=0.17u
X1475 MOT3_P cml_tlatch_16.OUTN cml_tlatch_18.xmux.xn.S1 VSS sg13_lv_nmos ad=63.19999f pd=0.74u as=63.19999f ps=0.74u w=0.26u l=0.38u
X1476 cml_tlatch_30.xmux.xn.S1 CKA0_P cml_tlatch_30.xtail.S1 VSS sg13_lv_nmos ad=89.3f pd=0.85u as=89.3f ps=0.85u w=0.47u l=0.16u
X1477 cml_tlatch_47.xmux.xp.S1 cml_tlatch_47.OUTN cml_tlatch_47.OUTP VSS sg13_lv_nmos ad=56.9f pd=0.74u as=56.9f ps=0.74u w=0.17u l=0.17u
X1478 cml_tlatch_13.xmux.xn.S1 cml_tlatch_5.INP stub_bi_17.BOTP VSS sg13_lv_nmos ad=63.19999f pd=0.74u as=63.19999f ps=0.74u w=0.26u l=0.38u
X1479 cml_tlatch_83.OUTP cml_tlatch_83.OUTN cml_tlatch_83.xmux.xp.S1 VSS sg13_lv_nmos ad=56.9f pd=0.74u as=56.9f ps=0.74u w=0.17u l=0.17u
X1480 cml_tlatch_10.xtail.S1 CKB0_N cml_tlatch_10.xmux.xn.S1 VSS sg13_lv_nmos ad=89.3f pd=0.85u as=0.1598p ps=1.62u w=0.47u l=0.16u
X1481 cml_tlatch_0.xmux.xp.S1 interco_bi_19.INP interco_bi_19.INN VSS sg13_lv_nmos ad=56.9f pd=0.74u as=56.9f ps=0.74u w=0.17u l=0.17u
X1482 cml_tlatch_13.xmux.xn.S1 cml_tlatch_5.INP stub_bi_17.BOTP VSS sg13_lv_nmos ad=63.19999f pd=0.74u as=63.19999f ps=0.74u w=0.26u l=0.38u
X1483 cml_tlatch_78.xmux.xp.S1 stub_bi_62.BOTN stub_bi_62.BOTP VSS sg13_lv_nmos ad=56.9f pd=0.74u as=56.9f ps=0.74u w=0.17u l=0.17u
X1484 cml_tlatch_55.xmux.xp.S1 cml_tlatch_89.INN cml_tlatch_89.INP VSS sg13_lv_nmos ad=0.1019p pd=1.34u as=56.9f ps=0.74u w=0.17u l=0.17u
X1485 cml_tlatch_55.xmux.xn.S1 A2_2_N cml_tlatch_89.INP VSS sg13_lv_nmos ad=63.19999f pd=0.74u as=63.19999f ps=0.74u w=0.26u l=0.38u
X1486 MOT18_N MOT18_P cml_tlatch_49.xmux.xp.S1 VSS sg13_lv_nmos ad=56.9f pd=0.74u as=56.9f ps=0.74u w=0.17u l=0.17u
X1487 cml_tlatch_96.xmux.xn.S1 A1_8_P MOT8_N VSS sg13_lv_nmos ad=0.1082p pd=1.34u as=63.19999f ps=0.74u w=0.26u l=0.38u
X1488 cml_tlatch_30.OUTN cml_tlatch_30.OUTP cml_tlatch_30.xmux.xp.S1 VSS sg13_lv_nmos ad=56.9f pd=0.74u as=56.9f ps=0.74u w=0.17u l=0.17u
X1489 cml_tlatch_86.xmux.xp.S1 MOT24_P MOT24_N VSS sg13_lv_nmos ad=56.9f pd=0.74u as=56.9f ps=0.74u w=0.17u l=0.17u
X1490 VSS POLN cml_tlatch_14.xtail.S1 VSS sg13_lv_nmos ad=2.7982p pd=17.14u as=1.5637p ps=8.61u w=8.23u l=0.13u
X1491 cml_tlatch_73.xtail.S1 CKHB2_N cml_tlatch_73.xmux.xp.S1 VSS sg13_lv_nmos ad=89.3f pd=0.85u as=89.3f ps=0.85u w=0.47u l=0.16u
X1492 cml_tlatch_31.xmux.xn.S1 CKA0_N cml_tlatch_31.xtail.S1 VSS sg13_lv_nmos ad=89.3f pd=0.85u as=89.3f ps=0.85u w=0.47u l=0.16u
X1493 cml_tlatch_3.xmux.xp.S1 CKA0_N cml_tlatch_3.xtail.S1 VSS sg13_lv_nmos ad=89.3f pd=0.85u as=89.3f ps=0.85u w=0.47u l=0.16u
X1494 cml_tlatch_9.xmux.xp.S1 cml_tlatch_9.OUTN cml_tlatch_9.OUTP VSS sg13_lv_nmos ad=56.9f pd=0.74u as=56.9f ps=0.74u w=0.17u l=0.17u
X1495 cml_tlatch_63.xtail.S1 CKB3_P cml_tlatch_63.xmux.xn.S1 VSS sg13_lv_nmos ad=89.3f pd=0.85u as=89.3f ps=0.85u w=0.47u l=0.16u
X1496 MOT19_N stub_bi_63.BOTN cml_tlatch_74.xmux.xn.S1 VSS sg13_lv_nmos ad=63.19999f pd=0.74u as=63.19999f ps=0.74u w=0.26u l=0.38u
X1497 cml_tlatch_29.xmux.xn.S1 CKB0_P cml_tlatch_29.xtail.S1 VSS sg13_lv_nmos ad=89.3f pd=0.85u as=89.3f ps=0.85u w=0.47u l=0.16u
X1498 cml_tlatch_11.xmux.xp.S1 cml_tlatch_11.OUTP cml_tlatch_11.OUTN VSS sg13_lv_nmos ad=0.1019p pd=1.34u as=56.9f ps=0.74u w=0.17u l=0.17u
X1499 ENA1_N VDD VSS rppd l=8.13u w=1u
X1500 ENB_N J2_P cml_gate2_8.sg13_lv_nmos_FTPY57_0.D0 VSS sg13_lv_nmos ad=0.1007p pd=0.91u as=0.1007p ps=0.91u w=0.53u l=0.13u
X1501 cml_tlatch_82.OUTP cml_tlatch_82.OUTN cml_tlatch_82.xmux.xp.S1 VSS sg13_lv_nmos ad=56.9f pd=0.74u as=56.9f ps=0.74u w=0.17u l=0.17u
X1502 MOT28_P MOT28_N cml_tlatch_58.xmux.xp.S1 VSS sg13_lv_nmos ad=56.9f pd=0.74u as=56.9f ps=0.74u w=0.17u l=0.17u
X1503 cml_tlatch_99.xmux.xp.S1 CKA0_P cml_tlatch_99.xtail.S1 VSS sg13_lv_nmos ad=89.3f pd=0.85u as=89.3f ps=0.85u w=0.47u l=0.16u
X1504 CLK_W_N J2_N cml_tlatch_91.xmux.xn.S1 VSS sg13_lv_nmos ad=63.19999f pd=0.74u as=63.19999f ps=0.74u w=0.26u l=0.38u
X1505 cml_tlatch_60.xmux.xn.S1 CKB3_N cml_tlatch_60.xtail.S1 VSS sg13_lv_nmos ad=89.3f pd=0.85u as=89.3f ps=0.85u w=0.47u l=0.16u
X1506 cml_tlatch_70.xtail.S1 POLN VSS VSS sg13_lv_nmos ad=1.5637p pd=8.61u as=2.7982p ps=17.14u w=8.23u l=0.13u
X1507 cml_gate2_7.xrtail.R1 CKA2_P cml_gate2_7.sg13_lv_nmos_FTPY57_0.D0 VSS sg13_lv_nmos ad=0.1007p pd=0.91u as=0.1007p ps=0.91u w=0.53u l=0.13u
X1508 cml_tlatch_17.xmux.xp.S1 MOT1_N MOT1_P VSS sg13_lv_nmos ad=56.9f pd=0.74u as=56.9f ps=0.74u w=0.17u l=0.17u
X1509 cml_tlatch_25.xmux.xn.S1 cml_tlatch_99.OUTN MOT4_P VSS sg13_lv_nmos ad=63.19999f pd=0.74u as=63.19999f ps=0.74u w=0.26u l=0.38u
X1510 cml_tlatch_35.xmux.xn.S1 D0_N cml_tlatch_35.OUTP VSS sg13_lv_nmos ad=63.19999f pd=0.74u as=63.19999f ps=0.74u w=0.26u l=0.38u
X1511 A1_8_P cml_tlatch_22.OUTN cml_tlatch_21.xmux.xn.S1 VSS sg13_lv_nmos ad=63.19999f pd=0.74u as=63.19999f ps=0.74u w=0.26u l=0.38u
X1512 MOT18_P MOT18_N cml_tlatch_49.xmux.xp.S1 VSS sg13_lv_nmos ad=56.9f pd=0.74u as=56.9f ps=0.74u w=0.17u l=0.17u
X1513 cml_tlatch_89.INN A2_2_P cml_tlatch_55.xmux.xn.S1 VSS sg13_lv_nmos ad=63.19999f pd=0.74u as=0.1082p ps=1.34u w=0.26u l=0.38u
X1514 MOT22_P A2_2_N cml_tlatch_51.xmux.xn.S1 VSS sg13_lv_nmos ad=63.19999f pd=0.74u as=0.1082p ps=1.34u w=0.26u l=0.38u
X1515 cml_tlatch_48.xmux.xp.S1 CKB2_N cml_tlatch_48.xtail.S1 VSS sg13_lv_nmos ad=89.3f pd=0.85u as=89.3f ps=0.85u w=0.47u l=0.16u
X1516 cml_tlatch_68.xtail.S1 CKHB3_N cml_tlatch_68.xmux.xp.S1 VSS sg13_lv_nmos ad=89.3f pd=0.85u as=89.3f ps=0.85u w=0.47u l=0.16u
X1517 VSS POLN cml_tlatch_5.xtail.S1 VSS sg13_lv_nmos ad=1.5637p pd=8.61u as=1.5637p ps=8.61u w=8.23u l=0.13u
X1518 cml_tlatch_37.xtail.S1 POLN VSS VSS sg13_lv_nmos ad=1.5637p pd=8.61u as=1.5637p ps=8.61u w=8.23u l=0.13u
X1519 cml_tlatch_54.xmux.xp.S1 CKA3_N cml_tlatch_54.xtail.S1 VSS sg13_lv_nmos ad=89.3f pd=0.85u as=0.1598p ps=1.62u w=0.47u l=0.16u
X1520 B1_2_N B1_2_P cml_tlatch_33.xmux.xp.S1 VSS sg13_lv_nmos ad=56.9f pd=0.74u as=56.9f ps=0.74u w=0.17u l=0.17u
X1521 cml_tlatch_15.xtail.S1 CKB1_P cml_tlatch_15.xmux.xn.S1 VSS sg13_lv_nmos ad=89.3f pd=0.85u as=0.1598p ps=1.62u w=0.47u l=0.16u
X1522 hs_to_clk_2.D2 CK_P CKB1_N VSS sg13_lv_nmos ad=0.408p pd=3.08u as=0.228p ps=1.58u w=1.2u l=0.2u
X1523 MOT10_P MOT10_N cml_tlatch_39.xmux.xp.S1 VSS sg13_lv_nmos ad=56.9f pd=0.74u as=56.9f ps=0.74u w=0.17u l=0.17u
X1524 cml_tlatch_45.OUTP VDD VSS rppd l=5.17u w=1u
X1525 cml_tlatch_97.xtail.S1 CKHA0_P cml_tlatch_97.xmux.xn.S1 VSS sg13_lv_nmos ad=89.3f pd=0.85u as=89.3f ps=0.85u w=0.47u l=0.16u
X1526 cml_tlatch_52.xtail.S1 CKA3_P cml_tlatch_52.xmux.xn.S1 VSS sg13_lv_nmos ad=89.3f pd=0.85u as=89.3f ps=0.85u w=0.47u l=0.16u
X1527 cml_tlatch_64.xtail.S1 CKA3_P cml_tlatch_64.xmux.xp.S1 VSS sg13_lv_nmos ad=89.3f pd=0.85u as=89.3f ps=0.85u w=0.47u l=0.16u
X1528 cml_tlatch_70.xmux.xp.S1 CKHB3_N cml_tlatch_70.xtail.S1 VSS sg13_lv_nmos ad=89.3f pd=0.85u as=89.3f ps=0.85u w=0.47u l=0.16u
X1529 cml_tlatch_85.xmux.xp.S1 cml_tlatch_58.INP cml_tlatch_58.INN VSS sg13_lv_nmos ad=56.9f pd=0.74u as=56.9f ps=0.74u w=0.17u l=0.17u
X1530 cml_tlatch_73.xmux.xp.S1 MOT17_N MOT17_P VSS sg13_lv_nmos ad=56.9f pd=0.74u as=56.9f ps=0.74u w=0.17u l=0.17u
X1531 MOT11_P MOT11_N cml_tlatch_5.xmux.xp.S1 VSS sg13_lv_nmos ad=56.9f pd=0.74u as=56.9f ps=0.74u w=0.17u l=0.17u
X1532 cml_tlatch_35.xmux.xp.S1 cml_tlatch_35.OUTN cml_tlatch_35.OUTP VSS sg13_lv_nmos ad=56.9f pd=0.74u as=56.9f ps=0.74u w=0.17u l=0.17u
X1533 cml_tlatch_79.xmux.xn.S1 CKB2_N cml_tlatch_79.xtail.S1 VSS sg13_lv_nmos ad=89.3f pd=0.85u as=89.3f ps=0.85u w=0.47u l=0.16u
X1534 cml_tlatch_88.xmux.xp.S1 stub_bi_55.BOTP stub_bi_55.BOTN VSS sg13_lv_nmos ad=56.9f pd=0.74u as=56.9f ps=0.74u w=0.17u l=0.17u
X1535 cml_tlatch_3.OUTP cml_tlatch_3.OUTN cml_tlatch_3.xmux.xp.S1 VSS sg13_lv_nmos ad=56.9f pd=0.74u as=56.9f ps=0.74u w=0.17u l=0.17u
X1536 MOT6_N MOT6_P cml_tlatch_26.xmux.xp.S1 VSS sg13_lv_nmos ad=56.9f pd=0.74u as=56.9f ps=0.74u w=0.17u l=0.17u
X1537 MOT24_P MOT24_N cml_tlatch_86.xmux.xp.S1 VSS sg13_lv_nmos ad=56.9f pd=0.74u as=56.9f ps=0.74u w=0.17u l=0.17u
X1538 cml_tlatch_20.xmux.xn.S1 CKHB0_P cml_tlatch_20.xtail.S1 VSS sg13_lv_nmos ad=89.3f pd=0.85u as=89.3f ps=0.85u w=0.47u l=0.16u
X1539 MOT31_P MOT31_N cml_tlatch_71.xmux.xp.S1 VSS sg13_lv_nmos ad=56.9f pd=0.74u as=56.9f ps=0.74u w=0.17u l=0.17u
X1540 cml_tlatch_92.xmux.xp.S1 J2_N J2_P VSS sg13_lv_nmos ad=56.9f pd=0.74u as=56.9f ps=0.74u w=0.17u l=0.17u
X1541 cml_tlatch_65.OUTN cml_tlatch_65.OUTP cml_tlatch_65.xmux.xp.S1 VSS sg13_lv_nmos ad=56.9f pd=0.74u as=56.9f ps=0.74u w=0.17u l=0.17u
X1542 cml_tlatch_11.xmux.xn.S1 CKB0_P cml_tlatch_11.xtail.S1 VSS sg13_lv_nmos ad=89.3f pd=0.85u as=89.3f ps=0.85u w=0.47u l=0.16u
X1543 cml_tlatch_30.xmux.xp.S1 cml_tlatch_30.OUTN cml_tlatch_30.OUTP VSS sg13_lv_nmos ad=56.9f pd=0.74u as=56.9f ps=0.74u w=0.17u l=0.17u
X1544 cml_tlatch_0.xmux.xp.S1 CKA1_N cml_tlatch_0.xtail.S1 VSS sg13_lv_nmos ad=89.3f pd=0.85u as=0.1598p ps=1.62u w=0.47u l=0.16u
X1545 cml_tlatch_96.xmux.xp.S1 MOT8_N MOT8_P VSS sg13_lv_nmos ad=56.9f pd=0.74u as=56.9f ps=0.74u w=0.17u l=0.17u
X1546 cml_tlatch_67.OUTN cml_tlatch_67.OUTP cml_tlatch_67.xmux.xp.S1 VSS sg13_lv_nmos ad=56.9f pd=0.74u as=56.9f ps=0.74u w=0.17u l=0.17u
X1547 stub_bi_62.BOTN stub_bi_62.BOTP cml_tlatch_78.xmux.xp.S1 VSS sg13_lv_nmos ad=56.9f pd=0.74u as=56.9f ps=0.74u w=0.17u l=0.17u
X1548 A2_8_P A2_8_N cml_tlatch_81.xmux.xp.S1 VSS sg13_lv_nmos ad=56.9f pd=0.74u as=56.9f ps=0.74u w=0.17u l=0.17u
X1549 cml_tlatch_78.xtail.S1 CKB2_N cml_tlatch_78.xmux.xp.S1 VSS sg13_lv_nmos ad=89.3f pd=0.85u as=89.3f ps=0.85u w=0.47u l=0.16u
X1550 cml_tlatch_88.xtail.S1 CKB2_P cml_tlatch_88.xmux.xp.S1 VSS sg13_lv_nmos ad=89.3f pd=0.85u as=89.3f ps=0.85u w=0.47u l=0.16u
X1551 cml_tlatch_56.INP cml_tlatch_56.INN cml_tlatch_42.xmux.xp.S1 VSS sg13_lv_nmos ad=56.9f pd=0.74u as=56.9f ps=0.74u w=0.17u l=0.17u
X1552 cml_tlatch_9.xmux.xn.S1 cml_tlatch_99.OUTN cml_tlatch_9.OUTP VSS sg13_lv_nmos ad=63.19999f pd=0.74u as=63.19999f ps=0.74u w=0.26u l=0.38u
X1553 cml_tlatch_94.xmux.xn.S1 CKB1_N cml_tlatch_94.xtail.S1 VSS sg13_lv_nmos ad=89.3f pd=0.85u as=89.3f ps=0.85u w=0.47u l=0.16u
X1554 cml_tlatch_53.xmux.xp.S1 A3_2_N A3_2_P VSS sg13_lv_nmos ad=56.9f pd=0.74u as=56.9f ps=0.74u w=0.17u l=0.17u
X1555 cml_tlatch_46.xmux.xn.S1 CKB3_N cml_tlatch_46.xtail.S1 VSS sg13_lv_nmos ad=89.3f pd=0.85u as=89.3f ps=0.85u w=0.47u l=0.16u
X1556 B3_2_P B3_2_N cml_tlatch_46.xmux.xp.S1 VSS sg13_lv_nmos ad=56.9f pd=0.74u as=56.9f ps=0.74u w=0.17u l=0.17u
X1557 cml_tlatch_79.xmux.xn.S1 stub_bi_49.BOTN stub_bi_63.BOTP VSS sg13_lv_nmos ad=0.1082p pd=1.34u as=63.19999f ps=0.74u w=0.26u l=0.38u
X1558 interco_bi_19.INP cml_tlatch_40.INN cml_tlatch_0.xmux.xn.S1 VSS sg13_lv_nmos ad=63.19999f pd=0.74u as=63.19999f ps=0.74u w=0.26u l=0.38u
X1559 cml_tlatch_39.INN cml_tlatch_39.INP cml_tlatch_23.xmux.xp.S1 VSS sg13_lv_nmos ad=56.9f pd=0.74u as=56.9f ps=0.74u w=0.17u l=0.17u
X1560 stub_bi_19.BOTP stub_bi_19.BOTN cml_tlatch_15.xmux.xp.S1 VSS sg13_lv_nmos ad=56.9f pd=0.74u as=56.9f ps=0.74u w=0.17u l=0.17u
X1561 MOT17_N B2_8_P cml_tlatch_73.xmux.xn.S1 VSS sg13_lv_nmos ad=0.1082p pd=1.34u as=63.19999f ps=0.74u w=0.26u l=0.38u
X1562 cml_tlatch_79.xmux.xp.S1 stub_bi_63.BOTN stub_bi_63.BOTP VSS sg13_lv_nmos ad=56.9f pd=0.74u as=56.9f ps=0.74u w=0.17u l=0.17u
X1563 cml_tlatch_20.xmux.xn.S1 B0_2_N MOT7_P VSS sg13_lv_nmos ad=63.19999f pd=0.74u as=63.19999f ps=0.74u w=0.26u l=0.38u
X1564 cml_gate2_3.xrtail.R1 CKB1_N GA1_P VSS sg13_lv_nmos ad=0.1802p pd=1.74u as=0.1007p ps=0.91u w=0.53u l=0.13u
X1565 cml_tlatch_39.INP cml_tlatch_39.INN cml_tlatch_23.xmux.xp.S1 VSS sg13_lv_nmos ad=56.9f pd=0.74u as=56.9f ps=0.74u w=0.17u l=0.17u
X1566 cml_tlatch_58.xtail.S1 CKHA3_N cml_tlatch_58.xmux.xp.S1 VSS sg13_lv_nmos ad=89.3f pd=0.85u as=89.3f ps=0.85u w=0.47u l=0.16u
X1567 cml_tlatch_25.xmux.xp.S1 MOT4_P MOT4_N VSS sg13_lv_nmos ad=56.9f pd=0.74u as=56.9f ps=0.74u w=0.17u l=0.17u
X1568 cml_tlatch_20.xmux.xn.S1 B0_2_N MOT7_P VSS sg13_lv_nmos ad=63.19999f pd=0.74u as=63.19999f ps=0.74u w=0.26u l=0.38u
X1569 cml_tlatch_91.xtail.S1 CKJ_N cml_tlatch_91.xmux.xp.S1 VSS sg13_lv_nmos ad=89.3f pd=0.85u as=89.3f ps=0.85u w=0.47u l=0.16u
X1570 cml_tlatch_87.xtail.S1 CKHA2_N cml_tlatch_87.xmux.xp.S1 VSS sg13_lv_nmos ad=89.3f pd=0.85u as=89.3f ps=0.85u w=0.47u l=0.16u
X1571 cml_tlatch_98.xmux.xp.S1 cml_tlatch_98.OUTP cml_tlatch_98.OUTN VSS sg13_lv_nmos ad=56.9f pd=0.74u as=56.9f ps=0.74u w=0.17u l=0.17u
X1572 cml_tlatch_69.xtail.S1 CKHB3_P cml_tlatch_69.xmux.xn.S1 VSS sg13_lv_nmos ad=89.3f pd=0.85u as=0.1598p ps=1.62u w=0.47u l=0.16u
X1573 cml_tlatch_9.OUTN cml_tlatch_9.OUTP cml_tlatch_9.xmux.xp.S1 VSS sg13_lv_nmos ad=56.9f pd=0.74u as=56.9f ps=0.74u w=0.17u l=0.17u
X1574 A1_8_N A1_8_P cml_tlatch_21.xmux.xp.S1 VSS sg13_lv_nmos ad=56.9f pd=0.74u as=56.9f ps=0.74u w=0.17u l=0.17u
X1575 cml_tlatch_36.xtail.S1 CKA1_N cml_tlatch_36.xmux.xp.S1 VSS sg13_lv_nmos ad=89.3f pd=0.85u as=89.3f ps=0.85u w=0.47u l=0.16u
X1576 cml_tlatch_35.xmux.xp.S1 cml_tlatch_35.OUTP cml_tlatch_35.OUTN VSS sg13_lv_nmos ad=56.9f pd=0.74u as=56.9f ps=0.74u w=0.17u l=0.17u
X1577 cml_tlatch_12.xmux.xp.S1 B1_8_P B1_8_N VSS sg13_lv_nmos ad=56.9f pd=0.74u as=56.9f ps=0.74u w=0.17u l=0.17u
X1578 cml_tlatch_89.INN cml_tlatch_89.INP cml_tlatch_55.xmux.xp.S1 VSS sg13_lv_nmos ad=56.9f pd=0.74u as=56.9f ps=0.74u w=0.17u l=0.17u
X1579 cml_tlatch_39.xmux.xn.S1 cml_tlatch_39.INN MOT10_P VSS sg13_lv_nmos ad=63.19999f pd=0.74u as=63.19999f ps=0.74u w=0.26u l=0.38u
X1580 VSS POLN hs_to_clk_2.D2 VSS sg13_lv_nmos ad=1.9p pd=10.38u as=3.4p ps=20.68u w=10u l=0.13u
X1581 cml_tlatch_54.xmux.xn.S1 CKA3_P cml_tlatch_54.xtail.S1 VSS sg13_lv_nmos ad=89.3f pd=0.85u as=89.3f ps=0.85u w=0.47u l=0.16u
X1582 cml_tlatch_65.OUTP cml_tlatch_57.INN cml_tlatch_65.xmux.xn.S1 VSS sg13_lv_nmos ad=63.19999f pd=0.74u as=0.1082p ps=1.34u w=0.26u l=0.38u
X1583 stub_bi_31.BOTP stub_bi_31.BOTN cml_tlatch_34.xmux.xp.S1 VSS sg13_lv_nmos ad=56.9f pd=0.74u as=56.9f ps=0.74u w=0.17u l=0.17u
X1584 cml_gate2_4.sg13_lv_nmos_FTPY57_0.D0 ENA1_P GA2_N VSS sg13_lv_nmos ad=0.1007p pd=0.91u as=0.1007p ps=0.91u w=0.53u l=0.13u
X1585 cml_tlatch_34.xmux.xn.S1 D1_P stub_bi_31.BOTP VSS sg13_lv_nmos ad=63.19999f pd=0.74u as=63.19999f ps=0.74u w=0.26u l=0.38u
X1586 cml_tlatch_58.INP cml_tlatch_58.INN cml_tlatch_85.xmux.xp.S1 VSS sg13_lv_nmos ad=56.9f pd=0.74u as=56.9f ps=0.74u w=0.17u l=0.17u
X1587 MOT10_P MOT10_N cml_tlatch_39.xmux.xp.S1 VSS sg13_lv_nmos ad=56.9f pd=0.74u as=56.9f ps=0.74u w=0.17u l=0.17u
X1588 cml_tlatch_95.INP cml_tlatch_95.INN cml_tlatch_36.xmux.xp.S1 VSS sg13_lv_nmos ad=56.9f pd=0.74u as=56.9f ps=0.74u w=0.17u l=0.17u
X1589 cml_tlatch_32.xmux.xp.S1 stub_bi_29.BOTP stub_bi_29.BOTN VSS sg13_lv_nmos ad=56.9f pd=0.74u as=56.9f ps=0.74u w=0.17u l=0.17u
X1590 cml_tlatch_63.OUTP cml_tlatch_70.INN cml_tlatch_63.xmux.xn.S1 VSS sg13_lv_nmos ad=63.19999f pd=0.74u as=63.19999f ps=0.74u w=0.26u l=0.38u
X1591 GA0_P ENA0_N cml_gate2_2.sg13_lv_nmos_FTPY57_0.D0 VSS sg13_lv_nmos ad=0.1007p pd=0.91u as=0.1007p ps=0.91u w=0.53u l=0.13u
X1592 cml_tlatch_34.xmux.xn.S1 D1_P stub_bi_31.BOTP VSS sg13_lv_nmos ad=63.19999f pd=0.74u as=63.19999f ps=0.74u w=0.26u l=0.38u
X1593 A0_2_P A0_2_N cml_tlatch_31.xmux.xp.S1 VSS sg13_lv_nmos ad=56.9f pd=0.74u as=0.1019p ps=1.34u w=0.17u l=0.17u
X1594 MOT5_P MOT5_N cml_tlatch_19.xmux.xp.S1 VSS sg13_lv_nmos ad=56.9f pd=0.74u as=56.9f ps=0.74u w=0.17u l=0.17u
X1595 cml_tlatch_72.xtail.S1 CKA2_N cml_tlatch_72.xmux.xp.S1 VSS sg13_lv_nmos ad=89.3f pd=0.85u as=89.3f ps=0.85u w=0.47u l=0.16u
X1596 cml_tlatch_69.INN VDD VSS rppd l=5.17u w=1u
X1597 cml_tlatch_21.xmux.xp.S1 A1_8_N A1_8_P VSS sg13_lv_nmos ad=56.9f pd=0.74u as=56.9f ps=0.74u w=0.17u l=0.17u
X1598 MOT25_P MOT25_N cml_tlatch_68.xmux.xp.S1 VSS sg13_lv_nmos ad=56.9f pd=0.74u as=56.9f ps=0.74u w=0.17u l=0.17u
X1599 stub_bi_32.BOTN stub_bi_32.BOTP cml_tlatch_48.xmux.xp.S1 VSS sg13_lv_nmos ad=56.9f pd=0.74u as=56.9f ps=0.74u w=0.17u l=0.17u
X1600 cml_tlatch_27.OUTP cml_tlatch_27.OUTN cml_tlatch_27.xmux.xp.S1 VSS sg13_lv_nmos ad=56.9f pd=0.74u as=56.9f ps=0.74u w=0.17u l=0.17u
X1601 cml_tlatch_70.xmux.xn.S1 cml_tlatch_70.INP MOT29_N VSS sg13_lv_nmos ad=0.1082p pd=1.34u as=63.19999f ps=0.74u w=0.26u l=0.38u
X1602 cml_tlatch_29.OUTP cml_tlatch_29.OUTN cml_tlatch_29.xmux.xp.S1 VSS sg13_lv_nmos ad=56.9f pd=0.74u as=0.1019p ps=1.34u w=0.17u l=0.17u
X1603 cml_tlatch_98.OUTP cml_tlatch_27.OUTN cml_tlatch_98.xmux.xn.S1 VSS sg13_lv_nmos ad=63.19999f pd=0.74u as=63.19999f ps=0.74u w=0.26u l=0.38u
X1604 cml_tlatch_88.xmux.xn.S1 stub_bi_42.BOTN stub_bi_55.BOTP VSS sg13_lv_nmos ad=63.19999f pd=0.74u as=63.19999f ps=0.74u w=0.26u l=0.38u
X1605 B1_2_P B1_2_N cml_tlatch_33.xmux.xp.S1 VSS sg13_lv_nmos ad=56.9f pd=0.74u as=56.9f ps=0.74u w=0.17u l=0.17u
X1606 cml_tlatch_47.OUTN cml_tlatch_47.OUTP cml_tlatch_47.xmux.xp.S1 VSS sg13_lv_nmos ad=56.9f pd=0.74u as=56.9f ps=0.74u w=0.17u l=0.17u
X1607 cml_tlatch_60.xtail.S1 CKB3_N cml_tlatch_60.xmux.xn.S1 VSS sg13_lv_nmos ad=89.3f pd=0.85u as=89.3f ps=0.85u w=0.47u l=0.16u
X1608 cml_tlatch_75.xmux.xn.S1 stub_bi_55.BOTP MOT21_P VSS sg13_lv_nmos ad=63.19999f pd=0.74u as=63.19999f ps=0.74u w=0.26u l=0.38u
X1609 MOT1_N MOT1_P cml_tlatch_17.xmux.xp.S1 VSS sg13_lv_nmos ad=56.9f pd=0.74u as=56.9f ps=0.74u w=0.17u l=0.17u
X1610 cml_tlatch_24.xtail.S1 CKHA0_N cml_tlatch_24.xmux.xp.S1 VSS sg13_lv_nmos ad=89.3f pd=0.85u as=89.3f ps=0.85u w=0.47u l=0.16u
X1611 cml_tlatch_92.xmux.xp.S1 J2_N J2_P VSS sg13_lv_nmos ad=56.9f pd=0.74u as=56.9f ps=0.74u w=0.17u l=0.17u
X1612 cml_tlatch_65.OUTN cml_tlatch_65.OUTP cml_tlatch_65.xmux.xp.S1 VSS sg13_lv_nmos ad=56.9f pd=0.74u as=56.9f ps=0.74u w=0.17u l=0.17u
X1613 cml_tlatch_61.xmux.xp.S1 cml_tlatch_61.OUTP cml_tlatch_61.OUTN VSS sg13_lv_nmos ad=56.9f pd=0.74u as=56.9f ps=0.74u w=0.17u l=0.17u
X1614 cml_tlatch_34.xmux.xn.S1 CKB1_P cml_tlatch_34.xtail.S1 VSS sg13_lv_nmos ad=89.3f pd=0.85u as=89.3f ps=0.85u w=0.47u l=0.16u
X1615 cml_tlatch_36.xtail.S1 CKA1_N cml_tlatch_36.xmux.xp.S1 VSS sg13_lv_nmos ad=89.3f pd=0.85u as=89.3f ps=0.85u w=0.47u l=0.16u
X1616 cml_tlatch_83.INP cml_tlatch_89.OUTN cml_tlatch_72.xmux.xn.S1 VSS sg13_lv_nmos ad=0.1082p pd=1.34u as=63.19999f ps=0.74u w=0.26u l=0.38u
X1617 stub_bi_17.BOTP stub_bi_17.BOTN cml_tlatch_13.xmux.xp.S1 VSS sg13_lv_nmos ad=56.9f pd=0.74u as=56.9f ps=0.74u w=0.17u l=0.17u
X1618 cml_tlatch_51.xmux.xn.S1 A2_2_P MOT22_N VSS sg13_lv_nmos ad=63.19999f pd=0.74u as=63.19999f ps=0.74u w=0.26u l=0.38u
X1619 cml_tlatch_28.xmux.xn.S1 cml_tlatch_29.OUTN B0_2_P VSS sg13_lv_nmos ad=63.19999f pd=0.74u as=0.1082p ps=1.34u w=0.26u l=0.38u
X1620 cml_tlatch_1.xmux.xp.S1 cml_tlatch_1.OUTP cml_tlatch_1.OUTN VSS sg13_lv_nmos ad=56.9f pd=0.74u as=56.9f ps=0.74u w=0.17u l=0.17u
X1621 cml_tlatch_75.xmux.xn.S1 CKHB2_P cml_tlatch_75.xtail.S1 VSS sg13_lv_nmos ad=89.3f pd=0.85u as=0.1598p ps=1.62u w=0.47u l=0.16u
X1622 cml_tlatch_47.xmux.xp.S1 cml_tlatch_47.OUTP cml_tlatch_47.OUTN VSS sg13_lv_nmos ad=56.9f pd=0.74u as=56.9f ps=0.74u w=0.17u l=0.17u
X1623 cml_tlatch_79.xtail.S1 CKB2_N cml_tlatch_79.xmux.xn.S1 VSS sg13_lv_nmos ad=89.3f pd=0.85u as=89.3f ps=0.85u w=0.47u l=0.16u
X1624 cml_tlatch_26.xmux.xp.S1 MOT6_N MOT6_P VSS sg13_lv_nmos ad=56.9f pd=0.74u as=56.9f ps=0.74u w=0.17u l=0.17u
X1625 GA3_P CKB3_N cml_gate2_5.xrtail.R1 VSS sg13_lv_nmos ad=0.1007p pd=0.91u as=0.1802p ps=1.74u w=0.53u l=0.13u
X1626 cml_tlatch_25.xmux.xp.S1 MOT4_P MOT4_N VSS sg13_lv_nmos ad=0.1019p pd=1.34u as=56.9f ps=0.74u w=0.17u l=0.17u
X1627 cml_tlatch_84.xtail.S1 CKB3_N cml_tlatch_84.xmux.xn.S1 VSS sg13_lv_nmos ad=89.3f pd=0.85u as=89.3f ps=0.85u w=0.47u l=0.16u
X1628 cml_tlatch_1.xmux.xp.S1 cml_tlatch_1.OUTN cml_tlatch_1.OUTP VSS sg13_lv_nmos ad=0.1019p pd=1.34u as=56.9f ps=0.74u w=0.17u l=0.17u
X1629 cml_tlatch_8.xmux.xp.S1 cml_tlatch_8.OUTP cml_tlatch_8.OUTN VSS sg13_lv_nmos ad=56.9f pd=0.74u as=56.9f ps=0.74u w=0.17u l=0.17u
X1630 cml_tlatch_29.OUTP cml_tlatch_29.OUTN cml_tlatch_29.xmux.xp.S1 VSS sg13_lv_nmos ad=56.9f pd=0.74u as=56.9f ps=0.74u w=0.17u l=0.17u
X1631 MOT14_N MOT14_P cml_tlatch_41.xmux.xp.S1 VSS sg13_lv_nmos ad=56.9f pd=0.74u as=56.9f ps=0.74u w=0.17u l=0.17u
X1632 cml_tlatch_72.xmux.xn.S1 cml_tlatch_89.OUTP cml_tlatch_83.INN VSS sg13_lv_nmos ad=63.19999f pd=0.74u as=63.19999f ps=0.74u w=0.26u l=0.38u
X1633 cml_tlatch_98.xmux.xp.S1 cml_tlatch_98.OUTP cml_tlatch_98.OUTN VSS sg13_lv_nmos ad=56.9f pd=0.74u as=56.9f ps=0.74u w=0.17u l=0.17u
X1634 MOT4_P MOT4_N cml_tlatch_25.xmux.xp.S1 VSS sg13_lv_nmos ad=56.9f pd=0.74u as=56.9f ps=0.74u w=0.17u l=0.17u
X1635 cml_tlatch_45.OUTP B3_2_N cml_tlatch_45.xmux.xn.S1 VSS sg13_lv_nmos ad=63.19999f pd=0.74u as=63.19999f ps=0.74u w=0.26u l=0.38u
X1636 cml_tlatch_63.xmux.xp.S1 cml_tlatch_63.OUTN cml_tlatch_63.OUTP VSS sg13_lv_nmos ad=56.9f pd=0.74u as=56.9f ps=0.74u w=0.17u l=0.17u
X1637 cml_tlatch_31.xmux.xn.S1 CKA0_N cml_tlatch_31.xtail.S1 VSS sg13_lv_nmos ad=89.3f pd=0.85u as=89.3f ps=0.85u w=0.47u l=0.16u
X1638 cml_tlatch_72.xmux.xn.S1 cml_tlatch_89.OUTP cml_tlatch_83.INN VSS sg13_lv_nmos ad=63.19999f pd=0.74u as=63.19999f ps=0.74u w=0.26u l=0.38u
X1639 cml_tlatch_69.INP cml_tlatch_69.INN cml_tlatch_62.xmux.xp.S1 VSS sg13_lv_nmos ad=56.9f pd=0.74u as=56.9f ps=0.74u w=0.17u l=0.17u
X1640 A3_8_P A3_8_N cml_tlatch_64.xmux.xp.S1 VSS sg13_lv_nmos ad=56.9f pd=0.74u as=56.9f ps=0.74u w=0.17u l=0.17u
X1641 GA3_P ENA1_N cml_gate2_5.sg13_lv_nmos_FTPY57_0.D0 VSS sg13_lv_nmos ad=0.1007p pd=0.91u as=0.1007p ps=0.91u w=0.53u l=0.13u
X1642 cml_tlatch_70.xmux.xn.S1 CKHB3_P cml_tlatch_70.xtail.S1 VSS sg13_lv_nmos ad=89.3f pd=0.85u as=89.3f ps=0.85u w=0.47u l=0.16u
X1643 cml_tlatch_37.xmux.xp.S1 A1_2_P A1_2_N VSS sg13_lv_nmos ad=56.9f pd=0.74u as=56.9f ps=0.74u w=0.17u l=0.17u
X1644 J4_P J4_N cml_tlatch_90.xmux.xp.S1 VSS sg13_lv_nmos ad=56.9f pd=0.74u as=56.9f ps=0.74u w=0.17u l=0.17u
X1645 cml_tlatch_84.xmux.xp.S1 cml_tlatch_70.INN cml_tlatch_70.INP VSS sg13_lv_nmos ad=56.9f pd=0.74u as=56.9f ps=0.74u w=0.17u l=0.17u
X1646 B2_2_N B2_2_P cml_tlatch_44.xmux.xp.S1 VSS sg13_lv_nmos ad=56.9f pd=0.74u as=56.9f ps=0.74u w=0.17u l=0.17u
X1647 stub_bi_29.BOTP B1_2_P cml_tlatch_32.xmux.xn.S1 VSS sg13_lv_nmos ad=63.19999f pd=0.74u as=63.19999f ps=0.74u w=0.26u l=0.38u
X1648 cml_tlatch_12.xmux.xp.S1 B1_8_P B1_8_N VSS sg13_lv_nmos ad=56.9f pd=0.74u as=56.9f ps=0.74u w=0.17u l=0.17u
X1649 cml_tlatch_10.xmux.xp.S1 B0_8_N B0_8_P VSS sg13_lv_nmos ad=56.9f pd=0.74u as=56.9f ps=0.74u w=0.17u l=0.17u
X1650 cml_tlatch_35.xmux.xp.S1 cml_tlatch_35.OUTP cml_tlatch_35.OUTN VSS sg13_lv_nmos ad=56.9f pd=0.74u as=56.9f ps=0.74u w=0.17u l=0.17u
X1651 cml_tlatch_87.xmux.xn.S1 CKHA2_P cml_tlatch_87.xtail.S1 VSS sg13_lv_nmos ad=89.3f pd=0.85u as=89.3f ps=0.85u w=0.47u l=0.16u
X1652 cml_tlatch_78.xmux.xp.S1 CKB2_N cml_tlatch_78.xtail.S1 VSS sg13_lv_nmos ad=89.3f pd=0.85u as=89.3f ps=0.85u w=0.47u l=0.16u
X1653 cml_tlatch_21.xmux.xp.S1 A1_8_N A1_8_P VSS sg13_lv_nmos ad=56.9f pd=0.74u as=56.9f ps=0.74u w=0.17u l=0.17u
X1654 cml_tlatch_94.xtail.S1 CKB1_N cml_tlatch_94.xmux.xn.S1 VSS sg13_lv_nmos ad=89.3f pd=0.85u as=0.1598p ps=1.62u w=0.47u l=0.16u
X1655 cml_tlatch_45.xmux.xn.S1 B3_2_P cml_tlatch_45.OUTN VSS sg13_lv_nmos ad=63.19999f pd=0.74u as=63.19999f ps=0.74u w=0.26u l=0.38u
X1656 B1_8_P B1_8_N cml_tlatch_12.xmux.xp.S1 VSS sg13_lv_nmos ad=56.9f pd=0.74u as=56.9f ps=0.74u w=0.17u l=0.17u
X1657 cml_drv_3.xrtail.R1 ENA_P ENA0_N VSS sg13_lv_nmos ad=56.2f pd=0.74u as=56.2f ps=0.74u w=0.16u l=0.19u
X1658 cml_tlatch_46.xtail.S1 CKB3_N cml_tlatch_46.xmux.xn.S1 VSS sg13_lv_nmos ad=89.3f pd=0.85u as=89.3f ps=0.85u w=0.47u l=0.16u
X1659 cml_tlatch_65.xmux.xp.S1 CKA3_N cml_tlatch_65.xtail.S1 VSS sg13_lv_nmos ad=89.3f pd=0.85u as=0.1598p ps=1.62u w=0.47u l=0.16u
X1660 cml_tlatch_68.xtail.S1 CKHB3_N cml_tlatch_68.xmux.xp.S1 VSS sg13_lv_nmos ad=89.3f pd=0.85u as=89.3f ps=0.85u w=0.47u l=0.16u
X1661 cml_tlatch_16.OUTP cml_tlatch_1.OUTN cml_tlatch_16.xmux.xn.S1 VSS sg13_lv_nmos ad=63.19999f pd=0.74u as=63.19999f ps=0.74u w=0.26u l=0.38u
X1662 cml_tlatch_75.xmux.xp.S1 MOT21_P MOT21_N VSS sg13_lv_nmos ad=56.9f pd=0.74u as=56.9f ps=0.74u w=0.17u l=0.17u
X1663 cml_tlatch_84.xmux.xp.S1 cml_tlatch_70.INN cml_tlatch_70.INP VSS sg13_lv_nmos ad=0.1019p pd=1.34u as=56.9f ps=0.74u w=0.17u l=0.17u
X1664 VDD cml_tlatch_22.OUTN VSS rppd l=5.17u w=1u
X1665 cml_tlatch_11.OUTN cml_tlatch_11.OUTP cml_tlatch_11.xmux.xp.S1 VSS sg13_lv_nmos ad=56.9f pd=0.74u as=56.9f ps=0.74u w=0.17u l=0.17u
X1666 cml_tlatch_32.xmux.xp.S1 stub_bi_29.BOTP stub_bi_29.BOTN VSS sg13_lv_nmos ad=56.9f pd=0.74u as=56.9f ps=0.74u w=0.17u l=0.17u
X1667 cml_tlatch_93.xmux.xp.S1 J1_N J1_P VSS sg13_lv_nmos ad=56.9f pd=0.74u as=56.9f ps=0.74u w=0.17u l=0.17u
X1668 cml_tlatch_92.xmux.xp.S1 J2_P J2_N VSS sg13_lv_nmos ad=56.9f pd=0.74u as=56.9f ps=0.74u w=0.17u l=0.17u
X1669 cml_tlatch_98.xtail.S1 CKB0_P cml_tlatch_98.xmux.xp.S1 VSS sg13_lv_nmos ad=89.3f pd=0.85u as=89.3f ps=0.85u w=0.47u l=0.16u
X1670 cml_tlatch_76.xtail.S1 CKHB2_P cml_tlatch_76.xmux.xn.S1 VSS sg13_lv_nmos ad=89.3f pd=0.85u as=89.3f ps=0.85u w=0.47u l=0.16u
X1671 cml_tlatch_30.xmux.xp.S1 CKA0_N cml_tlatch_30.xtail.S1 VSS sg13_lv_nmos ad=89.3f pd=0.85u as=89.3f ps=0.85u w=0.47u l=0.16u
X1672 cml_tlatch_14.xmux.xp.S1 cml_tlatch_5.INN cml_tlatch_5.INP VSS sg13_lv_nmos ad=0.1019p pd=1.34u as=56.9f ps=0.74u w=0.17u l=0.17u
X1673 cml_tlatch_91.xmux.xp.S1 CKJ_N cml_tlatch_91.xtail.S1 VSS sg13_lv_nmos ad=89.3f pd=0.85u as=0.1598p ps=1.62u w=0.47u l=0.16u
X1674 cml_tlatch_64.xtail.S1 CKA3_P cml_tlatch_64.xmux.xp.S1 VSS sg13_lv_nmos ad=89.3f pd=0.85u as=89.3f ps=0.85u w=0.47u l=0.16u
X1675 cml_tlatch_6.INP cml_tlatch_6.INN cml_tlatch_94.xmux.xp.S1 VSS sg13_lv_nmos ad=56.9f pd=0.74u as=56.9f ps=0.74u w=0.17u l=0.17u
X1676 MOT23_N B2_2_P cml_tlatch_76.xmux.xn.S1 VSS sg13_lv_nmos ad=63.19999f pd=0.74u as=63.19999f ps=0.74u w=0.26u l=0.38u
X1677 cml_tlatch_99.OUTP cml_tlatch_99.OUTN cml_tlatch_99.xmux.xp.S1 VSS sg13_lv_nmos ad=56.9f pd=0.74u as=56.9f ps=0.74u w=0.17u l=0.17u
X1678 cml_gate2_3.sg13_lv_nmos_FTPY57_0.D0 CKB1_P cml_gate2_3.xrtail.R1 VSS sg13_lv_nmos ad=0.1007p pd=0.91u as=0.1007p ps=0.91u w=0.53u l=0.13u
X1679 VSS POLN cml_tlatch_80.xtail.S1 VSS sg13_lv_nmos ad=1.5637p pd=8.61u as=1.5637p ps=8.61u w=8.23u l=0.13u
X1680 cml_tlatch_10.xtail.S1 CKB0_P cml_tlatch_10.xmux.xp.S1 VSS sg13_lv_nmos ad=89.3f pd=0.85u as=89.3f ps=0.85u w=0.47u l=0.16u
X1681 cml_gate2_0.xrtail.R1 CKA1_P cml_gate2_0.sg13_lv_nmos_FTPY57_0.D0 VSS sg13_lv_nmos ad=0.1802p pd=1.74u as=0.1007p ps=0.91u w=0.53u l=0.13u
X1682 cml_tlatch_74.xmux.xp.S1 MOT19_N MOT19_P VSS sg13_lv_nmos ad=56.9f pd=0.74u as=56.9f ps=0.74u w=0.17u l=0.17u
X1683 MOT7_P MOT7_N cml_tlatch_20.xmux.xp.S1 VSS sg13_lv_nmos ad=56.9f pd=0.74u as=56.9f ps=0.74u w=0.17u l=0.17u
X1684 MOT22_P MOT22_N cml_tlatch_51.xmux.xp.S1 VSS sg13_lv_nmos ad=56.9f pd=0.74u as=56.9f ps=0.74u w=0.17u l=0.17u
X1685 cml_tlatch_97.xmux.xn.S1 A0_8_N MOT0_P VSS sg13_lv_nmos ad=63.19999f pd=0.74u as=63.19999f ps=0.74u w=0.26u l=0.38u
X1686 cml_tlatch_38.xmux.xp.S1 CKA1_N cml_tlatch_38.xtail.S1 VSS sg13_lv_nmos ad=89.3f pd=0.85u as=89.3f ps=0.85u w=0.47u l=0.16u
X1687 cml_tlatch_74.xmux.xn.S1 stub_bi_63.BOTN MOT19_N VSS sg13_lv_nmos ad=63.19999f pd=0.74u as=63.19999f ps=0.74u w=0.26u l=0.38u
X1688 cml_tlatch_45.xtail.S1 CKB3_P cml_tlatch_45.xmux.xn.S1 VSS sg13_lv_nmos ad=89.3f pd=0.85u as=89.3f ps=0.85u w=0.47u l=0.16u
X1689 cml_tlatch_60.xtail.S1 CKB3_P cml_tlatch_60.xmux.xp.S1 VSS sg13_lv_nmos ad=0.1598p pd=1.62u as=89.3f ps=0.85u w=0.47u l=0.16u
X1690 cml_tlatch_72.xmux.xp.S1 cml_tlatch_83.INP cml_tlatch_83.INN VSS sg13_lv_nmos ad=56.9f pd=0.74u as=56.9f ps=0.74u w=0.17u l=0.17u
X1691 cml_tlatch_97.xmux.xn.S1 A0_8_N MOT0_P VSS sg13_lv_nmos ad=63.19999f pd=0.74u as=63.19999f ps=0.74u w=0.26u l=0.38u
X1692 cml_tlatch_13.xmux.xp.S1 stub_bi_17.BOTP stub_bi_17.BOTN VSS sg13_lv_nmos ad=56.9f pd=0.74u as=56.9f ps=0.74u w=0.17u l=0.17u
X1693 VDD cml_tlatch_67.OUTP VSS rppd l=5.17u w=1u
X1694 cml_tlatch_65.OUTN cml_tlatch_57.INP cml_tlatch_65.xmux.xn.S1 VSS sg13_lv_nmos ad=63.19999f pd=0.74u as=63.19999f ps=0.74u w=0.26u l=0.38u
X1695 cml_tlatch_65.xtail.S1 CKA3_P cml_tlatch_65.xmux.xn.S1 VSS sg13_lv_nmos ad=89.3f pd=0.85u as=89.3f ps=0.85u w=0.47u l=0.16u
X1696 cml_tlatch_5.xmux.xp.S1 MOT11_N MOT11_P VSS sg13_lv_nmos ad=56.9f pd=0.74u as=56.9f ps=0.74u w=0.17u l=0.17u
X1697 cml_tlatch_62.xmux.xp.S1 cml_tlatch_69.INP cml_tlatch_69.INN VSS sg13_lv_nmos ad=56.9f pd=0.74u as=56.9f ps=0.74u w=0.17u l=0.17u
X1698 cml_tlatch_6.xmux.xp.S1 CKHB1_N cml_tlatch_6.xtail.S1 VSS sg13_lv_nmos ad=89.3f pd=0.85u as=89.3f ps=0.85u w=0.47u l=0.16u
X1699 cml_tlatch_86.xmux.xn.S1 A3_8_P MOT24_N VSS sg13_lv_nmos ad=63.19999f pd=0.74u as=0.1082p ps=1.34u w=0.26u l=0.38u
X1700 cml_tlatch_98.OUTN cml_tlatch_27.OUTP cml_tlatch_98.xmux.xn.S1 VSS sg13_lv_nmos ad=63.19999f pd=0.74u as=63.19999f ps=0.74u w=0.26u l=0.38u
X1701 cml_tlatch_83.xtail.S1 CKA2_P cml_tlatch_83.xmux.xp.S1 VSS sg13_lv_nmos ad=89.3f pd=0.85u as=89.3f ps=0.85u w=0.47u l=0.16u
X1702 cml_tlatch_59.xmux.xp.S1 CKHA3_N cml_tlatch_59.xtail.S1 VSS sg13_lv_nmos ad=89.3f pd=0.85u as=89.3f ps=0.85u w=0.47u l=0.16u
X1703 cml_tlatch_31.xtail.S1 CKA0_P cml_tlatch_31.xmux.xp.S1 VSS sg13_lv_nmos ad=89.3f pd=0.85u as=89.3f ps=0.85u w=0.47u l=0.16u
X1704 cml_tlatch_55.xmux.xn.S1 A2_2_P cml_tlatch_89.INN VSS sg13_lv_nmos ad=63.19999f pd=0.74u as=63.19999f ps=0.74u w=0.26u l=0.38u
X1705 cml_tlatch_73.xmux.xp.S1 MOT17_P MOT17_N VSS sg13_lv_nmos ad=56.9f pd=0.74u as=56.9f ps=0.74u w=0.17u l=0.17u
X1706 cml_tlatch_36.xmux.xp.S1 cml_tlatch_95.INP cml_tlatch_95.INN VSS sg13_lv_nmos ad=56.9f pd=0.74u as=56.9f ps=0.74u w=0.17u l=0.17u
X1707 cml_tlatch_37.xmux.xp.S1 A1_2_P A1_2_N VSS sg13_lv_nmos ad=56.9f pd=0.74u as=56.9f ps=0.74u w=0.17u l=0.17u
X1708 A2_8_N A2_8_P cml_tlatch_81.xmux.xp.S1 VSS sg13_lv_nmos ad=56.9f pd=0.74u as=56.9f ps=0.74u w=0.17u l=0.17u
X1709 cml_tlatch_28.xmux.xp.S1 B0_2_N B0_2_P VSS sg13_lv_nmos ad=56.9f pd=0.74u as=56.9f ps=0.74u w=0.17u l=0.17u
X1710 cml_tlatch_52.xmux.xp.S1 CKA3_N cml_tlatch_52.xtail.S1 VSS sg13_lv_nmos ad=0.1598p pd=1.62u as=89.3f ps=0.85u w=0.47u l=0.16u
X1711 cml_tlatch_64.xmux.xn.S1 cml_tlatch_65.OUTP A3_8_N VSS sg13_lv_nmos ad=63.19999f pd=0.74u as=63.19999f ps=0.74u w=0.26u l=0.38u
X1712 cml_tlatch_97.xmux.xp.S1 MOT0_P MOT0_N VSS sg13_lv_nmos ad=56.9f pd=0.74u as=56.9f ps=0.74u w=0.17u l=0.17u
X1713 cml_tlatch_26.xmux.xp.S1 MOT6_N MOT6_P VSS sg13_lv_nmos ad=56.9f pd=0.74u as=56.9f ps=0.74u w=0.17u l=0.17u
X1714 cml_tlatch_79.xtail.S1 CKB2_P cml_tlatch_79.xmux.xp.S1 VSS sg13_lv_nmos ad=89.3f pd=0.85u as=89.3f ps=0.85u w=0.47u l=0.16u
X1715 cml_tlatch_27.OUTN B0_2_P cml_tlatch_27.xmux.xn.S1 VSS sg13_lv_nmos ad=63.19999f pd=0.74u as=63.19999f ps=0.74u w=0.26u l=0.38u
X1716 GB0_N ENB1_P cml_gate2_1.sg13_lv_nmos_FTPY57_0.D0 VSS sg13_lv_nmos ad=0.1007p pd=0.91u as=0.1007p ps=0.91u w=0.53u l=0.13u
X1717 cml_tlatch_66.xtail.S1 CKA3_P cml_tlatch_66.xmux.xp.S1 VSS sg13_lv_nmos ad=89.3f pd=0.85u as=89.3f ps=0.85u w=0.47u l=0.16u
X1718 cml_tlatch_8.xmux.xn.S1 CKA0_N cml_tlatch_8.xtail.S1 VSS sg13_lv_nmos ad=0.1598p pd=1.62u as=89.3f ps=0.85u w=0.47u l=0.16u
X1719 cml_tlatch_42.xmux.xp.S1 cml_tlatch_56.INP cml_tlatch_56.INN VSS sg13_lv_nmos ad=0.1019p pd=1.34u as=56.9f ps=0.74u w=0.17u l=0.17u
X1720 cml_tlatch_24.xmux.xp.S1 CKHA0_N cml_tlatch_24.xtail.S1 VSS sg13_lv_nmos ad=89.3f pd=0.85u as=89.3f ps=0.85u w=0.47u l=0.16u
X1721 cml_tlatch_37.xmux.xp.S1 A1_2_P A1_2_N VSS sg13_lv_nmos ad=56.9f pd=0.74u as=56.9f ps=0.74u w=0.17u l=0.17u
X1722 cml_tlatch_83.OUTP cml_tlatch_83.INN cml_tlatch_83.xmux.xn.S1 VSS sg13_lv_nmos ad=63.19999f pd=0.74u as=63.19999f ps=0.74u w=0.26u l=0.38u
X1723 cml_tlatch_89.INP cml_tlatch_89.INN cml_tlatch_55.xmux.xp.S1 VSS sg13_lv_nmos ad=56.9f pd=0.74u as=56.9f ps=0.74u w=0.17u l=0.17u
X1724 stub_bi_62.BOTN stub_bi_63.BOTP cml_tlatch_78.xmux.xn.S1 VSS sg13_lv_nmos ad=63.19999f pd=0.74u as=63.19999f ps=0.74u w=0.26u l=0.38u
X1725 cml_tlatch_97.xmux.xp.S1 MOT0_N MOT0_P VSS sg13_lv_nmos ad=56.9f pd=0.74u as=56.9f ps=0.74u w=0.17u l=0.17u
X1726 MOT21_P MOT21_N cml_tlatch_75.xmux.xp.S1 VSS sg13_lv_nmos ad=56.9f pd=0.74u as=56.9f ps=0.74u w=0.17u l=0.17u
X1727 MOT28_P cml_tlatch_58.INN cml_tlatch_58.xmux.xn.S1 VSS sg13_lv_nmos ad=63.19999f pd=0.74u as=63.19999f ps=0.74u w=0.26u l=0.38u
X1728 cml_tlatch_30.xmux.xp.S1 cml_tlatch_30.OUTP cml_tlatch_30.OUTN VSS sg13_lv_nmos ad=56.9f pd=0.74u as=56.9f ps=0.74u w=0.17u l=0.17u
X1729 cml_tlatch_23.xmux.xn.S1 interco_bi_19.INP cml_tlatch_39.INN VSS sg13_lv_nmos ad=63.19999f pd=0.74u as=63.19999f ps=0.74u w=0.26u l=0.38u
X1730 cml_tlatch_87.xmux.xp.S1 MOT16_P MOT16_N VSS sg13_lv_nmos ad=56.9f pd=0.74u as=56.9f ps=0.74u w=0.17u l=0.17u
X1731 cml_tlatch_86.xtail.S1 CKHA3_N cml_tlatch_86.xmux.xp.S1 VSS sg13_lv_nmos ad=89.3f pd=0.85u as=89.3f ps=0.85u w=0.47u l=0.16u
X1732 MOT13_P MOT13_N cml_tlatch_6.xmux.xp.S1 VSS sg13_lv_nmos ad=56.9f pd=0.74u as=56.9f ps=0.74u w=0.17u l=0.17u
X1733 cml_tlatch_11.OUTN cml_tlatch_11.OUTP cml_tlatch_11.xmux.xp.S1 VSS sg13_lv_nmos ad=56.9f pd=0.74u as=56.9f ps=0.74u w=0.17u l=0.17u
X1734 cml_tlatch_61.OUTP cml_tlatch_61.OUTN cml_tlatch_61.xmux.xp.S1 VSS sg13_lv_nmos ad=56.9f pd=0.74u as=56.9f ps=0.74u w=0.17u l=0.17u
X1735 cml_tlatch_7.xmux.xn.S1 CKHB1_P cml_tlatch_7.xtail.S1 VSS sg13_lv_nmos ad=89.3f pd=0.85u as=89.3f ps=0.85u w=0.47u l=0.16u
X1736 MOT1_P MOT1_N cml_tlatch_17.xmux.xp.S1 VSS sg13_lv_nmos ad=56.9f pd=0.74u as=56.9f ps=0.74u w=0.17u l=0.17u
X1737 cml_tlatch_34.xmux.xp.S1 stub_bi_31.BOTP stub_bi_31.BOTN VSS sg13_lv_nmos ad=56.9f pd=0.74u as=56.9f ps=0.74u w=0.17u l=0.17u
X1738 cml_tlatch_15.xtail.S1 POLN VSS VSS sg13_lv_nmos ad=1.5637p pd=8.61u as=1.5637p ps=8.61u w=8.23u l=0.13u
X1739 cml_tlatch_31.xmux.xp.S1 A0_2_P A0_2_N VSS sg13_lv_nmos ad=56.9f pd=0.74u as=56.9f ps=0.74u w=0.17u l=0.17u
X1740 cml_tlatch_58.xmux.xn.S1 cml_tlatch_58.INP MOT28_N VSS sg13_lv_nmos ad=63.19999f pd=0.74u as=63.19999f ps=0.74u w=0.26u l=0.38u
X1741 A3_2_P cml_tlatch_54.OUTN cml_tlatch_53.xmux.xn.S1 VSS sg13_lv_nmos ad=63.19999f pd=0.74u as=63.19999f ps=0.74u w=0.26u l=0.38u
X1742 cml_tlatch_49.xmux.xp.S1 MOT18_N MOT18_P VSS sg13_lv_nmos ad=56.9f pd=0.74u as=56.9f ps=0.74u w=0.17u l=0.17u
X1743 cml_tlatch_68.xmux.xp.S1 MOT25_P MOT25_N VSS sg13_lv_nmos ad=56.9f pd=0.74u as=56.9f ps=0.74u w=0.17u l=0.17u
X1744 cml_tlatch_47.xmux.xn.S1 CKB3_P cml_tlatch_47.xtail.S1 VSS sg13_lv_nmos ad=89.3f pd=0.85u as=89.3f ps=0.85u w=0.47u l=0.16u
X1745 cml_tlatch_8.xmux.xp.S1 cml_tlatch_8.OUTN cml_tlatch_8.OUTP VSS sg13_lv_nmos ad=56.9f pd=0.74u as=56.9f ps=0.74u w=0.17u l=0.17u
X1746 MOT2_N cml_tlatch_8.OUTP cml_tlatch_24.xmux.xn.S1 VSS sg13_lv_nmos ad=63.19999f pd=0.74u as=0.1082p ps=1.34u w=0.26u l=0.38u
X1747 cml_gate2_2.sg13_lv_nmos_FTPY57_0.D0 CKB0_P cml_gate2_2.xrtail.R1 VSS sg13_lv_nmos ad=0.1007p pd=0.91u as=0.1007p ps=0.91u w=0.53u l=0.13u
X1748 cml_gate2_6.sg13_lv_nmos_FTPY57_0.D0 CKA3_P cml_gate2_6.xrtail.R1 VSS sg13_lv_nmos ad=0.1007p pd=0.91u as=0.1802p ps=1.74u w=0.53u l=0.13u
X1749 MOT27_P MOT27_N cml_tlatch_69.xmux.xp.S1 VSS sg13_lv_nmos ad=56.9f pd=0.74u as=56.9f ps=0.74u w=0.17u l=0.17u
X1750 cml_tlatch_39.xmux.xp.S1 MOT10_N MOT10_P VSS sg13_lv_nmos ad=56.9f pd=0.74u as=56.9f ps=0.74u w=0.17u l=0.17u
X1751 cml_tlatch_44.xmux.xp.S1 CKB2_P cml_tlatch_44.xtail.S1 VSS sg13_lv_nmos ad=89.3f pd=0.85u as=89.3f ps=0.85u w=0.47u l=0.16u
X1752 cml_tlatch_82.xmux.xp.S1 cml_tlatch_82.OUTP cml_tlatch_82.OUTN VSS sg13_lv_nmos ad=56.9f pd=0.74u as=56.9f ps=0.74u w=0.17u l=0.17u
X1753 cml_tlatch_95.xmux.xp.S1 CKA1_P cml_tlatch_95.xtail.S1 VSS sg13_lv_nmos ad=89.3f pd=0.85u as=89.3f ps=0.85u w=0.47u l=0.16u
X1754 cml_tlatch_53.xmux.xp.S1 CKA3_P cml_tlatch_53.xtail.S1 VSS sg13_lv_nmos ad=89.3f pd=0.85u as=89.3f ps=0.85u w=0.47u l=0.16u
X1755 cml_tlatch_21.xtail.S1 CKA1_N cml_tlatch_21.xmux.xn.S1 VSS sg13_lv_nmos ad=89.3f pd=0.85u as=89.3f ps=0.85u w=0.47u l=0.16u
X1756 cml_tlatch_58.INN cml_tlatch_58.INP cml_tlatch_85.xmux.xp.S1 VSS sg13_lv_nmos ad=56.9f pd=0.74u as=56.9f ps=0.74u w=0.17u l=0.17u
X1757 GA1_P CKB1_N cml_gate2_3.xrtail.R1 VSS sg13_lv_nmos ad=0.1007p pd=0.91u as=0.1007p ps=0.91u w=0.53u l=0.13u
X1758 cml_tlatch_35.OUTP cml_tlatch_35.OUTN cml_tlatch_35.xmux.xp.S1 VSS sg13_lv_nmos ad=56.9f pd=0.74u as=0.1019p ps=1.34u w=0.17u l=0.17u
X1759 cml_tlatch_5.xmux.xp.S1 MOT11_N MOT11_P VSS sg13_lv_nmos ad=56.9f pd=0.74u as=56.9f ps=0.74u w=0.17u l=0.17u
X1760 GB3_N ENB0_P cml_gate2_6.sg13_lv_nmos_FTPY57_0.D0 VSS sg13_lv_nmos ad=0.1007p pd=0.91u as=0.1007p ps=0.91u w=0.53u l=0.13u
X1761 VSS hs_to_clk_4.sg13_lv_nmos_2HGZLP_0.G VSS VSS sg13_lv_nmos ad=2.071p pd=11.28u as=0 ps=0 w=10.9u l=1.38u
X1762 A1_2_P A1_2_N cml_tlatch_37.xmux.xp.S1 VSS sg13_lv_nmos ad=56.9f pd=0.74u as=56.9f ps=0.74u w=0.17u l=0.17u
X1763 VDD A3_8_N VSS rppd l=5.17u w=1u
X1764 cml_tlatch_54.xtail.S1 CKA3_N cml_tlatch_54.xmux.xp.S1 VSS sg13_lv_nmos ad=89.3f pd=0.85u as=89.3f ps=0.85u w=0.47u l=0.16u
X1765 stub_bi_55.BOTN stub_bi_55.BOTP cml_tlatch_88.xmux.xp.S1 VSS sg13_lv_nmos ad=56.9f pd=0.74u as=56.9f ps=0.74u w=0.17u l=0.17u
X1766 cml_tlatch_39.xmux.xn.S1 cml_tlatch_39.INP MOT10_N VSS sg13_lv_nmos ad=0.1082p pd=1.34u as=63.19999f ps=0.74u w=0.26u l=0.38u
X1767 MOT20_P MOT20_N cml_tlatch_50.xmux.xp.S1 VSS sg13_lv_nmos ad=56.9f pd=0.74u as=56.9f ps=0.74u w=0.17u l=0.17u
X1768 cml_tlatch_58.xmux.xp.S1 MOT28_N MOT28_P VSS sg13_lv_nmos ad=56.9f pd=0.74u as=56.9f ps=0.74u w=0.17u l=0.17u
X1769 cml_tlatch_76.xmux.xn.S1 CKHB2_P cml_tlatch_76.xtail.S1 VSS sg13_lv_nmos ad=89.3f pd=0.85u as=89.3f ps=0.85u w=0.47u l=0.16u
X1770 cml_tlatch_72.xmux.xn.S1 CKA2_P cml_tlatch_72.xtail.S1 VSS sg13_lv_nmos ad=89.3f pd=0.85u as=89.3f ps=0.85u w=0.47u l=0.16u
X1771 cml_tlatch_57.xmux.xp.S1 MOT26_P MOT26_N VSS sg13_lv_nmos ad=56.9f pd=0.74u as=56.9f ps=0.74u w=0.17u l=0.17u
X1772 cml_tlatch_12.xtail.S1 CKB1_N cml_tlatch_12.xmux.xn.S1 VSS sg13_lv_nmos ad=89.3f pd=0.85u as=89.3f ps=0.85u w=0.47u l=0.16u
X1773 cml_tlatch_28.xmux.xp.S1 B0_2_N B0_2_P VSS sg13_lv_nmos ad=56.9f pd=0.74u as=56.9f ps=0.74u w=0.17u l=0.17u
X1774 cml_tlatch_95.xmux.xn.S1 cml_tlatch_95.INP cml_tlatch_40.INN VSS sg13_lv_nmos ad=63.19999f pd=0.74u as=63.19999f ps=0.74u w=0.26u l=0.38u
X1775 cml_gate2_4.xrtail.R1 CKB2_N GA2_P VSS sg13_lv_nmos ad=0.1007p pd=0.91u as=0.1007p ps=0.91u w=0.53u l=0.13u
X1776 cml_tlatch_30.OUTP cml_tlatch_30.OUTN cml_tlatch_30.xmux.xp.S1 VSS sg13_lv_nmos ad=56.9f pd=0.74u as=56.9f ps=0.74u w=0.17u l=0.17u
X1777 cml_tlatch_63.xmux.xn.S1 cml_tlatch_70.INN cml_tlatch_63.OUTP VSS sg13_lv_nmos ad=63.19999f pd=0.74u as=63.19999f ps=0.74u w=0.26u l=0.38u
X1778 cml_tlatch_77.xmux.xp.S1 B2_8_P B2_8_N VSS sg13_lv_nmos ad=0.1019p pd=1.34u as=56.9f ps=0.74u w=0.17u l=0.17u
X1779 MOT8_P MOT8_N cml_tlatch_96.xmux.xp.S1 VSS sg13_lv_nmos ad=56.9f pd=0.74u as=56.9f ps=0.74u w=0.17u l=0.17u
X1780 J2_P J1_N cml_tlatch_92.xmux.xn.S1 VSS sg13_lv_nmos ad=63.19999f pd=0.74u as=63.19999f ps=0.74u w=0.26u l=0.38u
X1781 stub_bi_49.BOTN stub_bi_49.BOTP cml_tlatch_80.xmux.xp.S1 VSS sg13_lv_nmos ad=56.9f pd=0.74u as=56.9f ps=0.74u w=0.17u l=0.17u
X1782 cml_tlatch_92.xmux.xn.S1 CKJ_N cml_tlatch_92.xtail.S1 VSS sg13_lv_nmos ad=0.1598p pd=1.62u as=89.3f ps=0.85u w=0.47u l=0.16u
X1783 cml_tlatch_71.xtail.S1 POLN VSS VSS sg13_lv_nmos ad=1.5637p pd=8.61u as=2.7982p ps=17.14u w=8.23u l=0.13u
X1784 MOT31_P B3_2_N cml_tlatch_71.xmux.xn.S1 VSS sg13_lv_nmos ad=63.19999f pd=0.74u as=63.19999f ps=0.74u w=0.26u l=0.38u
X1785 cml_tlatch_78.xmux.xp.S1 stub_bi_62.BOTP stub_bi_62.BOTN VSS sg13_lv_nmos ad=56.9f pd=0.74u as=56.9f ps=0.74u w=0.17u l=0.17u
X1786 cml_tlatch_21.xmux.xn.S1 cml_tlatch_22.OUTN A1_8_P VSS sg13_lv_nmos ad=63.19999f pd=0.74u as=63.19999f ps=0.74u w=0.26u l=0.38u
X1787 VSS POLN cml_tlatch_57.xtail.S1 VSS sg13_lv_nmos ad=1.5637p pd=8.61u as=1.5637p ps=8.61u w=8.23u l=0.13u
X1788 cml_tlatch_95.xmux.xp.S1 cml_tlatch_40.INP cml_tlatch_40.INN VSS sg13_lv_nmos ad=56.9f pd=0.74u as=56.9f ps=0.74u w=0.17u l=0.17u
X1789 cml_tlatch_33.xmux.xn.S1 stub_bi_31.BOTN B1_2_N VSS sg13_lv_nmos ad=0.1082p pd=1.34u as=63.19999f ps=0.74u w=0.26u l=0.38u
X1790 cml_tlatch_81.xmux.xp.S1 A2_8_N A2_8_P VSS sg13_lv_nmos ad=56.9f pd=0.74u as=56.9f ps=0.74u w=0.17u l=0.17u
X1791 cml_tlatch_47.OUTP cml_tlatch_47.OUTN cml_tlatch_47.xmux.xp.S1 VSS sg13_lv_nmos ad=56.9f pd=0.74u as=56.9f ps=0.74u w=0.17u l=0.17u
X1792 A3_2_P A3_2_N cml_tlatch_53.xmux.xp.S1 VSS sg13_lv_nmos ad=56.9f pd=0.74u as=56.9f ps=0.74u w=0.17u l=0.17u
X1793 cml_tlatch_71.xmux.xn.S1 CKHB3_P cml_tlatch_71.xtail.S1 VSS sg13_lv_nmos ad=89.3f pd=0.85u as=89.3f ps=0.85u w=0.47u l=0.16u
X1794 cml_tlatch_29.xmux.xp.S1 cml_tlatch_29.OUTP cml_tlatch_29.OUTN VSS sg13_lv_nmos ad=0.1019p pd=1.34u as=56.9f ps=0.74u w=0.17u l=0.17u
X1795 cml_tlatch_45.xmux.xn.S1 CKB3_P cml_tlatch_45.xtail.S1 VSS sg13_lv_nmos ad=89.3f pd=0.85u as=89.3f ps=0.85u w=0.47u l=0.16u
X1796 MOT18_P cml_tlatch_83.OUTN cml_tlatch_49.xmux.xn.S1 VSS sg13_lv_nmos ad=63.19999f pd=0.74u as=0.1082p ps=1.34u w=0.26u l=0.38u
X1797 interco_bi_19.INN interco_bi_19.INP cml_tlatch_0.xmux.xp.S1 VSS sg13_lv_nmos ad=56.9f pd=0.74u as=56.9f ps=0.74u w=0.17u l=0.17u
X1798 cml_tlatch_91.xmux.xn.S1 CKJ_P cml_tlatch_91.xtail.S1 VSS sg13_lv_nmos ad=89.3f pd=0.85u as=89.3f ps=0.85u w=0.47u l=0.16u
X1799 ENA1_P ENA_N cml_drv_1.xrtail.R1 VSS sg13_lv_nmos ad=56.2f pd=0.74u as=56.2f ps=0.74u w=0.16u l=0.19u
X1800 cml_tlatch_43.xmux.xp.S1 stub_bi_42.BOTP stub_bi_42.BOTN VSS sg13_lv_nmos ad=0.1019p pd=1.34u as=56.9f ps=0.74u w=0.17u l=0.17u
X1801 stub_bi_63.BOTP stub_bi_63.BOTN cml_tlatch_79.xmux.xp.S1 VSS sg13_lv_nmos ad=56.9f pd=0.74u as=56.9f ps=0.74u w=0.17u l=0.17u
X1802 cml_tlatch_54.OUTN D3_P cml_tlatch_54.xmux.xn.S1 VSS sg13_lv_nmos ad=63.19999f pd=0.74u as=63.19999f ps=0.74u w=0.26u l=0.38u
X1803 cml_tlatch_63.OUTN cml_tlatch_70.INP cml_tlatch_63.xmux.xn.S1 VSS sg13_lv_nmos ad=63.19999f pd=0.74u as=63.19999f ps=0.74u w=0.26u l=0.38u
X1804 MOT4_N MOT4_P cml_tlatch_25.xmux.xp.S1 VSS sg13_lv_nmos ad=56.9f pd=0.74u as=56.9f ps=0.74u w=0.17u l=0.17u
X1805 cml_tlatch_1.OUTP cml_tlatch_1.OUTN cml_tlatch_1.xmux.xp.S1 VSS sg13_lv_nmos ad=56.9f pd=0.74u as=56.9f ps=0.74u w=0.17u l=0.17u
X1806 cml_tlatch_27.OUTN cml_tlatch_27.OUTP cml_tlatch_27.xmux.xp.S1 VSS sg13_lv_nmos ad=56.9f pd=0.74u as=0.1019p ps=1.34u w=0.17u l=0.17u
X1807 cml_tlatch_24.xtail.S1 CKHA0_P cml_tlatch_24.xmux.xn.S1 VSS sg13_lv_nmos ad=89.3f pd=0.85u as=89.3f ps=0.85u w=0.47u l=0.16u
X1808 MOT24_N MOT24_P cml_tlatch_86.xmux.xp.S1 VSS sg13_lv_nmos ad=56.9f pd=0.74u as=56.9f ps=0.74u w=0.17u l=0.17u
X1809 cml_tlatch_22.OUTN cml_tlatch_22.OUTP cml_tlatch_22.xmux.xp.S1 VSS sg13_lv_nmos ad=56.9f pd=0.74u as=56.9f ps=0.74u w=0.17u l=0.17u
X1810 VDD cml_tlatch_3.OUTP VSS rppd l=5.17u w=1u
X1811 cml_tlatch_9.xmux.xp.S1 cml_tlatch_9.OUTP cml_tlatch_9.OUTN VSS sg13_lv_nmos ad=56.9f pd=0.74u as=56.9f ps=0.74u w=0.17u l=0.17u
X1812 stub_bi_17.BOTP cml_tlatch_5.INP cml_tlatch_13.xmux.xn.S1 VSS sg13_lv_nmos ad=63.19999f pd=0.74u as=63.19999f ps=0.74u w=0.26u l=0.38u
X1813 MOT13_P MOT13_N cml_tlatch_6.xmux.xp.S1 VSS sg13_lv_nmos ad=56.9f pd=0.74u as=56.9f ps=0.74u w=0.17u l=0.17u
X1814 MOT23_P MOT23_N cml_tlatch_76.xmux.xp.S1 VSS sg13_lv_nmos ad=56.9f pd=0.74u as=56.9f ps=0.74u w=0.17u l=0.17u
X1815 cml_tlatch_37.xtail.S1 CKA1_N cml_tlatch_37.xmux.xn.S1 VSS sg13_lv_nmos ad=89.3f pd=0.85u as=89.3f ps=0.85u w=0.47u l=0.16u
X1816 cml_tlatch_71.xmux.xp.S1 MOT31_N MOT31_P VSS sg13_lv_nmos ad=56.9f pd=0.74u as=56.9f ps=0.74u w=0.17u l=0.17u
X1817 MOT8_N A1_8_P cml_tlatch_96.xmux.xn.S1 VSS sg13_lv_nmos ad=63.19999f pd=0.74u as=63.19999f ps=0.74u w=0.26u l=0.38u
X1818 cml_tlatch_37.xmux.xp.S1 A1_2_N A1_2_P VSS sg13_lv_nmos ad=0.1019p pd=1.34u as=56.9f ps=0.74u w=0.17u l=0.17u
X1819 cml_tlatch_98.OUTP cml_tlatch_98.OUTN cml_tlatch_98.xmux.xp.S1 VSS sg13_lv_nmos ad=56.9f pd=0.74u as=56.9f ps=0.74u w=0.17u l=0.17u
X1820 cml_tlatch_81.xmux.xn.S1 CKA2_N cml_tlatch_81.xtail.S1 VSS sg13_lv_nmos ad=89.3f pd=0.85u as=89.3f ps=0.85u w=0.47u l=0.16u
X1821 cml_tlatch_55.xmux.xp.S1 cml_tlatch_89.INP cml_tlatch_89.INN VSS sg13_lv_nmos ad=56.9f pd=0.74u as=56.9f ps=0.74u w=0.17u l=0.17u
X1822 cml_tlatch_89.INP A2_2_N cml_tlatch_55.xmux.xn.S1 VSS sg13_lv_nmos ad=63.19999f pd=0.74u as=0.1082p ps=1.34u w=0.26u l=0.38u
X1823 MOT8_N A1_8_P cml_tlatch_96.xmux.xn.S1 VSS sg13_lv_nmos ad=63.19999f pd=0.74u as=63.19999f ps=0.74u w=0.26u l=0.38u
X1824 MOT26_P MOT26_N cml_tlatch_57.xmux.xp.S1 VSS sg13_lv_nmos ad=56.9f pd=0.74u as=56.9f ps=0.74u w=0.17u l=0.17u
X1825 cml_tlatch_98.xtail.S1 CKB0_P cml_tlatch_98.xmux.xp.S1 VSS sg13_lv_nmos ad=89.3f pd=0.85u as=89.3f ps=0.85u w=0.47u l=0.16u
X1826 cml_tlatch_38.OUTN cml_tlatch_38.OUTP cml_tlatch_38.xmux.xp.S1 VSS sg13_lv_nmos ad=56.9f pd=0.74u as=56.9f ps=0.74u w=0.17u l=0.17u
X1827 cml_tlatch_78.xmux.xp.S1 stub_bi_62.BOTP stub_bi_62.BOTN VSS sg13_lv_nmos ad=56.9f pd=0.74u as=56.9f ps=0.74u w=0.17u l=0.17u
X1828 cml_tlatch_8.xmux.xp.S1 cml_tlatch_8.OUTN cml_tlatch_8.OUTP VSS sg13_lv_nmos ad=0.1019p pd=1.34u as=56.9f ps=0.74u w=0.17u l=0.17u
X1829 MOT15_N MOT15_P cml_tlatch_7.xmux.xp.S1 VSS sg13_lv_nmos ad=56.9f pd=0.74u as=56.9f ps=0.74u w=0.17u l=0.17u
X1830 cml_tlatch_34.xmux.xp.S1 stub_bi_31.BOTN stub_bi_31.BOTP VSS sg13_lv_nmos ad=56.9f pd=0.74u as=56.9f ps=0.74u w=0.17u l=0.17u
X1831 cml_tlatch_91.xmux.xn.S1 J2_N CLK_W_N VSS sg13_lv_nmos ad=63.19999f pd=0.74u as=63.19999f ps=0.74u w=0.26u l=0.38u
X1832 cml_tlatch_85.xmux.xp.S1 cml_tlatch_58.INN cml_tlatch_58.INP VSS sg13_lv_nmos ad=56.9f pd=0.74u as=56.9f ps=0.74u w=0.17u l=0.17u
X1833 cml_tlatch_51.xmux.xp.S1 MOT22_P MOT22_N VSS sg13_lv_nmos ad=56.9f pd=0.74u as=56.9f ps=0.74u w=0.17u l=0.17u
X1834 cml_tlatch_98.OUTN cml_tlatch_27.OUTP cml_tlatch_98.xmux.xn.S1 VSS sg13_lv_nmos ad=63.19999f pd=0.74u as=63.19999f ps=0.74u w=0.26u l=0.38u
X1835 cml_tlatch_10.xtail.S1 CKB0_P cml_tlatch_10.xmux.xp.S1 VSS sg13_lv_nmos ad=89.3f pd=0.85u as=89.3f ps=0.85u w=0.47u l=0.16u
X1836 cml_tlatch_35.OUTP D0_N cml_tlatch_35.xmux.xn.S1 VSS sg13_lv_nmos ad=63.19999f pd=0.74u as=63.19999f ps=0.74u w=0.26u l=0.38u
X1837 cml_tlatch_39.xmux.xp.S1 MOT10_N MOT10_P VSS sg13_lv_nmos ad=56.9f pd=0.74u as=56.9f ps=0.74u w=0.17u l=0.17u
X1838 cml_tlatch_22.xmux.xp.S1 CKA1_N cml_tlatch_22.xtail.S1 VSS sg13_lv_nmos ad=89.3f pd=0.85u as=89.3f ps=0.85u w=0.47u l=0.16u
X1839 cml_tlatch_33.xtail.S1 CKB1_N cml_tlatch_33.xmux.xn.S1 VSS sg13_lv_nmos ad=89.3f pd=0.85u as=89.3f ps=0.85u w=0.47u l=0.16u
X1840 cml_tlatch_77.xmux.xp.S1 B2_8_N B2_8_P VSS sg13_lv_nmos ad=56.9f pd=0.74u as=56.9f ps=0.74u w=0.17u l=0.17u
X1841 cml_tlatch_48.xmux.xp.S1 stub_bi_32.BOTP stub_bi_32.BOTN VSS sg13_lv_nmos ad=56.9f pd=0.74u as=56.9f ps=0.74u w=0.17u l=0.17u
X1842 cml_tlatch_40.INP cml_tlatch_40.INN cml_tlatch_95.xmux.xp.S1 VSS sg13_lv_nmos ad=56.9f pd=0.74u as=56.9f ps=0.74u w=0.17u l=0.17u
X1843 J4_N J4_P cml_tlatch_90.xmux.xp.S1 VSS sg13_lv_nmos ad=56.9f pd=0.74u as=56.9f ps=0.74u w=0.17u l=0.17u
X1844 cml_tlatch_27.xmux.xp.S1 cml_tlatch_27.OUTN cml_tlatch_27.OUTP VSS sg13_lv_nmos ad=56.9f pd=0.74u as=56.9f ps=0.74u w=0.17u l=0.17u
X1845 A0_8_N cml_tlatch_3.OUTP cml_tlatch_2.xmux.xn.S1 VSS sg13_lv_nmos ad=0.1082p pd=1.34u as=63.19999f ps=0.74u w=0.26u l=0.38u
X1846 cml_tlatch_27.OUTN cml_tlatch_27.OUTP cml_tlatch_27.xmux.xp.S1 VSS sg13_lv_nmos ad=56.9f pd=0.74u as=56.9f ps=0.74u w=0.17u l=0.17u
X1847 cml_tlatch_27.xtail.S1 CKB0_N cml_tlatch_27.xmux.xp.S1 VSS sg13_lv_nmos ad=89.3f pd=0.85u as=89.3f ps=0.85u w=0.47u l=0.16u
X1848 cml_tlatch_23.xmux.xn.S1 CKA1_N cml_tlatch_23.xtail.S1 VSS sg13_lv_nmos ad=89.3f pd=0.85u as=89.3f ps=0.85u w=0.47u l=0.16u
X1849 GA0_P CKB0_N cml_gate2_2.xrtail.R1 VSS sg13_lv_nmos ad=0.1007p pd=0.91u as=0.1007p ps=0.91u w=0.53u l=0.13u
X1850 MOT31_N MOT31_P cml_tlatch_71.xmux.xp.S1 VSS sg13_lv_nmos ad=56.9f pd=0.74u as=56.9f ps=0.74u w=0.17u l=0.17u
X1851 cml_tlatch_18.xmux.xp.S1 CKHB0_N cml_tlatch_18.xtail.S1 VSS sg13_lv_nmos ad=0.1598p pd=1.62u as=89.3f ps=0.85u w=0.47u l=0.16u
X1852 cml_tlatch_68.xtail.S1 POLN VSS VSS sg13_lv_nmos ad=1.5637p pd=8.61u as=2.7982p ps=17.14u w=8.23u l=0.13u
X1853 cml_tlatch_2.xtail.S1 POLN VSS VSS sg13_lv_nmos ad=1.5637p pd=8.61u as=2.7982p ps=17.14u w=8.23u l=0.13u
X1854 A0_8_N cml_tlatch_3.OUTP cml_tlatch_2.xmux.xn.S1 VSS sg13_lv_nmos ad=63.19999f pd=0.74u as=63.19999f ps=0.74u w=0.26u l=0.38u
X1855 cml_tlatch_29.xmux.xp.S1 CKB0_N cml_tlatch_29.xtail.S1 VSS sg13_lv_nmos ad=89.3f pd=0.85u as=89.3f ps=0.85u w=0.47u l=0.16u
X1856 cml_tlatch_1.xmux.xn.S1 CKB0_P cml_tlatch_1.xtail.S1 VSS sg13_lv_nmos ad=89.3f pd=0.85u as=89.3f ps=0.85u w=0.47u l=0.16u
X1857 cml_tlatch_49.xtail.S1 CKHA2_N cml_tlatch_49.xmux.xp.S1 VSS sg13_lv_nmos ad=89.3f pd=0.85u as=89.3f ps=0.85u w=0.47u l=0.16u
X1858 cml_tlatch_8.xtail.S1 POLN VSS VSS sg13_lv_nmos ad=1.5637p pd=8.61u as=1.5637p ps=8.61u w=8.23u l=0.13u
X1859 cml_tlatch_19.xmux.xp.S1 MOT5_P MOT5_N VSS sg13_lv_nmos ad=56.9f pd=0.74u as=56.9f ps=0.74u w=0.17u l=0.17u
X1860 cml_tlatch_40.INP cml_tlatch_40.INN cml_tlatch_95.xmux.xp.S1 VSS sg13_lv_nmos ad=56.9f pd=0.74u as=56.9f ps=0.74u w=0.17u l=0.17u
X1861 J2_P J2_N cml_tlatch_92.xmux.xp.S1 VSS sg13_lv_nmos ad=56.9f pd=0.74u as=56.9f ps=0.74u w=0.17u l=0.17u
X1862 cml_tlatch_65.xmux.xp.S1 cml_tlatch_65.OUTP cml_tlatch_65.OUTN VSS sg13_lv_nmos ad=56.9f pd=0.74u as=56.9f ps=0.74u w=0.17u l=0.17u
X1863 cml_tlatch_86.xtail.S1 CKHA3_P cml_tlatch_86.xmux.xn.S1 VSS sg13_lv_nmos ad=89.3f pd=0.85u as=89.3f ps=0.85u w=0.47u l=0.16u
X1864 cml_tlatch_47.xtail.S1 CKB3_P cml_tlatch_47.xmux.xn.S1 VSS sg13_lv_nmos ad=89.3f pd=0.85u as=89.3f ps=0.85u w=0.47u l=0.16u
X1865 cml_tlatch_63.xmux.xp.S1 cml_tlatch_63.OUTP cml_tlatch_63.OUTN VSS sg13_lv_nmos ad=56.9f pd=0.74u as=56.9f ps=0.74u w=0.17u l=0.17u
X1866 CKA2_P CK_P hs_to_clk_4.D2 VSS sg13_lv_nmos ad=0.228p pd=1.58u as=0.408p ps=3.08u w=1.2u l=0.2u
X1867 VSS POLN hs_to_clk_3.D2 VSS sg13_lv_nmos ad=1.9p pd=10.38u as=3.4p ps=20.68u w=10u l=0.13u
X1868 cml_tlatch_52.xmux.xp.S1 CKA3_N cml_tlatch_52.xtail.S1 VSS sg13_lv_nmos ad=89.3f pd=0.85u as=89.3f ps=0.85u w=0.47u l=0.16u
X1869 cml_tlatch_13.xmux.xp.S1 stub_bi_17.BOTN stub_bi_17.BOTP VSS sg13_lv_nmos ad=56.9f pd=0.74u as=56.9f ps=0.74u w=0.17u l=0.17u
X1870 cml_tlatch_56.xmux.xn.S1 CKA2_N cml_tlatch_56.xtail.S1 VSS sg13_lv_nmos ad=89.3f pd=0.85u as=89.3f ps=0.85u w=0.47u l=0.16u
X1871 cml_tlatch_80.xmux.xp.S1 CKB2_N cml_tlatch_80.xtail.S1 VSS sg13_lv_nmos ad=89.3f pd=0.85u as=89.3f ps=0.85u w=0.47u l=0.16u
X1872 cml_gate2_1.xrtail.R1 CKA0_N GB0_P VSS sg13_lv_nmos ad=0.1007p pd=0.91u as=0.1007p ps=0.91u w=0.53u l=0.13u
X1873 cml_tlatch_62.xmux.xn.S1 cml_tlatch_63.OUTN cml_tlatch_69.INP VSS sg13_lv_nmos ad=0.1082p pd=1.34u as=63.19999f ps=0.74u w=0.26u l=0.38u
X1874 MOT17_P MOT17_N cml_tlatch_73.xmux.xp.S1 VSS sg13_lv_nmos ad=56.9f pd=0.74u as=56.9f ps=0.74u w=0.17u l=0.17u
X1875 MOT6_P MOT6_N cml_tlatch_26.xmux.xp.S1 VSS sg13_lv_nmos ad=56.9f pd=0.74u as=0.1019p ps=1.34u w=0.17u l=0.17u
X1876 cml_tlatch_68.xmux.xp.S1 MOT25_N MOT25_P VSS sg13_lv_nmos ad=56.9f pd=0.74u as=56.9f ps=0.74u w=0.17u l=0.17u
X1877 cml_tlatch_48.xmux.xp.S1 stub_bi_32.BOTP stub_bi_32.BOTN VSS sg13_lv_nmos ad=56.9f pd=0.74u as=56.9f ps=0.74u w=0.17u l=0.17u
X1878 cml_tlatch_90.xmux.xn.S1 CKJ_N cml_tlatch_90.xtail.S1 VSS sg13_lv_nmos ad=0.1598p pd=1.62u as=89.3f ps=0.85u w=0.47u l=0.16u
X1879 cml_tlatch_62.xmux.xn.S1 cml_tlatch_63.OUTN cml_tlatch_69.INP VSS sg13_lv_nmos ad=63.19999f pd=0.74u as=63.19999f ps=0.74u w=0.26u l=0.38u
X1880 cml_tlatch_1.OUTP cml_tlatch_1.OUTN cml_tlatch_1.xmux.xp.S1 VSS sg13_lv_nmos ad=56.9f pd=0.74u as=56.9f ps=0.74u w=0.17u l=0.17u
X1881 cml_tlatch_8.OUTN cml_tlatch_8.OUTP cml_tlatch_8.xmux.xp.S1 VSS sg13_lv_nmos ad=56.9f pd=0.74u as=56.9f ps=0.74u w=0.17u l=0.17u
X1882 cml_tlatch_29.xmux.xp.S1 cml_tlatch_29.OUTN cml_tlatch_29.OUTP VSS sg13_lv_nmos ad=56.9f pd=0.74u as=56.9f ps=0.74u w=0.17u l=0.17u
X1883 cml_tlatch_23.xmux.xn.S1 interco_bi_19.INN cml_tlatch_39.INP VSS sg13_lv_nmos ad=63.19999f pd=0.74u as=63.19999f ps=0.74u w=0.26u l=0.38u
X1884 cml_gate2_0.sg13_lv_nmos_FTPY57_0.D0 CKA1_P cml_gate2_0.xrtail.R1 VSS sg13_lv_nmos ad=0.1007p pd=0.91u as=0.1007p ps=0.91u w=0.53u l=0.13u
X1885 stub_bi_63.BOTP stub_bi_49.BOTN cml_tlatch_79.xmux.xn.S1 VSS sg13_lv_nmos ad=63.19999f pd=0.74u as=63.19999f ps=0.74u w=0.26u l=0.38u
X1886 A2_2_N A2_2_P cml_tlatch_56.xmux.xp.S1 VSS sg13_lv_nmos ad=56.9f pd=0.74u as=56.9f ps=0.74u w=0.17u l=0.17u
X1887 cml_tlatch_90.xmux.xp.S1 J4_N J4_P VSS sg13_lv_nmos ad=56.9f pd=0.74u as=56.9f ps=0.74u w=0.17u l=0.17u
X1888 cml_tlatch_44.xmux.xp.S1 B2_2_P B2_2_N VSS sg13_lv_nmos ad=56.9f pd=0.74u as=56.9f ps=0.74u w=0.17u l=0.17u
X1889 B0_8_P B0_8_N cml_tlatch_10.xmux.xp.S1 VSS sg13_lv_nmos ad=56.9f pd=0.74u as=56.9f ps=0.74u w=0.17u l=0.17u
X1890 MOT7_P B0_2_N cml_tlatch_20.xmux.xn.S1 VSS sg13_lv_nmos ad=63.19999f pd=0.74u as=63.19999f ps=0.74u w=0.26u l=0.38u
X1891 cml_tlatch_94.xmux.xn.S1 stub_bi_29.BOTP cml_tlatch_6.INP VSS sg13_lv_nmos ad=0.1082p pd=1.34u as=63.19999f ps=0.74u w=0.26u l=0.38u
X1892 cml_tlatch_17.xtail.S1 CKHB0_P cml_tlatch_17.xmux.xn.S1 VSS sg13_lv_nmos ad=89.3f pd=0.85u as=89.3f ps=0.85u w=0.47u l=0.16u
X1893 cml_tlatch_32.xmux.xp.S1 CKB1_N cml_tlatch_32.xtail.S1 VSS sg13_lv_nmos ad=89.3f pd=0.85u as=89.3f ps=0.85u w=0.47u l=0.16u
X1894 cml_tlatch_34.xmux.xp.S1 stub_bi_31.BOTN stub_bi_31.BOTP VSS sg13_lv_nmos ad=56.9f pd=0.74u as=56.9f ps=0.74u w=0.17u l=0.17u
X1895 cml_tlatch_22.OUTP cml_tlatch_39.INN cml_tlatch_22.xmux.xn.S1 VSS sg13_lv_nmos ad=63.19999f pd=0.74u as=63.19999f ps=0.74u w=0.26u l=0.38u
X1896 cml_tlatch_85.xmux.xp.S1 cml_tlatch_58.INN cml_tlatch_58.INP VSS sg13_lv_nmos ad=56.9f pd=0.74u as=56.9f ps=0.74u w=0.17u l=0.17u
X1897 cml_tlatch_70.xtail.S1 POLN VSS VSS sg13_lv_nmos ad=1.5637p pd=8.61u as=1.5637p ps=8.61u w=8.23u l=0.13u
X1898 cml_gate2_7.xrtail.R1 CKA2_P cml_gate2_7.sg13_lv_nmos_FTPY57_0.D0 VSS sg13_lv_nmos ad=0.1007p pd=0.91u as=0.1007p ps=0.91u w=0.53u l=0.13u
X1899 MOT21_N MOT21_P cml_tlatch_75.xmux.xp.S1 VSS sg13_lv_nmos ad=56.9f pd=0.74u as=56.9f ps=0.74u w=0.17u l=0.17u
X1900 cml_tlatch_70.INP cml_tlatch_70.INN cml_tlatch_84.xmux.xp.S1 VSS sg13_lv_nmos ad=56.9f pd=0.74u as=56.9f ps=0.74u w=0.17u l=0.17u
X1901 cml_tlatch_51.xmux.xp.S1 MOT22_P MOT22_N VSS sg13_lv_nmos ad=0.1019p pd=1.34u as=56.9f ps=0.74u w=0.17u l=0.17u
X1902 MOT30_N MOT30_P cml_tlatch_59.xmux.xp.S1 VSS sg13_lv_nmos ad=56.9f pd=0.74u as=56.9f ps=0.74u w=0.17u l=0.17u
X1903 A0_8_N A0_8_P cml_tlatch_2.xmux.xp.S1 VSS sg13_lv_nmos ad=56.9f pd=0.74u as=56.9f ps=0.74u w=0.17u l=0.17u
X1904 cml_tlatch_29.xtail.S1 CKB0_P cml_tlatch_29.xmux.xn.S1 VSS sg13_lv_nmos ad=89.3f pd=0.85u as=89.3f ps=0.85u w=0.47u l=0.16u
X1905 cml_tlatch_96.xtail.S1 CKHA1_N cml_tlatch_96.xmux.xp.S1 VSS sg13_lv_nmos ad=0.1598p pd=1.62u as=89.3f ps=0.85u w=0.47u l=0.16u
X1906 J1_P J1_N cml_tlatch_93.xmux.xp.S1 VSS sg13_lv_nmos ad=56.9f pd=0.74u as=56.9f ps=0.74u w=0.17u l=0.17u
X1907 cml_tlatch_44.xmux.xp.S1 CKB2_P cml_tlatch_44.xtail.S1 VSS sg13_lv_nmos ad=89.3f pd=0.85u as=89.3f ps=0.85u w=0.47u l=0.16u
X1908 MOT24_P A3_8_N cml_tlatch_86.xmux.xn.S1 VSS sg13_lv_nmos ad=63.19999f pd=0.74u as=63.19999f ps=0.74u w=0.26u l=0.38u
X1909 A1_8_P A1_8_N cml_tlatch_21.xmux.xp.S1 VSS sg13_lv_nmos ad=56.9f pd=0.74u as=56.9f ps=0.74u w=0.17u l=0.17u
X1910 cml_tlatch_5.INP cml_tlatch_5.INN cml_tlatch_14.xmux.xp.S1 VSS sg13_lv_nmos ad=56.9f pd=0.74u as=56.9f ps=0.74u w=0.17u l=0.17u
X1911 cml_tlatch_94.xmux.xp.S1 cml_tlatch_6.INN cml_tlatch_6.INP VSS sg13_lv_nmos ad=56.9f pd=0.74u as=56.9f ps=0.74u w=0.17u l=0.17u
X1912 MOT11_N MOT11_P cml_tlatch_5.xmux.xp.S1 VSS sg13_lv_nmos ad=56.9f pd=0.74u as=56.9f ps=0.74u w=0.17u l=0.17u
X1913 cml_tlatch_41.xmux.xp.S1 MOT14_P MOT14_N VSS sg13_lv_nmos ad=56.9f pd=0.74u as=56.9f ps=0.74u w=0.17u l=0.17u
X1914 cml_tlatch_65.xtail.S1 CKA3_N cml_tlatch_65.xmux.xp.S1 VSS sg13_lv_nmos ad=89.3f pd=0.85u as=89.3f ps=0.85u w=0.47u l=0.16u
X1915 cml_tlatch_89.xmux.xn.S1 CKA2_N cml_tlatch_89.xtail.S1 VSS sg13_lv_nmos ad=89.3f pd=0.85u as=89.3f ps=0.85u w=0.47u l=0.16u
X1916 stub_bi_31.BOTP D1_P cml_tlatch_34.xmux.xn.S1 VSS sg13_lv_nmos ad=63.19999f pd=0.74u as=63.19999f ps=0.74u w=0.26u l=0.38u
X1917 cml_gate2_8.sg13_lv_nmos_FTPY57_0.D0 NS1_P cml_gate2_8.xrtail.R1 VSS sg13_lv_nmos ad=0.1007p pd=0.91u as=0.1007p ps=0.91u w=0.53u l=0.13u
X1918 cml_tlatch_65.OUTP cml_tlatch_65.OUTN cml_tlatch_65.xmux.xp.S1 VSS sg13_lv_nmos ad=56.9f pd=0.74u as=56.9f ps=0.74u w=0.17u l=0.17u
X1919 cml_tlatch_54.xtail.S1 CKA3_N cml_tlatch_54.xmux.xp.S1 VSS sg13_lv_nmos ad=89.3f pd=0.85u as=89.3f ps=0.85u w=0.47u l=0.16u
X1920 GB2_P CKA2_N cml_gate2_7.xrtail.R1 VSS sg13_lv_nmos ad=0.1007p pd=0.91u as=0.1802p ps=1.74u w=0.53u l=0.13u
X1921 VSS POLN cml_tlatch_72.xtail.S1 VSS sg13_lv_nmos ad=2.7982p pd=17.14u as=1.5637p ps=8.61u w=8.23u l=0.13u
X1922 cml_tlatch_6.xtail.S1 CKHB1_P cml_tlatch_6.xmux.xn.S1 VSS sg13_lv_nmos ad=89.3f pd=0.85u as=89.3f ps=0.85u w=0.47u l=0.16u
X1923 cml_tlatch_19.xmux.xp.S1 MOT5_P MOT5_N VSS sg13_lv_nmos ad=56.9f pd=0.74u as=56.9f ps=0.74u w=0.17u l=0.17u
X1924 VDD CKHB2_P VSS rppd l=13.09u w=1u
X1925 cml_tlatch_22.xmux.xp.S1 cml_tlatch_22.OUTN cml_tlatch_22.OUTP VSS sg13_lv_nmos ad=56.9f pd=0.74u as=56.9f ps=0.74u w=0.17u l=0.17u
X1926 cml_tlatch_15.xmux.xn.S1 cml_tlatch_6.INP stub_bi_19.BOTP VSS sg13_lv_nmos ad=63.19999f pd=0.74u as=63.19999f ps=0.74u w=0.26u l=0.38u
X1927 cml_tlatch_72.xmux.xn.S1 CKA2_P cml_tlatch_72.xtail.S1 VSS sg13_lv_nmos ad=89.3f pd=0.85u as=89.3f ps=0.85u w=0.47u l=0.16u
X1928 cml_tlatch_83.INN cml_tlatch_83.INP cml_tlatch_72.xmux.xp.S1 VSS sg13_lv_nmos ad=56.9f pd=0.74u as=56.9f ps=0.74u w=0.17u l=0.17u
X1929 cml_tlatch_98.xmux.xn.S1 cml_tlatch_27.OUTN cml_tlatch_98.OUTP VSS sg13_lv_nmos ad=63.19999f pd=0.74u as=63.19999f ps=0.74u w=0.26u l=0.38u
X1930 cml_tlatch_97.xmux.xn.S1 CKHA0_P cml_tlatch_97.xtail.S1 VSS sg13_lv_nmos ad=89.3f pd=0.85u as=89.3f ps=0.85u w=0.47u l=0.16u
X1931 stub_bi_17.BOTN stub_bi_17.BOTP cml_tlatch_13.xmux.xp.S1 VSS sg13_lv_nmos ad=56.9f pd=0.74u as=56.9f ps=0.74u w=0.17u l=0.17u
X1932 cml_tlatch_66.xmux.xp.S1 cml_tlatch_57.INP cml_tlatch_57.INN VSS sg13_lv_nmos ad=56.9f pd=0.74u as=56.9f ps=0.74u w=0.17u l=0.17u
X1933 CLK_W_N CLK_W_P cml_tlatch_91.xmux.xp.S1 VSS sg13_lv_nmos ad=56.9f pd=0.74u as=56.9f ps=0.74u w=0.17u l=0.17u
X1934 cml_tlatch_69.INN cml_tlatch_69.INP cml_tlatch_62.xmux.xp.S1 VSS sg13_lv_nmos ad=56.9f pd=0.74u as=56.9f ps=0.74u w=0.17u l=0.17u
X1935 cml_tlatch_69.INP cml_tlatch_69.INN cml_tlatch_62.xmux.xp.S1 VSS sg13_lv_nmos ad=56.9f pd=0.74u as=56.9f ps=0.74u w=0.17u l=0.17u
X1936 MOT29_N cml_tlatch_70.INP cml_tlatch_70.xmux.xn.S1 VSS sg13_lv_nmos ad=63.19999f pd=0.74u as=63.19999f ps=0.74u w=0.26u l=0.38u
X1937 MOT20_N MOT20_P cml_tlatch_50.xmux.xp.S1 VSS sg13_lv_nmos ad=56.9f pd=0.74u as=56.9f ps=0.74u w=0.17u l=0.17u
X1938 MOT27_N MOT27_P cml_tlatch_69.xmux.xp.S1 VSS sg13_lv_nmos ad=56.9f pd=0.74u as=56.9f ps=0.74u w=0.17u l=0.17u
X1939 stub_bi_55.BOTP stub_bi_42.BOTN cml_tlatch_88.xmux.xn.S1 VSS sg13_lv_nmos ad=63.19999f pd=0.74u as=63.19999f ps=0.74u w=0.26u l=0.38u
X1940 cml_tlatch_98.xmux.xn.S1 cml_tlatch_27.OUTN cml_tlatch_98.OUTP VSS sg13_lv_nmos ad=63.19999f pd=0.74u as=63.19999f ps=0.74u w=0.26u l=0.38u
X1941 cml_tlatch_47.xtail.S1 CKB3_N cml_tlatch_47.xmux.xp.S1 VSS sg13_lv_nmos ad=0.1598p pd=1.62u as=89.3f ps=0.85u w=0.47u l=0.16u
X1942 MOT17_N MOT17_P cml_tlatch_73.xmux.xp.S1 VSS sg13_lv_nmos ad=56.9f pd=0.74u as=56.9f ps=0.74u w=0.17u l=0.17u
X1943 MOT21_P stub_bi_55.BOTP cml_tlatch_75.xmux.xn.S1 VSS sg13_lv_nmos ad=63.19999f pd=0.74u as=63.19999f ps=0.74u w=0.26u l=0.38u
X1944 cml_tlatch_49.xmux.xn.S1 CKHA2_P cml_tlatch_49.xtail.S1 VSS sg13_lv_nmos ad=89.3f pd=0.85u as=89.3f ps=0.85u w=0.47u l=0.16u
X1945 cml_tlatch_54.OUTP D3_N cml_tlatch_54.xmux.xn.S1 VSS sg13_lv_nmos ad=63.19999f pd=0.74u as=63.19999f ps=0.74u w=0.26u l=0.38u
X1946 cml_tlatch_89.xmux.xp.S1 CKA2_P cml_tlatch_89.xtail.S1 VSS sg13_lv_nmos ad=89.3f pd=0.85u as=0.1598p ps=1.62u w=0.47u l=0.16u
X1947 MOT12_N MOT12_P cml_tlatch_40.xmux.xp.S1 VSS sg13_lv_nmos ad=56.9f pd=0.74u as=56.9f ps=0.74u w=0.17u l=0.17u
X1948 cml_tlatch_60.xmux.xp.S1 CKB3_P cml_tlatch_60.xtail.S1 VSS sg13_lv_nmos ad=89.3f pd=0.85u as=89.3f ps=0.85u w=0.47u l=0.16u
X1949 cml_tlatch_2.xmux.xn.S1 cml_tlatch_3.OUTN A0_8_P VSS sg13_lv_nmos ad=63.19999f pd=0.74u as=63.19999f ps=0.74u w=0.26u l=0.38u
X1950 cml_tlatch_18.xmux.xp.S1 MOT3_N MOT3_P VSS sg13_lv_nmos ad=56.9f pd=0.74u as=56.9f ps=0.74u w=0.17u l=0.17u
X1951 B3_8_N B3_8_P cml_tlatch_60.xmux.xp.S1 VSS sg13_lv_nmos ad=56.9f pd=0.74u as=56.9f ps=0.74u w=0.17u l=0.17u
X1952 CKB2_P CK_N hs_to_clk_6.D2 VSS sg13_lv_nmos ad=0.228p pd=1.58u as=0.228p ps=1.58u w=1.2u l=0.2u
X1953 MOT6_P MOT6_N cml_tlatch_26.xmux.xp.S1 VSS sg13_lv_nmos ad=56.9f pd=0.74u as=56.9f ps=0.74u w=0.17u l=0.17u
X1954 cml_tlatch_81.xmux.xp.S1 A2_8_P A2_8_N VSS sg13_lv_nmos ad=56.9f pd=0.74u as=56.9f ps=0.74u w=0.17u l=0.17u
X1955 MOT0_N MOT0_P cml_tlatch_97.xmux.xp.S1 VSS sg13_lv_nmos ad=56.9f pd=0.74u as=56.9f ps=0.74u w=0.17u l=0.17u
X1956 cml_tlatch_36.xmux.xn.S1 CKA1_P cml_tlatch_36.xtail.S1 VSS sg13_lv_nmos ad=89.3f pd=0.85u as=89.3f ps=0.85u w=0.47u l=0.16u
X1957 cml_tlatch_29.xmux.xp.S1 cml_tlatch_29.OUTN cml_tlatch_29.OUTP VSS sg13_lv_nmos ad=56.9f pd=0.74u as=56.9f ps=0.74u w=0.17u l=0.17u
X1958 cml_tlatch_72.xmux.xn.S1 cml_tlatch_89.OUTN cml_tlatch_83.INP VSS sg13_lv_nmos ad=63.19999f pd=0.74u as=63.19999f ps=0.74u w=0.26u l=0.38u
X1959 cml_tlatch_93.xmux.xp.S1 J1_N J1_P VSS sg13_lv_nmos ad=56.9f pd=0.74u as=56.9f ps=0.74u w=0.17u l=0.17u
X1960 cml_tlatch_56.INN cml_tlatch_56.INP cml_tlatch_42.xmux.xp.S1 VSS sg13_lv_nmos ad=56.9f pd=0.74u as=56.9f ps=0.74u w=0.17u l=0.17u
X1961 cml_tlatch_72.xmux.xn.S1 cml_tlatch_89.OUTN cml_tlatch_83.INP VSS sg13_lv_nmos ad=63.19999f pd=0.74u as=63.19999f ps=0.74u w=0.26u l=0.38u
X1962 cml_tlatch_29.OUTN cml_tlatch_29.OUTP cml_tlatch_29.xmux.xp.S1 VSS sg13_lv_nmos ad=56.9f pd=0.74u as=56.9f ps=0.74u w=0.17u l=0.17u
X1963 cml_gate2_2.xrtail.R1 CKB0_P cml_gate2_2.sg13_lv_nmos_FTPY57_0.D0 VSS sg13_lv_nmos ad=0.1007p pd=0.91u as=0.1007p ps=0.91u w=0.53u l=0.13u
X1964 ENA1_N ENA_P cml_drv_1.xrtail.R1 VSS sg13_lv_nmos ad=56.2f pd=0.74u as=56.2f ps=0.74u w=0.16u l=0.19u
X1965 cml_tlatch_62.xmux.xp.S1 cml_tlatch_69.INN cml_tlatch_69.INP VSS sg13_lv_nmos ad=56.9f pd=0.74u as=56.9f ps=0.74u w=0.17u l=0.17u
X1966 stub_bi_29.BOTN B1_2_N cml_tlatch_32.xmux.xn.S1 VSS sg13_lv_nmos ad=63.19999f pd=0.74u as=63.19999f ps=0.74u w=0.26u l=0.38u
X1967 cml_tlatch_90.xmux.xp.S1 J4_N J4_P VSS sg13_lv_nmos ad=56.9f pd=0.74u as=56.9f ps=0.74u w=0.17u l=0.17u
X1968 cml_tlatch_44.xmux.xp.S1 B2_2_P B2_2_N VSS sg13_lv_nmos ad=56.9f pd=0.74u as=56.9f ps=0.74u w=0.17u l=0.17u
X1969 B0_8_P B0_8_N cml_tlatch_10.xmux.xp.S1 VSS sg13_lv_nmos ad=56.9f pd=0.74u as=56.9f ps=0.74u w=0.17u l=0.17u
X1970 cml_tlatch_55.xmux.xp.S1 cml_tlatch_89.INN cml_tlatch_89.INP VSS sg13_lv_nmos ad=56.9f pd=0.74u as=56.9f ps=0.74u w=0.17u l=0.17u
X1971 cml_tlatch_45.OUTP cml_tlatch_45.OUTN cml_tlatch_45.xmux.xp.S1 VSS sg13_lv_nmos ad=56.9f pd=0.74u as=56.9f ps=0.74u w=0.17u l=0.17u
X1972 GB3_N VDD VSS rppd l=7.42u w=1u
X1973 VSS POLN cml_tlatch_52.xtail.S1 VSS sg13_lv_nmos ad=1.5637p pd=8.61u as=1.5637p ps=8.61u w=8.23u l=0.13u
X1974 cml_tlatch_11.xmux.xn.S1 cml_tlatch_16.OUTP cml_tlatch_11.OUTN VSS sg13_lv_nmos ad=63.19999f pd=0.74u as=0.1082p ps=1.34u w=0.26u l=0.38u
X1975 MOT0_P MOT0_N cml_tlatch_97.xmux.xp.S1 VSS sg13_lv_nmos ad=56.9f pd=0.74u as=56.9f ps=0.74u w=0.17u l=0.17u
X1976 cml_gate2_1.sg13_lv_nmos_FTPY57_0.D0 CKA0_P cml_gate2_1.xrtail.R1 VSS sg13_lv_nmos ad=0.1007p pd=0.91u as=0.1007p ps=0.91u w=0.53u l=0.13u
X1977 cml_tlatch_75.xmux.xp.S1 MOT21_N MOT21_P VSS sg13_lv_nmos ad=56.9f pd=0.74u as=56.9f ps=0.74u w=0.17u l=0.17u
X1978 cml_tlatch_26.xtail.S1 CKHA0_P cml_tlatch_26.xmux.xn.S1 VSS sg13_lv_nmos ad=89.3f pd=0.85u as=89.3f ps=0.85u w=0.47u l=0.16u
X1979 cml_tlatch_32.xmux.xn.S1 CKB1_P cml_tlatch_32.xtail.S1 VSS sg13_lv_nmos ad=89.3f pd=0.85u as=89.3f ps=0.85u w=0.47u l=0.16u
X1980 cml_tlatch_45.xmux.xn.S1 B3_2_N cml_tlatch_45.OUTP VSS sg13_lv_nmos ad=63.19999f pd=0.74u as=63.19999f ps=0.74u w=0.26u l=0.38u
X1981 cml_tlatch_30.OUTN cml_tlatch_30.OUTP cml_tlatch_30.xmux.xp.S1 VSS sg13_lv_nmos ad=56.9f pd=0.74u as=0.1019p ps=1.34u w=0.17u l=0.17u
X1982 cml_tlatch_60.xmux.xp.S1 B3_8_N B3_8_P VSS sg13_lv_nmos ad=56.9f pd=0.74u as=56.9f ps=0.74u w=0.17u l=0.17u
X1983 cml_tlatch_54.OUTP cml_tlatch_54.OUTN cml_tlatch_54.xmux.xp.S1 VSS sg13_lv_nmos ad=56.9f pd=0.74u as=56.9f ps=0.74u w=0.17u l=0.17u
X1984 cml_tlatch_83.INN cml_tlatch_89.OUTP cml_tlatch_72.xmux.xn.S1 VSS sg13_lv_nmos ad=63.19999f pd=0.74u as=63.19999f ps=0.74u w=0.26u l=0.38u
X1985 cml_tlatch_8.xtail.S1 CKA0_N cml_tlatch_8.xmux.xn.S1 VSS sg13_lv_nmos ad=89.3f pd=0.85u as=89.3f ps=0.85u w=0.47u l=0.16u
X1986 cml_tlatch_91.xmux.xp.S1 CLK_W_N CLK_W_P VSS sg13_lv_nmos ad=56.9f pd=0.74u as=56.9f ps=0.74u w=0.17u l=0.17u
X1987 stub_bi_62.BOTP stub_bi_63.BOTN cml_tlatch_78.xmux.xn.S1 VSS sg13_lv_nmos ad=63.19999f pd=0.74u as=63.19999f ps=0.74u w=0.26u l=0.38u
X1988 cml_tlatch_32.xmux.xn.S1 B1_2_P stub_bi_29.BOTP VSS sg13_lv_nmos ad=63.19999f pd=0.74u as=63.19999f ps=0.74u w=0.26u l=0.38u
X1989 A2_2_P A2_2_N cml_tlatch_56.xmux.xp.S1 VSS sg13_lv_nmos ad=56.9f pd=0.74u as=56.9f ps=0.74u w=0.17u l=0.17u
X1990 cml_tlatch_6.xmux.xp.S1 MOT13_N MOT13_P VSS sg13_lv_nmos ad=56.9f pd=0.74u as=56.9f ps=0.74u w=0.17u l=0.17u
X1991 cml_tlatch_87.xmux.xp.S1 CKHA2_N cml_tlatch_87.xtail.S1 VSS sg13_lv_nmos ad=89.3f pd=0.85u as=89.3f ps=0.85u w=0.47u l=0.16u
X1992 cml_tlatch_57.xmux.xn.S1 cml_tlatch_57.INP MOT26_N VSS sg13_lv_nmos ad=63.19999f pd=0.74u as=0.1082p ps=1.34u w=0.26u l=0.38u
X1993 stub_bi_49.BOTP stub_bi_49.BOTN cml_tlatch_80.xmux.xp.S1 VSS sg13_lv_nmos ad=56.9f pd=0.74u as=56.9f ps=0.74u w=0.17u l=0.17u
X1994 cml_tlatch_11.xmux.xp.S1 cml_tlatch_11.OUTP cml_tlatch_11.OUTN VSS sg13_lv_nmos ad=56.9f pd=0.74u as=56.9f ps=0.74u w=0.17u l=0.17u
X1995 cml_tlatch_38.xmux.xp.S1 cml_tlatch_38.OUTN cml_tlatch_38.OUTP VSS sg13_lv_nmos ad=56.9f pd=0.74u as=56.9f ps=0.74u w=0.17u l=0.17u
X1996 cml_tlatch_32.xmux.xn.S1 B1_2_P stub_bi_29.BOTP VSS sg13_lv_nmos ad=63.19999f pd=0.74u as=63.19999f ps=0.74u w=0.26u l=0.38u
X1997 stub_bi_31.BOTN stub_bi_31.BOTP cml_tlatch_34.xmux.xp.S1 VSS sg13_lv_nmos ad=56.9f pd=0.74u as=56.9f ps=0.74u w=0.17u l=0.17u
X1998 J1_P J1_N cml_tlatch_93.xmux.xp.S1 VSS sg13_lv_nmos ad=56.9f pd=0.74u as=56.9f ps=0.74u w=0.17u l=0.17u
X1999 A0_2_N A0_2_P cml_tlatch_31.xmux.xp.S1 VSS sg13_lv_nmos ad=56.9f pd=0.74u as=56.9f ps=0.74u w=0.17u l=0.17u
X2000 cml_tlatch_5.INN cml_tlatch_5.INP cml_tlatch_14.xmux.xp.S1 VSS sg13_lv_nmos ad=56.9f pd=0.74u as=56.9f ps=0.74u w=0.17u l=0.17u
X2001 MOT25_N MOT25_P cml_tlatch_68.xmux.xp.S1 VSS sg13_lv_nmos ad=56.9f pd=0.74u as=56.9f ps=0.74u w=0.17u l=0.17u
X2002 cml_gate2_4.sg13_lv_nmos_FTPY57_0.D0 ENA1_P GA2_N VSS sg13_lv_nmos ad=0.1802p pd=1.74u as=0.1007p ps=0.91u w=0.53u l=0.13u
X2003 cml_tlatch_23.xtail.S1 CKA1_P cml_tlatch_23.xmux.xp.S1 VSS sg13_lv_nmos ad=89.3f pd=0.85u as=89.3f ps=0.85u w=0.47u l=0.16u
X2004 cml_tlatch_8.OUTP cml_tlatch_8.OUTN cml_tlatch_8.xmux.xp.S1 VSS sg13_lv_nmos ad=56.9f pd=0.74u as=56.9f ps=0.74u w=0.17u l=0.17u
X2005 cml_tlatch_27.xtail.S1 CKB0_N cml_tlatch_27.xmux.xp.S1 VSS sg13_lv_nmos ad=89.3f pd=0.85u as=89.3f ps=0.85u w=0.47u l=0.16u
X2006 cml_tlatch_24.xmux.xp.S1 MOT2_P MOT2_N VSS sg13_lv_nmos ad=56.9f pd=0.74u as=56.9f ps=0.74u w=0.17u l=0.17u
X2007 cml_tlatch_61.xmux.xp.S1 cml_tlatch_61.OUTN cml_tlatch_61.OUTP VSS sg13_lv_nmos ad=56.9f pd=0.74u as=56.9f ps=0.74u w=0.17u l=0.17u
X2008 cml_tlatch_4.xmux.xp.S1 MOT9_P MOT9_N VSS sg13_lv_nmos ad=56.9f pd=0.74u as=56.9f ps=0.74u w=0.17u l=0.17u
X2009 cml_tlatch_85.xtail.S1 CKA3_P cml_tlatch_85.xmux.xp.S1 VSS sg13_lv_nmos ad=89.3f pd=0.85u as=89.3f ps=0.85u w=0.47u l=0.16u
X2010 cml_tlatch_18.xmux.xp.S1 CKHB0_N cml_tlatch_18.xtail.S1 VSS sg13_lv_nmos ad=89.3f pd=0.85u as=89.3f ps=0.85u w=0.47u l=0.16u
X2011 cml_tlatch_0.xmux.xp.S1 CKA1_N cml_tlatch_0.xtail.S1 VSS sg13_lv_nmos ad=89.3f pd=0.85u as=89.3f ps=0.85u w=0.47u l=0.16u
X2012 cml_tlatch_82.OUTN cml_tlatch_82.OUTP cml_tlatch_82.xmux.xp.S1 VSS sg13_lv_nmos ad=56.9f pd=0.74u as=56.9f ps=0.74u w=0.17u l=0.17u
X2013 cml_tlatch_76.xmux.xn.S1 B2_2_P MOT23_N VSS sg13_lv_nmos ad=63.19999f pd=0.74u as=63.19999f ps=0.74u w=0.26u l=0.38u
X2014 cml_tlatch_68.xmux.xn.S1 B3_8_N MOT25_P VSS sg13_lv_nmos ad=0.1082p pd=1.34u as=63.19999f ps=0.74u w=0.26u l=0.38u
X2015 cml_tlatch_72.xmux.xp.S1 CKA2_N cml_tlatch_72.xtail.S1 VSS sg13_lv_nmos ad=0.1598p pd=1.62u as=89.3f ps=0.85u w=0.47u l=0.16u
X2016 VDD A1_8_P VSS rppd l=5.17u w=1u
X2017 stub_bi_17.BOTN stub_bi_17.BOTP cml_tlatch_13.xmux.xp.S1 VSS sg13_lv_nmos ad=56.9f pd=0.74u as=56.9f ps=0.74u w=0.17u l=0.17u
X2018 MOT11_P MOT11_N cml_tlatch_5.xmux.xp.S1 VSS sg13_lv_nmos ad=56.9f pd=0.74u as=56.9f ps=0.74u w=0.17u l=0.17u
X2019 cml_tlatch_55.xmux.xn.S1 A2_2_N cml_tlatch_89.INP VSS sg13_lv_nmos ad=63.19999f pd=0.74u as=63.19999f ps=0.74u w=0.26u l=0.38u
X2020 cml_tlatch_24.xmux.xp.S1 MOT2_N MOT2_P VSS sg13_lv_nmos ad=56.9f pd=0.74u as=56.9f ps=0.74u w=0.17u l=0.17u
X2021 cml_tlatch_38.xtail.S1 CKA1_P cml_tlatch_38.xmux.xn.S1 VSS sg13_lv_nmos ad=89.3f pd=0.85u as=89.3f ps=0.85u w=0.47u l=0.16u
X2022 cml_tlatch_96.xmux.xp.S1 CKHA1_N cml_tlatch_96.xtail.S1 VSS sg13_lv_nmos ad=89.3f pd=0.85u as=89.3f ps=0.85u w=0.47u l=0.16u
X2023 cml_tlatch_39.INN interco_bi_19.INP cml_tlatch_23.xmux.xn.S1 VSS sg13_lv_nmos ad=0.1082p pd=1.34u as=63.19999f ps=0.74u w=0.26u l=0.38u
X2024 cml_tlatch_50.xmux.xp.S1 MOT20_N MOT20_P VSS sg13_lv_nmos ad=56.9f pd=0.74u as=56.9f ps=0.74u w=0.17u l=0.17u
X2025 cml_tlatch_44.xtail.S1 CKB2_P cml_tlatch_44.xmux.xp.S1 VSS sg13_lv_nmos ad=89.3f pd=0.85u as=0.1598p ps=1.62u w=0.47u l=0.16u
X2026 MOT0_P A0_8_N cml_tlatch_97.xmux.xn.S1 VSS sg13_lv_nmos ad=63.19999f pd=0.74u as=63.19999f ps=0.74u w=0.26u l=0.38u
X2027 cml_tlatch_49.xmux.xp.S1 MOT18_P MOT18_N VSS sg13_lv_nmos ad=56.9f pd=0.74u as=56.9f ps=0.74u w=0.17u l=0.17u
X2028 MOT12_N MOT12_P cml_tlatch_40.xmux.xp.S1 VSS sg13_lv_nmos ad=56.9f pd=0.74u as=56.9f ps=0.74u w=0.17u l=0.17u
X2029 VDD cml_tlatch_54.OUTN VSS rppd l=5.17u w=1u
X2030 A3_2_N A3_2_P cml_tlatch_53.xmux.xp.S1 VSS sg13_lv_nmos ad=56.9f pd=0.74u as=56.9f ps=0.74u w=0.17u l=0.17u
X2031 MOT19_N stub_bi_63.BOTN cml_tlatch_74.xmux.xn.S1 VSS sg13_lv_nmos ad=63.19999f pd=0.74u as=63.19999f ps=0.74u w=0.26u l=0.38u
X2032 cml_tlatch_16.OUTN cml_tlatch_16.OUTP cml_tlatch_16.xmux.xp.S1 VSS sg13_lv_nmos ad=56.9f pd=0.74u as=56.9f ps=0.74u w=0.17u l=0.17u
X2033 cml_tlatch_99.xmux.xp.S1 cml_tlatch_99.OUTP cml_tlatch_99.OUTN VSS sg13_lv_nmos ad=56.9f pd=0.74u as=56.9f ps=0.74u w=0.17u l=0.17u
X2034 cml_tlatch_20.xtail.S1 CKHB0_N cml_tlatch_20.xmux.xp.S1 VSS sg13_lv_nmos ad=89.3f pd=0.85u as=89.3f ps=0.85u w=0.47u l=0.16u
X2035 cml_tlatch_57.xtail.S1 CKHA3_N cml_tlatch_57.xmux.xp.S1 VSS sg13_lv_nmos ad=89.3f pd=0.85u as=89.3f ps=0.85u w=0.47u l=0.16u
X2036 cml_tlatch_81.xmux.xp.S1 A2_8_P A2_8_N VSS sg13_lv_nmos ad=56.9f pd=0.74u as=56.9f ps=0.74u w=0.17u l=0.17u
X2037 cml_tlatch_98.xmux.xn.S1 cml_tlatch_27.OUTP cml_tlatch_98.OUTN VSS sg13_lv_nmos ad=63.19999f pd=0.74u as=63.19999f ps=0.74u w=0.26u l=0.38u
X2038 cml_tlatch_30.xmux.xp.S1 cml_tlatch_30.OUTN cml_tlatch_30.OUTP VSS sg13_lv_nmos ad=56.9f pd=0.74u as=56.9f ps=0.74u w=0.17u l=0.17u
X2039 cml_tlatch_40.xtail.S1 CKHA1_N cml_tlatch_40.xmux.xp.S1 VSS sg13_lv_nmos ad=89.3f pd=0.85u as=0.1598p ps=1.62u w=0.47u l=0.16u
X2040 cml_tlatch_80.xmux.xp.S1 stub_bi_49.BOTP stub_bi_49.BOTN VSS sg13_lv_nmos ad=56.9f pd=0.74u as=56.9f ps=0.74u w=0.17u l=0.17u
X2041 cml_tlatch_45.xmux.xp.S1 CKB3_N cml_tlatch_45.xtail.S1 VSS sg13_lv_nmos ad=89.3f pd=0.85u as=89.3f ps=0.85u w=0.47u l=0.16u
X2042 cml_tlatch_60.xmux.xp.S1 B3_8_N B3_8_P VSS sg13_lv_nmos ad=56.9f pd=0.74u as=56.9f ps=0.74u w=0.17u l=0.17u
X2043 CKA3_P CK_P hs_to_clk_7.D2 VSS sg13_lv_nmos ad=0.228p pd=1.58u as=0.408p ps=3.08u w=1.2u l=0.2u
X2044 cml_tlatch_73.xmux.xn.S1 CKHB2_P cml_tlatch_73.xtail.S1 VSS sg13_lv_nmos ad=0.1598p pd=1.62u as=89.3f ps=0.85u w=0.47u l=0.16u
X2045 cml_tlatch_34.xtail.S1 CKB1_P cml_tlatch_34.xmux.xn.S1 VSS sg13_lv_nmos ad=89.3f pd=0.85u as=89.3f ps=0.85u w=0.47u l=0.16u
X2046 A2_8_P A2_8_N cml_tlatch_81.xmux.xp.S1 VSS sg13_lv_nmos ad=56.9f pd=0.74u as=56.9f ps=0.74u w=0.17u l=0.17u
X2047 cml_tlatch_83.xmux.xn.S1 CKA2_N cml_tlatch_83.xtail.S1 VSS sg13_lv_nmos ad=89.3f pd=0.85u as=0.1598p ps=1.62u w=0.47u l=0.16u
X2048 cml_tlatch_88.xmux.xp.S1 stub_bi_55.BOTN stub_bi_55.BOTP VSS sg13_lv_nmos ad=56.9f pd=0.74u as=56.9f ps=0.74u w=0.17u l=0.17u
X2049 cml_tlatch_40.INN cml_tlatch_40.INP cml_tlatch_95.xmux.xp.S1 VSS sg13_lv_nmos ad=56.9f pd=0.74u as=56.9f ps=0.74u w=0.17u l=0.17u
X2050 cml_tlatch_48.xmux.xp.S1 stub_bi_32.BOTN stub_bi_32.BOTP VSS sg13_lv_nmos ad=0.1019p pd=1.34u as=56.9f ps=0.74u w=0.17u l=0.17u
X2051 cml_tlatch_29.OUTN cml_tlatch_29.OUTP cml_tlatch_29.xmux.xp.S1 VSS sg13_lv_nmos ad=56.9f pd=0.74u as=56.9f ps=0.74u w=0.17u l=0.17u
X2052 cml_tlatch_46.xtail.S1 CKB3_P cml_tlatch_46.xmux.xp.S1 VSS sg13_lv_nmos ad=89.3f pd=0.85u as=89.3f ps=0.85u w=0.47u l=0.16u
X2053 cml_tlatch_37.xmux.xp.S1 CKA1_P cml_tlatch_37.xtail.S1 VSS sg13_lv_nmos ad=0.1598p pd=1.62u as=89.3f ps=0.85u w=0.47u l=0.16u
X2054 cml_tlatch_55.xmux.xp.S1 cml_tlatch_89.INN cml_tlatch_89.INP VSS sg13_lv_nmos ad=56.9f pd=0.74u as=56.9f ps=0.74u w=0.17u l=0.17u
X2055 MOT4_N cml_tlatch_99.OUTP cml_tlatch_25.xmux.xn.S1 VSS sg13_lv_nmos ad=63.19999f pd=0.74u as=0.1082p ps=1.34u w=0.26u l=0.38u
X2056 cml_tlatch_27.xmux.xn.S1 B0_2_P cml_tlatch_27.OUTN VSS sg13_lv_nmos ad=63.19999f pd=0.74u as=63.19999f ps=0.74u w=0.26u l=0.38u
X2057 MOT1_N B0_8_P cml_tlatch_17.xmux.xn.S1 VSS sg13_lv_nmos ad=63.19999f pd=0.74u as=63.19999f ps=0.74u w=0.26u l=0.38u
X2058 A3_8_N cml_tlatch_65.OUTP cml_tlatch_64.xmux.xn.S1 VSS sg13_lv_nmos ad=63.19999f pd=0.74u as=0.1082p ps=1.34u w=0.26u l=0.38u
X2059 MOT29_P MOT29_N cml_tlatch_70.xmux.xp.S1 VSS sg13_lv_nmos ad=56.9f pd=0.74u as=56.9f ps=0.74u w=0.17u l=0.17u
X2060 cml_tlatch_83.xmux.xp.S1 cml_tlatch_83.OUTN cml_tlatch_83.OUTP VSS sg13_lv_nmos ad=0.1019p pd=1.34u as=56.9f ps=0.74u w=0.17u l=0.17u
X2061 cml_tlatch_27.xmux.xn.S1 B0_2_P cml_tlatch_27.OUTN VSS sg13_lv_nmos ad=63.19999f pd=0.74u as=63.19999f ps=0.74u w=0.26u l=0.38u
X2062 cml_tlatch_26.xmux.xn.S1 A0_2_P MOT6_N VSS sg13_lv_nmos ad=63.19999f pd=0.74u as=63.19999f ps=0.74u w=0.26u l=0.38u
X2063 MOT25_N MOT25_P cml_tlatch_68.xmux.xp.S1 VSS sg13_lv_nmos ad=56.9f pd=0.74u as=0.1019p ps=1.34u w=0.17u l=0.17u
X2064 cml_tlatch_89.OUTP cml_tlatch_89.OUTN cml_tlatch_89.xmux.xp.S1 VSS sg13_lv_nmos ad=56.9f pd=0.74u as=56.9f ps=0.74u w=0.17u l=0.17u
X2065 cml_tlatch_47.xmux.xp.S1 cml_tlatch_47.OUTN cml_tlatch_47.OUTP VSS sg13_lv_nmos ad=56.9f pd=0.74u as=56.9f ps=0.74u w=0.17u l=0.17u
X2066 cml_tlatch_83.xmux.xn.S1 cml_tlatch_83.INN cml_tlatch_83.OUTP VSS sg13_lv_nmos ad=63.19999f pd=0.74u as=63.19999f ps=0.74u w=0.26u l=0.38u
X2067 VSS hs_to_clk_7.sg13_lv_nmos_2HGZLP_0.G VSS VSS sg13_lv_nmos ad=2.071p pd=11.28u as=0 ps=0 w=10.9u l=1.38u
X2068 cml_tlatch_9.OUTN cml_tlatch_9.OUTP cml_tlatch_9.xmux.xp.S1 VSS sg13_lv_nmos ad=56.9f pd=0.74u as=56.9f ps=0.74u w=0.17u l=0.17u
X2069 cml_tlatch_87.xmux.xp.S1 MOT16_N MOT16_P VSS sg13_lv_nmos ad=56.9f pd=0.74u as=56.9f ps=0.74u w=0.17u l=0.17u
X2070 cml_tlatch_6.xmux.xp.S1 MOT13_N MOT13_P VSS sg13_lv_nmos ad=56.9f pd=0.74u as=56.9f ps=0.74u w=0.17u l=0.17u
X2071 cml_tlatch_76.xmux.xp.S1 MOT23_N MOT23_P VSS sg13_lv_nmos ad=56.9f pd=0.74u as=56.9f ps=0.74u w=0.17u l=0.17u
X2072 stub_bi_31.BOTN stub_bi_31.BOTP cml_tlatch_34.xmux.xp.S1 VSS sg13_lv_nmos ad=56.9f pd=0.74u as=56.9f ps=0.74u w=0.17u l=0.17u
X2073 cml_tlatch_58.xmux.xn.S1 cml_tlatch_58.INN MOT28_P VSS sg13_lv_nmos ad=63.19999f pd=0.74u as=63.19999f ps=0.74u w=0.26u l=0.38u
X2074 cml_tlatch_70.xtail.S1 CKHB3_P cml_tlatch_70.xmux.xn.S1 VSS sg13_lv_nmos ad=0.1598p pd=1.62u as=89.3f ps=0.85u w=0.47u l=0.16u
X2075 A1_2_P A1_2_N cml_tlatch_37.xmux.xp.S1 VSS sg13_lv_nmos ad=56.9f pd=0.74u as=56.9f ps=0.74u w=0.17u l=0.17u
X2076 VDD A1_2_P VSS rppd l=5.17u w=1u
X2077 cml_tlatch_98.xmux.xp.S1 cml_tlatch_98.OUTN cml_tlatch_98.OUTP VSS sg13_lv_nmos ad=56.9f pd=0.74u as=56.9f ps=0.74u w=0.17u l=0.17u
X2078 cml_tlatch_99.xmux.xn.S1 CKA0_N cml_tlatch_99.xtail.S1 VSS sg13_lv_nmos ad=89.3f pd=0.85u as=89.3f ps=0.85u w=0.47u l=0.16u
X2079 cml_tlatch_40.xmux.xn.S1 cml_tlatch_40.INP MOT12_N VSS sg13_lv_nmos ad=0.1082p pd=1.34u as=63.19999f ps=0.74u w=0.26u l=0.38u
X2080 cml_tlatch_82.xmux.xp.S1 cml_tlatch_82.OUTN cml_tlatch_82.OUTP VSS sg13_lv_nmos ad=56.9f pd=0.74u as=56.9f ps=0.74u w=0.17u l=0.17u
X2081 cml_tlatch_7.xmux.xp.S1 MOT15_P MOT15_N VSS sg13_lv_nmos ad=56.9f pd=0.74u as=56.9f ps=0.74u w=0.17u l=0.17u
X2082 cml_tlatch_87.xtail.S1 CKHA2_P cml_tlatch_87.xmux.xn.S1 VSS sg13_lv_nmos ad=89.3f pd=0.85u as=89.3f ps=0.85u w=0.47u l=0.16u
X2083 cml_tlatch_8.OUTP cml_tlatch_8.OUTN cml_tlatch_8.xmux.xp.S1 VSS sg13_lv_nmos ad=56.9f pd=0.74u as=56.9f ps=0.74u w=0.17u l=0.17u
X2084 cml_tlatch_42.xmux.xn.S1 CKA2_P cml_tlatch_42.xtail.S1 VSS sg13_lv_nmos ad=89.3f pd=0.85u as=89.3f ps=0.85u w=0.47u l=0.16u
X2085 cml_tlatch_16.xmux.xp.S1 CKB0_P cml_tlatch_16.xtail.S1 VSS sg13_lv_nmos ad=89.3f pd=0.85u as=89.3f ps=0.85u w=0.47u l=0.16u
X2086 cml_tlatch_65.xtail.S1 CKA3_N cml_tlatch_65.xmux.xp.S1 VSS sg13_lv_nmos ad=89.3f pd=0.85u as=89.3f ps=0.85u w=0.47u l=0.16u
X2087 cml_drv_3.xrtail.R1 ENA_N ENA0_P VSS sg13_lv_nmos ad=56.2f pd=0.74u as=56.2f ps=0.74u w=0.16u l=0.19u
X2088 cml_tlatch_89.xmux.xn.S1 CKA2_N cml_tlatch_89.xtail.S1 VSS sg13_lv_nmos ad=89.3f pd=0.85u as=89.3f ps=0.85u w=0.47u l=0.16u
X2089 MOT22_N MOT22_P cml_tlatch_51.xmux.xp.S1 VSS sg13_lv_nmos ad=56.9f pd=0.74u as=56.9f ps=0.74u w=0.17u l=0.17u
X2090 MOT10_P MOT10_N cml_tlatch_39.xmux.xp.S1 VSS sg13_lv_nmos ad=56.9f pd=0.74u as=56.9f ps=0.74u w=0.17u l=0.17u
X2091 cml_tlatch_53.xmux.xn.S1 cml_tlatch_54.OUTN A3_2_P VSS sg13_lv_nmos ad=63.19999f pd=0.74u as=63.19999f ps=0.74u w=0.26u l=0.38u
X2092 J1_P J4_P cml_tlatch_93.xmux.xn.S1 VSS sg13_lv_nmos ad=63.19999f pd=0.74u as=63.19999f ps=0.74u w=0.26u l=0.38u
X2093 cml_tlatch_93.xmux.xn.S1 CKJ_P cml_tlatch_93.xtail.S1 VSS sg13_lv_nmos ad=0.1598p pd=1.62u as=89.3f ps=0.85u w=0.47u l=0.16u
X2094 cml_tlatch_45.xmux.xp.S1 cml_tlatch_45.OUTP cml_tlatch_45.OUTN VSS sg13_lv_nmos ad=56.9f pd=0.74u as=56.9f ps=0.74u w=0.17u l=0.17u
X2095 VSS POLN cml_tlatch_58.xtail.S1 VSS sg13_lv_nmos ad=1.5637p pd=8.61u as=1.5637p ps=8.61u w=8.23u l=0.13u
X2096 cml_gate2_4.sg13_lv_nmos_FTPY57_0.D0 ENA1_N GA2_P VSS sg13_lv_nmos ad=0.1007p pd=0.91u as=0.1007p ps=0.91u w=0.53u l=0.13u
X2097 cml_tlatch_6.xtail.S1 CKHB1_P cml_tlatch_6.xmux.xn.S1 VSS sg13_lv_nmos ad=89.3f pd=0.85u as=89.3f ps=0.85u w=0.47u l=0.16u
X2098 B2_8_P B2_8_N cml_tlatch_77.xmux.xp.S1 VSS sg13_lv_nmos ad=56.9f pd=0.74u as=0.1019p ps=1.34u w=0.17u l=0.17u
X2099 cml_tlatch_46.xmux.xp.S1 B3_2_P B3_2_N VSS sg13_lv_nmos ad=56.9f pd=0.74u as=56.9f ps=0.74u w=0.17u l=0.17u
X2100 cml_tlatch_66.xtail.S1 CKA3_N cml_tlatch_66.xmux.xn.S1 VSS sg13_lv_nmos ad=89.3f pd=0.85u as=89.3f ps=0.85u w=0.47u l=0.16u
X2101 cml_tlatch_59.xmux.xp.S1 MOT30_N MOT30_P VSS sg13_lv_nmos ad=0.1019p pd=1.34u as=56.9f ps=0.74u w=0.17u l=0.17u
X2102 MOT16_N MOT16_P cml_tlatch_87.xmux.xp.S1 VSS sg13_lv_nmos ad=56.9f pd=0.74u as=56.9f ps=0.74u w=0.17u l=0.17u
X2103 cml_tlatch_27.xmux.xp.S1 cml_tlatch_27.OUTP cml_tlatch_27.OUTN VSS sg13_lv_nmos ad=56.9f pd=0.74u as=56.9f ps=0.74u w=0.17u l=0.17u
X2104 cml_tlatch_86.xmux.xp.S1 MOT24_P MOT24_N VSS sg13_lv_nmos ad=56.9f pd=0.74u as=56.9f ps=0.74u w=0.17u l=0.17u
X2105 stub_bi_32.BOTP D2_P cml_tlatch_48.xmux.xn.S1 VSS sg13_lv_nmos ad=63.19999f pd=0.74u as=63.19999f ps=0.74u w=0.26u l=0.38u
X2106 cml_tlatch_61.xtail.S1 CKB3_N cml_tlatch_61.xmux.xp.S1 VSS sg13_lv_nmos ad=0.1598p pd=1.62u as=89.3f ps=0.85u w=0.47u l=0.16u
X2107 MOT7_N B0_2_P cml_tlatch_20.xmux.xn.S1 VSS sg13_lv_nmos ad=0.1082p pd=1.34u as=63.19999f ps=0.74u w=0.26u l=0.38u
X2108 cml_tlatch_71.xmux.xp.S1 MOT31_P MOT31_N VSS sg13_lv_nmos ad=56.9f pd=0.74u as=56.9f ps=0.74u w=0.17u l=0.17u
X2109 cml_tlatch_27.xtail.S1 CKB0_P cml_tlatch_27.xmux.xn.S1 VSS sg13_lv_nmos ad=89.3f pd=0.85u as=89.3f ps=0.85u w=0.47u l=0.16u
X2110 cml_tlatch_77.xtail.S1 CKB2_N cml_tlatch_77.xmux.xn.S1 VSS sg13_lv_nmos ad=89.3f pd=0.85u as=89.3f ps=0.85u w=0.47u l=0.16u
X2111 MOT26_N MOT26_P cml_tlatch_57.xmux.xp.S1 VSS sg13_lv_nmos ad=56.9f pd=0.74u as=56.9f ps=0.74u w=0.17u l=0.17u
X2112 cml_tlatch_25.xtail.S1 CKHA0_P cml_tlatch_25.xmux.xn.S1 VSS sg13_lv_nmos ad=89.3f pd=0.85u as=89.3f ps=0.85u w=0.47u l=0.16u
X2113 MOT5_N MOT5_P cml_tlatch_19.xmux.xp.S1 VSS sg13_lv_nmos ad=56.9f pd=0.74u as=0.1019p ps=1.34u w=0.17u l=0.17u
X2114 cml_tlatch_95.xmux.xp.S1 cml_tlatch_40.INN cml_tlatch_40.INP VSS sg13_lv_nmos ad=56.9f pd=0.74u as=56.9f ps=0.74u w=0.17u l=0.17u
X2115 cml_tlatch_46.xmux.xp.S1 B3_2_P B3_2_N VSS sg13_lv_nmos ad=0.1019p pd=1.34u as=56.9f ps=0.74u w=0.17u l=0.17u
X2116 cml_tlatch_30.xmux.xp.S1 cml_tlatch_30.OUTN cml_tlatch_30.OUTP VSS sg13_lv_nmos ad=56.9f pd=0.74u as=56.9f ps=0.74u w=0.17u l=0.17u
X2117 cml_tlatch_26.xmux.xp.S1 MOT6_P MOT6_N VSS sg13_lv_nmos ad=56.9f pd=0.74u as=56.9f ps=0.74u w=0.17u l=0.17u
X2118 cml_tlatch_86.xmux.xp.S1 MOT24_N MOT24_P VSS sg13_lv_nmos ad=56.9f pd=0.74u as=56.9f ps=0.74u w=0.17u l=0.17u
X2119 MOT10_N cml_tlatch_39.INP cml_tlatch_39.xmux.xn.S1 VSS sg13_lv_nmos ad=63.19999f pd=0.74u as=63.19999f ps=0.74u w=0.26u l=0.38u
X2120 interco_bi_19.INP interco_bi_19.INN cml_tlatch_0.xmux.xp.S1 VSS sg13_lv_nmos ad=56.9f pd=0.74u as=0.1019p ps=1.34u w=0.17u l=0.17u
X2121 GB1_P CKA1_N cml_gate2_0.xrtail.R1 VSS sg13_lv_nmos ad=0.1007p pd=0.91u as=0.1007p ps=0.91u w=0.53u l=0.13u
X2122 cml_tlatch_21.xmux.xp.S1 CKA1_P cml_tlatch_21.xtail.S1 VSS sg13_lv_nmos ad=89.3f pd=0.85u as=0.1598p ps=1.62u w=0.47u l=0.16u
X2123 cml_tlatch_18.xtail.S1 CKHB0_N cml_tlatch_18.xmux.xp.S1 VSS sg13_lv_nmos ad=89.3f pd=0.85u as=89.3f ps=0.85u w=0.47u l=0.16u
X2124 B1_2_N B1_2_P cml_tlatch_33.xmux.xp.S1 VSS sg13_lv_nmos ad=56.9f pd=0.74u as=56.9f ps=0.74u w=0.17u l=0.17u
X2125 cml_tlatch_31.xmux.xp.S1 CKA0_P cml_tlatch_31.xtail.S1 VSS sg13_lv_nmos ad=0.1598p pd=1.62u as=89.3f ps=0.85u w=0.47u l=0.16u
X2126 MOT10_N cml_tlatch_39.INP cml_tlatch_39.xmux.xn.S1 VSS sg13_lv_nmos ad=63.19999f pd=0.74u as=63.19999f ps=0.74u w=0.26u l=0.38u
X2127 cml_tlatch_40.INN cml_tlatch_95.INP cml_tlatch_95.xmux.xn.S1 VSS sg13_lv_nmos ad=63.19999f pd=0.74u as=63.19999f ps=0.74u w=0.26u l=0.38u
X2128 cml_tlatch_11.xtail.S1 CKB0_N cml_tlatch_11.xmux.xp.S1 VSS sg13_lv_nmos ad=89.3f pd=0.85u as=89.3f ps=0.85u w=0.47u l=0.16u
X2129 cml_tlatch_92.xmux.xn.S1 J1_N J2_P VSS sg13_lv_nmos ad=63.19999f pd=0.74u as=63.19999f ps=0.74u w=0.26u l=0.38u
X2130 cml_tlatch_71.xmux.xn.S1 B3_2_N MOT31_P VSS sg13_lv_nmos ad=63.19999f pd=0.74u as=63.19999f ps=0.74u w=0.26u l=0.38u
X2131 cml_tlatch_42.xmux.xp.S1 cml_tlatch_56.INN cml_tlatch_56.INP VSS sg13_lv_nmos ad=56.9f pd=0.74u as=56.9f ps=0.74u w=0.17u l=0.17u
X2132 VDD ENA_P VSS rppd l=7.42u w=1u
X2133 cml_tlatch_63.OUTP cml_tlatch_70.INN cml_tlatch_63.xmux.xn.S1 VSS sg13_lv_nmos ad=63.19999f pd=0.74u as=63.19999f ps=0.74u w=0.26u l=0.38u
X2134 cml_tlatch_73.xmux.xp.S1 MOT17_N MOT17_P VSS sg13_lv_nmos ad=56.9f pd=0.74u as=56.9f ps=0.74u w=0.17u l=0.17u
X2135 A1_8_P cml_tlatch_22.OUTN cml_tlatch_21.xmux.xn.S1 VSS sg13_lv_nmos ad=63.19999f pd=0.74u as=63.19999f ps=0.74u w=0.26u l=0.38u
X2136 cml_tlatch_62.xtail.S1 POLN VSS VSS sg13_lv_nmos ad=1.5637p pd=8.61u as=1.5637p ps=8.61u w=8.23u l=0.13u
X2137 VSS POLN cml_tlatch_96.xtail.S1 VSS sg13_lv_nmos ad=2.7982p pd=17.14u as=1.5637p ps=8.61u w=8.23u l=0.13u
X2138 cml_tlatch_1.xmux.xp.S1 cml_tlatch_1.OUTN cml_tlatch_1.OUTP VSS sg13_lv_nmos ad=56.9f pd=0.74u as=56.9f ps=0.74u w=0.17u l=0.17u
X2139 cml_tlatch_26.xtail.S1 CKHA0_P cml_tlatch_26.xmux.xn.S1 VSS sg13_lv_nmos ad=89.3f pd=0.85u as=89.3f ps=0.85u w=0.47u l=0.16u
X2140 cml_tlatch_71.xmux.xn.S1 B3_2_N MOT31_P VSS sg13_lv_nmos ad=63.19999f pd=0.74u as=63.19999f ps=0.74u w=0.26u l=0.38u
X2141 cml_tlatch_3.OUTP cml_tlatch_3.OUTN cml_tlatch_3.xmux.xp.S1 VSS sg13_lv_nmos ad=56.9f pd=0.74u as=56.9f ps=0.74u w=0.17u l=0.17u
X2142 cml_tlatch_22.xmux.xp.S1 cml_tlatch_22.OUTP cml_tlatch_22.OUTN VSS sg13_lv_nmos ad=56.9f pd=0.74u as=56.9f ps=0.74u w=0.17u l=0.17u
X2143 B1_2_N stub_bi_31.BOTN cml_tlatch_33.xmux.xn.S1 VSS sg13_lv_nmos ad=63.19999f pd=0.74u as=63.19999f ps=0.74u w=0.26u l=0.38u
X2144 cml_tlatch_15.xmux.xp.S1 stub_bi_19.BOTN stub_bi_19.BOTP VSS sg13_lv_nmos ad=56.9f pd=0.74u as=56.9f ps=0.74u w=0.17u l=0.17u
X2145 cml_tlatch_4.xtail.S1 CKHB1_N cml_tlatch_4.xmux.xp.S1 VSS sg13_lv_nmos ad=89.3f pd=0.85u as=0.1598p ps=1.62u w=0.47u l=0.16u
X2146 cml_tlatch_63.xmux.xn.S1 cml_tlatch_70.INP cml_tlatch_63.OUTN VSS sg13_lv_nmos ad=63.19999f pd=0.74u as=0.1082p ps=1.34u w=0.26u l=0.38u
X2147 cml_tlatch_98.OUTP VDD VSS rppd l=5.17u w=1u
X2148 cml_tlatch_80.xtail.S1 CKB2_P cml_tlatch_80.xmux.xn.S1 VSS sg13_lv_nmos ad=89.3f pd=0.85u as=89.3f ps=0.85u w=0.47u l=0.16u
X2149 cml_tlatch_98.xmux.xp.S1 cml_tlatch_98.OUTN cml_tlatch_98.OUTP VSS sg13_lv_nmos ad=56.9f pd=0.74u as=56.9f ps=0.74u w=0.17u l=0.17u
X2150 cml_tlatch_19.xmux.xp.S1 CKHB0_N cml_tlatch_19.xtail.S1 VSS sg13_lv_nmos ad=0.1598p pd=1.62u as=89.3f ps=0.85u w=0.47u l=0.16u
X2151 J4_P CLK_W_P cml_tlatch_90.xmux.xn.S1 VSS sg13_lv_nmos ad=63.19999f pd=0.74u as=63.19999f ps=0.74u w=0.26u l=0.38u
X2152 cml_tlatch_74.xtail.S1 CKHB2_N cml_tlatch_74.xmux.xp.S1 VSS sg13_lv_nmos ad=89.3f pd=0.85u as=89.3f ps=0.85u w=0.47u l=0.16u
X2153 cml_tlatch_69.xtail.S1 POLN VSS VSS sg13_lv_nmos ad=1.5637p pd=8.61u as=2.7982p ps=17.14u w=8.23u l=0.13u
X2154 cml_tlatch_45.xtail.S1 CKB3_N cml_tlatch_45.xmux.xp.S1 VSS sg13_lv_nmos ad=89.3f pd=0.85u as=89.3f ps=0.85u w=0.47u l=0.16u
X2155 cml_gate2_1.sg13_lv_nmos_FTPY57_0.D0 ENB1_N GB0_P VSS sg13_lv_nmos ad=0.1007p pd=0.91u as=0.1007p ps=0.91u w=0.53u l=0.13u
X2156 stub_bi_62.BOTN stub_bi_62.BOTP cml_tlatch_78.xmux.xp.S1 VSS sg13_lv_nmos ad=56.9f pd=0.74u as=56.9f ps=0.74u w=0.17u l=0.17u
X2157 cml_tlatch_7.xmux.xp.S1 MOT15_P MOT15_N VSS sg13_lv_nmos ad=0.1019p pd=1.34u as=56.9f ps=0.74u w=0.17u l=0.17u
X2158 cml_tlatch_44.xtail.S1 CKB2_N cml_tlatch_44.xmux.xn.S1 VSS sg13_lv_nmos ad=89.3f pd=0.85u as=89.3f ps=0.85u w=0.47u l=0.16u
X2159 cml_tlatch_58.INP cml_tlatch_58.INN cml_tlatch_85.xmux.xp.S1 VSS sg13_lv_nmos ad=56.9f pd=0.74u as=56.9f ps=0.74u w=0.17u l=0.17u
X2160 cml_tlatch_57.xtail.S1 CKHA3_P cml_tlatch_57.xmux.xn.S1 VSS sg13_lv_nmos ad=89.3f pd=0.85u as=89.3f ps=0.85u w=0.47u l=0.16u
X2161 B3_2_P B3_2_N cml_tlatch_46.xmux.xp.S1 VSS sg13_lv_nmos ad=56.9f pd=0.74u as=56.9f ps=0.74u w=0.17u l=0.17u
X2162 cml_gate2_8.xrtail.R1 NS1_N ENB_P VSS sg13_lv_nmos ad=0.1802p pd=1.74u as=0.1007p ps=0.91u w=0.53u l=0.13u
X2163 cml_tlatch_85.xtail.S1 POLN VSS VSS sg13_lv_nmos ad=1.5637p pd=8.61u as=1.5637p ps=8.61u w=8.23u l=0.13u
X2164 MOT22_N MOT22_P cml_tlatch_51.xmux.xp.S1 VSS sg13_lv_nmos ad=56.9f pd=0.74u as=56.9f ps=0.74u w=0.17u l=0.17u
X2165 cml_tlatch_59.xmux.xp.S1 MOT30_P MOT30_N VSS sg13_lv_nmos ad=56.9f pd=0.74u as=56.9f ps=0.74u w=0.17u l=0.17u
X2166 cml_tlatch_96.xmux.xn.S1 A1_8_P MOT8_N VSS sg13_lv_nmos ad=63.19999f pd=0.74u as=63.19999f ps=0.74u w=0.26u l=0.38u
X2167 GA3_N ENA1_P cml_gate2_5.sg13_lv_nmos_FTPY57_0.D0 VSS sg13_lv_nmos ad=0.1007p pd=0.91u as=0.1802p ps=1.74u w=0.53u l=0.13u
X2168 cml_tlatch_7.xtail.S1 CKHB1_P cml_tlatch_7.xmux.xn.S1 VSS sg13_lv_nmos ad=89.3f pd=0.85u as=89.3f ps=0.85u w=0.47u l=0.16u
X2169 cml_tlatch_39.INN cml_tlatch_39.INP cml_tlatch_23.xmux.xp.S1 VSS sg13_lv_nmos ad=56.9f pd=0.74u as=56.9f ps=0.74u w=0.17u l=0.17u
X2170 cml_tlatch_39.INP cml_tlatch_39.INN cml_tlatch_23.xmux.xp.S1 VSS sg13_lv_nmos ad=56.9f pd=0.74u as=56.9f ps=0.74u w=0.17u l=0.17u
X2171 cml_tlatch_95.xmux.xp.S1 cml_tlatch_40.INN cml_tlatch_40.INP VSS sg13_lv_nmos ad=56.9f pd=0.74u as=56.9f ps=0.74u w=0.17u l=0.17u
X2172 B3_8_P cml_tlatch_61.OUTN cml_tlatch_60.xmux.xn.S1 VSS sg13_lv_nmos ad=63.19999f pd=0.74u as=63.19999f ps=0.74u w=0.26u l=0.38u
X2173 cml_tlatch_14.xmux.xp.S1 cml_tlatch_5.INN cml_tlatch_5.INP VSS sg13_lv_nmos ad=56.9f pd=0.74u as=56.9f ps=0.74u w=0.17u l=0.17u
X2174 cml_tlatch_5.xmux.xp.S1 MOT11_P MOT11_N VSS sg13_lv_nmos ad=56.9f pd=0.74u as=56.9f ps=0.74u w=0.17u l=0.17u
X2175 cml_tlatch_6.INP cml_tlatch_6.INN cml_tlatch_94.xmux.xp.S1 VSS sg13_lv_nmos ad=56.9f pd=0.74u as=56.9f ps=0.74u w=0.17u l=0.17u
X2176 cml_tlatch_64.xmux.xp.S1 A3_8_P A3_8_N VSS sg13_lv_nmos ad=0.1019p pd=1.34u as=56.9f ps=0.74u w=0.17u l=0.17u
X2177 cml_tlatch_76.xmux.xp.S1 CKHB2_N cml_tlatch_76.xtail.S1 VSS sg13_lv_nmos ad=89.3f pd=0.85u as=89.3f ps=0.85u w=0.47u l=0.16u
X2178 cml_tlatch_27.xmux.xp.S1 cml_tlatch_27.OUTP cml_tlatch_27.OUTN VSS sg13_lv_nmos ad=56.9f pd=0.74u as=56.9f ps=0.74u w=0.17u l=0.17u
X2179 cml_tlatch_81.xtail.S1 CKA2_P cml_tlatch_81.xmux.xp.S1 VSS sg13_lv_nmos ad=89.3f pd=0.85u as=89.3f ps=0.85u w=0.47u l=0.16u
X2180 cml_tlatch_67.OUTP cml_tlatch_67.OUTN cml_tlatch_67.xmux.xp.S1 VSS sg13_lv_nmos ad=56.9f pd=0.74u as=56.9f ps=0.74u w=0.17u l=0.17u
X2181 cml_tlatch_31.xmux.xp.S1 A0_2_N A0_2_P VSS sg13_lv_nmos ad=56.9f pd=0.74u as=56.9f ps=0.74u w=0.17u l=0.17u
X2182 cml_tlatch_65.xmux.xp.S1 cml_tlatch_65.OUTN cml_tlatch_65.OUTP VSS sg13_lv_nmos ad=56.9f pd=0.74u as=56.9f ps=0.74u w=0.17u l=0.17u
X2183 cml_tlatch_3.xmux.xp.S1 cml_tlatch_3.OUTP cml_tlatch_3.OUTN VSS sg13_lv_nmos ad=56.9f pd=0.74u as=56.9f ps=0.74u w=0.17u l=0.17u
X2184 cml_tlatch_35.xmux.xn.S1 D0_N cml_tlatch_35.OUTP VSS sg13_lv_nmos ad=63.19999f pd=0.74u as=63.19999f ps=0.74u w=0.26u l=0.38u
X2185 cml_tlatch_84.xmux.xp.S1 cml_tlatch_70.INP cml_tlatch_70.INN VSS sg13_lv_nmos ad=56.9f pd=0.74u as=56.9f ps=0.74u w=0.17u l=0.17u
X2186 cml_tlatch_84.xtail.S1 CKB3_P cml_tlatch_84.xmux.xp.S1 VSS sg13_lv_nmos ad=89.3f pd=0.85u as=89.3f ps=0.85u w=0.47u l=0.16u
X2187 cml_tlatch_78.xmux.xn.S1 stub_bi_63.BOTN stub_bi_62.BOTP VSS sg13_lv_nmos ad=63.19999f pd=0.74u as=63.19999f ps=0.74u w=0.26u l=0.38u
X2188 cml_tlatch_96.xmux.xp.S1 CKHA1_N cml_tlatch_96.xtail.S1 VSS sg13_lv_nmos ad=89.3f pd=0.85u as=89.3f ps=0.85u w=0.47u l=0.16u
X2189 GA1_P CKB1_N cml_gate2_3.xrtail.R1 VSS sg13_lv_nmos ad=0.1007p pd=0.91u as=0.1007p ps=0.91u w=0.53u l=0.13u
X2190 MOT5_N MOT5_P cml_tlatch_19.xmux.xp.S1 VSS sg13_lv_nmos ad=56.9f pd=0.74u as=56.9f ps=0.74u w=0.17u l=0.17u
X2191 cml_tlatch_5.xtail.S1 CKHB1_N cml_tlatch_5.xmux.xp.S1 VSS sg13_lv_nmos ad=89.3f pd=0.85u as=89.3f ps=0.85u w=0.47u l=0.16u
X2192 cml_tlatch_33.xmux.xp.S1 B1_2_N B1_2_P VSS sg13_lv_nmos ad=0.1019p pd=1.34u as=56.9f ps=0.74u w=0.17u l=0.17u
X2193 cml_tlatch_63.OUTN cml_tlatch_63.OUTP cml_tlatch_63.xmux.xp.S1 VSS sg13_lv_nmos ad=56.9f pd=0.74u as=56.9f ps=0.74u w=0.17u l=0.17u
X2194 cml_tlatch_52.xmux.xp.S1 cml_tlatch_52.OUTN cml_tlatch_52.OUTP VSS sg13_lv_nmos ad=0.1019p pd=1.34u as=56.9f ps=0.74u w=0.17u l=0.17u
X2195 cml_tlatch_57.INN cml_tlatch_57.INP cml_tlatch_66.xmux.xp.S1 VSS sg13_lv_nmos ad=56.9f pd=0.74u as=56.9f ps=0.74u w=0.17u l=0.17u
X2196 CKA0_N CK_N hs_to_clk_0.D2 VSS sg13_lv_nmos ad=0.228p pd=1.58u as=0.408p ps=3.08u w=1.2u l=0.2u
X2197 cml_tlatch_91.xmux.xp.S1 CLK_W_P CLK_W_N VSS sg13_lv_nmos ad=56.9f pd=0.74u as=56.9f ps=0.74u w=0.17u l=0.17u
X2198 cml_tlatch_2.xmux.xn.S1 cml_tlatch_3.OUTP A0_8_N VSS sg13_lv_nmos ad=63.19999f pd=0.74u as=63.19999f ps=0.74u w=0.26u l=0.38u
X2199 cml_tlatch_69.xmux.xp.S1 MOT27_P MOT27_N VSS sg13_lv_nmos ad=56.9f pd=0.74u as=56.9f ps=0.74u w=0.17u l=0.17u
X2200 cml_tlatch_50.xmux.xp.S1 MOT20_P MOT20_N VSS sg13_lv_nmos ad=56.9f pd=0.74u as=56.9f ps=0.74u w=0.17u l=0.17u
X2201 cml_tlatch_82.xtail.S1 CKA2_P cml_tlatch_82.xmux.xn.S1 VSS sg13_lv_nmos ad=89.3f pd=0.85u as=89.3f ps=0.85u w=0.47u l=0.16u
X2202 ENA_P J1_N cml_gate2_9.sg13_lv_nmos_FTPY57_0.D0 VSS sg13_lv_nmos ad=0.1007p pd=0.91u as=0.1007p ps=0.91u w=0.53u l=0.13u
X2203 VSS POLN cml_tlatch_79.xtail.S1 VSS sg13_lv_nmos ad=2.7982p pd=17.14u as=1.5637p ps=8.61u w=8.23u l=0.13u
X2204 cml_tlatch_18.xtail.S1 CKHB0_P cml_tlatch_18.xmux.xn.S1 VSS sg13_lv_nmos ad=89.3f pd=0.85u as=89.3f ps=0.85u w=0.47u l=0.16u
X2205 B2_8_N stub_bi_62.BOTN cml_tlatch_77.xmux.xn.S1 VSS sg13_lv_nmos ad=63.19999f pd=0.74u as=63.19999f ps=0.74u w=0.26u l=0.38u
X2206 cml_tlatch_40.xmux.xp.S1 MOT12_P MOT12_N VSS sg13_lv_nmos ad=56.9f pd=0.74u as=56.9f ps=0.74u w=0.17u l=0.17u
X2207 cml_tlatch_22.xmux.xn.S1 cml_tlatch_39.INN cml_tlatch_22.OUTP VSS sg13_lv_nmos ad=63.19999f pd=0.74u as=63.19999f ps=0.74u w=0.26u l=0.38u
X2208 MOT3_P MOT3_N cml_tlatch_18.xmux.xp.S1 VSS sg13_lv_nmos ad=56.9f pd=0.74u as=56.9f ps=0.74u w=0.17u l=0.17u
X2209 cml_drv_2.xrtail.R1 ENB_P ENB0_N VSS sg13_lv_nmos ad=56.2f pd=0.74u as=56.2f ps=0.74u w=0.16u l=0.19u
X2210 A2_8_P cml_tlatch_82.OUTN cml_tlatch_81.xmux.xn.S1 VSS sg13_lv_nmos ad=0.1082p pd=1.34u as=63.19999f ps=0.74u w=0.26u l=0.38u
X2211 cml_tlatch_26.xmux.xp.S1 MOT6_N MOT6_P VSS sg13_lv_nmos ad=56.9f pd=0.74u as=56.9f ps=0.74u w=0.17u l=0.17u
X2212 cml_tlatch_60.xmux.xp.S1 B3_8_P B3_8_N VSS sg13_lv_nmos ad=56.9f pd=0.74u as=56.9f ps=0.74u w=0.17u l=0.17u
X2213 cml_tlatch_52.OUTN A3_2_P cml_tlatch_52.xmux.xn.S1 VSS sg13_lv_nmos ad=63.19999f pd=0.74u as=63.19999f ps=0.74u w=0.26u l=0.38u
X2214 cml_tlatch_52.xtail.S1 CKA3_P cml_tlatch_52.xmux.xn.S1 VSS sg13_lv_nmos ad=89.3f pd=0.85u as=89.3f ps=0.85u w=0.47u l=0.16u
X2215 cml_tlatch_71.xtail.S1 POLN VSS VSS sg13_lv_nmos ad=1.5637p pd=8.61u as=1.5637p ps=8.61u w=8.23u l=0.13u
X2216 cml_gate2_6.sg13_lv_nmos_FTPY57_0.D0 ENB0_N GB3_P VSS sg13_lv_nmos ad=0.1007p pd=0.91u as=0.1007p ps=0.91u w=0.53u l=0.13u
X2217 stub_bi_32.BOTN stub_bi_32.BOTP cml_tlatch_48.xmux.xp.S1 VSS sg13_lv_nmos ad=56.9f pd=0.74u as=56.9f ps=0.74u w=0.17u l=0.17u
X2218 VSS POLN cml_tlatch_57.xtail.S1 VSS sg13_lv_nmos ad=2.7982p pd=17.14u as=1.5637p ps=8.61u w=8.23u l=0.13u
X2219 GA2_N ENA1_P cml_gate2_4.sg13_lv_nmos_FTPY57_0.D0 VSS sg13_lv_nmos ad=0.1007p pd=0.91u as=0.1007p ps=0.91u w=0.53u l=0.13u
X2220 cml_tlatch_78.xtail.S1 CKB2_P cml_tlatch_78.xmux.xn.S1 VSS sg13_lv_nmos ad=89.3f pd=0.85u as=89.3f ps=0.85u w=0.47u l=0.16u
X2221 cml_tlatch_37.xtail.S1 CKA1_P cml_tlatch_37.xmux.xp.S1 VSS sg13_lv_nmos ad=89.3f pd=0.85u as=89.3f ps=0.85u w=0.47u l=0.16u
X2222 cml_tlatch_1.OUTN cml_tlatch_1.OUTP cml_tlatch_1.xmux.xp.S1 VSS sg13_lv_nmos ad=56.9f pd=0.74u as=56.9f ps=0.74u w=0.17u l=0.17u
X2223 cml_tlatch_39.xtail.S1 CKHA1_N cml_tlatch_39.xmux.xp.S1 VSS sg13_lv_nmos ad=0.1598p pd=1.62u as=89.3f ps=0.85u w=0.47u l=0.16u
X2224 cml_tlatch_14.xtail.S1 CKB1_P cml_tlatch_14.xmux.xp.S1 VSS sg13_lv_nmos ad=0.1598p pd=1.62u as=89.3f ps=0.85u w=0.47u l=0.16u
X2225 cml_tlatch_65.xtail.S1 CKA3_P cml_tlatch_65.xmux.xn.S1 VSS sg13_lv_nmos ad=89.3f pd=0.85u as=89.3f ps=0.85u w=0.47u l=0.16u
X2226 cml_tlatch_47.xmux.xp.S1 CKB3_N cml_tlatch_47.xtail.S1 VSS sg13_lv_nmos ad=89.3f pd=0.85u as=89.3f ps=0.85u w=0.47u l=0.16u
X2227 cml_tlatch_65.xmux.xp.S1 cml_tlatch_65.OUTN cml_tlatch_65.OUTP VSS sg13_lv_nmos ad=56.9f pd=0.74u as=56.9f ps=0.74u w=0.17u l=0.17u
X2228 cml_tlatch_23.xmux.xp.S1 cml_tlatch_39.INP cml_tlatch_39.INN VSS sg13_lv_nmos ad=0.1019p pd=1.34u as=56.9f ps=0.74u w=0.17u l=0.17u
X2229 cml_tlatch_42.xmux.xp.S1 cml_tlatch_56.INP cml_tlatch_56.INN VSS sg13_lv_nmos ad=56.9f pd=0.74u as=56.9f ps=0.74u w=0.17u l=0.17u
X2230 cml_tlatch_47.OUTN cml_tlatch_47.OUTP cml_tlatch_47.xmux.xp.S1 VSS sg13_lv_nmos ad=56.9f pd=0.74u as=56.9f ps=0.74u w=0.17u l=0.17u
X2231 cml_gate2_7.sg13_lv_nmos_FTPY57_0.D0 ENB0_P GB2_N VSS sg13_lv_nmos ad=0.1007p pd=0.91u as=0.1007p ps=0.91u w=0.53u l=0.13u
X2232 CKA0_P CK_P hs_to_clk_0.D2 VSS sg13_lv_nmos ad=0.228p pd=1.58u as=0.408p ps=3.08u w=1.2u l=0.2u
X2233 J4_P J4_N cml_tlatch_90.xmux.xp.S1 VSS sg13_lv_nmos ad=56.9f pd=0.74u as=56.9f ps=0.74u w=0.17u l=0.17u
X2234 B2_2_N B2_2_P cml_tlatch_44.xmux.xp.S1 VSS sg13_lv_nmos ad=56.9f pd=0.74u as=56.9f ps=0.74u w=0.17u l=0.17u
X2235 MOT1_N MOT1_P cml_tlatch_17.xmux.xp.S1 VSS sg13_lv_nmos ad=56.9f pd=0.74u as=56.9f ps=0.74u w=0.17u l=0.17u
X2236 cml_tlatch_69.INP cml_tlatch_63.OUTN cml_tlatch_62.xmux.xn.S1 VSS sg13_lv_nmos ad=63.19999f pd=0.74u as=63.19999f ps=0.74u w=0.26u l=0.38u
X2237 cml_tlatch_45.xmux.xp.S1 cml_tlatch_45.OUTN cml_tlatch_45.OUTP VSS sg13_lv_nmos ad=56.9f pd=0.74u as=56.9f ps=0.74u w=0.17u l=0.17u
X2238 cml_tlatch_98.OUTN cml_tlatch_98.OUTP cml_tlatch_98.xmux.xp.S1 VSS sg13_lv_nmos ad=56.9f pd=0.74u as=56.9f ps=0.74u w=0.17u l=0.17u
X2239 cml_tlatch_25.xmux.xp.S1 MOT4_N MOT4_P VSS sg13_lv_nmos ad=56.9f pd=0.74u as=56.9f ps=0.74u w=0.17u l=0.17u
X2240 cml_tlatch_91.xtail.S1 CKJ_P cml_tlatch_91.xmux.xn.S1 VSS sg13_lv_nmos ad=89.3f pd=0.85u as=89.3f ps=0.85u w=0.47u l=0.16u
X2241 cml_tlatch_64.xmux.xp.S1 A3_8_N A3_8_P VSS sg13_lv_nmos ad=56.9f pd=0.74u as=56.9f ps=0.74u w=0.17u l=0.17u
X2242 cml_tlatch_54.xmux.xp.S1 cml_tlatch_54.OUTN cml_tlatch_54.OUTP VSS sg13_lv_nmos ad=56.9f pd=0.74u as=56.9f ps=0.74u w=0.17u l=0.17u
X2243 cml_tlatch_99.xmux.xn.S1 CKA0_N cml_tlatch_99.xtail.S1 VSS sg13_lv_nmos ad=89.3f pd=0.85u as=89.3f ps=0.85u w=0.47u l=0.16u
X2244 cml_tlatch_79.xmux.xn.S1 stub_bi_49.BOTN stub_bi_63.BOTP VSS sg13_lv_nmos ad=63.19999f pd=0.74u as=63.19999f ps=0.74u w=0.26u l=0.38u
X2245 CLK_W_P CLK_W_N cml_tlatch_91.xmux.xp.S1 VSS sg13_lv_nmos ad=56.9f pd=0.74u as=56.9f ps=0.74u w=0.17u l=0.17u
X2246 cml_tlatch_24.xmux.xn.S1 CKHA0_P cml_tlatch_24.xtail.S1 VSS sg13_lv_nmos ad=89.3f pd=0.85u as=89.3f ps=0.85u w=0.47u l=0.16u
X2247 stub_bi_42.BOTP stub_bi_42.BOTN cml_tlatch_43.xmux.xp.S1 VSS sg13_lv_nmos ad=56.9f pd=0.74u as=56.9f ps=0.74u w=0.17u l=0.17u
X2248 MOT24_N VDD VSS rppd l=5.17u w=1u
X2249 cml_tlatch_80.xmux.xp.S1 stub_bi_49.BOTN stub_bi_49.BOTP VSS sg13_lv_nmos ad=56.9f pd=0.74u as=56.9f ps=0.74u w=0.17u l=0.17u
X2250 cml_tlatch_94.xtail.S1 POLN VSS VSS sg13_lv_nmos ad=1.5637p pd=8.61u as=2.7982p ps=17.14u w=8.23u l=0.13u
X2251 cml_tlatch_12.xmux.xp.S1 B1_8_N B1_8_P VSS sg13_lv_nmos ad=56.9f pd=0.74u as=56.9f ps=0.74u w=0.17u l=0.17u
X2252 cml_tlatch_35.OUTN D0_P cml_tlatch_35.xmux.xn.S1 VSS sg13_lv_nmos ad=0.1082p pd=1.34u as=63.19999f ps=0.74u w=0.26u l=0.38u
X2253 cml_tlatch_55.xtail.S1 POLN VSS VSS sg13_lv_nmos ad=1.5637p pd=8.61u as=2.7982p ps=17.14u w=8.23u l=0.13u
X2254 cml_tlatch_26.xmux.xn.S1 CKHA0_P cml_tlatch_26.xtail.S1 VSS sg13_lv_nmos ad=89.3f pd=0.85u as=0.1598p ps=1.62u w=0.47u l=0.16u
X2255 cml_tlatch_14.xmux.xp.S1 cml_tlatch_5.INN cml_tlatch_5.INP VSS sg13_lv_nmos ad=56.9f pd=0.74u as=56.9f ps=0.74u w=0.17u l=0.17u
X2256 cml_tlatch_6.INP stub_bi_29.BOTP cml_tlatch_94.xmux.xn.S1 VSS sg13_lv_nmos ad=63.19999f pd=0.74u as=63.19999f ps=0.74u w=0.26u l=0.38u
X2257 cml_tlatch_50.xmux.xn.S1 CKHA2_P cml_tlatch_50.xtail.S1 VSS sg13_lv_nmos ad=89.3f pd=0.85u as=89.3f ps=0.85u w=0.47u l=0.16u
X2258 cml_tlatch_5.xmux.xp.S1 MOT11_P MOT11_N VSS sg13_lv_nmos ad=0.1019p pd=1.34u as=56.9f ps=0.74u w=0.17u l=0.17u
X2259 cml_tlatch_35.OUTN D0_P cml_tlatch_35.xmux.xn.S1 VSS sg13_lv_nmos ad=63.19999f pd=0.74u as=63.19999f ps=0.74u w=0.26u l=0.38u
X2260 cml_tlatch_19.xmux.xp.S1 MOT5_N MOT5_P VSS sg13_lv_nmos ad=56.9f pd=0.74u as=56.9f ps=0.74u w=0.17u l=0.17u
X2261 MOT2_N MOT2_P cml_tlatch_24.xmux.xp.S1 VSS sg13_lv_nmos ad=56.9f pd=0.74u as=56.9f ps=0.74u w=0.17u l=0.17u
X2262 cml_tlatch_80.xmux.xn.S1 CKB2_P cml_tlatch_80.xtail.S1 VSS sg13_lv_nmos ad=89.3f pd=0.85u as=89.3f ps=0.85u w=0.47u l=0.16u
X2263 cml_tlatch_86.xmux.xn.S1 A3_8_N MOT24_P VSS sg13_lv_nmos ad=63.19999f pd=0.74u as=63.19999f ps=0.74u w=0.26u l=0.38u
X2264 cml_tlatch_74.xmux.xp.S1 CKHB2_N cml_tlatch_74.xtail.S1 VSS sg13_lv_nmos ad=89.3f pd=0.85u as=89.3f ps=0.85u w=0.47u l=0.16u
X2265 cml_tlatch_82.xmux.xp.S1 cml_tlatch_82.OUTP cml_tlatch_82.OUTN VSS sg13_lv_nmos ad=56.9f pd=0.74u as=56.9f ps=0.74u w=0.17u l=0.17u
X2266 cml_tlatch_27.xtail.S1 CKB0_P cml_tlatch_27.xmux.xn.S1 VSS sg13_lv_nmos ad=89.3f pd=0.85u as=89.3f ps=0.85u w=0.47u l=0.16u
X2267 cml_tlatch_27.xmux.xp.S1 cml_tlatch_27.OUTN cml_tlatch_27.OUTP VSS sg13_lv_nmos ad=0.1019p pd=1.34u as=56.9f ps=0.74u w=0.17u l=0.17u
X2268 cml_tlatch_67.xmux.xn.S1 CKA3_P cml_tlatch_67.xtail.S1 VSS sg13_lv_nmos ad=89.3f pd=0.85u as=0.1598p ps=1.62u w=0.47u l=0.16u
X2269 cml_tlatch_15.xmux.xn.S1 cml_tlatch_6.INN stub_bi_19.BOTN VSS sg13_lv_nmos ad=63.19999f pd=0.74u as=63.19999f ps=0.74u w=0.26u l=0.38u
X2270 cml_gate2_9.sg13_lv_nmos_FTPY57_0.D0 J1_N ENA_P VSS sg13_lv_nmos ad=0.1007p pd=0.91u as=0.1007p ps=0.91u w=0.53u l=0.13u
X2271 cml_tlatch_86.xmux.xn.S1 A3_8_N MOT24_P VSS sg13_lv_nmos ad=63.19999f pd=0.74u as=63.19999f ps=0.74u w=0.26u l=0.38u
X2272 cml_tlatch_13.xmux.xp.S1 stub_bi_17.BOTP stub_bi_17.BOTN VSS sg13_lv_nmos ad=56.9f pd=0.74u as=56.9f ps=0.74u w=0.17u l=0.17u
X2273 cml_tlatch_20.xmux.xp.S1 MOT7_N MOT7_P VSS sg13_lv_nmos ad=56.9f pd=0.74u as=56.9f ps=0.74u w=0.17u l=0.17u
X2274 GA0_P CKB0_N cml_gate2_2.xrtail.R1 VSS sg13_lv_nmos ad=0.1007p pd=0.91u as=0.1007p ps=0.91u w=0.53u l=0.13u
X2275 cml_tlatch_91.xmux.xp.S1 CLK_W_P CLK_W_N VSS sg13_lv_nmos ad=56.9f pd=0.74u as=56.9f ps=0.74u w=0.17u l=0.17u
X2276 cml_tlatch_54.xmux.xp.S1 cml_tlatch_54.OUTN cml_tlatch_54.OUTP VSS sg13_lv_nmos ad=56.9f pd=0.74u as=56.9f ps=0.74u w=0.17u l=0.17u
X2277 cml_tlatch_2.xtail.S1 POLN VSS VSS sg13_lv_nmos ad=1.5637p pd=8.61u as=1.5637p ps=8.61u w=8.23u l=0.13u
X2278 cml_tlatch_68.xtail.S1 POLN VSS VSS sg13_lv_nmos ad=1.5637p pd=8.61u as=1.5637p ps=8.61u w=8.23u l=0.13u
X2279 cml_tlatch_62.xtail.S1 CKB3_N cml_tlatch_62.xmux.xn.S1 VSS sg13_lv_nmos ad=89.3f pd=0.85u as=89.3f ps=0.85u w=0.47u l=0.16u
X2280 MOT28_N MOT28_P cml_tlatch_58.xmux.xp.S1 VSS sg13_lv_nmos ad=56.9f pd=0.74u as=56.9f ps=0.74u w=0.17u l=0.17u
X2281 cml_tlatch_4.xtail.S1 CKHB1_P cml_tlatch_4.xmux.xn.S1 VSS sg13_lv_nmos ad=89.3f pd=0.85u as=89.3f ps=0.85u w=0.47u l=0.16u
X2282 CKHA2_N GA2_P cml_drvb_4.xrtail.R1 VSS sg13_lv_nmos ad=0.2618p pd=2.22u as=0.1463p ps=1.15u w=0.77u l=0.21u
X2283 MOT2_P MOT2_N cml_tlatch_24.xmux.xp.S1 VSS sg13_lv_nmos ad=56.9f pd=0.74u as=56.9f ps=0.74u w=0.17u l=0.17u
X2284 cml_tlatch_69.xmux.xp.S1 CKHB3_N cml_tlatch_69.xtail.S1 VSS sg13_lv_nmos ad=89.3f pd=0.85u as=89.3f ps=0.85u w=0.47u l=0.16u
X2285 cml_tlatch_51.xmux.xn.S1 CKHA2_P cml_tlatch_51.xtail.S1 VSS sg13_lv_nmos ad=89.3f pd=0.85u as=89.3f ps=0.85u w=0.47u l=0.16u
X2286 cml_gate2_2.sg13_lv_nmos_FTPY57_0.D0 ENA0_P GA0_N VSS sg13_lv_nmos ad=0.1007p pd=0.91u as=0.1007p ps=0.91u w=0.53u l=0.13u
X2287 VDD cml_tlatch_38.OUTP VSS rppd l=5.17u w=1u
X2288 MOT20_P MOT20_N cml_tlatch_50.xmux.xp.S1 VSS sg13_lv_nmos ad=56.9f pd=0.74u as=56.9f ps=0.74u w=0.17u l=0.17u
X2289 cml_tlatch_80.xmux.xp.S1 stub_bi_49.BOTN stub_bi_49.BOTP VSS sg13_lv_nmos ad=56.9f pd=0.74u as=56.9f ps=0.74u w=0.17u l=0.17u
X2290 cml_tlatch_53.xmux.xp.S1 A3_2_P A3_2_N VSS sg13_lv_nmos ad=56.9f pd=0.74u as=56.9f ps=0.74u w=0.17u l=0.17u
X2291 cml_tlatch_28.xtail.S1 CKB0_N cml_tlatch_28.xmux.xn.S1 VSS sg13_lv_nmos ad=89.3f pd=0.85u as=89.3f ps=0.85u w=0.47u l=0.16u
X2292 cml_tlatch_11.xtail.S1 CKB0_N cml_tlatch_11.xmux.xp.S1 VSS sg13_lv_nmos ad=89.3f pd=0.85u as=89.3f ps=0.85u w=0.47u l=0.16u
X2293 cml_tlatch_40.xmux.xp.S1 MOT12_P MOT12_N VSS sg13_lv_nmos ad=56.9f pd=0.74u as=56.9f ps=0.74u w=0.17u l=0.17u
X2294 cml_tlatch_92.xmux.xp.S1 J2_P J2_N VSS sg13_lv_nmos ad=56.9f pd=0.74u as=56.9f ps=0.74u w=0.17u l=0.17u
X2295 cml_tlatch_16.xmux.xp.S1 cml_tlatch_16.OUTP cml_tlatch_16.OUTN VSS sg13_lv_nmos ad=56.9f pd=0.74u as=56.9f ps=0.74u w=0.17u l=0.17u
X2296 cml_tlatch_99.xtail.S1 CKA0_P cml_tlatch_99.xmux.xp.S1 VSS sg13_lv_nmos ad=89.3f pd=0.85u as=89.3f ps=0.85u w=0.47u l=0.16u
X2297 cml_tlatch_91.xmux.xp.S1 CLK_W_N CLK_W_P VSS sg13_lv_nmos ad=56.9f pd=0.74u as=56.9f ps=0.74u w=0.17u l=0.17u
X2298 cml_tlatch_98.OUTP cml_tlatch_27.OUTN cml_tlatch_98.xmux.xn.S1 VSS sg13_lv_nmos ad=63.19999f pd=0.74u as=63.19999f ps=0.74u w=0.26u l=0.38u
X2299 cml_tlatch_49.xmux.xp.S1 CKHA2_N cml_tlatch_49.xtail.S1 VSS sg13_lv_nmos ad=89.3f pd=0.85u as=89.3f ps=0.85u w=0.47u l=0.16u
X2300 cml_tlatch_88.xmux.xn.S1 stub_bi_42.BOTN stub_bi_55.BOTP VSS sg13_lv_nmos ad=63.19999f pd=0.74u as=0.1082p ps=1.34u w=0.26u l=0.38u
X2301 cml_tlatch_72.xtail.S1 CKA2_N cml_tlatch_72.xmux.xp.S1 VSS sg13_lv_nmos ad=89.3f pd=0.85u as=89.3f ps=0.85u w=0.47u l=0.16u
X2302 cml_tlatch_58.xmux.xn.S1 cml_tlatch_58.INP MOT28_N VSS sg13_lv_nmos ad=63.19999f pd=0.74u as=0.1082p ps=1.34u w=0.26u l=0.38u
X2303 cml_tlatch_75.xmux.xn.S1 stub_bi_55.BOTP MOT21_P VSS sg13_lv_nmos ad=63.19999f pd=0.74u as=63.19999f ps=0.74u w=0.26u l=0.38u
X2304 stub_bi_49.BOTN stub_bi_49.BOTP cml_tlatch_80.xmux.xp.S1 VSS sg13_lv_nmos ad=56.9f pd=0.74u as=56.9f ps=0.74u w=0.17u l=0.17u
X2305 VDD CKHB0_N VSS rppd l=13.09u w=1u
X2306 A1_2_N A1_2_P cml_tlatch_37.xmux.xp.S1 VSS sg13_lv_nmos ad=56.9f pd=0.74u as=56.9f ps=0.74u w=0.17u l=0.17u
X2307 cml_tlatch_54.xmux.xn.S1 D3_N cml_tlatch_54.OUTP VSS sg13_lv_nmos ad=63.19999f pd=0.74u as=63.19999f ps=0.74u w=0.26u l=0.38u
X2308 stub_bi_55.BOTP stub_bi_55.BOTN cml_tlatch_88.xmux.xp.S1 VSS sg13_lv_nmos ad=56.9f pd=0.74u as=56.9f ps=0.74u w=0.17u l=0.17u
X2309 cml_tlatch_2.xtail.S1 CKA0_P cml_tlatch_2.xmux.xp.S1 VSS sg13_lv_nmos ad=89.3f pd=0.85u as=89.3f ps=0.85u w=0.47u l=0.16u
X2310 cml_tlatch_84.xmux.xp.S1 CKB3_P cml_tlatch_84.xtail.S1 VSS sg13_lv_nmos ad=89.3f pd=0.85u as=89.3f ps=0.85u w=0.47u l=0.16u
X2311 cml_tlatch_88.xtail.S1 CKB2_N cml_tlatch_88.xmux.xn.S1 VSS sg13_lv_nmos ad=89.3f pd=0.85u as=89.3f ps=0.85u w=0.47u l=0.16u
X2312 cml_tlatch_42.xmux.xp.S1 cml_tlatch_56.INP cml_tlatch_56.INN VSS sg13_lv_nmos ad=56.9f pd=0.74u as=56.9f ps=0.74u w=0.17u l=0.17u
X2313 MOT30_N A3_2_P cml_tlatch_59.xmux.xn.S1 VSS sg13_lv_nmos ad=63.19999f pd=0.74u as=63.19999f ps=0.74u w=0.26u l=0.38u
X2314 cml_tlatch_74.xmux.xp.S1 MOT19_N MOT19_P VSS sg13_lv_nmos ad=56.9f pd=0.74u as=56.9f ps=0.74u w=0.17u l=0.17u
X2315 cml_tlatch_29.xmux.xp.S1 cml_tlatch_29.OUTP cml_tlatch_29.OUTN VSS sg13_lv_nmos ad=56.9f pd=0.74u as=56.9f ps=0.74u w=0.17u l=0.17u
X2316 A0_8_P cml_tlatch_3.OUTN cml_tlatch_2.xmux.xn.S1 VSS sg13_lv_nmos ad=63.19999f pd=0.74u as=63.19999f ps=0.74u w=0.26u l=0.38u
X2317 cml_tlatch_48.xmux.xn.S1 D2_P stub_bi_32.BOTP VSS sg13_lv_nmos ad=63.19999f pd=0.74u as=63.19999f ps=0.74u w=0.26u l=0.38u
X2318 cml_tlatch_80.xtail.S1 CKB2_N cml_tlatch_80.xmux.xp.S1 VSS sg13_lv_nmos ad=89.3f pd=0.85u as=89.3f ps=0.85u w=0.47u l=0.16u
X2319 cml_tlatch_25.xmux.xp.S1 MOT4_N MOT4_P VSS sg13_lv_nmos ad=56.9f pd=0.74u as=56.9f ps=0.74u w=0.17u l=0.17u
X2320 cml_tlatch_19.xmux.xp.S1 CKHB0_N cml_tlatch_19.xtail.S1 VSS sg13_lv_nmos ad=89.3f pd=0.85u as=89.3f ps=0.85u w=0.47u l=0.16u
X2321 cml_tlatch_83.OUTP cml_tlatch_83.OUTN cml_tlatch_83.xmux.xp.S1 VSS sg13_lv_nmos ad=56.9f pd=0.74u as=56.9f ps=0.74u w=0.17u l=0.17u
X2322 B3_8_P B3_8_N cml_tlatch_60.xmux.xp.S1 VSS sg13_lv_nmos ad=56.9f pd=0.74u as=56.9f ps=0.74u w=0.17u l=0.17u
X2323 cml_tlatch_89.xmux.xp.S1 cml_tlatch_89.OUTN cml_tlatch_89.OUTP VSS sg13_lv_nmos ad=56.9f pd=0.74u as=56.9f ps=0.74u w=0.17u l=0.17u
X2324 A1_2_N A1_2_P cml_tlatch_37.xmux.xp.S1 VSS sg13_lv_nmos ad=56.9f pd=0.74u as=56.9f ps=0.74u w=0.17u l=0.17u
X2325 cml_tlatch_83.INP cml_tlatch_89.OUTN cml_tlatch_72.xmux.xn.S1 VSS sg13_lv_nmos ad=63.19999f pd=0.74u as=63.19999f ps=0.74u w=0.26u l=0.38u
X2326 VSS POLN cml_tlatch_46.xtail.S1 VSS sg13_lv_nmos ad=1.5637p pd=8.61u as=1.5637p ps=8.61u w=8.23u l=0.13u
X2327 cml_tlatch_8.xmux.xn.S1 cml_tlatch_9.OUTN cml_tlatch_8.OUTP VSS sg13_lv_nmos ad=63.19999f pd=0.74u as=63.19999f ps=0.74u w=0.26u l=0.38u
X2328 cml_tlatch_96.xmux.xn.S1 CKHA1_P cml_tlatch_96.xtail.S1 VSS sg13_lv_nmos ad=89.3f pd=0.85u as=89.3f ps=0.85u w=0.47u l=0.16u
X2329 cml_gate2_0.sg13_lv_nmos_FTPY57_0.D0 CKA1_P cml_gate2_0.xrtail.R1 VSS sg13_lv_nmos ad=0.1007p pd=0.91u as=0.1007p ps=0.91u w=0.53u l=0.13u
X2330 cml_tlatch_73.xtail.S1 CKHB2_P cml_tlatch_73.xmux.xn.S1 VSS sg13_lv_nmos ad=89.3f pd=0.85u as=89.3f ps=0.85u w=0.47u l=0.16u
X2331 cml_tlatch_32.xmux.xn.S1 B1_2_N stub_bi_29.BOTN VSS sg13_lv_nmos ad=63.19999f pd=0.74u as=63.19999f ps=0.74u w=0.26u l=0.38u
X2332 CLK_W_P CLK_W_N cml_tlatch_91.xmux.xp.S1 VSS sg13_lv_nmos ad=56.9f pd=0.74u as=56.9f ps=0.74u w=0.17u l=0.17u
X2333 VSS POLN cml_tlatch_36.xtail.S1 VSS sg13_lv_nmos ad=1.5637p pd=8.61u as=1.5637p ps=8.61u w=8.23u l=0.13u
X2334 cml_drv_0.xrtail.R1 ENB_P ENB1_N VSS sg13_lv_nmos ad=56.2f pd=0.74u as=56.2f ps=0.74u w=0.16u l=0.19u
X2335 cml_tlatch_69.xmux.xn.S1 cml_tlatch_69.INN MOT27_P VSS sg13_lv_nmos ad=0.1082p pd=1.34u as=63.19999f ps=0.74u w=0.26u l=0.38u
X2336 VSS POLN cml_tlatch_20.xtail.S1 VSS sg13_lv_nmos ad=2.7982p pd=17.14u as=1.5637p ps=8.61u w=8.23u l=0.13u
X2337 cml_tlatch_36.xtail.S1 CKA1_N cml_tlatch_36.xmux.xp.S1 VSS sg13_lv_nmos ad=89.3f pd=0.85u as=89.3f ps=0.85u w=0.47u l=0.16u
X2338 MOT16_P MOT16_N cml_tlatch_87.xmux.xp.S1 VSS sg13_lv_nmos ad=56.9f pd=0.74u as=56.9f ps=0.74u w=0.17u l=0.17u
X2339 CKA2_N CK_N hs_to_clk_4.D2 VSS sg13_lv_nmos ad=0.408p pd=3.08u as=0.228p ps=1.58u w=1.2u l=0.2u
X2340 MOT13_P MOT13_N cml_tlatch_6.xmux.xp.S1 VSS sg13_lv_nmos ad=56.9f pd=0.74u as=56.9f ps=0.74u w=0.17u l=0.17u
X2341 cml_tlatch_32.xmux.xn.S1 B1_2_N stub_bi_29.BOTN VSS sg13_lv_nmos ad=63.19999f pd=0.74u as=63.19999f ps=0.74u w=0.26u l=0.38u
X2342 VSS POLN cml_tlatch_61.xtail.S1 VSS sg13_lv_nmos ad=2.7982p pd=17.14u as=1.5637p ps=8.61u w=8.23u l=0.13u
X2343 MOT23_P MOT23_N cml_tlatch_76.xmux.xp.S1 VSS sg13_lv_nmos ad=56.9f pd=0.74u as=56.9f ps=0.74u w=0.17u l=0.17u
X2344 cml_tlatch_12.xmux.xp.S1 B1_8_N B1_8_P VSS sg13_lv_nmos ad=56.9f pd=0.74u as=56.9f ps=0.74u w=0.17u l=0.17u
X2345 cml_tlatch_34.xmux.xp.S1 stub_bi_31.BOTP stub_bi_31.BOTN VSS sg13_lv_nmos ad=56.9f pd=0.74u as=56.9f ps=0.74u w=0.17u l=0.17u
X2346 cml_gate2_5.xrtail.R1 CKB3_P cml_gate2_5.sg13_lv_nmos_FTPY57_0.D0 VSS sg13_lv_nmos ad=0.1007p pd=0.91u as=0.1007p ps=0.91u w=0.53u l=0.13u
X2347 cml_tlatch_9.xmux.xp.S1 cml_tlatch_9.OUTN cml_tlatch_9.OUTP VSS sg13_lv_nmos ad=56.9f pd=0.74u as=56.9f ps=0.74u w=0.17u l=0.17u
X2348 cml_tlatch_39.xmux.xp.S1 CKHA1_N cml_tlatch_39.xtail.S1 VSS sg13_lv_nmos ad=89.3f pd=0.85u as=89.3f ps=0.85u w=0.47u l=0.16u
X2349 cml_tlatch_70.xmux.xp.S1 MOT29_P MOT29_N VSS sg13_lv_nmos ad=0.1019p pd=1.34u as=56.9f ps=0.74u w=0.17u l=0.17u
X2350 cml_tlatch_82.OUTP cml_tlatch_82.OUTN cml_tlatch_82.xmux.xp.S1 VSS sg13_lv_nmos ad=56.9f pd=0.74u as=56.9f ps=0.74u w=0.17u l=0.17u
X2351 VSS hs_to_clk_1.sg13_lv_nmos_2HGZLP_0.G VSS VSS sg13_lv_nmos ad=2.071p pd=11.28u as=0 ps=0 w=10.9u l=1.38u
X2352 cml_tlatch_8.xmux.xp.S1 cml_tlatch_8.OUTN cml_tlatch_8.OUTP VSS sg13_lv_nmos ad=56.9f pd=0.74u as=56.9f ps=0.74u w=0.17u l=0.17u
X2353 cml_tlatch_17.xmux.xp.S1 MOT1_N MOT1_P VSS sg13_lv_nmos ad=56.9f pd=0.74u as=56.9f ps=0.74u w=0.17u l=0.17u
X2354 MOT15_N MOT15_P cml_tlatch_7.xmux.xp.S1 VSS sg13_lv_nmos ad=56.9f pd=0.74u as=56.9f ps=0.74u w=0.17u l=0.17u
X2355 cml_tlatch_26.xmux.xp.S1 CKHA0_N cml_tlatch_26.xtail.S1 VSS sg13_lv_nmos ad=89.3f pd=0.85u as=89.3f ps=0.85u w=0.47u l=0.16u
X2356 cml_gate2_0.xrtail.R1 CKA1_N GB1_P VSS sg13_lv_nmos ad=0.1007p pd=0.91u as=0.1007p ps=0.91u w=0.53u l=0.13u
X2357 stub_bi_29.BOTP B1_2_P cml_tlatch_32.xmux.xn.S1 VSS sg13_lv_nmos ad=63.19999f pd=0.74u as=63.19999f ps=0.74u w=0.26u l=0.38u
X2358 cml_tlatch_32.xtail.S1 CKB1_N cml_tlatch_32.xmux.xp.S1 VSS sg13_lv_nmos ad=89.3f pd=0.85u as=89.3f ps=0.85u w=0.47u l=0.16u
X2359 cml_gate2_5.sg13_lv_nmos_FTPY57_0.D0 ENA1_P GA3_N VSS sg13_lv_nmos ad=0.1802p pd=1.74u as=0.1007p ps=0.91u w=0.53u l=0.13u
X2360 MOT9_N MOT9_P cml_tlatch_4.xmux.xp.S1 VSS sg13_lv_nmos ad=56.9f pd=0.74u as=56.9f ps=0.74u w=0.17u l=0.17u
X2361 cml_tlatch_92.xmux.xp.S1 CKJ_P cml_tlatch_92.xtail.S1 VSS sg13_lv_nmos ad=89.3f pd=0.85u as=89.3f ps=0.85u w=0.47u l=0.16u
X2362 cml_tlatch_70.xmux.xn.S1 CKHB3_P cml_tlatch_70.xtail.S1 VSS sg13_lv_nmos ad=89.3f pd=0.85u as=89.3f ps=0.85u w=0.47u l=0.16u
X2363 cml_tlatch_74.xmux.xn.S1 CKHB2_P cml_tlatch_74.xtail.S1 VSS sg13_lv_nmos ad=0.1598p pd=1.62u as=89.3f ps=0.85u w=0.47u l=0.16u
X2364 MOT13_N cml_tlatch_6.INP cml_tlatch_6.xmux.xn.S1 VSS sg13_lv_nmos ad=63.19999f pd=0.74u as=63.19999f ps=0.74u w=0.26u l=0.38u
X2365 cml_gate2_0.sg13_lv_nmos_FTPY57_0.D0 ENB1_N GB1_P VSS sg13_lv_nmos ad=0.1007p pd=0.91u as=0.1007p ps=0.91u w=0.53u l=0.13u
X2366 cml_tlatch_20.xmux.xp.S1 MOT7_N MOT7_P VSS sg13_lv_nmos ad=56.9f pd=0.74u as=56.9f ps=0.74u w=0.17u l=0.17u
X2367 cml_tlatch_51.xmux.xp.S1 MOT22_N MOT22_P VSS sg13_lv_nmos ad=56.9f pd=0.74u as=56.9f ps=0.74u w=0.17u l=0.17u
X2368 cml_tlatch_69.xmux.xp.S1 MOT27_N MOT27_P VSS sg13_lv_nmos ad=56.9f pd=0.74u as=56.9f ps=0.74u w=0.17u l=0.17u
X2369 cml_tlatch_87.xmux.xp.S1 MOT16_P MOT16_N VSS sg13_lv_nmos ad=56.9f pd=0.74u as=56.9f ps=0.74u w=0.17u l=0.17u
X2370 MOT30_P MOT30_N cml_tlatch_59.xmux.xp.S1 VSS sg13_lv_nmos ad=56.9f pd=0.74u as=56.9f ps=0.74u w=0.17u l=0.17u
X2371 GB2_P CKA2_N cml_gate2_7.xrtail.R1 VSS sg13_lv_nmos ad=0.1007p pd=0.91u as=0.1007p ps=0.91u w=0.53u l=0.13u
X2372 MOT31_N MOT31_P cml_tlatch_71.xmux.xp.S1 VSS sg13_lv_nmos ad=56.9f pd=0.74u as=56.9f ps=0.74u w=0.17u l=0.17u
X2373 VDD MOT0_P VSS rppd l=5.17u w=1u
X2374 cml_tlatch_3.xtail.S1 POLN VSS VSS sg13_lv_nmos ad=1.5637p pd=8.61u as=2.7982p ps=17.14u w=8.23u l=0.13u
X2375 cml_tlatch_2.xmux.xn.S1 CKA0_N cml_tlatch_2.xtail.S1 VSS sg13_lv_nmos ad=89.3f pd=0.85u as=89.3f ps=0.85u w=0.47u l=0.16u
X2376 cml_tlatch_35.xmux.xp.S1 cml_tlatch_35.OUTN cml_tlatch_35.OUTP VSS sg13_lv_nmos ad=56.9f pd=0.74u as=56.9f ps=0.74u w=0.17u l=0.17u
X2377 cml_tlatch_53.xmux.xp.S1 A3_2_P A3_2_N VSS sg13_lv_nmos ad=56.9f pd=0.74u as=56.9f ps=0.74u w=0.17u l=0.17u
X2378 cml_tlatch_88.xmux.xp.S1 stub_bi_55.BOTP stub_bi_55.BOTN VSS sg13_lv_nmos ad=56.9f pd=0.74u as=56.9f ps=0.74u w=0.17u l=0.17u
X2379 cml_tlatch_16.xmux.xp.S1 cml_tlatch_16.OUTP cml_tlatch_16.OUTN VSS sg13_lv_nmos ad=56.9f pd=0.74u as=56.9f ps=0.74u w=0.17u l=0.17u
X2380 B3_2_N B3_2_P cml_tlatch_46.xmux.xp.S1 VSS sg13_lv_nmos ad=56.9f pd=0.74u as=56.9f ps=0.74u w=0.17u l=0.17u
X2381 MOT6_N MOT6_P cml_tlatch_26.xmux.xp.S1 VSS sg13_lv_nmos ad=56.9f pd=0.74u as=56.9f ps=0.74u w=0.17u l=0.17u
X2382 MOT25_P B3_8_N cml_tlatch_68.xmux.xn.S1 VSS sg13_lv_nmos ad=63.19999f pd=0.74u as=63.19999f ps=0.74u w=0.26u l=0.38u
X2383 cml_tlatch_49.xmux.xp.S1 MOT18_N MOT18_P VSS sg13_lv_nmos ad=56.9f pd=0.74u as=56.9f ps=0.74u w=0.17u l=0.17u
X2384 MOT24_P MOT24_N cml_tlatch_86.xmux.xp.S1 VSS sg13_lv_nmos ad=56.9f pd=0.74u as=56.9f ps=0.74u w=0.17u l=0.17u
X2385 cml_tlatch_48.xtail.S1 CKB2_P cml_tlatch_48.xmux.xn.S1 VSS sg13_lv_nmos ad=89.3f pd=0.85u as=89.3f ps=0.85u w=0.47u l=0.16u
X2386 cml_tlatch_22.xmux.xn.S1 cml_tlatch_39.INP cml_tlatch_22.OUTN VSS sg13_lv_nmos ad=63.19999f pd=0.74u as=63.19999f ps=0.74u w=0.26u l=0.38u
X2387 cml_tlatch_60.xmux.xn.S1 cml_tlatch_61.OUTN B3_8_P VSS sg13_lv_nmos ad=63.19999f pd=0.74u as=63.19999f ps=0.74u w=0.26u l=0.38u
X2388 cml_tlatch_55.xmux.xp.S1 CKA2_N cml_tlatch_55.xtail.S1 VSS sg13_lv_nmos ad=89.3f pd=0.85u as=89.3f ps=0.85u w=0.47u l=0.16u
X2389 cml_tlatch_61.xmux.xp.S1 CKB3_N cml_tlatch_61.xtail.S1 VSS sg13_lv_nmos ad=89.3f pd=0.85u as=89.3f ps=0.85u w=0.47u l=0.16u
X2390 cml_tlatch_33.xmux.xp.S1 B1_2_P B1_2_N VSS sg13_lv_nmos ad=56.9f pd=0.74u as=56.9f ps=0.74u w=0.17u l=0.17u
X2391 B0_2_P B0_2_N cml_tlatch_28.xmux.xp.S1 VSS sg13_lv_nmos ad=56.9f pd=0.74u as=56.9f ps=0.74u w=0.17u l=0.17u
X2392 cml_tlatch_14.xtail.S1 CKB1_P cml_tlatch_14.xmux.xp.S1 VSS sg13_lv_nmos ad=89.3f pd=0.85u as=89.3f ps=0.85u w=0.47u l=0.16u
X2393 cml_tlatch_74.xmux.xn.S1 stub_bi_63.BOTN MOT19_N VSS sg13_lv_nmos ad=63.19999f pd=0.74u as=63.19999f ps=0.74u w=0.26u l=0.38u
X2394 ENB_P NS1_N cml_gate2_8.xrtail.R1 VSS sg13_lv_nmos ad=0.1007p pd=0.91u as=0.1007p ps=0.91u w=0.53u l=0.13u
X2395 cml_tlatch_96.xmux.xp.S1 MOT8_N MOT8_P VSS sg13_lv_nmos ad=56.9f pd=0.74u as=56.9f ps=0.74u w=0.17u l=0.17u
X2396 cml_tlatch_49.xtail.S1 CKHA2_P cml_tlatch_49.xmux.xn.S1 VSS sg13_lv_nmos ad=89.3f pd=0.85u as=89.3f ps=0.85u w=0.47u l=0.16u
X2397 cml_tlatch_1.xmux.xp.S1 CKB0_N cml_tlatch_1.xtail.S1 VSS sg13_lv_nmos ad=89.3f pd=0.85u as=89.3f ps=0.85u w=0.47u l=0.16u
X2398 MOT4_P cml_tlatch_99.OUTN cml_tlatch_25.xmux.xn.S1 VSS sg13_lv_nmos ad=63.19999f pd=0.74u as=0.1082p ps=1.34u w=0.26u l=0.38u
X2399 cml_tlatch_67.OUTN cml_tlatch_67.OUTP cml_tlatch_67.xmux.xp.S1 VSS sg13_lv_nmos ad=56.9f pd=0.74u as=56.9f ps=0.74u w=0.17u l=0.17u
X2400 cml_tlatch_44.xtail.S1 POLN VSS VSS sg13_lv_nmos ad=1.5637p pd=8.61u as=1.5637p ps=8.61u w=8.23u l=0.13u
X2401 cml_tlatch_38.xmux.xp.S1 CKA1_N cml_tlatch_38.xtail.S1 VSS sg13_lv_nmos ad=89.3f pd=0.85u as=0.1598p ps=1.62u w=0.47u l=0.16u
X2402 cml_drv_1.xrtail.R1 ENA_P ENA1_N VSS sg13_lv_nmos ad=56.2f pd=0.74u as=56.2f ps=0.74u w=0.16u l=0.19u
X2403 CLK_W_P J2_P cml_tlatch_91.xmux.xn.S1 VSS sg13_lv_nmos ad=63.19999f pd=0.74u as=63.19999f ps=0.74u w=0.26u l=0.38u
X2404 MOT17_P MOT17_N cml_tlatch_73.xmux.xp.S1 VSS sg13_lv_nmos ad=56.9f pd=0.74u as=56.9f ps=0.74u w=0.17u l=0.17u
X2405 cml_tlatch_56.INP cml_tlatch_56.INN cml_tlatch_42.xmux.xp.S1 VSS sg13_lv_nmos ad=56.9f pd=0.74u as=56.9f ps=0.74u w=0.17u l=0.17u
X2406 cml_tlatch_62.xmux.xn.S1 CKB3_N cml_tlatch_62.xtail.S1 VSS sg13_lv_nmos ad=89.3f pd=0.85u as=89.3f ps=0.85u w=0.47u l=0.16u
X2407 cml_tlatch_71.xtail.S1 CKHB3_N cml_tlatch_71.xmux.xp.S1 VSS sg13_lv_nmos ad=89.3f pd=0.85u as=89.3f ps=0.85u w=0.47u l=0.16u
X2408 cml_tlatch_83.OUTN cml_tlatch_83.OUTP cml_tlatch_83.xmux.xp.S1 VSS sg13_lv_nmos ad=56.9f pd=0.74u as=56.9f ps=0.74u w=0.17u l=0.17u
X2409 A1_8_N cml_tlatch_22.OUTP cml_tlatch_21.xmux.xn.S1 VSS sg13_lv_nmos ad=63.19999f pd=0.74u as=63.19999f ps=0.74u w=0.26u l=0.38u
X2410 cml_tlatch_79.xmux.xp.S1 stub_bi_63.BOTP stub_bi_63.BOTN VSS sg13_lv_nmos ad=0.1019p pd=1.34u as=56.9f ps=0.74u w=0.17u l=0.17u
X2411 ENB_P J2_N cml_gate2_8.sg13_lv_nmos_FTPY57_0.D0 VSS sg13_lv_nmos ad=0.1007p pd=0.91u as=0.1007p ps=0.91u w=0.53u l=0.13u
X2412 cml_tlatch_51.xtail.S1 CKHA2_P cml_tlatch_51.xmux.xn.S1 VSS sg13_lv_nmos ad=89.3f pd=0.85u as=89.3f ps=0.85u w=0.47u l=0.16u
X2413 cml_tlatch_0.xmux.xp.S1 interco_bi_19.INP interco_bi_19.INN VSS sg13_lv_nmos ad=56.9f pd=0.74u as=56.9f ps=0.74u w=0.17u l=0.17u
X2414 MOT16_N A2_8_P cml_tlatch_87.xmux.xn.S1 VSS sg13_lv_nmos ad=63.19999f pd=0.74u as=0.1082p ps=1.34u w=0.26u l=0.38u
X2415 cml_tlatch_3.xmux.xp.S1 cml_tlatch_3.OUTN cml_tlatch_3.OUTP VSS sg13_lv_nmos ad=56.9f pd=0.74u as=56.9f ps=0.74u w=0.17u l=0.17u
X2416 stub_bi_19.BOTP stub_bi_19.BOTN cml_tlatch_15.xmux.xp.S1 VSS sg13_lv_nmos ad=56.9f pd=0.74u as=56.9f ps=0.74u w=0.17u l=0.17u
X2417 cml_tlatch_31.xtail.S1 CKA0_P cml_tlatch_31.xmux.xp.S1 VSS sg13_lv_nmos ad=89.3f pd=0.85u as=89.3f ps=0.85u w=0.47u l=0.16u
X2418 VSS POLN cml_tlatch_17.xtail.S1 VSS sg13_lv_nmos ad=1.5637p pd=8.61u as=1.5637p ps=8.61u w=8.23u l=0.13u
X2419 cml_gate2_1.sg13_lv_nmos_FTPY57_0.D0 CKA0_P cml_gate2_1.xrtail.R1 VSS sg13_lv_nmos ad=0.1007p pd=0.91u as=0.1007p ps=0.91u w=0.53u l=0.13u
X2420 VSS hs_to_clk_7.sg13_lv_nmos_2HGZLP_0.G VSS VSS sg13_lv_nmos ad=2.071p pd=11.28u as=0 ps=0 w=10.9u l=1.38u
X2421 MOT18_N MOT18_P cml_tlatch_49.xmux.xp.S1 VSS sg13_lv_nmos ad=56.9f pd=0.74u as=56.9f ps=0.74u w=0.17u l=0.17u
X2422 cml_tlatch_57.xmux.xp.S1 MOT26_P MOT26_N VSS sg13_lv_nmos ad=56.9f pd=0.74u as=56.9f ps=0.74u w=0.17u l=0.17u
X2423 cml_tlatch_27.OUTN B0_2_P cml_tlatch_27.xmux.xn.S1 VSS sg13_lv_nmos ad=63.19999f pd=0.74u as=63.19999f ps=0.74u w=0.26u l=0.38u
X2424 cml_tlatch_98.OUTP cml_tlatch_98.OUTN cml_tlatch_98.xmux.xp.S1 VSS sg13_lv_nmos ad=56.9f pd=0.74u as=56.9f ps=0.74u w=0.17u l=0.17u
X2425 cml_tlatch_40.xmux.xn.S1 cml_tlatch_40.INN MOT12_P VSS sg13_lv_nmos ad=0.1082p pd=1.34u as=63.19999f ps=0.74u w=0.26u l=0.38u
X2426 cml_tlatch_3.xmux.xn.S1 cml_tlatch_8.OUTN cml_tlatch_3.OUTP VSS sg13_lv_nmos ad=63.19999f pd=0.74u as=63.19999f ps=0.74u w=0.26u l=0.38u
X2427 cml_tlatch_59.xtail.S1 CKHA3_P cml_tlatch_59.xmux.xn.S1 VSS sg13_lv_nmos ad=89.3f pd=0.85u as=89.3f ps=0.85u w=0.47u l=0.16u
X2428 cml_tlatch_88.xmux.xn.S1 CKB2_N cml_tlatch_88.xtail.S1 VSS sg13_lv_nmos ad=89.3f pd=0.85u as=89.3f ps=0.85u w=0.47u l=0.16u
X2429 cml_tlatch_82.OUTP cml_tlatch_82.OUTN cml_tlatch_82.xmux.xp.S1 VSS sg13_lv_nmos ad=56.9f pd=0.74u as=56.9f ps=0.74u w=0.17u l=0.17u
X2430 cml_tlatch_78.xmux.xp.S1 stub_bi_62.BOTP stub_bi_62.BOTN VSS sg13_lv_nmos ad=56.9f pd=0.74u as=56.9f ps=0.74u w=0.17u l=0.17u
X2431 MOT15_N MOT15_P cml_tlatch_7.xmux.xp.S1 VSS sg13_lv_nmos ad=56.9f pd=0.74u as=56.9f ps=0.74u w=0.17u l=0.17u
X2432 cml_tlatch_17.xmux.xp.S1 MOT1_N MOT1_P VSS sg13_lv_nmos ad=56.9f pd=0.74u as=56.9f ps=0.74u w=0.17u l=0.17u
X2433 cml_tlatch_83.OUTP cml_tlatch_83.INN cml_tlatch_83.xmux.xn.S1 VSS sg13_lv_nmos ad=63.19999f pd=0.74u as=0.1082p ps=1.34u w=0.26u l=0.38u
X2434 cml_tlatch_85.xmux.xn.S1 CKA3_N cml_tlatch_85.xtail.S1 VSS sg13_lv_nmos ad=89.3f pd=0.85u as=0.1598p ps=1.62u w=0.47u l=0.16u
X2435 cml_tlatch_66.xtail.S1 CKA3_P cml_tlatch_66.xmux.xp.S1 VSS sg13_lv_nmos ad=89.3f pd=0.85u as=89.3f ps=0.85u w=0.47u l=0.16u
X2436 cml_tlatch_51.xmux.xp.S1 MOT22_P MOT22_N VSS sg13_lv_nmos ad=56.9f pd=0.74u as=56.9f ps=0.74u w=0.17u l=0.17u
X2437 cml_tlatch_57.xmux.xp.S1 MOT26_N MOT26_P VSS sg13_lv_nmos ad=56.9f pd=0.74u as=56.9f ps=0.74u w=0.17u l=0.17u
X2438 VDD cml_tlatch_82.OUTP VSS rppd l=5.17u w=1u
X2439 MOT12_N cml_tlatch_40.INP cml_tlatch_40.xmux.xn.S1 VSS sg13_lv_nmos ad=63.19999f pd=0.74u as=63.19999f ps=0.74u w=0.26u l=0.38u
X2440 cml_tlatch_19.xtail.S1 CKHB0_N cml_tlatch_19.xmux.xp.S1 VSS sg13_lv_nmos ad=89.3f pd=0.85u as=89.3f ps=0.85u w=0.47u l=0.16u
X2441 MOT12_N cml_tlatch_40.INP cml_tlatch_40.xmux.xn.S1 VSS sg13_lv_nmos ad=63.19999f pd=0.74u as=63.19999f ps=0.74u w=0.26u l=0.38u
X2442 MOT11_N MOT11_P cml_tlatch_5.xmux.xp.S1 VSS sg13_lv_nmos ad=56.9f pd=0.74u as=56.9f ps=0.74u w=0.17u l=0.17u
X2443 MOT24_P MOT24_N cml_tlatch_86.xmux.xp.S1 VSS sg13_lv_nmos ad=56.9f pd=0.74u as=0.1019p ps=1.34u w=0.17u l=0.17u
X2444 cml_tlatch_1.OUTN VDD VSS rppd l=5.17u w=1u
X2445 cml_tlatch_67.xmux.xp.S1 cml_tlatch_67.OUTN cml_tlatch_67.OUTP VSS sg13_lv_nmos ad=56.9f pd=0.74u as=56.9f ps=0.74u w=0.17u l=0.17u
X2446 cml_tlatch_9.OUTP cml_tlatch_99.OUTN cml_tlatch_9.xmux.xn.S1 VSS sg13_lv_nmos ad=63.19999f pd=0.74u as=0.1082p ps=1.34u w=0.26u l=0.38u
X2447 cml_tlatch_93.xmux.xn.S1 J4_P J1_P VSS sg13_lv_nmos ad=63.19999f pd=0.74u as=63.19999f ps=0.74u w=0.26u l=0.38u
X2448 cml_tlatch_85.xmux.xp.S1 cml_tlatch_58.INP cml_tlatch_58.INN VSS sg13_lv_nmos ad=56.9f pd=0.74u as=56.9f ps=0.74u w=0.17u l=0.17u
X2449 VSS POLN cml_tlatch_89.xtail.S1 VSS sg13_lv_nmos ad=1.5637p pd=8.61u as=1.5637p ps=8.61u w=8.23u l=0.13u
X2450 cml_tlatch_70.INN cml_tlatch_70.INP cml_tlatch_84.xmux.xp.S1 VSS sg13_lv_nmos ad=56.9f pd=0.74u as=56.9f ps=0.74u w=0.17u l=0.17u
X2451 A3_2_P cml_tlatch_54.OUTN cml_tlatch_53.xmux.xn.S1 VSS sg13_lv_nmos ad=63.19999f pd=0.74u as=0.1082p ps=1.34u w=0.26u l=0.38u
X2452 cml_tlatch_86.xtail.S1 CKHA3_N cml_tlatch_86.xmux.xp.S1 VSS sg13_lv_nmos ad=89.3f pd=0.85u as=0.1598p ps=1.62u w=0.47u l=0.16u
X2453 cml_tlatch_54.xmux.xp.S1 cml_tlatch_54.OUTP cml_tlatch_54.OUTN VSS sg13_lv_nmos ad=0.1019p pd=1.34u as=56.9f ps=0.74u w=0.17u l=0.17u
X2454 cml_tlatch_42.xtail.S1 CKA2_N cml_tlatch_42.xmux.xp.S1 VSS sg13_lv_nmos ad=89.3f pd=0.85u as=89.3f ps=0.85u w=0.47u l=0.16u
X2455 cml_tlatch_27.OUTP cml_tlatch_27.OUTN cml_tlatch_27.xmux.xp.S1 VSS sg13_lv_nmos ad=56.9f pd=0.74u as=56.9f ps=0.74u w=0.17u l=0.17u
X2456 cml_tlatch_69.xmux.xp.S1 CKHB3_N cml_tlatch_69.xtail.S1 VSS sg13_lv_nmos ad=89.3f pd=0.85u as=89.3f ps=0.85u w=0.47u l=0.16u
X2457 cml_gate2_3.sg13_lv_nmos_FTPY57_0.D0 ENA0_P GA1_N VSS sg13_lv_nmos ad=0.1007p pd=0.91u as=0.1007p ps=0.91u w=0.53u l=0.13u
X2458 cml_tlatch_19.xmux.xp.S1 MOT5_P MOT5_N VSS sg13_lv_nmos ad=56.9f pd=0.74u as=56.9f ps=0.74u w=0.17u l=0.17u
X2459 cml_tlatch_40.INP cml_tlatch_40.INN cml_tlatch_95.xmux.xp.S1 VSS sg13_lv_nmos ad=56.9f pd=0.74u as=56.9f ps=0.74u w=0.17u l=0.17u
X2460 B1_2_P B1_2_N cml_tlatch_33.xmux.xp.S1 VSS sg13_lv_nmos ad=56.9f pd=0.74u as=56.9f ps=0.74u w=0.17u l=0.17u
X2461 MOT6_N MOT6_P cml_tlatch_26.xmux.xp.S1 VSS sg13_lv_nmos ad=56.9f pd=0.74u as=56.9f ps=0.74u w=0.17u l=0.17u
X2462 cml_tlatch_28.xtail.S1 CKB0_N cml_tlatch_28.xmux.xn.S1 VSS sg13_lv_nmos ad=89.3f pd=0.85u as=89.3f ps=0.85u w=0.47u l=0.16u
X2463 cml_tlatch_20.xmux.xn.S1 B0_2_P MOT7_N VSS sg13_lv_nmos ad=63.19999f pd=0.74u as=63.19999f ps=0.74u w=0.26u l=0.38u
X2464 cml_tlatch_0.xmux.xn.S1 CKA1_P cml_tlatch_0.xtail.S1 VSS sg13_lv_nmos ad=89.3f pd=0.85u as=89.3f ps=0.85u w=0.47u l=0.16u
X2465 MOT27_N MOT27_P cml_tlatch_69.xmux.xp.S1 VSS sg13_lv_nmos ad=56.9f pd=0.74u as=56.9f ps=0.74u w=0.17u l=0.17u
X2466 VSS POLN cml_tlatch_92.xtail.S1 VSS sg13_lv_nmos ad=1.5637p pd=8.61u as=1.5637p ps=8.61u w=8.23u l=0.13u
X2467 cml_tlatch_75.xtail.S1 CKHB2_N cml_tlatch_75.xmux.xp.S1 VSS sg13_lv_nmos ad=89.3f pd=0.85u as=89.3f ps=0.85u w=0.47u l=0.16u
X2468 cml_tlatch_20.xmux.xn.S1 B0_2_P MOT7_N VSS sg13_lv_nmos ad=63.19999f pd=0.74u as=63.19999f ps=0.74u w=0.26u l=0.38u
X2469 cml_tlatch_92.xtail.S1 CKJ_P cml_tlatch_92.xmux.xp.S1 VSS sg13_lv_nmos ad=89.3f pd=0.85u as=89.3f ps=0.85u w=0.47u l=0.16u
X2470 cml_tlatch_92.xmux.xp.S1 J2_N J2_P VSS sg13_lv_nmos ad=56.9f pd=0.74u as=56.9f ps=0.74u w=0.17u l=0.17u
X2471 cml_tlatch_95.xmux.xp.S1 CKA1_P cml_tlatch_95.xtail.S1 VSS sg13_lv_nmos ad=89.3f pd=0.85u as=89.3f ps=0.85u w=0.47u l=0.16u
X2472 cml_tlatch_63.xmux.xp.S1 cml_tlatch_63.OUTP cml_tlatch_63.OUTN VSS sg13_lv_nmos ad=56.9f pd=0.74u as=56.9f ps=0.74u w=0.17u l=0.17u
X2473 cml_tlatch_58.xtail.S1 CKHA3_P cml_tlatch_58.xmux.xn.S1 VSS sg13_lv_nmos ad=89.3f pd=0.85u as=89.3f ps=0.85u w=0.47u l=0.16u
X2474 cml_tlatch_77.xmux.xp.S1 B2_8_N B2_8_P VSS sg13_lv_nmos ad=56.9f pd=0.74u as=56.9f ps=0.74u w=0.17u l=0.17u
X2475 cml_tlatch_56.INP cml_tlatch_56.INN cml_tlatch_42.xmux.xp.S1 VSS sg13_lv_nmos ad=56.9f pd=0.74u as=56.9f ps=0.74u w=0.17u l=0.17u
X2476 cml_tlatch_48.xmux.xp.S1 stub_bi_32.BOTP stub_bi_32.BOTN VSS sg13_lv_nmos ad=56.9f pd=0.74u as=56.9f ps=0.74u w=0.17u l=0.17u
X2477 B3_2_P B3_2_N cml_tlatch_46.xmux.xp.S1 VSS sg13_lv_nmos ad=56.9f pd=0.74u as=56.9f ps=0.74u w=0.17u l=0.17u
X2478 cml_tlatch_53.xmux.xp.S1 CKA3_P cml_tlatch_53.xtail.S1 VSS sg13_lv_nmos ad=89.3f pd=0.85u as=89.3f ps=0.85u w=0.47u l=0.16u
X2479 cml_tlatch_77.xmux.xp.S1 CKB2_P cml_tlatch_77.xtail.S1 VSS sg13_lv_nmos ad=89.3f pd=0.85u as=89.3f ps=0.85u w=0.47u l=0.16u
X2480 cml_tlatch_20.xmux.xp.S1 CKHB0_N cml_tlatch_20.xtail.S1 VSS sg13_lv_nmos ad=89.3f pd=0.85u as=89.3f ps=0.85u w=0.47u l=0.16u
X2481 MOT3_N cml_tlatch_16.OUTP cml_tlatch_18.xmux.xn.S1 VSS sg13_lv_nmos ad=0.1082p pd=1.34u as=63.19999f ps=0.74u w=0.26u l=0.38u
X2482 cml_tlatch_1.xmux.xp.S1 cml_tlatch_1.OUTP cml_tlatch_1.OUTN VSS sg13_lv_nmos ad=56.9f pd=0.74u as=56.9f ps=0.74u w=0.17u l=0.17u
X2483 cml_tlatch_30.xtail.S1 CKA0_N cml_tlatch_30.xmux.xp.S1 VSS sg13_lv_nmos ad=89.3f pd=0.85u as=89.3f ps=0.85u w=0.47u l=0.16u
X2484 cml_tlatch_39.xmux.xn.S1 cml_tlatch_39.INP MOT10_N VSS sg13_lv_nmos ad=63.19999f pd=0.74u as=63.19999f ps=0.74u w=0.26u l=0.38u
X2485 MOT6_P A0_2_N cml_tlatch_26.xmux.xn.S1 VSS sg13_lv_nmos ad=63.19999f pd=0.74u as=63.19999f ps=0.74u w=0.26u l=0.38u
X2486 cml_tlatch_3.OUTN cml_tlatch_3.OUTP cml_tlatch_3.xmux.xp.S1 VSS sg13_lv_nmos ad=56.9f pd=0.74u as=56.9f ps=0.74u w=0.17u l=0.17u
X2487 cml_tlatch_7.xmux.xn.S1 B1_2_N MOT15_P VSS sg13_lv_nmos ad=63.19999f pd=0.74u as=63.19999f ps=0.74u w=0.26u l=0.38u
X2488 cml_tlatch_39.INN cml_tlatch_39.INP cml_tlatch_23.xmux.xp.S1 VSS sg13_lv_nmos ad=56.9f pd=0.74u as=56.9f ps=0.74u w=0.17u l=0.17u
X2489 stub_bi_19.BOTP stub_bi_19.BOTN cml_tlatch_15.xmux.xp.S1 VSS sg13_lv_nmos ad=56.9f pd=0.74u as=56.9f ps=0.74u w=0.17u l=0.17u
X2490 cml_tlatch_47.xmux.xp.S1 cml_tlatch_47.OUTP cml_tlatch_47.OUTN VSS sg13_lv_nmos ad=56.9f pd=0.74u as=56.9f ps=0.74u w=0.17u l=0.17u
X2491 cml_tlatch_11.OUTP cml_tlatch_11.OUTN cml_tlatch_11.xmux.xp.S1 VSS sg13_lv_nmos ad=56.9f pd=0.74u as=0.1019p ps=1.34u w=0.17u l=0.17u
X2492 cml_tlatch_9.xmux.xp.S1 CKA0_N cml_tlatch_9.xtail.S1 VSS sg13_lv_nmos ad=89.3f pd=0.85u as=0.1598p ps=1.62u w=0.47u l=0.16u
X2493 cml_tlatch_25.xmux.xp.S1 MOT4_P MOT4_N VSS sg13_lv_nmos ad=56.9f pd=0.74u as=56.9f ps=0.74u w=0.17u l=0.17u
X2494 cml_tlatch_63.xmux.xn.S1 cml_tlatch_70.INN cml_tlatch_63.OUTP VSS sg13_lv_nmos ad=63.19999f pd=0.74u as=0.1082p ps=1.34u w=0.26u l=0.38u
X2495 cml_tlatch_9.xmux.xn.S1 CKA0_P cml_tlatch_9.xtail.S1 VSS sg13_lv_nmos ad=89.3f pd=0.85u as=89.3f ps=0.85u w=0.47u l=0.16u
X2496 cml_tlatch_8.OUTN cml_tlatch_9.OUTP cml_tlatch_8.xmux.xn.S1 VSS sg13_lv_nmos ad=0.1082p pd=1.34u as=63.19999f ps=0.74u w=0.26u l=0.38u
X2497 MOT14_N MOT14_P cml_tlatch_41.xmux.xp.S1 VSS sg13_lv_nmos ad=56.9f pd=0.74u as=0.1019p ps=1.34u w=0.17u l=0.17u
X2498 cml_tlatch_94.xmux.xp.S1 CKB1_P cml_tlatch_94.xtail.S1 VSS sg13_lv_nmos ad=89.3f pd=0.85u as=89.3f ps=0.85u w=0.47u l=0.16u
X2499 cml_gate2_4.sg13_lv_nmos_FTPY57_0.D0 CKB2_P cml_gate2_4.xrtail.R1 VSS sg13_lv_nmos ad=0.1007p pd=0.91u as=0.1007p ps=0.91u w=0.53u l=0.13u
X2500 cml_tlatch_46.xmux.xp.S1 CKB3_P cml_tlatch_46.xtail.S1 VSS sg13_lv_nmos ad=89.3f pd=0.85u as=89.3f ps=0.85u w=0.47u l=0.16u
X2501 MOT31_P B3_2_N cml_tlatch_71.xmux.xn.S1 VSS sg13_lv_nmos ad=63.19999f pd=0.74u as=63.19999f ps=0.74u w=0.26u l=0.38u
X2502 cml_tlatch_98.xmux.xp.S1 cml_tlatch_98.OUTP cml_tlatch_98.OUTN VSS sg13_lv_nmos ad=56.9f pd=0.74u as=56.9f ps=0.74u w=0.17u l=0.17u
X2503 B0_8_N VDD VSS rppd l=5.17u w=1u
X2504 MOT4_P MOT4_N cml_tlatch_25.xmux.xp.S1 VSS sg13_lv_nmos ad=56.9f pd=0.74u as=0.1019p ps=1.34u w=0.17u l=0.17u
X2505 CKHA3_N GA3_P cml_drvb_5.xrtail.R1 VSS sg13_lv_nmos ad=0.2618p pd=2.22u as=0.1463p ps=1.15u w=0.77u l=0.21u
X2506 cml_tlatch_8.OUTN cml_tlatch_9.OUTP cml_tlatch_8.xmux.xn.S1 VSS sg13_lv_nmos ad=63.19999f pd=0.74u as=63.19999f ps=0.74u w=0.26u l=0.38u
X2507 A3_8_P A3_8_N cml_tlatch_64.xmux.xp.S1 VSS sg13_lv_nmos ad=56.9f pd=0.74u as=0.1019p ps=1.34u w=0.17u l=0.17u
X2508 cml_gate2_2.xrtail.R1 CKB0_N GA0_P VSS sg13_lv_nmos ad=0.1007p pd=0.91u as=0.1007p ps=0.91u w=0.53u l=0.13u
X2509 cml_tlatch_38.xmux.xn.S1 D1_P cml_tlatch_38.OUTN VSS sg13_lv_nmos ad=63.19999f pd=0.74u as=63.19999f ps=0.74u w=0.26u l=0.38u
X2510 cml_tlatch_39.xmux.xp.S1 CKHA1_N cml_tlatch_39.xtail.S1 VSS sg13_lv_nmos ad=89.3f pd=0.85u as=89.3f ps=0.85u w=0.47u l=0.16u
X2511 CKHA1_N VDD VSS rppd l=13.09u w=1u
X2512 hs_to_clk_3.D2 CK_P CKA1_P VSS sg13_lv_nmos ad=0.228p pd=1.58u as=0.228p ps=1.58u w=1.2u l=0.2u
X2513 cml_tlatch_14.xmux.xp.S1 CKB1_P cml_tlatch_14.xtail.S1 VSS sg13_lv_nmos ad=89.3f pd=0.85u as=89.3f ps=0.85u w=0.47u l=0.16u
X2514 cml_tlatch_6.xtail.S1 CKHB1_N cml_tlatch_6.xmux.xp.S1 VSS sg13_lv_nmos ad=89.3f pd=0.85u as=89.3f ps=0.85u w=0.47u l=0.16u
X2515 cml_tlatch_12.xmux.xp.S1 B1_8_P B1_8_N VSS sg13_lv_nmos ad=56.9f pd=0.74u as=56.9f ps=0.74u w=0.17u l=0.17u
X2516 cml_tlatch_35.xmux.xp.S1 cml_tlatch_35.OUTP cml_tlatch_35.OUTN VSS sg13_lv_nmos ad=56.9f pd=0.74u as=56.9f ps=0.74u w=0.17u l=0.17u
X2517 VSS POLN cml_tlatch_28.xtail.S1 VSS sg13_lv_nmos ad=1.5637p pd=8.61u as=1.5637p ps=8.61u w=8.23u l=0.13u
X2518 cml_tlatch_6.INN cml_tlatch_6.INP cml_tlatch_94.xmux.xp.S1 VSS sg13_lv_nmos ad=56.9f pd=0.74u as=56.9f ps=0.74u w=0.17u l=0.17u
X2519 cml_tlatch_46.xmux.xp.S1 B3_2_N B3_2_P VSS sg13_lv_nmos ad=56.9f pd=0.74u as=56.9f ps=0.74u w=0.17u l=0.17u
X2520 cml_tlatch_43.xmux.xp.S1 stub_bi_42.BOTN stub_bi_42.BOTP VSS sg13_lv_nmos ad=56.9f pd=0.74u as=56.9f ps=0.74u w=0.17u l=0.17u
X2521 cml_tlatch_26.xmux.xp.S1 CKHA0_N cml_tlatch_26.xtail.S1 VSS sg13_lv_nmos ad=89.3f pd=0.85u as=89.3f ps=0.85u w=0.47u l=0.16u
X2522 cml_tlatch_90.xmux.xn.S1 CLK_W_P J4_P VSS sg13_lv_nmos ad=63.19999f pd=0.74u as=63.19999f ps=0.74u w=0.26u l=0.38u
X2523 cml_tlatch_75.xmux.xn.S1 stub_bi_55.BOTN MOT21_N VSS sg13_lv_nmos ad=63.19999f pd=0.74u as=63.19999f ps=0.74u w=0.26u l=0.38u
X2524 cml_tlatch_84.xmux.xp.S1 cml_tlatch_70.INN cml_tlatch_70.INP VSS sg13_lv_nmos ad=56.9f pd=0.74u as=56.9f ps=0.74u w=0.17u l=0.17u
X2525 hs_to_clk_1.D2 POLN VSS VSS sg13_lv_nmos ad=1.9p pd=10.38u as=1.9p ps=10.38u w=10u l=0.13u
X2526 MOT11_N MOT11_P cml_tlatch_5.xmux.xp.S1 VSS sg13_lv_nmos ad=56.9f pd=0.74u as=56.9f ps=0.74u w=0.17u l=0.17u
X2527 cml_tlatch_95.xtail.S1 POLN VSS VSS sg13_lv_nmos ad=1.5637p pd=8.61u as=1.5637p ps=8.61u w=8.23u l=0.13u
X2528 cml_tlatch_32.xmux.xp.S1 stub_bi_29.BOTP stub_bi_29.BOTN VSS sg13_lv_nmos ad=56.9f pd=0.74u as=56.9f ps=0.74u w=0.17u l=0.17u
X2529 cml_tlatch_67.xmux.xn.S1 cml_tlatch_58.INP cml_tlatch_67.OUTN VSS sg13_lv_nmos ad=63.19999f pd=0.74u as=63.19999f ps=0.74u w=0.26u l=0.38u
X2530 cml_tlatch_22.xtail.S1 CKA1_P cml_tlatch_22.xmux.xn.S1 VSS sg13_lv_nmos ad=89.3f pd=0.85u as=89.3f ps=0.85u w=0.47u l=0.16u
X2531 stub_bi_42.BOTP B2_2_P cml_tlatch_43.xmux.xn.S1 VSS sg13_lv_nmos ad=63.19999f pd=0.74u as=63.19999f ps=0.74u w=0.26u l=0.38u
X2532 MOT5_P MOT5_N cml_tlatch_19.xmux.xp.S1 VSS sg13_lv_nmos ad=56.9f pd=0.74u as=56.9f ps=0.74u w=0.17u l=0.17u
X2533 cml_tlatch_11.OUTP cml_tlatch_11.OUTN cml_tlatch_11.xmux.xp.S1 VSS sg13_lv_nmos ad=56.9f pd=0.74u as=56.9f ps=0.74u w=0.17u l=0.17u
X2534 VSS POLN cml_tlatch_58.xtail.S1 VSS sg13_lv_nmos ad=2.7982p pd=17.14u as=1.5637p ps=8.61u w=8.23u l=0.13u
X2535 A2_2_N A2_2_P cml_tlatch_56.xmux.xp.S1 VSS sg13_lv_nmos ad=56.9f pd=0.74u as=56.9f ps=0.74u w=0.17u l=0.17u
X2536 cml_gate2_4.sg13_lv_nmos_FTPY57_0.D0 ENA1_N GA2_P VSS sg13_lv_nmos ad=0.1802p pd=1.74u as=0.1007p ps=0.91u w=0.53u l=0.13u
X2537 cml_tlatch_27.OUTP cml_tlatch_27.OUTN cml_tlatch_27.xmux.xp.S1 VSS sg13_lv_nmos ad=56.9f pd=0.74u as=56.9f ps=0.74u w=0.17u l=0.17u
X2538 cml_tlatch_2.xmux.xn.S1 CKA0_N cml_tlatch_2.xtail.S1 VSS sg13_lv_nmos ad=89.3f pd=0.85u as=89.3f ps=0.85u w=0.47u l=0.16u
X2539 cml_tlatch_81.xmux.xn.S1 CKA2_N cml_tlatch_81.xtail.S1 VSS sg13_lv_nmos ad=89.3f pd=0.85u as=89.3f ps=0.85u w=0.47u l=0.16u
X2540 MOT7_P MOT7_N cml_tlatch_20.xmux.xp.S1 VSS sg13_lv_nmos ad=56.9f pd=0.74u as=0.1019p ps=1.34u w=0.17u l=0.17u
X2541 CLK_W_N CLK_W_P cml_tlatch_91.xmux.xp.S1 VSS sg13_lv_nmos ad=56.9f pd=0.74u as=56.9f ps=0.74u w=0.17u l=0.17u
X2542 cml_tlatch_68.xmux.xn.S1 CKHB3_P cml_tlatch_68.xtail.S1 VSS sg13_lv_nmos ad=89.3f pd=0.85u as=89.3f ps=0.85u w=0.47u l=0.16u
X2543 cml_tlatch_72.xmux.xp.S1 cml_tlatch_83.INP cml_tlatch_83.INN VSS sg13_lv_nmos ad=56.9f pd=0.74u as=56.9f ps=0.74u w=0.17u l=0.17u
X2544 cml_tlatch_61.xmux.xp.S1 cml_tlatch_61.OUTP cml_tlatch_61.OUTN VSS sg13_lv_nmos ad=56.9f pd=0.74u as=56.9f ps=0.74u w=0.17u l=0.17u
X2545 cml_gate2_9.xrtail.R1 NM1_N ENA_P VSS sg13_lv_nmos ad=0.1007p pd=0.91u as=0.1007p ps=0.91u w=0.53u l=0.13u
X2546 stub_bi_62.BOTP stub_bi_63.BOTN cml_tlatch_78.xmux.xn.S1 VSS sg13_lv_nmos ad=63.19999f pd=0.74u as=63.19999f ps=0.74u w=0.26u l=0.38u
X2547 A0_8_N A0_8_P cml_tlatch_2.xmux.xp.S1 VSS sg13_lv_nmos ad=56.9f pd=0.74u as=56.9f ps=0.74u w=0.17u l=0.17u
X2548 cml_tlatch_35.xtail.S1 CKA0_P cml_tlatch_35.xmux.xn.S1 VSS sg13_lv_nmos ad=89.3f pd=0.85u as=89.3f ps=0.85u w=0.47u l=0.16u
X2549 cml_tlatch_67.xtail.S1 CKA3_P cml_tlatch_67.xmux.xn.S1 VSS sg13_lv_nmos ad=89.3f pd=0.85u as=89.3f ps=0.85u w=0.47u l=0.16u
X2550 MOT12_N MOT12_P cml_tlatch_40.xmux.xp.S1 VSS sg13_lv_nmos ad=56.9f pd=0.74u as=56.9f ps=0.74u w=0.17u l=0.17u
X2551 cml_tlatch_22.xmux.xp.S1 CKA1_N cml_tlatch_22.xtail.S1 VSS sg13_lv_nmos ad=89.3f pd=0.85u as=0.1598p ps=1.62u w=0.47u l=0.16u
X2552 cml_tlatch_33.xtail.S1 CKB1_P cml_tlatch_33.xmux.xp.S1 VSS sg13_lv_nmos ad=89.3f pd=0.85u as=89.3f ps=0.85u w=0.47u l=0.16u
X2553 J2_N J2_P cml_tlatch_92.xmux.xp.S1 VSS sg13_lv_nmos ad=56.9f pd=0.74u as=56.9f ps=0.74u w=0.17u l=0.17u
X2554 cml_tlatch_77.xmux.xn.S1 CKB2_N cml_tlatch_77.xtail.S1 VSS sg13_lv_nmos ad=89.3f pd=0.85u as=89.3f ps=0.85u w=0.47u l=0.16u
X2555 cml_tlatch_52.OUTP A3_2_N cml_tlatch_52.xmux.xn.S1 VSS sg13_lv_nmos ad=63.19999f pd=0.74u as=63.19999f ps=0.74u w=0.26u l=0.38u
X2556 cml_tlatch_73.xmux.xp.S1 MOT17_P MOT17_N VSS sg13_lv_nmos ad=56.9f pd=0.74u as=56.9f ps=0.74u w=0.17u l=0.17u
X2557 cml_tlatch_1.xmux.xp.S1 CKB0_N cml_tlatch_1.xtail.S1 VSS sg13_lv_nmos ad=89.3f pd=0.85u as=89.3f ps=0.85u w=0.47u l=0.16u
X2558 cml_tlatch_25.xmux.xn.S1 CKHA0_P cml_tlatch_25.xtail.S1 VSS sg13_lv_nmos ad=89.3f pd=0.85u as=89.3f ps=0.85u w=0.47u l=0.16u
X2559 cml_tlatch_64.xmux.xn.S1 CKA3_N cml_tlatch_64.xtail.S1 VSS sg13_lv_nmos ad=89.3f pd=0.85u as=89.3f ps=0.85u w=0.47u l=0.16u
X2560 cml_tlatch_1.xmux.xp.S1 cml_tlatch_1.OUTP cml_tlatch_1.OUTN VSS sg13_lv_nmos ad=56.9f pd=0.74u as=56.9f ps=0.74u w=0.17u l=0.17u
X2561 cml_tlatch_65.OUTP cml_tlatch_65.OUTN cml_tlatch_65.xmux.xp.S1 VSS sg13_lv_nmos ad=56.9f pd=0.74u as=56.9f ps=0.74u w=0.17u l=0.17u
X2562 MOT19_P MOT19_N cml_tlatch_74.xmux.xp.S1 VSS sg13_lv_nmos ad=56.9f pd=0.74u as=56.9f ps=0.74u w=0.17u l=0.17u
X2563 cml_tlatch_23.xmux.xn.S1 CKA1_N cml_tlatch_23.xtail.S1 VSS sg13_lv_nmos ad=89.3f pd=0.85u as=89.3f ps=0.85u w=0.47u l=0.16u
X2564 cml_tlatch_22.OUTP cml_tlatch_39.INN cml_tlatch_22.xmux.xn.S1 VSS sg13_lv_nmos ad=63.19999f pd=0.74u as=63.19999f ps=0.74u w=0.26u l=0.38u
X2565 cml_tlatch_97.xmux.xp.S1 MOT0_P MOT0_N VSS sg13_lv_nmos ad=56.9f pd=0.74u as=56.9f ps=0.74u w=0.17u l=0.17u
X2566 cml_tlatch_81.xmux.xn.S1 cml_tlatch_82.OUTN A2_8_P VSS sg13_lv_nmos ad=63.19999f pd=0.74u as=63.19999f ps=0.74u w=0.26u l=0.38u
X2567 cml_tlatch_29.OUTP cml_tlatch_29.OUTN cml_tlatch_29.xmux.xp.S1 VSS sg13_lv_nmos ad=56.9f pd=0.74u as=56.9f ps=0.74u w=0.17u l=0.17u
X2568 cml_tlatch_81.xmux.xn.S1 cml_tlatch_82.OUTN A2_8_P VSS sg13_lv_nmos ad=63.19999f pd=0.74u as=63.19999f ps=0.74u w=0.26u l=0.38u
X2569 MOT4_P MOT4_N cml_tlatch_25.xmux.xp.S1 VSS sg13_lv_nmos ad=56.9f pd=0.74u as=56.9f ps=0.74u w=0.17u l=0.17u
X2570 cml_tlatch_5.INP stub_bi_19.BOTP cml_tlatch_14.xmux.xn.S1 VSS sg13_lv_nmos ad=63.19999f pd=0.74u as=63.19999f ps=0.74u w=0.26u l=0.38u
X2571 cml_tlatch_69.INP cml_tlatch_69.INN cml_tlatch_62.xmux.xp.S1 VSS sg13_lv_nmos ad=56.9f pd=0.74u as=56.9f ps=0.74u w=0.17u l=0.17u
X2572 cml_tlatch_69.INN cml_tlatch_69.INP cml_tlatch_62.xmux.xp.S1 VSS sg13_lv_nmos ad=56.9f pd=0.74u as=56.9f ps=0.74u w=0.17u l=0.17u
X2573 cml_tlatch_86.xtail.S1 CKHA3_P cml_tlatch_86.xmux.xn.S1 VSS sg13_lv_nmos ad=89.3f pd=0.85u as=89.3f ps=0.85u w=0.47u l=0.16u
X2574 cml_tlatch_75.xmux.xp.S1 CKHB2_N cml_tlatch_75.xtail.S1 VSS sg13_lv_nmos ad=89.3f pd=0.85u as=89.3f ps=0.85u w=0.47u l=0.16u
X2575 cml_tlatch_37.xmux.xp.S1 A1_2_P A1_2_N VSS sg13_lv_nmos ad=56.9f pd=0.74u as=56.9f ps=0.74u w=0.17u l=0.17u
X2576 cml_tlatch_83.xmux.xp.S1 cml_tlatch_83.OUTN cml_tlatch_83.OUTP VSS sg13_lv_nmos ad=56.9f pd=0.74u as=56.9f ps=0.74u w=0.17u l=0.17u
X2577 cml_tlatch_84.xmux.xp.S1 cml_tlatch_70.INN cml_tlatch_70.INP VSS sg13_lv_nmos ad=56.9f pd=0.74u as=56.9f ps=0.74u w=0.17u l=0.17u
X2578 cml_tlatch_89.OUTP cml_tlatch_89.OUTN cml_tlatch_89.xmux.xp.S1 VSS sg13_lv_nmos ad=56.9f pd=0.74u as=56.9f ps=0.74u w=0.17u l=0.17u
X2579 cml_tlatch_14.xmux.xn.S1 CKB1_N cml_tlatch_14.xtail.S1 VSS sg13_lv_nmos ad=89.3f pd=0.85u as=89.3f ps=0.85u w=0.47u l=0.16u
X2580 cml_tlatch_59.xtail.S1 CKHA3_P cml_tlatch_59.xmux.xn.S1 VSS sg13_lv_nmos ad=89.3f pd=0.85u as=89.3f ps=0.85u w=0.47u l=0.16u
X2581 cml_tlatch_62.xmux.xn.S1 cml_tlatch_63.OUTN cml_tlatch_69.INP VSS sg13_lv_nmos ad=63.19999f pd=0.74u as=63.19999f ps=0.74u w=0.26u l=0.38u
X2582 cml_tlatch_95.INN cml_tlatch_95.INP cml_tlatch_36.xmux.xp.S1 VSS sg13_lv_nmos ad=56.9f pd=0.74u as=0.1019p ps=1.34u w=0.17u l=0.17u
X2583 cml_tlatch_30.xmux.xp.S1 cml_tlatch_30.OUTP cml_tlatch_30.OUTN VSS sg13_lv_nmos ad=56.9f pd=0.74u as=56.9f ps=0.74u w=0.17u l=0.17u
X2584 cml_tlatch_69.xtail.S1 POLN VSS VSS sg13_lv_nmos ad=1.5637p pd=8.61u as=1.5637p ps=8.61u w=8.23u l=0.13u
X2585 B1_8_P B1_8_N cml_tlatch_12.xmux.xp.S1 VSS sg13_lv_nmos ad=56.9f pd=0.74u as=56.9f ps=0.74u w=0.17u l=0.17u
X2586 cml_tlatch_5.xtail.S1 CKHB1_P cml_tlatch_5.xmux.xn.S1 VSS sg13_lv_nmos ad=89.3f pd=0.85u as=89.3f ps=0.85u w=0.47u l=0.16u
X2587 cml_tlatch_56.xmux.xn.S1 CKA2_N cml_tlatch_56.xtail.S1 VSS sg13_lv_nmos ad=89.3f pd=0.85u as=89.3f ps=0.85u w=0.47u l=0.16u
X2588 cml_tlatch_70.xmux.xp.S1 CKHB3_N cml_tlatch_70.xtail.S1 VSS sg13_lv_nmos ad=89.3f pd=0.85u as=89.3f ps=0.85u w=0.47u l=0.16u
X2589 cml_tlatch_75.xmux.xp.S1 MOT21_P MOT21_N VSS sg13_lv_nmos ad=56.9f pd=0.74u as=56.9f ps=0.74u w=0.17u l=0.17u
X2590 cml_tlatch_56.xmux.xp.S1 A2_2_N A2_2_P VSS sg13_lv_nmos ad=0.1019p pd=1.34u as=56.9f ps=0.74u w=0.17u l=0.17u
X2591 MOT29_N MOT29_P cml_tlatch_70.xmux.xp.S1 VSS sg13_lv_nmos ad=56.9f pd=0.74u as=56.9f ps=0.74u w=0.17u l=0.17u
X2592 hs_to_clk_2.D2 CK_N CKB1_P VSS sg13_lv_nmos ad=0.408p pd=3.08u as=0.228p ps=1.58u w=1.2u l=0.2u
X2593 cml_tlatch_61.OUTP cml_tlatch_61.OUTN cml_tlatch_61.xmux.xp.S1 VSS sg13_lv_nmos ad=56.9f pd=0.74u as=0.1019p ps=1.34u w=0.17u l=0.17u
X2594 B2_2_P stub_bi_32.BOTP cml_tlatch_44.xmux.xn.S1 VSS sg13_lv_nmos ad=63.19999f pd=0.74u as=63.19999f ps=0.74u w=0.26u l=0.38u
X2595 MOT1_P MOT1_N cml_tlatch_17.xmux.xp.S1 VSS sg13_lv_nmos ad=56.9f pd=0.74u as=0.1019p ps=1.34u w=0.17u l=0.17u
X2596 cml_tlatch_92.xmux.xp.S1 J2_P J2_N VSS sg13_lv_nmos ad=56.9f pd=0.74u as=56.9f ps=0.74u w=0.17u l=0.17u
X2597 cml_tlatch_93.xmux.xp.S1 J1_N J1_P VSS sg13_lv_nmos ad=56.9f pd=0.74u as=56.9f ps=0.74u w=0.17u l=0.17u
X2598 cml_tlatch_31.xmux.xp.S1 A0_2_P A0_2_N VSS sg13_lv_nmos ad=56.9f pd=0.74u as=56.9f ps=0.74u w=0.17u l=0.17u
X2599 cml_tlatch_45.xtail.S1 POLN VSS VSS sg13_lv_nmos ad=1.5637p pd=8.61u as=2.7982p ps=17.14u w=8.23u l=0.13u
X2600 cml_tlatch_61.OUTP cml_tlatch_69.INN cml_tlatch_61.xmux.xn.S1 VSS sg13_lv_nmos ad=63.19999f pd=0.74u as=63.19999f ps=0.74u w=0.26u l=0.38u
X2601 cml_tlatch_14.xmux.xp.S1 cml_tlatch_5.INP cml_tlatch_5.INN VSS sg13_lv_nmos ad=0.1019p pd=1.34u as=56.9f ps=0.74u w=0.17u l=0.17u
X2602 GA3_N ENA1_P cml_gate2_5.sg13_lv_nmos_FTPY57_0.D0 VSS sg13_lv_nmos ad=0.1007p pd=0.91u as=0.1007p ps=0.91u w=0.53u l=0.13u
X2603 cml_tlatch_44.xmux.xn.S1 CKB2_N cml_tlatch_44.xtail.S1 VSS sg13_lv_nmos ad=89.3f pd=0.85u as=89.3f ps=0.85u w=0.47u l=0.16u
X2604 cml_tlatch_95.xmux.xn.S1 CKA1_N cml_tlatch_95.xtail.S1 VSS sg13_lv_nmos ad=89.3f pd=0.85u as=89.3f ps=0.85u w=0.47u l=0.16u
X2605 cml_tlatch_82.xtail.S1 CKA2_N cml_tlatch_82.xmux.xp.S1 VSS sg13_lv_nmos ad=89.3f pd=0.85u as=89.3f ps=0.85u w=0.47u l=0.16u
X2606 cml_tlatch_53.xmux.xn.S1 CKA3_N cml_tlatch_53.xtail.S1 VSS sg13_lv_nmos ad=89.3f pd=0.85u as=89.3f ps=0.85u w=0.47u l=0.16u
X2607 cml_tlatch_35.xmux.xn.S1 D0_P cml_tlatch_35.OUTN VSS sg13_lv_nmos ad=63.19999f pd=0.74u as=63.19999f ps=0.74u w=0.26u l=0.38u
X2608 MOT0_P MOT0_N cml_tlatch_97.xmux.xp.S1 VSS sg13_lv_nmos ad=56.9f pd=0.74u as=56.9f ps=0.74u w=0.17u l=0.17u
X2609 cml_tlatch_75.xmux.xp.S1 MOT21_N MOT21_P VSS sg13_lv_nmos ad=56.9f pd=0.74u as=56.9f ps=0.74u w=0.17u l=0.17u
X2610 cml_tlatch_21.xmux.xp.S1 CKA1_P cml_tlatch_21.xtail.S1 VSS sg13_lv_nmos ad=89.3f pd=0.85u as=89.3f ps=0.85u w=0.47u l=0.16u
X2611 MOT7_P MOT7_N cml_tlatch_20.xmux.xp.S1 VSS sg13_lv_nmos ad=56.9f pd=0.74u as=56.9f ps=0.74u w=0.17u l=0.17u
X2612 cml_tlatch_54.OUTP cml_tlatch_54.OUTN cml_tlatch_54.xmux.xp.S1 VSS sg13_lv_nmos ad=56.9f pd=0.74u as=56.9f ps=0.74u w=0.17u l=0.17u
X2613 MOT27_P MOT27_N cml_tlatch_69.xmux.xp.S1 VSS sg13_lv_nmos ad=56.9f pd=0.74u as=56.9f ps=0.74u w=0.17u l=0.17u
X2614 MOT22_P MOT22_N cml_tlatch_51.xmux.xp.S1 VSS sg13_lv_nmos ad=56.9f pd=0.74u as=56.9f ps=0.74u w=0.17u l=0.17u
X2615 cml_tlatch_11.xmux.xn.S1 CKB0_P cml_tlatch_11.xtail.S1 VSS sg13_lv_nmos ad=89.3f pd=0.85u as=89.3f ps=0.85u w=0.47u l=0.16u
X2616 cml_tlatch_96.xmux.xn.S1 A1_8_N MOT8_P VSS sg13_lv_nmos ad=63.19999f pd=0.74u as=63.19999f ps=0.74u w=0.26u l=0.38u
X2617 cml_tlatch_59.xmux.xp.S1 MOT30_N MOT30_P VSS sg13_lv_nmos ad=56.9f pd=0.74u as=56.9f ps=0.74u w=0.17u l=0.17u
X2618 MOT16_N MOT16_P cml_tlatch_87.xmux.xp.S1 VSS sg13_lv_nmos ad=56.9f pd=0.74u as=56.9f ps=0.74u w=0.17u l=0.17u
X2619 cml_tlatch_64.xtail.S1 POLN VSS VSS sg13_lv_nmos ad=1.5637p pd=8.61u as=1.5637p ps=8.61u w=8.23u l=0.13u
X2620 cml_tlatch_76.xtail.S1 CKHB2_N cml_tlatch_76.xmux.xp.S1 VSS sg13_lv_nmos ad=89.3f pd=0.85u as=89.3f ps=0.85u w=0.47u l=0.16u
X2621 cml_tlatch_81.xmux.xp.S1 CKA2_P cml_tlatch_81.xtail.S1 VSS sg13_lv_nmos ad=0.1598p pd=1.62u as=89.3f ps=0.85u w=0.47u l=0.16u
X2622 stub_bi_49.BOTP stub_bi_49.BOTN cml_tlatch_80.xmux.xp.S1 VSS sg13_lv_nmos ad=56.9f pd=0.74u as=56.9f ps=0.74u w=0.17u l=0.17u
X2623 cml_tlatch_5.xmux.xp.S1 MOT11_N MOT11_P VSS sg13_lv_nmos ad=56.9f pd=0.74u as=56.9f ps=0.74u w=0.17u l=0.17u
X2624 cml_tlatch_83.xmux.xn.S1 cml_tlatch_83.INN cml_tlatch_83.OUTP VSS sg13_lv_nmos ad=63.19999f pd=0.74u as=63.19999f ps=0.74u w=0.26u l=0.38u
X2625 MOT24_P A3_8_N cml_tlatch_86.xmux.xn.S1 VSS sg13_lv_nmos ad=63.19999f pd=0.74u as=63.19999f ps=0.74u w=0.26u l=0.38u
X2626 cml_gate2_1.xrtail.R1 CKA0_P cml_gate2_1.sg13_lv_nmos_FTPY57_0.D0 VSS sg13_lv_nmos ad=0.1007p pd=0.91u as=0.1007p ps=0.91u w=0.53u l=0.13u
X2627 cml_tlatch_39.xmux.xn.S1 CKHA1_P cml_tlatch_39.xtail.S1 VSS sg13_lv_nmos ad=89.3f pd=0.85u as=89.3f ps=0.85u w=0.47u l=0.16u
X2628 VDD CLK_W_P VSS rppd l=5.17u w=1u
X2629 cml_tlatch_74.xtail.S1 CKHB2_P cml_tlatch_74.xmux.xn.S1 VSS sg13_lv_nmos ad=89.3f pd=0.85u as=89.3f ps=0.85u w=0.47u l=0.16u
X2630 A3_2_N A3_2_P cml_tlatch_53.xmux.xp.S1 VSS sg13_lv_nmos ad=56.9f pd=0.74u as=56.9f ps=0.74u w=0.17u l=0.17u
X2631 J2_N J2_P cml_tlatch_92.xmux.xp.S1 VSS sg13_lv_nmos ad=56.9f pd=0.74u as=56.9f ps=0.74u w=0.17u l=0.17u
X2632 cml_drv_1.xrtail.R1 ENA_P ENA1_N VSS sg13_lv_nmos ad=56.2f pd=0.74u as=56.2f ps=0.74u w=0.16u l=0.19u
X2633 stub_bi_55.BOTN stub_bi_55.BOTP cml_tlatch_88.xmux.xp.S1 VSS sg13_lv_nmos ad=56.9f pd=0.74u as=0.1019p ps=1.34u w=0.17u l=0.17u
X2634 cml_tlatch_16.OUTN cml_tlatch_16.OUTP cml_tlatch_16.xmux.xp.S1 VSS sg13_lv_nmos ad=56.9f pd=0.74u as=56.9f ps=0.74u w=0.17u l=0.17u
X2635 cml_tlatch_9.OUTP cml_tlatch_9.OUTN cml_tlatch_9.xmux.xp.S1 VSS sg13_lv_nmos ad=56.9f pd=0.74u as=56.9f ps=0.74u w=0.17u l=0.17u
X2636 MOT18_P MOT18_N cml_tlatch_49.xmux.xp.S1 VSS sg13_lv_nmos ad=56.9f pd=0.74u as=56.9f ps=0.74u w=0.17u l=0.17u
X2637 cml_tlatch_73.xmux.xp.S1 MOT17_P MOT17_N VSS sg13_lv_nmos ad=0.1019p pd=1.34u as=56.9f ps=0.74u w=0.17u l=0.17u
X2638 cml_tlatch_26.xmux.xp.S1 MOT6_P MOT6_N VSS sg13_lv_nmos ad=56.9f pd=0.74u as=56.9f ps=0.74u w=0.17u l=0.17u
X2639 MOT25_N MOT25_P cml_tlatch_68.xmux.xp.S1 VSS sg13_lv_nmos ad=56.9f pd=0.74u as=56.9f ps=0.74u w=0.17u l=0.17u
X2640 cml_tlatch_5.xmux.xp.S1 CKHB1_N cml_tlatch_5.xtail.S1 VSS sg13_lv_nmos ad=89.3f pd=0.85u as=89.3f ps=0.85u w=0.47u l=0.16u
X2641 hs_to_clk_3.sg13_lv_nmos_2HGZLP_0.G CKA1_N VSS rppd l=4.25u w=1u
X2642 cml_tlatch_58.xmux.xn.S1 cml_tlatch_58.INN MOT28_P VSS sg13_lv_nmos ad=63.19999f pd=0.74u as=0.1082p ps=1.34u w=0.26u l=0.38u
X2643 cml_tlatch_39.INN interco_bi_19.INP cml_tlatch_23.xmux.xn.S1 VSS sg13_lv_nmos ad=63.19999f pd=0.74u as=0.1082p ps=1.34u w=0.26u l=0.38u
X2644 cml_tlatch_37.xmux.xp.S1 A1_2_P A1_2_N VSS sg13_lv_nmos ad=56.9f pd=0.74u as=56.9f ps=0.74u w=0.17u l=0.17u
X2645 cml_gate2_9.xrtail.R1 NM1_P cml_gate2_9.sg13_lv_nmos_FTPY57_0.D0 VSS sg13_lv_nmos ad=0.1007p pd=0.91u as=0.1007p ps=0.91u w=0.53u l=0.13u
X2646 cml_tlatch_82.OUTP cml_tlatch_83.OUTN cml_tlatch_82.xmux.xn.S1 VSS sg13_lv_nmos ad=0.1082p pd=1.34u as=63.19999f ps=0.74u w=0.26u l=0.38u
X2647 cml_tlatch_28.xmux.xp.S1 B0_2_N B0_2_P VSS sg13_lv_nmos ad=56.9f pd=0.74u as=56.9f ps=0.74u w=0.17u l=0.17u
X2648 B1_2_N B1_2_P cml_tlatch_33.xmux.xp.S1 VSS sg13_lv_nmos ad=56.9f pd=0.74u as=56.9f ps=0.74u w=0.17u l=0.17u
X2649 cml_tlatch_97.xmux.xp.S1 MOT0_P MOT0_N VSS sg13_lv_nmos ad=56.9f pd=0.74u as=56.9f ps=0.74u w=0.17u l=0.17u
X2650 cml_tlatch_4.xmux.xp.S1 MOT9_P MOT9_N VSS sg13_lv_nmos ad=56.9f pd=0.74u as=56.9f ps=0.74u w=0.17u l=0.17u
X2651 cml_tlatch_16.xmux.xn.S1 CKB0_N cml_tlatch_16.xtail.S1 VSS sg13_lv_nmos ad=89.3f pd=0.85u as=89.3f ps=0.85u w=0.47u l=0.16u
X2652 cml_drvb_6.xrtail.R1 GB3_N CKHB3_P VSS sg13_lv_nmos ad=0.1463p pd=1.15u as=0.2618p ps=2.22u w=0.77u l=0.21u
X2653 cml_tlatch_52.OUTN cml_tlatch_52.OUTP cml_tlatch_52.xmux.xp.S1 VSS sg13_lv_nmos ad=56.9f pd=0.74u as=56.9f ps=0.74u w=0.17u l=0.17u
X2654 cml_tlatch_63.xtail.S1 CKB3_N cml_tlatch_63.xmux.xp.S1 VSS sg13_lv_nmos ad=89.3f pd=0.85u as=89.3f ps=0.85u w=0.47u l=0.16u
X2655 cml_tlatch_67.xmux.xp.S1 cml_tlatch_67.OUTP cml_tlatch_67.OUTN VSS sg13_lv_nmos ad=56.9f pd=0.74u as=56.9f ps=0.74u w=0.17u l=0.17u
X2656 cml_tlatch_51.xtail.S1 CKHA2_N cml_tlatch_51.xmux.xp.S1 VSS sg13_lv_nmos ad=89.3f pd=0.85u as=89.3f ps=0.85u w=0.47u l=0.16u
X2657 cml_tlatch_81.xmux.xp.S1 A2_8_N A2_8_P VSS sg13_lv_nmos ad=56.9f pd=0.74u as=56.9f ps=0.74u w=0.17u l=0.17u
X2658 cml_tlatch_47.OUTP cml_tlatch_47.OUTN cml_tlatch_47.xmux.xp.S1 VSS sg13_lv_nmos ad=56.9f pd=0.74u as=0.1019p ps=1.34u w=0.17u l=0.17u
X2659 cml_tlatch_93.xmux.xp.S1 CKJ_N cml_tlatch_93.xtail.S1 VSS sg13_lv_nmos ad=89.3f pd=0.85u as=89.3f ps=0.85u w=0.47u l=0.16u
X2660 A3_2_N cml_tlatch_54.OUTP cml_tlatch_53.xmux.xn.S1 VSS sg13_lv_nmos ad=63.19999f pd=0.74u as=63.19999f ps=0.74u w=0.26u l=0.38u
X2661 cml_gate2_7.sg13_lv_nmos_FTPY57_0.D0 ENB0_P GB2_N VSS sg13_lv_nmos ad=0.1802p pd=1.74u as=0.1007p ps=0.91u w=0.53u l=0.13u
X2662 cml_tlatch_83.xmux.xp.S1 cml_tlatch_83.OUTN cml_tlatch_83.OUTP VSS sg13_lv_nmos ad=56.9f pd=0.74u as=56.9f ps=0.74u w=0.17u l=0.17u
X2663 cml_tlatch_59.xmux.xn.S1 A3_2_P MOT30_N VSS sg13_lv_nmos ad=63.19999f pd=0.74u as=63.19999f ps=0.74u w=0.26u l=0.38u
X2664 cml_tlatch_3.OUTP cml_tlatch_3.OUTN cml_tlatch_3.xmux.xp.S1 VSS sg13_lv_nmos ad=56.9f pd=0.74u as=0.1019p ps=1.34u w=0.17u l=0.17u
X2665 VSS hs_to_clk_7.sg13_lv_nmos_2HGZLP_0.G VSS VSS sg13_lv_nmos ad=2.071p pd=11.28u as=0 ps=0 w=10.9u l=1.38u
X2666 cml_tlatch_54.OUTP D3_N cml_tlatch_54.xmux.xn.S1 VSS sg13_lv_nmos ad=63.19999f pd=0.74u as=0.1082p ps=1.34u w=0.26u l=0.38u
X2667 hs_to_clk_5.D2 POLN VSS VSS sg13_lv_nmos ad=1.9p pd=10.38u as=1.9p ps=10.38u w=10u l=0.13u
X2668 cml_tlatch_31.xmux.xn.S1 cml_tlatch_35.OUTP A0_2_N VSS sg13_lv_nmos ad=63.19999f pd=0.74u as=63.19999f ps=0.74u w=0.26u l=0.38u
X2669 cml_tlatch_2.xmux.xn.S1 cml_tlatch_3.OUTN A0_8_P VSS sg13_lv_nmos ad=63.19999f pd=0.74u as=63.19999f ps=0.74u w=0.26u l=0.38u
X2670 cml_tlatch_70.xmux.xp.S1 MOT29_N MOT29_P VSS sg13_lv_nmos ad=56.9f pd=0.74u as=56.9f ps=0.74u w=0.17u l=0.17u
X2671 stub_bi_32.BOTP D2_P cml_tlatch_48.xmux.xn.S1 VSS sg13_lv_nmos ad=63.19999f pd=0.74u as=63.19999f ps=0.74u w=0.26u l=0.38u
X2672 cml_tlatch_49.xmux.xp.S1 MOT18_P MOT18_N VSS sg13_lv_nmos ad=56.9f pd=0.74u as=56.9f ps=0.74u w=0.17u l=0.17u
X2673 cml_tlatch_1.xtail.S1 CKB0_N cml_tlatch_1.xmux.xp.S1 VSS sg13_lv_nmos ad=89.3f pd=0.85u as=0.1598p ps=1.62u w=0.47u l=0.16u
X2674 cml_tlatch_80.xmux.xn.S1 stub_bi_55.BOTN stub_bi_49.BOTP VSS sg13_lv_nmos ad=0.1082p pd=1.34u as=63.19999f ps=0.74u w=0.26u l=0.38u
X2675 VDD MOT2_P VSS rppd l=5.17u w=1u
X2676 cml_tlatch_82.xmux.xp.S1 cml_tlatch_82.OUTN cml_tlatch_82.OUTP VSS sg13_lv_nmos ad=56.9f pd=0.74u as=56.9f ps=0.74u w=0.17u l=0.17u
X2677 cml_tlatch_43.xtail.S1 CKB2_N cml_tlatch_43.xmux.xp.S1 VSS sg13_lv_nmos ad=89.3f pd=0.85u as=89.3f ps=0.85u w=0.47u l=0.16u
X2678 VSS POLN cml_tlatch_97.xtail.S1 VSS sg13_lv_nmos ad=1.5637p pd=8.61u as=1.5637p ps=8.61u w=8.23u l=0.13u
X2679 MOT27_P MOT27_N cml_tlatch_69.xmux.xp.S1 VSS sg13_lv_nmos ad=56.9f pd=0.74u as=0.1019p ps=1.34u w=0.17u l=0.17u
X2680 GB2_P ENB0_N cml_gate2_7.sg13_lv_nmos_FTPY57_0.D0 VSS sg13_lv_nmos ad=0.1007p pd=0.91u as=0.1007p ps=0.91u w=0.53u l=0.13u
X2681 MOT1_P MOT1_N cml_tlatch_17.xmux.xp.S1 VSS sg13_lv_nmos ad=56.9f pd=0.74u as=56.9f ps=0.74u w=0.17u l=0.17u
X2682 stub_bi_29.BOTN B1_2_N cml_tlatch_32.xmux.xn.S1 VSS sg13_lv_nmos ad=63.19999f pd=0.74u as=63.19999f ps=0.74u w=0.26u l=0.38u
X2683 cml_tlatch_40.INN cml_tlatch_40.INP cml_tlatch_95.xmux.xp.S1 VSS sg13_lv_nmos ad=56.9f pd=0.74u as=56.9f ps=0.74u w=0.17u l=0.17u
X2684 MOT27_P cml_tlatch_69.INN cml_tlatch_69.xmux.xn.S1 VSS sg13_lv_nmos ad=63.19999f pd=0.74u as=63.19999f ps=0.74u w=0.26u l=0.38u
X2685 cml_tlatch_31.xmux.xp.S1 A0_2_P A0_2_N VSS sg13_lv_nmos ad=0.1019p pd=1.34u as=56.9f ps=0.74u w=0.17u l=0.17u
X2686 MOT26_P MOT26_N cml_tlatch_57.xmux.xp.S1 VSS sg13_lv_nmos ad=56.9f pd=0.74u as=56.9f ps=0.74u w=0.17u l=0.17u
X2687 VSS POLN cml_tlatch_25.xtail.S1 VSS sg13_lv_nmos ad=1.5637p pd=8.61u as=1.5637p ps=8.61u w=8.23u l=0.13u
X2688 cml_tlatch_67.xmux.xp.S1 cml_tlatch_67.OUTP cml_tlatch_67.OUTN VSS sg13_lv_nmos ad=56.9f pd=0.74u as=56.9f ps=0.74u w=0.17u l=0.17u
X2689 cml_gate2_8.xrtail.R1 VSS VSS rppd l=4.86u w=1u
X2690 cml_tlatch_39.xmux.xp.S1 MOT10_N MOT10_P VSS sg13_lv_nmos ad=56.9f pd=0.74u as=56.9f ps=0.74u w=0.17u l=0.17u
X2691 hs_to_clk_0.D2 POLN VSS VSS sg13_lv_nmos ad=1.9p pd=10.38u as=1.9p ps=10.38u w=10u l=0.13u
X2692 cml_tlatch_50.xtail.S1 CKHA2_P cml_tlatch_50.xmux.xn.S1 VSS sg13_lv_nmos ad=89.3f pd=0.85u as=89.3f ps=0.85u w=0.47u l=0.16u
X2693 stub_bi_62.BOTP stub_bi_62.BOTN cml_tlatch_78.xmux.xp.S1 VSS sg13_lv_nmos ad=56.9f pd=0.74u as=56.9f ps=0.74u w=0.17u l=0.17u
X2694 J2_N J1_P cml_tlatch_92.xmux.xn.S1 VSS sg13_lv_nmos ad=63.19999f pd=0.74u as=63.19999f ps=0.74u w=0.26u l=0.38u
X2695 cml_tlatch_85.xtail.S1 CKA3_N cml_tlatch_85.xmux.xn.S1 VSS sg13_lv_nmos ad=89.3f pd=0.85u as=89.3f ps=0.85u w=0.47u l=0.16u
X2696 cml_tlatch_67.OUTP cml_tlatch_67.OUTN cml_tlatch_67.xmux.xp.S1 VSS sg13_lv_nmos ad=56.9f pd=0.74u as=56.9f ps=0.74u w=0.17u l=0.17u
X2697 cml_tlatch_12.xtail.S1 POLN VSS VSS sg13_lv_nmos ad=1.5637p pd=8.61u as=2.7982p ps=17.14u w=8.23u l=0.13u
X2698 GA3_P ENA1_N cml_gate2_5.sg13_lv_nmos_FTPY57_0.D0 VSS sg13_lv_nmos ad=0.1007p pd=0.91u as=0.1802p ps=1.74u w=0.53u l=0.13u
X2699 MOT31_N B3_2_P cml_tlatch_71.xmux.xn.S1 VSS sg13_lv_nmos ad=63.19999f pd=0.74u as=63.19999f ps=0.74u w=0.26u l=0.38u
X2700 cml_tlatch_21.xmux.xn.S1 cml_tlatch_22.OUTP A1_8_N VSS sg13_lv_nmos ad=63.19999f pd=0.74u as=63.19999f ps=0.74u w=0.26u l=0.38u
X2701 cml_tlatch_58.INN cml_tlatch_58.INP cml_tlatch_85.xmux.xp.S1 VSS sg13_lv_nmos ad=56.9f pd=0.74u as=56.9f ps=0.74u w=0.17u l=0.17u
X2702 A1_2_P A1_2_N cml_tlatch_37.xmux.xp.S1 VSS sg13_lv_nmos ad=56.9f pd=0.74u as=56.9f ps=0.74u w=0.17u l=0.17u
X2703 MOT18_N cml_tlatch_83.OUTP cml_tlatch_49.xmux.xn.S1 VSS sg13_lv_nmos ad=63.19999f pd=0.74u as=0.1082p ps=1.34u w=0.26u l=0.38u
X2704 cml_tlatch_3.xmux.xn.S1 CKA0_P cml_tlatch_3.xtail.S1 VSS sg13_lv_nmos ad=89.3f pd=0.85u as=0.1598p ps=1.62u w=0.47u l=0.16u
X2705 cml_tlatch_33.xmux.xp.S1 B1_2_N B1_2_P VSS sg13_lv_nmos ad=56.9f pd=0.74u as=56.9f ps=0.74u w=0.17u l=0.17u
X2706 cml_tlatch_26.xmux.xp.S1 MOT6_P MOT6_N VSS sg13_lv_nmos ad=56.9f pd=0.74u as=56.9f ps=0.74u w=0.17u l=0.17u
X2707 cml_tlatch_67.xtail.S1 CKA3_P cml_tlatch_67.xmux.xn.S1 VSS sg13_lv_nmos ad=89.3f pd=0.85u as=89.3f ps=0.85u w=0.47u l=0.16u
X2708 cml_gate2_8.sg13_lv_nmos_FTPY57_0.D0 J2_P ENB_N VSS sg13_lv_nmos ad=0.1007p pd=0.91u as=0.1007p ps=0.91u w=0.53u l=0.13u
X2709 cml_tlatch_58.xmux.xp.S1 MOT28_N MOT28_P VSS sg13_lv_nmos ad=0.1019p pd=1.34u as=56.9f ps=0.74u w=0.17u l=0.17u
X2710 cml_tlatch_9.xmux.xn.S1 cml_tlatch_99.OUTP cml_tlatch_9.OUTN VSS sg13_lv_nmos ad=63.19999f pd=0.74u as=63.19999f ps=0.74u w=0.26u l=0.38u
X2711 cml_gate2_2.sg13_lv_nmos_FTPY57_0.D0 ENA0_P GA0_N VSS sg13_lv_nmos ad=0.1007p pd=0.91u as=0.1007p ps=0.91u w=0.53u l=0.13u
X2712 cml_tlatch_4.xmux.xn.S1 CKHB1_P cml_tlatch_4.xtail.S1 VSS sg13_lv_nmos ad=89.3f pd=0.85u as=89.3f ps=0.85u w=0.47u l=0.16u
X2713 cml_tlatch_43.xmux.xn.S1 B2_2_P stub_bi_42.BOTP VSS sg13_lv_nmos ad=63.19999f pd=0.74u as=63.19999f ps=0.74u w=0.26u l=0.38u
X2714 cml_tlatch_41.xmux.xp.S1 CKHA1_N cml_tlatch_41.xtail.S1 VSS sg13_lv_nmos ad=89.3f pd=0.85u as=89.3f ps=0.85u w=0.47u l=0.16u
X2715 MOT8_P MOT8_N cml_tlatch_96.xmux.xp.S1 VSS sg13_lv_nmos ad=56.9f pd=0.74u as=56.9f ps=0.74u w=0.17u l=0.17u
X2716 cml_tlatch_85.xtail.S1 CKA3_P cml_tlatch_85.xmux.xp.S1 VSS sg13_lv_nmos ad=89.3f pd=0.85u as=89.3f ps=0.85u w=0.47u l=0.16u
X2717 cml_tlatch_0.xmux.xp.S1 interco_bi_19.INN interco_bi_19.INP VSS sg13_lv_nmos ad=56.9f pd=0.74u as=56.9f ps=0.74u w=0.17u l=0.17u
X2718 cml_tlatch_63.xtail.S1 CKB3_P cml_tlatch_63.xmux.xn.S1 VSS sg13_lv_nmos ad=0.1598p pd=1.62u as=89.3f ps=0.85u w=0.47u l=0.16u
X2719 cml_tlatch_81.xmux.xp.S1 A2_8_N A2_8_P VSS sg13_lv_nmos ad=56.9f pd=0.74u as=56.9f ps=0.74u w=0.17u l=0.17u
X2720 cml_tlatch_42.xmux.xp.S1 cml_tlatch_56.INN cml_tlatch_56.INP VSS sg13_lv_nmos ad=56.9f pd=0.74u as=56.9f ps=0.74u w=0.17u l=0.17u
X2721 cml_tlatch_22.OUTN cml_tlatch_39.INP cml_tlatch_22.xmux.xn.S1 VSS sg13_lv_nmos ad=63.19999f pd=0.74u as=63.19999f ps=0.74u w=0.26u l=0.38u
X2722 cml_tlatch_95.xmux.xp.S1 cml_tlatch_40.INP cml_tlatch_40.INN VSS sg13_lv_nmos ad=0.1019p pd=1.34u as=56.9f ps=0.74u w=0.17u l=0.17u
X2723 B2_8_P B2_8_N cml_tlatch_77.xmux.xp.S1 VSS sg13_lv_nmos ad=56.9f pd=0.74u as=56.9f ps=0.74u w=0.17u l=0.17u
X2724 cml_tlatch_30.OUTP A0_2_N cml_tlatch_30.xmux.xn.S1 VSS sg13_lv_nmos ad=0.1082p pd=1.34u as=63.19999f ps=0.74u w=0.26u l=0.38u
X2725 VSS POLN hs_to_clk_6.D2 VSS sg13_lv_nmos ad=1.9p pd=10.38u as=1.9p ps=10.38u w=10u l=0.13u
X2726 cml_tlatch_99.xmux.xp.S1 CKA0_P cml_tlatch_99.xtail.S1 VSS sg13_lv_nmos ad=0.1598p pd=1.62u as=89.3f ps=0.85u w=0.47u l=0.16u
X2727 cml_tlatch_55.xtail.S1 CKA2_P cml_tlatch_55.xmux.xn.S1 VSS sg13_lv_nmos ad=89.3f pd=0.85u as=89.3f ps=0.85u w=0.47u l=0.16u
X2728 cml_tlatch_30.OUTP A0_2_N cml_tlatch_30.xmux.xn.S1 VSS sg13_lv_nmos ad=63.19999f pd=0.74u as=63.19999f ps=0.74u w=0.26u l=0.38u
X2729 cml_tlatch_13.xtail.S1 CKB1_P cml_tlatch_13.xmux.xn.S1 VSS sg13_lv_nmos ad=0.1598p pd=1.62u as=89.3f ps=0.85u w=0.47u l=0.16u
X2730 B3_8_P cml_tlatch_61.OUTN cml_tlatch_60.xmux.xn.S1 VSS sg13_lv_nmos ad=63.19999f pd=0.74u as=63.19999f ps=0.74u w=0.26u l=0.38u
X2731 cml_tlatch_15.xmux.xp.S1 stub_bi_19.BOTN stub_bi_19.BOTP VSS sg13_lv_nmos ad=56.9f pd=0.74u as=56.9f ps=0.74u w=0.17u l=0.17u
X2732 cml_tlatch_30.xtail.S1 CKA0_P cml_tlatch_30.xmux.xn.S1 VSS sg13_lv_nmos ad=89.3f pd=0.85u as=89.3f ps=0.85u w=0.47u l=0.16u
X2733 cml_tlatch_48.xmux.xp.S1 CKB2_N cml_tlatch_48.xtail.S1 VSS sg13_lv_nmos ad=89.3f pd=0.85u as=89.3f ps=0.85u w=0.47u l=0.16u
X2734 cml_tlatch_2.xmux.xp.S1 CKA0_P cml_tlatch_2.xtail.S1 VSS sg13_lv_nmos ad=89.3f pd=0.85u as=89.3f ps=0.85u w=0.47u l=0.16u
X2735 MOT4_N MOT4_P cml_tlatch_25.xmux.xp.S1 VSS sg13_lv_nmos ad=56.9f pd=0.74u as=56.9f ps=0.74u w=0.17u l=0.17u
X2736 cml_tlatch_91.xmux.xn.S1 J2_P CLK_W_P VSS sg13_lv_nmos ad=63.19999f pd=0.74u as=63.19999f ps=0.74u w=0.26u l=0.38u
X2737 GA2_P ENA1_N cml_gate2_4.sg13_lv_nmos_FTPY57_0.D0 VSS sg13_lv_nmos ad=0.1007p pd=0.91u as=0.1007p ps=0.91u w=0.53u l=0.13u
X2738 cml_tlatch_19.xmux.xn.S1 cml_tlatch_98.OUTN MOT5_P VSS sg13_lv_nmos ad=63.19999f pd=0.74u as=63.19999f ps=0.74u w=0.26u l=0.38u
X2739 MOT26_P MOT26_N cml_tlatch_57.xmux.xp.S1 VSS sg13_lv_nmos ad=56.9f pd=0.74u as=0.1019p ps=1.34u w=0.17u l=0.17u
X2740 cml_tlatch_98.OUTN cml_tlatch_98.OUTP cml_tlatch_98.xmux.xp.S1 VSS sg13_lv_nmos ad=56.9f pd=0.74u as=56.9f ps=0.74u w=0.17u l=0.17u
X2741 cml_tlatch_43.xtail.S1 CKB2_P cml_tlatch_43.xmux.xn.S1 VSS sg13_lv_nmos ad=89.3f pd=0.85u as=89.3f ps=0.85u w=0.47u l=0.16u
X2742 cml_tlatch_62.xtail.S1 CKB3_P cml_tlatch_62.xmux.xp.S1 VSS sg13_lv_nmos ad=89.3f pd=0.85u as=0.1598p ps=1.62u w=0.47u l=0.16u
X2743 cml_tlatch_57.xtail.S1 CKHA3_N cml_tlatch_57.xmux.xp.S1 VSS sg13_lv_nmos ad=89.3f pd=0.85u as=0.1598p ps=1.62u w=0.47u l=0.16u
X2744 VSS POLN cml_tlatch_36.xtail.S1 VSS sg13_lv_nmos ad=2.7982p pd=17.14u as=1.5637p ps=8.61u w=8.23u l=0.13u
X2745 cml_tlatch_52.xtail.S1 CKA3_P cml_tlatch_52.xmux.xn.S1 VSS sg13_lv_nmos ad=89.3f pd=0.85u as=89.3f ps=0.85u w=0.47u l=0.16u
X2746 cml_tlatch_70.xmux.xp.S1 CKHB3_N cml_tlatch_70.xtail.S1 VSS sg13_lv_nmos ad=89.3f pd=0.85u as=89.3f ps=0.85u w=0.47u l=0.16u
X2747 cml_tlatch_71.xmux.xp.S1 MOT31_N MOT31_P VSS sg13_lv_nmos ad=0.1019p pd=1.34u as=56.9f ps=0.74u w=0.17u l=0.17u
X2748 B1_8_N B1_8_P cml_tlatch_12.xmux.xp.S1 VSS sg13_lv_nmos ad=56.9f pd=0.74u as=0.1019p ps=1.34u w=0.17u l=0.17u
X2749 CKHA1_P VDD VSS rppd l=13.09u w=1u
X2750 cml_gate2_5.xrtail.R1 CKB3_P cml_gate2_5.sg13_lv_nmos_FTPY57_0.D0 VSS sg13_lv_nmos ad=0.1007p pd=0.91u as=0.1007p ps=0.91u w=0.53u l=0.13u
X2751 stub_bi_42.BOTP stub_bi_42.BOTN cml_tlatch_43.xmux.xp.S1 VSS sg13_lv_nmos ad=56.9f pd=0.74u as=56.9f ps=0.74u w=0.17u l=0.17u
X2752 cml_tlatch_3.xtail.S1 CKA0_N cml_tlatch_3.xmux.xp.S1 VSS sg13_lv_nmos ad=89.3f pd=0.85u as=89.3f ps=0.85u w=0.47u l=0.16u
X2753 cml_tlatch_51.xmux.xp.S1 CKHA2_N cml_tlatch_51.xtail.S1 VSS sg13_lv_nmos ad=89.3f pd=0.85u as=89.3f ps=0.85u w=0.47u l=0.16u
X2754 MOT12_P cml_tlatch_40.INN cml_tlatch_40.xmux.xn.S1 VSS sg13_lv_nmos ad=63.19999f pd=0.74u as=63.19999f ps=0.74u w=0.26u l=0.38u
X2755 cml_tlatch_3.OUTP cml_tlatch_8.OUTN cml_tlatch_3.xmux.xn.S1 VSS sg13_lv_nmos ad=63.19999f pd=0.74u as=63.19999f ps=0.74u w=0.26u l=0.38u
X2756 cml_tlatch_58.INP cml_tlatch_52.OUTN cml_tlatch_85.xmux.xn.S1 VSS sg13_lv_nmos ad=63.19999f pd=0.74u as=63.19999f ps=0.74u w=0.26u l=0.38u
X2757 cml_tlatch_22.OUTP cml_tlatch_22.OUTN cml_tlatch_22.xmux.xp.S1 VSS sg13_lv_nmos ad=56.9f pd=0.74u as=56.9f ps=0.74u w=0.17u l=0.17u
X2758 cml_tlatch_34.xmux.xp.S1 stub_bi_31.BOTN stub_bi_31.BOTP VSS sg13_lv_nmos ad=56.9f pd=0.74u as=56.9f ps=0.74u w=0.17u l=0.17u
X2759 VSS POLN cml_tlatch_93.xtail.S1 VSS sg13_lv_nmos ad=1.5637p pd=8.61u as=1.5637p ps=8.61u w=8.23u l=0.13u
X2760 cml_tlatch_93.xtail.S1 CKJ_N cml_tlatch_93.xmux.xp.S1 VSS sg13_lv_nmos ad=89.3f pd=0.85u as=89.3f ps=0.85u w=0.47u l=0.16u
X2761 MOT12_P cml_tlatch_40.INN cml_tlatch_40.xmux.xn.S1 VSS sg13_lv_nmos ad=63.19999f pd=0.74u as=63.19999f ps=0.74u w=0.26u l=0.38u
X2762 cml_tlatch_85.xmux.xp.S1 cml_tlatch_58.INN cml_tlatch_58.INP VSS sg13_lv_nmos ad=56.9f pd=0.74u as=56.9f ps=0.74u w=0.17u l=0.17u
X2763 cml_gate2_0.xrtail.R1 CKA1_N GB1_P VSS sg13_lv_nmos ad=0.1007p pd=0.91u as=0.1007p ps=0.91u w=0.53u l=0.13u
X2764 cml_tlatch_29.OUTP D0_N cml_tlatch_29.xmux.xn.S1 VSS sg13_lv_nmos ad=63.19999f pd=0.74u as=63.19999f ps=0.74u w=0.26u l=0.38u
X2765 MOT30_N MOT30_P cml_tlatch_59.xmux.xp.S1 VSS sg13_lv_nmos ad=56.9f pd=0.74u as=56.9f ps=0.74u w=0.17u l=0.17u
X2766 stub_bi_29.BOTN stub_bi_29.BOTP cml_tlatch_32.xmux.xp.S1 VSS sg13_lv_nmos ad=56.9f pd=0.74u as=0.1019p ps=1.34u w=0.17u l=0.17u
X2767 cml_tlatch_11.xmux.xn.S1 CKB0_P cml_tlatch_11.xtail.S1 VSS sg13_lv_nmos ad=89.3f pd=0.85u as=89.3f ps=0.85u w=0.47u l=0.16u
X2768 cml_tlatch_11.xmux.xp.S1 cml_tlatch_11.OUTN cml_tlatch_11.OUTP VSS sg13_lv_nmos ad=56.9f pd=0.74u as=56.9f ps=0.74u w=0.17u l=0.17u
X2769 cml_tlatch_83.xtail.S1 CKA2_P cml_tlatch_83.xmux.xp.S1 VSS sg13_lv_nmos ad=89.3f pd=0.85u as=89.3f ps=0.85u w=0.47u l=0.16u
X2770 cml_tlatch_59.xmux.xp.S1 CKHA3_N cml_tlatch_59.xtail.S1 VSS sg13_lv_nmos ad=89.3f pd=0.85u as=89.3f ps=0.85u w=0.47u l=0.16u
X2771 cml_tlatch_56.xmux.xp.S1 A2_2_P A2_2_N VSS sg13_lv_nmos ad=56.9f pd=0.74u as=56.9f ps=0.74u w=0.17u l=0.17u
X2772 J4_N J4_P cml_tlatch_90.xmux.xp.S1 VSS sg13_lv_nmos ad=56.9f pd=0.74u as=56.9f ps=0.74u w=0.17u l=0.17u
X2773 MOT9_P B1_8_N cml_tlatch_4.xmux.xn.S1 VSS sg13_lv_nmos ad=63.19999f pd=0.74u as=63.19999f ps=0.74u w=0.26u l=0.38u
X2774 cml_tlatch_94.xmux.xp.S1 cml_tlatch_6.INN cml_tlatch_6.INP VSS sg13_lv_nmos ad=56.9f pd=0.74u as=56.9f ps=0.74u w=0.17u l=0.17u
X2775 B0_8_N cml_tlatch_11.OUTP cml_tlatch_10.xmux.xn.S1 VSS sg13_lv_nmos ad=63.19999f pd=0.74u as=63.19999f ps=0.74u w=0.26u l=0.38u
X2776 cml_tlatch_27.xmux.xp.S1 cml_tlatch_27.OUTN cml_tlatch_27.OUTP VSS sg13_lv_nmos ad=56.9f pd=0.74u as=56.9f ps=0.74u w=0.17u l=0.17u
X2777 cml_tlatch_40.xmux.xn.S1 cml_tlatch_40.INP MOT12_N VSS sg13_lv_nmos ad=63.19999f pd=0.74u as=63.19999f ps=0.74u w=0.26u l=0.38u
X2778 cml_tlatch_27.OUTN cml_tlatch_27.OUTP cml_tlatch_27.xmux.xp.S1 VSS sg13_lv_nmos ad=56.9f pd=0.74u as=56.9f ps=0.74u w=0.17u l=0.17u
X2779 MOT2_P cml_tlatch_8.OUTN cml_tlatch_24.xmux.xn.S1 VSS sg13_lv_nmos ad=63.19999f pd=0.74u as=63.19999f ps=0.74u w=0.26u l=0.38u
X2780 A1_2_P cml_tlatch_38.OUTN cml_tlatch_37.xmux.xn.S1 VSS sg13_lv_nmos ad=63.19999f pd=0.74u as=63.19999f ps=0.74u w=0.26u l=0.38u
X2781 cml_tlatch_33.xmux.xp.S1 B1_2_N B1_2_P VSS sg13_lv_nmos ad=56.9f pd=0.74u as=56.9f ps=0.74u w=0.17u l=0.17u
X2782 cml_gate2_6.xrtail.R1 CKA3_N GB3_P VSS sg13_lv_nmos ad=0.1007p pd=0.91u as=0.1007p ps=0.91u w=0.53u l=0.13u
X2783 MOT29_N VDD VSS rppd l=5.17u w=1u
X2784 cml_tlatch_3.xtail.S1 POLN VSS VSS sg13_lv_nmos ad=1.5637p pd=8.61u as=1.5637p ps=8.61u w=8.23u l=0.13u
X2785 B1_8_N B1_8_P cml_tlatch_12.xmux.xp.S1 VSS sg13_lv_nmos ad=56.9f pd=0.74u as=56.9f ps=0.74u w=0.17u l=0.17u
X2786 cml_tlatch_66.xmux.xp.S1 cml_tlatch_57.INN cml_tlatch_57.INP VSS sg13_lv_nmos ad=0.1019p pd=1.34u as=56.9f ps=0.74u w=0.17u l=0.17u
X2787 cml_tlatch_35.OUTN cml_tlatch_35.OUTP cml_tlatch_35.xmux.xp.S1 VSS sg13_lv_nmos ad=56.9f pd=0.74u as=56.9f ps=0.74u w=0.17u l=0.17u
X2788 J2_P J2_N cml_tlatch_92.xmux.xp.S1 VSS sg13_lv_nmos ad=56.9f pd=0.74u as=56.9f ps=0.74u w=0.17u l=0.17u
X2789 cml_tlatch_83.INN cml_tlatch_83.INP cml_tlatch_72.xmux.xp.S1 VSS sg13_lv_nmos ad=56.9f pd=0.74u as=56.9f ps=0.74u w=0.17u l=0.17u
X2790 cml_tlatch_42.xmux.xn.S1 CKA2_P cml_tlatch_42.xtail.S1 VSS sg13_lv_nmos ad=89.3f pd=0.85u as=89.3f ps=0.85u w=0.47u l=0.16u
X2791 cml_tlatch_91.xtail.S1 CKJ_N cml_tlatch_91.xmux.xp.S1 VSS sg13_lv_nmos ad=89.3f pd=0.85u as=89.3f ps=0.85u w=0.47u l=0.16u
X2792 cml_tlatch_2.xmux.xp.S1 A0_8_P A0_8_N VSS sg13_lv_nmos ad=56.9f pd=0.74u as=56.9f ps=0.74u w=0.17u l=0.17u
X2793 cml_tlatch_61.xmux.xn.S1 cml_tlatch_69.INN cml_tlatch_61.OUTP VSS sg13_lv_nmos ad=63.19999f pd=0.74u as=63.19999f ps=0.74u w=0.26u l=0.38u
X2794 cml_tlatch_20.xtail.S1 CKHB0_P cml_tlatch_20.xmux.xn.S1 VSS sg13_lv_nmos ad=89.3f pd=0.85u as=89.3f ps=0.85u w=0.47u l=0.16u
X2795 MOT17_N MOT17_P cml_tlatch_73.xmux.xp.S1 VSS sg13_lv_nmos ad=56.9f pd=0.74u as=56.9f ps=0.74u w=0.17u l=0.17u
X2796 stub_bi_32.BOTN D2_N cml_tlatch_48.xmux.xn.S1 VSS sg13_lv_nmos ad=63.19999f pd=0.74u as=63.19999f ps=0.74u w=0.26u l=0.38u
X2797 MOT7_N B0_2_P cml_tlatch_20.xmux.xn.S1 VSS sg13_lv_nmos ad=63.19999f pd=0.74u as=63.19999f ps=0.74u w=0.26u l=0.38u
X2798 cml_gate2_2.sg13_lv_nmos_FTPY57_0.D0 ENA0_N GA0_P VSS sg13_lv_nmos ad=0.1007p pd=0.91u as=0.1007p ps=0.91u w=0.53u l=0.13u
X2799 stub_bi_29.BOTN stub_bi_29.BOTP cml_tlatch_32.xmux.xp.S1 VSS sg13_lv_nmos ad=56.9f pd=0.74u as=56.9f ps=0.74u w=0.17u l=0.17u
X2800 cml_tlatch_94.xmux.xn.S1 stub_bi_29.BOTN cml_tlatch_6.INN VSS sg13_lv_nmos ad=0.1082p pd=1.34u as=63.19999f ps=0.74u w=0.26u l=0.38u
X2801 cml_tlatch_1.OUTN cml_tlatch_1.OUTP cml_tlatch_1.xmux.xp.S1 VSS sg13_lv_nmos ad=56.9f pd=0.74u as=56.9f ps=0.74u w=0.17u l=0.17u
X2802 cml_tlatch_0.xtail.S1 CKA1_N cml_tlatch_0.xmux.xp.S1 VSS sg13_lv_nmos ad=89.3f pd=0.85u as=89.3f ps=0.85u w=0.47u l=0.16u
X2803 cml_tlatch_66.xtail.S1 CKA3_N cml_tlatch_66.xmux.xn.S1 VSS sg13_lv_nmos ad=89.3f pd=0.85u as=89.3f ps=0.85u w=0.47u l=0.16u
X2804 ENB_P NS1_N cml_gate2_8.xrtail.R1 VSS sg13_lv_nmos ad=0.1007p pd=0.91u as=0.1007p ps=0.91u w=0.53u l=0.13u
X2805 cml_tlatch_65.xmux.xp.S1 cml_tlatch_65.OUTN cml_tlatch_65.OUTP VSS sg13_lv_nmos ad=56.9f pd=0.74u as=56.9f ps=0.74u w=0.17u l=0.17u
X2806 cml_tlatch_50.xmux.xp.S1 CKHA2_N cml_tlatch_50.xtail.S1 VSS sg13_lv_nmos ad=89.3f pd=0.85u as=0.1598p ps=1.62u w=0.47u l=0.16u
X2807 cml_tlatch_48.xmux.xn.S1 CKB2_P cml_tlatch_48.xtail.S1 VSS sg13_lv_nmos ad=89.3f pd=0.85u as=89.3f ps=0.85u w=0.47u l=0.16u
X2808 cml_tlatch_3.xmux.xp.S1 cml_tlatch_3.OUTP cml_tlatch_3.OUTN VSS sg13_lv_nmos ad=56.9f pd=0.74u as=56.9f ps=0.74u w=0.17u l=0.17u
X2809 B3_8_N B3_8_P cml_tlatch_60.xmux.xp.S1 VSS sg13_lv_nmos ad=56.9f pd=0.74u as=56.9f ps=0.74u w=0.17u l=0.17u
X2810 MOT6_P MOT6_N cml_tlatch_26.xmux.xp.S1 VSS sg13_lv_nmos ad=56.9f pd=0.74u as=56.9f ps=0.74u w=0.17u l=0.17u
X2811 MOT0_N MOT0_P cml_tlatch_97.xmux.xp.S1 VSS sg13_lv_nmos ad=56.9f pd=0.74u as=0.1019p ps=1.34u w=0.17u l=0.17u
X2812 cml_tlatch_38.OUTP cml_tlatch_38.OUTN cml_tlatch_38.xmux.xp.S1 VSS sg13_lv_nmos ad=56.9f pd=0.74u as=56.9f ps=0.74u w=0.17u l=0.17u
X2813 cml_tlatch_54.xmux.xn.S1 CKA3_P cml_tlatch_54.xtail.S1 VSS sg13_lv_nmos ad=89.3f pd=0.85u as=89.3f ps=0.85u w=0.47u l=0.16u
X2814 cml_tlatch_68.xmux.xp.S1 MOT25_N MOT25_P VSS sg13_lv_nmos ad=0.1019p pd=1.34u as=56.9f ps=0.74u w=0.17u l=0.17u
X2815 cml_tlatch_29.xmux.xp.S1 cml_tlatch_29.OUTN cml_tlatch_29.OUTP VSS sg13_lv_nmos ad=56.9f pd=0.74u as=56.9f ps=0.74u w=0.17u l=0.17u
X2816 cml_tlatch_18.xmux.xn.S1 cml_tlatch_16.OUTP MOT3_N VSS sg13_lv_nmos ad=63.19999f pd=0.74u as=63.19999f ps=0.74u w=0.26u l=0.38u
X2817 GB3_N ENB0_P cml_gate2_6.sg13_lv_nmos_FTPY57_0.D0 VSS sg13_lv_nmos ad=0.1007p pd=0.91u as=0.1802p ps=1.74u w=0.53u l=0.13u
X2818 cml_tlatch_98.OUTN cml_tlatch_98.OUTP cml_tlatch_98.xmux.xp.S1 VSS sg13_lv_nmos ad=56.9f pd=0.74u as=56.9f ps=0.74u w=0.17u l=0.17u
X2819 cml_tlatch_25.xmux.xp.S1 MOT4_N MOT4_P VSS sg13_lv_nmos ad=56.9f pd=0.74u as=56.9f ps=0.74u w=0.17u l=0.17u
X2820 cml_tlatch_18.xmux.xn.S1 cml_tlatch_16.OUTP MOT3_N VSS sg13_lv_nmos ad=63.19999f pd=0.74u as=63.19999f ps=0.74u w=0.26u l=0.38u
X2821 MOT15_P B1_2_N cml_tlatch_7.xmux.xn.S1 VSS sg13_lv_nmos ad=63.19999f pd=0.74u as=63.19999f ps=0.74u w=0.26u l=0.38u
X2822 cml_tlatch_15.xtail.S1 CKB1_N cml_tlatch_15.xmux.xp.S1 VSS sg13_lv_nmos ad=89.3f pd=0.85u as=89.3f ps=0.85u w=0.47u l=0.16u
X2823 cml_tlatch_62.xmux.xp.S1 cml_tlatch_69.INN cml_tlatch_69.INP VSS sg13_lv_nmos ad=56.9f pd=0.74u as=56.9f ps=0.74u w=0.17u l=0.17u
X2824 cml_tlatch_90.xmux.xp.S1 J4_N J4_P VSS sg13_lv_nmos ad=56.9f pd=0.74u as=56.9f ps=0.74u w=0.17u l=0.17u
X2825 VSS POLN cml_tlatch_63.xtail.S1 VSS sg13_lv_nmos ad=2.7982p pd=17.14u as=1.5637p ps=8.61u w=8.23u l=0.13u
X2826 cml_tlatch_50.xmux.xp.S1 MOT20_P MOT20_N VSS sg13_lv_nmos ad=56.9f pd=0.74u as=56.9f ps=0.74u w=0.17u l=0.17u
X2827 cml_tlatch_44.xmux.xp.S1 B2_2_P B2_2_N VSS sg13_lv_nmos ad=56.9f pd=0.74u as=56.9f ps=0.74u w=0.17u l=0.17u
X2828 cml_tlatch_58.xmux.xp.S1 CKHA3_N cml_tlatch_58.xtail.S1 VSS sg13_lv_nmos ad=89.3f pd=0.85u as=89.3f ps=0.85u w=0.47u l=0.16u
X2829 cml_tlatch_17.xmux.xp.S1 MOT1_P MOT1_N VSS sg13_lv_nmos ad=56.9f pd=0.74u as=56.9f ps=0.74u w=0.17u l=0.17u
X2830 cml_tlatch_26.xmux.xn.S1 A0_2_N MOT6_P VSS sg13_lv_nmos ad=63.19999f pd=0.74u as=63.19999f ps=0.74u w=0.26u l=0.38u
X2831 cml_tlatch_72.xtail.S1 CKA2_N cml_tlatch_72.xmux.xp.S1 VSS sg13_lv_nmos ad=89.3f pd=0.85u as=89.3f ps=0.85u w=0.47u l=0.16u
X2832 cml_tlatch_45.OUTP cml_tlatch_45.OUTN cml_tlatch_45.xmux.xp.S1 VSS sg13_lv_nmos ad=56.9f pd=0.74u as=56.9f ps=0.74u w=0.17u l=0.17u
X2833 B0_8_P B0_8_N cml_tlatch_10.xmux.xp.S1 VSS sg13_lv_nmos ad=56.9f pd=0.74u as=56.9f ps=0.74u w=0.17u l=0.17u
X2834 cml_tlatch_69.xmux.xn.S1 CKHB3_P cml_tlatch_69.xtail.S1 VSS sg13_lv_nmos ad=89.3f pd=0.85u as=89.3f ps=0.85u w=0.47u l=0.16u
X2835 cml_tlatch_8.xmux.xn.S1 cml_tlatch_9.OUTP cml_tlatch_8.OUTN VSS sg13_lv_nmos ad=63.19999f pd=0.74u as=63.19999f ps=0.74u w=0.26u l=0.38u
X2836 MOT3_P MOT3_N cml_tlatch_18.xmux.xp.S1 VSS sg13_lv_nmos ad=56.9f pd=0.74u as=56.9f ps=0.74u w=0.17u l=0.17u
X2837 cml_tlatch_38.OUTN D1_P cml_tlatch_38.xmux.xn.S1 VSS sg13_lv_nmos ad=63.19999f pd=0.74u as=63.19999f ps=0.74u w=0.26u l=0.38u
X2838 stub_bi_62.BOTN VDD VSS rppd l=5.17u w=1u
X2839 MOT21_N MOT21_P cml_tlatch_75.xmux.xp.S1 VSS sg13_lv_nmos ad=56.9f pd=0.74u as=56.9f ps=0.74u w=0.17u l=0.17u
X2840 A2_2_P A2_2_N cml_tlatch_56.xmux.xp.S1 VSS sg13_lv_nmos ad=56.9f pd=0.74u as=56.9f ps=0.74u w=0.17u l=0.17u
X2841 cml_tlatch_70.INP cml_tlatch_70.INN cml_tlatch_84.xmux.xp.S1 VSS sg13_lv_nmos ad=56.9f pd=0.74u as=56.9f ps=0.74u w=0.17u l=0.17u
X2842 cml_tlatch_70.xmux.xp.S1 MOT29_P MOT29_N VSS sg13_lv_nmos ad=56.9f pd=0.74u as=56.9f ps=0.74u w=0.17u l=0.17u
X2843 cml_tlatch_67.xmux.xn.S1 cml_tlatch_58.INN cml_tlatch_67.OUTP VSS sg13_lv_nmos ad=63.19999f pd=0.74u as=63.19999f ps=0.74u w=0.26u l=0.38u
X2844 stub_bi_42.BOTN B2_2_N cml_tlatch_43.xmux.xn.S1 VSS sg13_lv_nmos ad=63.19999f pd=0.74u as=63.19999f ps=0.74u w=0.26u l=0.38u
X2845 cml_tlatch_7.xmux.xp.S1 CKHB1_N cml_tlatch_7.xtail.S1 VSS sg13_lv_nmos ad=89.3f pd=0.85u as=89.3f ps=0.85u w=0.47u l=0.16u
X2846 J1_P J1_N cml_tlatch_93.xmux.xp.S1 VSS sg13_lv_nmos ad=56.9f pd=0.74u as=56.9f ps=0.74u w=0.17u l=0.17u
X2847 A0_2_N A0_2_P cml_tlatch_31.xmux.xp.S1 VSS sg13_lv_nmos ad=56.9f pd=0.74u as=56.9f ps=0.74u w=0.17u l=0.17u
X2848 cml_tlatch_0.xmux.xn.S1 cml_tlatch_40.INP interco_bi_19.INN VSS sg13_lv_nmos ad=63.19999f pd=0.74u as=63.19999f ps=0.74u w=0.26u l=0.38u
X2849 cml_gate2_9.sg13_lv_nmos_FTPY57_0.D0 NM1_P cml_gate2_9.xrtail.R1 VSS sg13_lv_nmos ad=0.1007p pd=0.91u as=0.1802p ps=1.74u w=0.53u l=0.13u
X2850 cml_gate2_5.xrtail.R1 CKB3_N GA3_P VSS sg13_lv_nmos ad=0.1007p pd=0.91u as=0.1007p ps=0.91u w=0.53u l=0.13u
X2851 cml_tlatch_11.xmux.xp.S1 cml_tlatch_11.OUTN cml_tlatch_11.OUTP VSS sg13_lv_nmos ad=56.9f pd=0.74u as=56.9f ps=0.74u w=0.17u l=0.17u
X2852 cml_tlatch_5.INN cml_tlatch_5.INP cml_tlatch_14.xmux.xp.S1 VSS sg13_lv_nmos ad=56.9f pd=0.74u as=56.9f ps=0.74u w=0.17u l=0.17u
X2853 cml_tlatch_85.xtail.S1 CKA3_N cml_tlatch_85.xmux.xn.S1 VSS sg13_lv_nmos ad=89.3f pd=0.85u as=89.3f ps=0.85u w=0.47u l=0.16u
X2854 cml_tlatch_94.xmux.xp.S1 cml_tlatch_6.INN cml_tlatch_6.INP VSS sg13_lv_nmos ad=56.9f pd=0.74u as=56.9f ps=0.74u w=0.17u l=0.17u
X2855 MOT21_N stub_bi_55.BOTN cml_tlatch_75.xmux.xn.S1 VSS sg13_lv_nmos ad=63.19999f pd=0.74u as=63.19999f ps=0.74u w=0.26u l=0.38u
X2856 cml_tlatch_41.xmux.xp.S1 MOT14_P MOT14_N VSS sg13_lv_nmos ad=56.9f pd=0.74u as=56.9f ps=0.74u w=0.17u l=0.17u
X2857 MOT21_P MOT21_N cml_tlatch_75.xmux.xp.S1 VSS sg13_lv_nmos ad=56.9f pd=0.74u as=56.9f ps=0.74u w=0.17u l=0.17u
X2858 cml_tlatch_24.xmux.xp.S1 MOT2_P MOT2_N VSS sg13_lv_nmos ad=56.9f pd=0.74u as=56.9f ps=0.74u w=0.17u l=0.17u
X2859 cml_gate2_5.sg13_lv_nmos_FTPY57_0.D0 ENA1_N GA3_P VSS sg13_lv_nmos ad=0.1802p pd=1.74u as=0.1007p ps=0.91u w=0.53u l=0.13u
X2860 cml_tlatch_20.xmux.xp.S1 MOT7_N MOT7_P VSS sg13_lv_nmos ad=56.9f pd=0.74u as=56.9f ps=0.74u w=0.17u l=0.17u
X2861 cml_tlatch_54.xmux.xp.S1 cml_tlatch_54.OUTN cml_tlatch_54.OUTP VSS sg13_lv_nmos ad=56.9f pd=0.74u as=56.9f ps=0.74u w=0.17u l=0.17u
X2862 cml_tlatch_64.xmux.xp.S1 A3_8_N A3_8_P VSS sg13_lv_nmos ad=56.9f pd=0.74u as=56.9f ps=0.74u w=0.17u l=0.17u
X2863 cml_tlatch_12.xmux.xn.S1 stub_bi_17.BOTP B1_8_P VSS sg13_lv_nmos ad=63.19999f pd=0.74u as=63.19999f ps=0.74u w=0.26u l=0.38u
X2864 GB2_N ENB0_P cml_gate2_7.sg13_lv_nmos_FTPY57_0.D0 VSS sg13_lv_nmos ad=0.1007p pd=0.91u as=0.1007p ps=0.91u w=0.53u l=0.13u
X2865 cml_tlatch_38.xmux.xp.S1 CKA1_N cml_tlatch_38.xtail.S1 VSS sg13_lv_nmos ad=89.3f pd=0.85u as=89.3f ps=0.85u w=0.47u l=0.16u
X2866 cml_tlatch_84.xtail.S1 CKB3_N cml_tlatch_84.xmux.xn.S1 VSS sg13_lv_nmos ad=0.1598p pd=1.62u as=89.3f ps=0.85u w=0.47u l=0.16u
X2867 cml_gate2_3.sg13_lv_nmos_FTPY57_0.D0 ENA0_P GA1_N VSS sg13_lv_nmos ad=0.1007p pd=0.91u as=0.1007p ps=0.91u w=0.53u l=0.13u
X2868 cml_tlatch_83.INN cml_tlatch_83.INP cml_tlatch_72.xmux.xp.S1 VSS sg13_lv_nmos ad=56.9f pd=0.74u as=56.9f ps=0.74u w=0.17u l=0.17u
X2869 stub_bi_17.BOTN stub_bi_17.BOTP cml_tlatch_13.xmux.xp.S1 VSS sg13_lv_nmos ad=56.9f pd=0.74u as=56.9f ps=0.74u w=0.17u l=0.17u
X2870 cml_tlatch_57.xtail.S1 CKHA3_P cml_tlatch_57.xmux.xn.S1 VSS sg13_lv_nmos ad=89.3f pd=0.85u as=89.3f ps=0.85u w=0.47u l=0.16u
X2871 cml_tlatch_80.xmux.xp.S1 stub_bi_49.BOTN stub_bi_49.BOTP VSS sg13_lv_nmos ad=56.9f pd=0.74u as=56.9f ps=0.74u w=0.17u l=0.17u
X2872 cml_tlatch_69.INN cml_tlatch_69.INP cml_tlatch_62.xmux.xp.S1 VSS sg13_lv_nmos ad=56.9f pd=0.74u as=56.9f ps=0.74u w=0.17u l=0.17u
X2873 cml_tlatch_60.xmux.xn.S1 CKB3_N cml_tlatch_60.xtail.S1 VSS sg13_lv_nmos ad=89.3f pd=0.85u as=89.3f ps=0.85u w=0.47u l=0.16u
X2874 cml_tlatch_54.xtail.S1 POLN VSS VSS sg13_lv_nmos ad=1.5637p pd=8.61u as=1.5637p ps=8.61u w=8.23u l=0.13u
X2875 B0_8_N B0_8_P cml_tlatch_10.xmux.xp.S1 VSS sg13_lv_nmos ad=56.9f pd=0.74u as=0.1019p ps=1.34u w=0.17u l=0.17u
X2876 cml_tlatch_58.xmux.xp.S1 MOT28_P MOT28_N VSS sg13_lv_nmos ad=56.9f pd=0.74u as=56.9f ps=0.74u w=0.17u l=0.17u
X2877 cml_tlatch_42.xmux.xp.S1 CKA2_N cml_tlatch_42.xtail.S1 VSS sg13_lv_nmos ad=0.1598p pd=1.62u as=89.3f ps=0.85u w=0.47u l=0.16u
X2878 MOT17_N MOT17_P cml_tlatch_73.xmux.xp.S1 VSS sg13_lv_nmos ad=56.9f pd=0.74u as=56.9f ps=0.74u w=0.17u l=0.17u
X2879 cml_tlatch_68.xmux.xp.S1 MOT25_P MOT25_N VSS sg13_lv_nmos ad=56.9f pd=0.74u as=56.9f ps=0.74u w=0.17u l=0.17u
X2880 cml_tlatch_11.xtail.S1 CKB0_P cml_tlatch_11.xmux.xn.S1 VSS sg13_lv_nmos ad=89.3f pd=0.85u as=0.1598p ps=1.62u w=0.47u l=0.16u
X2881 cml_tlatch_78.xmux.xn.S1 stub_bi_63.BOTN stub_bi_62.BOTP VSS sg13_lv_nmos ad=63.19999f pd=0.74u as=0.1082p ps=1.34u w=0.26u l=0.38u
X2882 VSS POLN cml_tlatch_81.xtail.S1 VSS sg13_lv_nmos ad=1.5637p pd=8.61u as=1.5637p ps=8.61u w=8.23u l=0.13u
X2883 cml_tlatch_81.xtail.S1 CKA2_P cml_tlatch_81.xmux.xp.S1 VSS sg13_lv_nmos ad=89.3f pd=0.85u as=89.3f ps=0.85u w=0.47u l=0.16u
X2884 cml_tlatch_98.xtail.S1 CKB0_N cml_tlatch_98.xmux.xn.S1 VSS sg13_lv_nmos ad=89.3f pd=0.85u as=89.3f ps=0.85u w=0.47u l=0.16u
X2885 B0_2_P B0_2_N cml_tlatch_28.xmux.xp.S1 VSS sg13_lv_nmos ad=56.9f pd=0.74u as=56.9f ps=0.74u w=0.17u l=0.17u
X2886 cml_tlatch_78.xmux.xp.S1 CKB2_N cml_tlatch_78.xtail.S1 VSS sg13_lv_nmos ad=89.3f pd=0.85u as=89.3f ps=0.85u w=0.47u l=0.16u
X2887 cml_tlatch_13.xtail.S1 CKB1_P cml_tlatch_13.xmux.xn.S1 VSS sg13_lv_nmos ad=89.3f pd=0.85u as=89.3f ps=0.85u w=0.47u l=0.16u
X2888 cml_drv_3.xrtail.R1 ENA_P ENA0_N VSS sg13_lv_nmos ad=56.2f pd=0.74u as=56.2f ps=0.74u w=0.16u l=0.19u
X2889 cml_tlatch_81.xmux.xp.S1 A2_8_P A2_8_N VSS sg13_lv_nmos ad=56.9f pd=0.74u as=56.9f ps=0.74u w=0.17u l=0.17u
X2890 MOT0_N MOT0_P cml_tlatch_97.xmux.xp.S1 VSS sg13_lv_nmos ad=56.9f pd=0.74u as=56.9f ps=0.74u w=0.17u l=0.17u
X2891 cml_tlatch_89.OUTN cml_tlatch_89.OUTP cml_tlatch_89.xmux.xp.S1 VSS sg13_lv_nmos ad=56.9f pd=0.74u as=56.9f ps=0.74u w=0.17u l=0.17u
X2892 cml_tlatch_99.xmux.xp.S1 cml_tlatch_99.OUTN cml_tlatch_99.OUTP VSS sg13_lv_nmos ad=56.9f pd=0.74u as=56.9f ps=0.74u w=0.17u l=0.17u
X2893 cml_tlatch_52.xmux.xp.S1 cml_tlatch_52.OUTP cml_tlatch_52.OUTN VSS sg13_lv_nmos ad=56.9f pd=0.74u as=56.9f ps=0.74u w=0.17u l=0.17u
X2894 MOT31_P VDD VSS rppd l=5.17u w=1u
X2895 cml_tlatch_36.xmux.xn.S1 A1_2_P cml_tlatch_95.INN VSS sg13_lv_nmos ad=63.19999f pd=0.74u as=63.19999f ps=0.74u w=0.26u l=0.38u
X2896 cml_tlatch_62.xmux.xp.S1 cml_tlatch_69.INP cml_tlatch_69.INN VSS sg13_lv_nmos ad=56.9f pd=0.74u as=56.9f ps=0.74u w=0.17u l=0.17u
X2897 A1_2_N A1_2_P cml_tlatch_37.xmux.xp.S1 VSS sg13_lv_nmos ad=56.9f pd=0.74u as=56.9f ps=0.74u w=0.17u l=0.17u
X2898 cml_tlatch_77.xtail.S1 CKB2_P cml_tlatch_77.xmux.xp.S1 VSS sg13_lv_nmos ad=89.3f pd=0.85u as=89.3f ps=0.85u w=0.47u l=0.16u
X2899 A0_2_P cml_tlatch_35.OUTN cml_tlatch_31.xmux.xn.S1 VSS sg13_lv_nmos ad=0.1082p pd=1.34u as=63.19999f ps=0.74u w=0.26u l=0.38u
X2900 MOT2_P MOT2_N cml_tlatch_24.xmux.xp.S1 VSS sg13_lv_nmos ad=56.9f pd=0.74u as=56.9f ps=0.74u w=0.17u l=0.17u
X2901 cml_tlatch_55.xmux.xp.S1 cml_tlatch_89.INN cml_tlatch_89.INP VSS sg13_lv_nmos ad=56.9f pd=0.74u as=56.9f ps=0.74u w=0.17u l=0.17u
X2902 cml_tlatch_30.xmux.xp.S1 CKA0_N cml_tlatch_30.xtail.S1 VSS sg13_lv_nmos ad=0.1598p pd=1.62u as=89.3f ps=0.85u w=0.47u l=0.16u
X2903 cml_tlatch_91.xmux.xp.S1 CKJ_N cml_tlatch_91.xtail.S1 VSS sg13_lv_nmos ad=89.3f pd=0.85u as=89.3f ps=0.85u w=0.47u l=0.16u
X2904 cml_gate2_4.sg13_lv_nmos_FTPY57_0.D0 CKB2_P cml_gate2_4.xrtail.R1 VSS sg13_lv_nmos ad=0.1007p pd=0.91u as=0.1007p ps=0.91u w=0.53u l=0.13u
X2905 cml_tlatch_29.OUTP D0_N cml_tlatch_29.xmux.xn.S1 VSS sg13_lv_nmos ad=63.19999f pd=0.74u as=63.19999f ps=0.74u w=0.26u l=0.38u
X2906 A2_8_P cml_tlatch_82.OUTN cml_tlatch_81.xmux.xn.S1 VSS sg13_lv_nmos ad=63.19999f pd=0.74u as=63.19999f ps=0.74u w=0.26u l=0.38u
X2907 MOT29_P MOT29_N cml_tlatch_70.xmux.xp.S1 VSS sg13_lv_nmos ad=56.9f pd=0.74u as=56.9f ps=0.74u w=0.17u l=0.17u
X2908 MOT18_N MOT18_P cml_tlatch_49.xmux.xp.S1 VSS sg13_lv_nmos ad=56.9f pd=0.74u as=56.9f ps=0.74u w=0.17u l=0.17u
X2909 A0_2_P cml_tlatch_35.OUTN cml_tlatch_31.xmux.xn.S1 VSS sg13_lv_nmos ad=63.19999f pd=0.74u as=63.19999f ps=0.74u w=0.26u l=0.38u
X2910 cml_tlatch_20.xmux.xn.S1 CKHB0_P cml_tlatch_20.xtail.S1 VSS sg13_lv_nmos ad=89.3f pd=0.85u as=89.3f ps=0.85u w=0.47u l=0.16u
X2911 cml_tlatch_14.xmux.xn.S1 stub_bi_19.BOTP cml_tlatch_5.INP VSS sg13_lv_nmos ad=63.19999f pd=0.74u as=63.19999f ps=0.74u w=0.26u l=0.38u
X2912 cml_tlatch_73.xmux.xp.S1 CKHB2_N cml_tlatch_73.xtail.S1 VSS sg13_lv_nmos ad=89.3f pd=0.85u as=0.1598p ps=1.62u w=0.47u l=0.16u
X2913 cml_tlatch_10.xtail.S1 CKB0_P cml_tlatch_10.xmux.xp.S1 VSS sg13_lv_nmos ad=89.3f pd=0.85u as=89.3f ps=0.85u w=0.47u l=0.16u
X2914 B0_8_N B0_8_P cml_tlatch_10.xmux.xp.S1 VSS sg13_lv_nmos ad=56.9f pd=0.74u as=56.9f ps=0.74u w=0.17u l=0.17u
X2915 cml_tlatch_9.xtail.S1 CKA0_P cml_tlatch_9.xmux.xn.S1 VSS sg13_lv_nmos ad=89.3f pd=0.85u as=89.3f ps=0.85u w=0.47u l=0.16u
X2916 cml_tlatch_31.xtail.S1 CKA0_N cml_tlatch_31.xmux.xn.S1 VSS sg13_lv_nmos ad=89.3f pd=0.85u as=89.3f ps=0.85u w=0.47u l=0.16u
X2917 cml_tlatch_91.xmux.xp.S1 CLK_W_N CLK_W_P VSS sg13_lv_nmos ad=56.9f pd=0.74u as=56.9f ps=0.74u w=0.17u l=0.17u
X2918 cml_tlatch_14.xmux.xn.S1 stub_bi_19.BOTP cml_tlatch_5.INP VSS sg13_lv_nmos ad=63.19999f pd=0.74u as=63.19999f ps=0.74u w=0.26u l=0.38u
X2919 cml_tlatch_87.xmux.xp.S1 MOT16_N MOT16_P VSS sg13_lv_nmos ad=56.9f pd=0.74u as=56.9f ps=0.74u w=0.17u l=0.17u
X2920 cml_tlatch_6.xmux.xp.S1 MOT13_N MOT13_P VSS sg13_lv_nmos ad=56.9f pd=0.74u as=56.9f ps=0.74u w=0.17u l=0.17u
X2921 cml_tlatch_68.xmux.xn.S1 B3_8_P MOT25_N VSS sg13_lv_nmos ad=0.1082p pd=1.34u as=63.19999f ps=0.74u w=0.26u l=0.38u
X2922 cml_tlatch_44.xmux.xp.S1 B2_2_N B2_2_P VSS sg13_lv_nmos ad=0.1019p pd=1.34u as=56.9f ps=0.74u w=0.17u l=0.17u
X2923 VSS POLN cml_tlatch_28.xtail.S1 VSS sg13_lv_nmos ad=2.7982p pd=17.14u as=1.5637p ps=8.61u w=8.23u l=0.13u
X2924 cml_tlatch_40.xmux.xn.S1 CKHA1_P cml_tlatch_40.xtail.S1 VSS sg13_lv_nmos ad=89.3f pd=0.85u as=89.3f ps=0.85u w=0.47u l=0.16u
X2925 cml_tlatch_17.xmux.xp.S1 MOT1_N MOT1_P VSS sg13_lv_nmos ad=56.9f pd=0.74u as=56.9f ps=0.74u w=0.17u l=0.17u
X2926 stub_bi_31.BOTN stub_bi_31.BOTP cml_tlatch_34.xmux.xp.S1 VSS sg13_lv_nmos ad=56.9f pd=0.74u as=56.9f ps=0.74u w=0.17u l=0.17u
X2927 GA0_N ENA0_P cml_gate2_2.sg13_lv_nmos_FTPY57_0.D0 VSS sg13_lv_nmos ad=0.1007p pd=0.91u as=0.1802p ps=1.74u w=0.53u l=0.13u
X2928 A0_2_N A0_2_P cml_tlatch_31.xmux.xp.S1 VSS sg13_lv_nmos ad=56.9f pd=0.74u as=56.9f ps=0.74u w=0.17u l=0.17u
X2929 cml_tlatch_46.xmux.xn.S1 CKB3_N cml_tlatch_46.xtail.S1 VSS sg13_lv_nmos ad=89.3f pd=0.85u as=89.3f ps=0.85u w=0.47u l=0.16u
X2930 cml_tlatch_65.xtail.S1 CKA3_P cml_tlatch_65.xmux.xn.S1 VSS sg13_lv_nmos ad=89.3f pd=0.85u as=89.3f ps=0.85u w=0.47u l=0.16u
X2931 cml_tlatch_6.xmux.xp.S1 CKHB1_N cml_tlatch_6.xtail.S1 VSS sg13_lv_nmos ad=89.3f pd=0.85u as=89.3f ps=0.85u w=0.47u l=0.16u
X2932 cml_tlatch_68.xmux.xp.S1 CKHB3_N cml_tlatch_68.xtail.S1 VSS sg13_lv_nmos ad=89.3f pd=0.85u as=89.3f ps=0.85u w=0.47u l=0.16u
X2933 cml_tlatch_83.xtail.S1 CKA2_P cml_tlatch_83.xmux.xp.S1 VSS sg13_lv_nmos ad=89.3f pd=0.85u as=89.3f ps=0.85u w=0.47u l=0.16u
X2934 cml_gate2_1.sg13_lv_nmos_FTPY57_0.D0 ENB1_P GB0_N VSS sg13_lv_nmos ad=0.1007p pd=0.91u as=0.1007p ps=0.91u w=0.53u l=0.13u
X2935 cml_tlatch_73.xmux.xn.S1 B2_8_N MOT17_P VSS sg13_lv_nmos ad=63.19999f pd=0.74u as=63.19999f ps=0.74u w=0.26u l=0.38u
X2936 cml_tlatch_29.xmux.xp.S1 CKB0_N cml_tlatch_29.xtail.S1 VSS sg13_lv_nmos ad=89.3f pd=0.85u as=89.3f ps=0.85u w=0.47u l=0.16u
X2937 cml_tlatch_8.OUTP cml_tlatch_8.OUTN cml_tlatch_8.xmux.xp.S1 VSS sg13_lv_nmos ad=56.9f pd=0.74u as=56.9f ps=0.74u w=0.17u l=0.17u
X2938 hs_to_clk_1.D2 POLN VSS VSS sg13_lv_nmos ad=3.4p pd=20.68u as=1.9p ps=10.38u w=10u l=0.13u
X2939 cml_tlatch_24.xmux.xp.S1 MOT2_P MOT2_N VSS sg13_lv_nmos ad=56.9f pd=0.74u as=56.9f ps=0.74u w=0.17u l=0.17u
X2940 cml_tlatch_78.xmux.xp.S1 stub_bi_62.BOTN stub_bi_62.BOTP VSS sg13_lv_nmos ad=56.9f pd=0.74u as=56.9f ps=0.74u w=0.17u l=0.17u
X2941 hs_to_clk_7.D2 POLN VSS VSS sg13_lv_nmos ad=1.9p pd=10.38u as=1.9p ps=10.38u w=10u l=0.13u
X2942 cml_tlatch_79.xtail.S1 CKB2_P cml_tlatch_79.xmux.xp.S1 VSS sg13_lv_nmos ad=0.1598p pd=1.62u as=89.3f ps=0.85u w=0.47u l=0.16u
X2943 cml_drvb_4.xrtail.R1 GA2_N CKHA2_P VSS sg13_lv_nmos ad=0.1463p pd=1.15u as=0.2618p ps=2.22u w=0.77u l=0.21u
X2944 MOT23_N MOT23_P cml_tlatch_76.xmux.xp.S1 VSS sg13_lv_nmos ad=56.9f pd=0.74u as=56.9f ps=0.74u w=0.17u l=0.17u
X2945 VDD cml_tlatch_89.INP VSS rppd l=5.17u w=1u
X2946 MOT11_P MOT11_N cml_tlatch_5.xmux.xp.S1 VSS sg13_lv_nmos ad=56.9f pd=0.74u as=56.9f ps=0.74u w=0.17u l=0.17u
X2947 cml_tlatch_99.xmux.xn.S1 cml_tlatch_30.OUTN cml_tlatch_99.OUTP VSS sg13_lv_nmos ad=63.19999f pd=0.74u as=63.19999f ps=0.74u w=0.26u l=0.38u
X2948 MOT8_P A1_8_N cml_tlatch_96.xmux.xn.S1 VSS sg13_lv_nmos ad=63.19999f pd=0.74u as=63.19999f ps=0.74u w=0.26u l=0.38u
X2949 cml_tlatch_21.xtail.S1 POLN VSS VSS sg13_lv_nmos ad=1.5637p pd=8.61u as=1.5637p ps=8.61u w=8.23u l=0.13u
X2950 cml_tlatch_9.xmux.xp.S1 cml_tlatch_9.OUTN cml_tlatch_9.OUTP VSS sg13_lv_nmos ad=56.9f pd=0.74u as=56.9f ps=0.74u w=0.17u l=0.17u
X2951 cml_tlatch_34.xtail.S1 POLN VSS VSS sg13_lv_nmos ad=1.5637p pd=8.61u as=2.7982p ps=17.14u w=8.23u l=0.13u
X2952 MOT6_N A0_2_P cml_tlatch_26.xmux.xn.S1 VSS sg13_lv_nmos ad=63.19999f pd=0.74u as=0.1082p ps=1.34u w=0.26u l=0.38u
X2953 cml_tlatch_50.xmux.xp.S1 MOT20_N MOT20_P VSS sg13_lv_nmos ad=56.9f pd=0.74u as=56.9f ps=0.74u w=0.17u l=0.17u
X2954 MOT28_P MOT28_N cml_tlatch_58.xmux.xp.S1 VSS sg13_lv_nmos ad=56.9f pd=0.74u as=56.9f ps=0.74u w=0.17u l=0.17u
X2955 cml_gate2_9.xrtail.R1 NM1_N ENA_P VSS sg13_lv_nmos ad=0.1007p pd=0.91u as=0.1007p ps=0.91u w=0.53u l=0.13u
X2956 VDD MOT4_P VSS rppd l=5.17u w=1u
X2957 cml_gate2_3.sg13_lv_nmos_FTPY57_0.D0 ENA0_N GA1_P VSS sg13_lv_nmos ad=0.1007p pd=0.91u as=0.1007p ps=0.91u w=0.53u l=0.13u
X2958 cml_tlatch_46.xmux.xp.S1 B3_2_P B3_2_N VSS sg13_lv_nmos ad=56.9f pd=0.74u as=56.9f ps=0.74u w=0.17u l=0.17u
X2959 B0_2_P B0_2_N cml_tlatch_28.xmux.xp.S1 VSS sg13_lv_nmos ad=56.9f pd=0.74u as=56.9f ps=0.74u w=0.17u l=0.17u
X2960 cml_tlatch_30.xmux.xp.S1 cml_tlatch_30.OUTN cml_tlatch_30.OUTP VSS sg13_lv_nmos ad=56.9f pd=0.74u as=56.9f ps=0.74u w=0.17u l=0.17u
X2961 cml_gate2_9.sg13_lv_nmos_FTPY57_0.D0 J1_P ENA_N VSS sg13_lv_nmos ad=0.1802p pd=1.74u as=0.1007p ps=0.91u w=0.53u l=0.13u
X2962 B2_8_N B2_8_P cml_tlatch_77.xmux.xp.S1 VSS sg13_lv_nmos ad=56.9f pd=0.74u as=56.9f ps=0.74u w=0.17u l=0.17u
X2963 MOT29_P MOT29_N cml_tlatch_70.xmux.xp.S1 VSS sg13_lv_nmos ad=56.9f pd=0.74u as=0.1019p ps=1.34u w=0.17u l=0.17u
X2964 cml_tlatch_80.xmux.xp.S1 stub_bi_49.BOTP stub_bi_49.BOTN VSS sg13_lv_nmos ad=56.9f pd=0.74u as=56.9f ps=0.74u w=0.17u l=0.17u
X2965 interco_bi_19.INP interco_bi_19.INN cml_tlatch_0.xmux.xp.S1 VSS sg13_lv_nmos ad=56.9f pd=0.74u as=56.9f ps=0.74u w=0.17u l=0.17u
X2966 A2_8_P A2_8_N cml_tlatch_81.xmux.xp.S1 VSS sg13_lv_nmos ad=56.9f pd=0.74u as=56.9f ps=0.74u w=0.17u l=0.17u
X2967 cml_tlatch_77.xmux.xp.S1 B2_8_N B2_8_P VSS sg13_lv_nmos ad=56.9f pd=0.74u as=56.9f ps=0.74u w=0.17u l=0.17u
X2968 cml_tlatch_40.INN cml_tlatch_40.INP cml_tlatch_95.xmux.xp.S1 VSS sg13_lv_nmos ad=56.9f pd=0.74u as=56.9f ps=0.74u w=0.17u l=0.17u
X2969 cml_tlatch_33.xmux.xp.S1 CKB1_P cml_tlatch_33.xtail.S1 VSS sg13_lv_nmos ad=89.3f pd=0.85u as=89.3f ps=0.85u w=0.47u l=0.16u
X2970 cml_gate2_6.xrtail.R1 CKA3_P cml_gate2_6.sg13_lv_nmos_FTPY57_0.D0 VSS sg13_lv_nmos ad=0.1007p pd=0.91u as=0.1007p ps=0.91u w=0.53u l=0.13u
X2971 cml_tlatch_82.xmux.xn.S1 cml_tlatch_83.OUTN cml_tlatch_82.OUTP VSS sg13_lv_nmos ad=63.19999f pd=0.74u as=63.19999f ps=0.74u w=0.26u l=0.38u
X2972 MOT29_P cml_tlatch_70.INN cml_tlatch_70.xmux.xn.S1 VSS sg13_lv_nmos ad=63.19999f pd=0.74u as=63.19999f ps=0.74u w=0.26u l=0.38u
X2973 cml_tlatch_56.xmux.xp.S1 CKA2_P cml_tlatch_56.xtail.S1 VSS sg13_lv_nmos ad=89.3f pd=0.85u as=89.3f ps=0.85u w=0.47u l=0.16u
X2974 cml_tlatch_15.xtail.S1 CKB1_N cml_tlatch_15.xmux.xp.S1 VSS sg13_lv_nmos ad=89.3f pd=0.85u as=89.3f ps=0.85u w=0.47u l=0.16u
X2975 cml_tlatch_41.xmux.xn.S1 A1_2_P MOT14_N VSS sg13_lv_nmos ad=0.1082p pd=1.34u as=63.19999f ps=0.74u w=0.26u l=0.38u
X2976 cml_tlatch_82.xmux.xn.S1 cml_tlatch_83.OUTN cml_tlatch_82.OUTP VSS sg13_lv_nmos ad=63.19999f pd=0.74u as=63.19999f ps=0.74u w=0.26u l=0.38u
X2977 stub_bi_42.BOTN stub_bi_42.BOTP cml_tlatch_43.xmux.xp.S1 VSS sg13_lv_nmos ad=56.9f pd=0.74u as=56.9f ps=0.74u w=0.17u l=0.17u
X2978 cml_tlatch_38.OUTP D1_N cml_tlatch_38.xmux.xn.S1 VSS sg13_lv_nmos ad=63.19999f pd=0.74u as=63.19999f ps=0.74u w=0.26u l=0.38u
X2979 cml_gate2_6.sg13_lv_nmos_FTPY57_0.D0 ENB0_P GB3_N VSS sg13_lv_nmos ad=0.1802p pd=1.74u as=0.1007p ps=0.91u w=0.53u l=0.13u
X2980 VSS hs_to_clk_7.sg13_lv_nmos_2HGZLP_0.G VSS VSS sg13_lv_nmos ad=2.071p pd=11.28u as=0 ps=0 w=10.9u l=1.38u
X2981 cml_tlatch_83.xmux.xp.S1 cml_tlatch_83.OUTP cml_tlatch_83.OUTN VSS sg13_lv_nmos ad=0.1019p pd=1.34u as=56.9f ps=0.74u w=0.17u l=0.17u
X2982 cml_tlatch_80.xmux.xn.S1 stub_bi_55.BOTP stub_bi_49.BOTN VSS sg13_lv_nmos ad=0.1082p pd=1.34u as=63.19999f ps=0.74u w=0.26u l=0.38u
X2983 cml_tlatch_63.xmux.xn.S1 CKB3_P cml_tlatch_63.xtail.S1 VSS sg13_lv_nmos ad=89.3f pd=0.85u as=89.3f ps=0.85u w=0.47u l=0.16u
X2984 cml_tlatch_53.xmux.xn.S1 cml_tlatch_54.OUTP A3_2_N VSS sg13_lv_nmos ad=63.19999f pd=0.74u as=63.19999f ps=0.74u w=0.26u l=0.38u
X2985 cml_tlatch_88.xmux.xp.S1 stub_bi_55.BOTP stub_bi_55.BOTN VSS sg13_lv_nmos ad=56.9f pd=0.74u as=56.9f ps=0.74u w=0.17u l=0.17u
X2986 J1_N J4_N cml_tlatch_93.xmux.xn.S1 VSS sg13_lv_nmos ad=63.19999f pd=0.74u as=63.19999f ps=0.74u w=0.26u l=0.38u
X2987 cml_tlatch_19.xmux.xn.S1 CKHB0_P cml_tlatch_19.xtail.S1 VSS sg13_lv_nmos ad=89.3f pd=0.85u as=89.3f ps=0.85u w=0.47u l=0.16u
X2988 cml_tlatch_87.xmux.xp.S1 MOT16_N MOT16_P VSS sg13_lv_nmos ad=0.1019p pd=1.34u as=56.9f ps=0.74u w=0.17u l=0.17u
X2989 cml_tlatch_99.xtail.S1 CKA0_P cml_tlatch_99.xmux.xp.S1 VSS sg13_lv_nmos ad=89.3f pd=0.85u as=89.3f ps=0.85u w=0.47u l=0.16u
X2990 MOT24_P MOT24_N cml_tlatch_86.xmux.xp.S1 VSS sg13_lv_nmos ad=56.9f pd=0.74u as=56.9f ps=0.74u w=0.17u l=0.17u
X2991 cml_tlatch_76.xmux.xp.S1 MOT23_N MOT23_P VSS sg13_lv_nmos ad=56.9f pd=0.74u as=56.9f ps=0.74u w=0.17u l=0.17u
X2992 A0_2_N cml_tlatch_35.OUTP cml_tlatch_31.xmux.xn.S1 VSS sg13_lv_nmos ad=63.19999f pd=0.74u as=63.19999f ps=0.74u w=0.26u l=0.38u
X2993 cml_tlatch_13.xmux.xn.S1 CKB1_P cml_tlatch_13.xtail.S1 VSS sg13_lv_nmos ad=89.3f pd=0.85u as=89.3f ps=0.85u w=0.47u l=0.16u
X2994 MOT31_P MOT31_N cml_tlatch_71.xmux.xp.S1 VSS sg13_lv_nmos ad=56.9f pd=0.74u as=56.9f ps=0.74u w=0.17u l=0.17u
X2995 MOT20_N cml_tlatch_89.OUTP cml_tlatch_50.xmux.xn.S1 VSS sg13_lv_nmos ad=63.19999f pd=0.74u as=0.1082p ps=1.34u w=0.26u l=0.38u
X2996 cml_tlatch_48.xmux.xn.S1 D2_P stub_bi_32.BOTP VSS sg13_lv_nmos ad=63.19999f pd=0.74u as=0.1082p ps=1.34u w=0.26u l=0.38u
X2997 GA2_P CKB2_N cml_gate2_4.xrtail.R1 VSS sg13_lv_nmos ad=0.1007p pd=0.91u as=0.1007p ps=0.91u w=0.53u l=0.13u
X2998 cml_tlatch_98.xmux.xp.S1 cml_tlatch_98.OUTN cml_tlatch_98.OUTP VSS sg13_lv_nmos ad=56.9f pd=0.74u as=56.9f ps=0.74u w=0.17u l=0.17u
X2999 cml_tlatch_96.xmux.xp.S1 MOT8_N MOT8_P VSS sg13_lv_nmos ad=56.9f pd=0.74u as=56.9f ps=0.74u w=0.17u l=0.17u
X3000 cml_tlatch_67.OUTN cml_tlatch_67.OUTP cml_tlatch_67.xmux.xp.S1 VSS sg13_lv_nmos ad=56.9f pd=0.74u as=56.9f ps=0.74u w=0.17u l=0.17u
X3001 stub_bi_62.BOTN stub_bi_62.BOTP cml_tlatch_78.xmux.xp.S1 VSS sg13_lv_nmos ad=56.9f pd=0.74u as=56.9f ps=0.74u w=0.17u l=0.17u
X3002 cml_tlatch_7.xmux.xp.S1 MOT15_P MOT15_N VSS sg13_lv_nmos ad=56.9f pd=0.74u as=56.9f ps=0.74u w=0.17u l=0.17u
X3003 cml_tlatch_22.xmux.xp.S1 cml_tlatch_22.OUTN cml_tlatch_22.OUTP VSS sg13_lv_nmos ad=56.9f pd=0.74u as=56.9f ps=0.74u w=0.17u l=0.17u
X3004 stub_bi_49.BOTP stub_bi_55.BOTN cml_tlatch_80.xmux.xn.S1 VSS sg13_lv_nmos ad=63.19999f pd=0.74u as=63.19999f ps=0.74u w=0.26u l=0.38u
X3005 stub_bi_31.BOTP stub_bi_31.BOTN cml_tlatch_34.xmux.xp.S1 VSS sg13_lv_nmos ad=56.9f pd=0.74u as=0.1019p ps=1.34u w=0.17u l=0.17u
X3006 J1_N J1_P cml_tlatch_93.xmux.xp.S1 VSS sg13_lv_nmos ad=56.9f pd=0.74u as=56.9f ps=0.74u w=0.17u l=0.17u
X3007 cml_tlatch_5.xmux.xn.S1 CKHB1_P cml_tlatch_5.xtail.S1 VSS sg13_lv_nmos ad=89.3f pd=0.85u as=89.3f ps=0.85u w=0.47u l=0.16u
X3008 VSS POLN hs_to_clk_4.D2 VSS sg13_lv_nmos ad=1.9p pd=10.38u as=1.9p ps=10.38u w=10u l=0.13u
X3009 cml_tlatch_58.INP cml_tlatch_58.INN cml_tlatch_85.xmux.xp.S1 VSS sg13_lv_nmos ad=56.9f pd=0.74u as=0.1019p ps=1.34u w=0.17u l=0.17u
X3010 MOT22_N MOT22_P cml_tlatch_51.xmux.xp.S1 VSS sg13_lv_nmos ad=56.9f pd=0.74u as=56.9f ps=0.74u w=0.17u l=0.17u
X3011 MOT10_P MOT10_N cml_tlatch_39.xmux.xp.S1 VSS sg13_lv_nmos ad=56.9f pd=0.74u as=56.9f ps=0.74u w=0.17u l=0.17u
X3012 cml_tlatch_59.xmux.xp.S1 MOT30_P MOT30_N VSS sg13_lv_nmos ad=56.9f pd=0.74u as=56.9f ps=0.74u w=0.17u l=0.17u
X3013 cml_tlatch_22.OUTN cml_tlatch_22.OUTP cml_tlatch_22.xmux.xp.S1 VSS sg13_lv_nmos ad=56.9f pd=0.74u as=0.1019p ps=1.34u w=0.17u l=0.17u
X3014 cml_tlatch_22.xmux.xp.S1 CKA1_N cml_tlatch_22.xtail.S1 VSS sg13_lv_nmos ad=89.3f pd=0.85u as=89.3f ps=0.85u w=0.47u l=0.16u
X3015 cml_tlatch_35.xmux.xp.S1 CKA0_N cml_tlatch_35.xtail.S1 VSS sg13_lv_nmos ad=89.3f pd=0.85u as=0.1598p ps=1.62u w=0.47u l=0.16u
X3016 cml_tlatch_90.xtail.S1 CKJ_P cml_tlatch_90.xmux.xp.S1 VSS sg13_lv_nmos ad=89.3f pd=0.85u as=89.3f ps=0.85u w=0.47u l=0.16u
X3017 cml_tlatch_46.xmux.xp.S1 B3_2_P B3_2_N VSS sg13_lv_nmos ad=56.9f pd=0.74u as=56.9f ps=0.74u w=0.17u l=0.17u
X3018 A2_2_N A2_2_P cml_tlatch_56.xmux.xp.S1 VSS sg13_lv_nmos ad=56.9f pd=0.74u as=56.9f ps=0.74u w=0.17u l=0.17u
X3019 cml_tlatch_27.xmux.xp.S1 cml_tlatch_27.OUTP cml_tlatch_27.OUTN VSS sg13_lv_nmos ad=56.9f pd=0.74u as=56.9f ps=0.74u w=0.17u l=0.17u
X3020 cml_tlatch_86.xmux.xp.S1 MOT24_P MOT24_N VSS sg13_lv_nmos ad=0.1019p pd=1.34u as=56.9f ps=0.74u w=0.17u l=0.17u
X3021 cml_tlatch_11.OUTN VDD VSS rppd l=5.17u w=1u
X3022 VDD cml_tlatch_83.OUTN VSS rppd l=5.17u w=1u
X3023 cml_tlatch_82.xmux.xp.S1 CKA2_N cml_tlatch_82.xtail.S1 VSS sg13_lv_nmos ad=0.1598p pd=1.62u as=89.3f ps=0.85u w=0.47u l=0.16u
X3024 cml_tlatch_91.xtail.S1 POLN VSS VSS sg13_lv_nmos ad=1.5637p pd=8.61u as=2.7982p ps=17.14u w=8.23u l=0.13u
X3025 cml_tlatch_92.xmux.xn.S1 J1_P J2_N VSS sg13_lv_nmos ad=63.19999f pd=0.74u as=63.19999f ps=0.74u w=0.26u l=0.38u
X3026 cml_tlatch_71.xmux.xn.S1 B3_2_P MOT31_N VSS sg13_lv_nmos ad=63.19999f pd=0.74u as=63.19999f ps=0.74u w=0.26u l=0.38u
X3027 cml_tlatch_21.xmux.xn.S1 CKA1_N cml_tlatch_21.xtail.S1 VSS sg13_lv_nmos ad=89.3f pd=0.85u as=89.3f ps=0.85u w=0.47u l=0.16u
X3028 A1_8_N cml_tlatch_22.OUTP cml_tlatch_21.xmux.xn.S1 VSS sg13_lv_nmos ad=63.19999f pd=0.74u as=63.19999f ps=0.74u w=0.26u l=0.38u
X3029 cml_tlatch_36.xtail.S1 CKA1_P cml_tlatch_36.xmux.xn.S1 VSS sg13_lv_nmos ad=89.3f pd=0.85u as=89.3f ps=0.85u w=0.47u l=0.16u
X3030 cml_tlatch_71.xmux.xn.S1 B3_2_P MOT31_N VSS sg13_lv_nmos ad=63.19999f pd=0.74u as=63.19999f ps=0.74u w=0.26u l=0.38u
X3031 VDD MOT18_N VSS rppd l=5.17u w=1u
X3032 MOT5_N MOT5_P cml_tlatch_19.xmux.xp.S1 VSS sg13_lv_nmos ad=56.9f pd=0.74u as=56.9f ps=0.74u w=0.17u l=0.17u
X3033 MOT19_N MOT19_P cml_tlatch_74.xmux.xp.S1 VSS sg13_lv_nmos ad=56.9f pd=0.74u as=56.9f ps=0.74u w=0.17u l=0.17u
X3034 cml_tlatch_63.OUTN cml_tlatch_63.OUTP cml_tlatch_63.xmux.xp.S1 VSS sg13_lv_nmos ad=56.9f pd=0.74u as=0.1019p ps=1.34u w=0.17u l=0.17u
X3035 cml_tlatch_43.xmux.xn.S1 B2_2_N stub_bi_42.BOTN VSS sg13_lv_nmos ad=63.19999f pd=0.74u as=63.19999f ps=0.74u w=0.26u l=0.38u
X3036 cml_tlatch_98.xtail.S1 CKB0_N cml_tlatch_98.xmux.xn.S1 VSS sg13_lv_nmos ad=89.3f pd=0.85u as=89.3f ps=0.85u w=0.47u l=0.16u
X3037 A0_8_N A0_8_P cml_tlatch_2.xmux.xp.S1 VSS sg13_lv_nmos ad=56.9f pd=0.74u as=0.1019p ps=1.34u w=0.17u l=0.17u
X3038 cml_tlatch_28.xmux.xp.S1 CKB0_P cml_tlatch_28.xtail.S1 VSS sg13_lv_nmos ad=89.3f pd=0.85u as=89.3f ps=0.85u w=0.47u l=0.16u
X3039 stub_bi_31.BOTP stub_bi_31.BOTN cml_tlatch_34.xmux.xp.S1 VSS sg13_lv_nmos ad=56.9f pd=0.74u as=56.9f ps=0.74u w=0.17u l=0.17u
X3040 cml_tlatch_76.xtail.S1 CKHB2_P cml_tlatch_76.xmux.xn.S1 VSS sg13_lv_nmos ad=89.3f pd=0.85u as=89.3f ps=0.85u w=0.47u l=0.16u
X3041 cml_tlatch_9.OUTN cml_tlatch_99.OUTP cml_tlatch_9.xmux.xn.S1 VSS sg13_lv_nmos ad=63.19999f pd=0.74u as=63.19999f ps=0.74u w=0.26u l=0.38u
X3042 cml_gate2_6.xrtail.R1 VSS VSS rppd l=4.86u w=1u
X3043 cml_tlatch_12.xmux.xn.S1 CKB1_N cml_tlatch_12.xtail.S1 VSS sg13_lv_nmos ad=89.3f pd=0.85u as=89.3f ps=0.85u w=0.47u l=0.16u
X3044 J4_N CLK_W_N cml_tlatch_90.xmux.xn.S1 VSS sg13_lv_nmos ad=63.19999f pd=0.74u as=63.19999f ps=0.74u w=0.26u l=0.38u
X3045 cml_gate2_9.xrtail.R1 NM1_P cml_gate2_9.sg13_lv_nmos_FTPY57_0.D0 VSS sg13_lv_nmos ad=0.1802p pd=1.74u as=0.1007p ps=0.91u w=0.53u l=0.13u
X3046 cml_tlatch_67.xmux.xp.S1 CKA3_N cml_tlatch_67.xtail.S1 VSS sg13_lv_nmos ad=89.3f pd=0.85u as=89.3f ps=0.85u w=0.47u l=0.16u
X3047 MOT27_N cml_tlatch_69.INP cml_tlatch_69.xmux.xn.S1 VSS sg13_lv_nmos ad=63.19999f pd=0.74u as=63.19999f ps=0.74u w=0.26u l=0.38u
X3048 cml_drv_1.xrtail.R1 ENA_N ENA1_P VSS sg13_lv_nmos ad=56.2f pd=0.74u as=56.2f ps=0.74u w=0.16u l=0.19u
X3049 cml_tlatch_3.OUTN cml_tlatch_3.OUTP cml_tlatch_3.xmux.xp.S1 VSS sg13_lv_nmos ad=56.9f pd=0.74u as=56.9f ps=0.74u w=0.17u l=0.17u
X3050 cml_tlatch_60.xmux.xp.S1 B3_8_P B3_8_N VSS sg13_lv_nmos ad=56.9f pd=0.74u as=56.9f ps=0.74u w=0.17u l=0.17u
X3051 cml_tlatch_41.xtail.S1 CKHA1_P cml_tlatch_41.xmux.xn.S1 VSS sg13_lv_nmos ad=89.3f pd=0.85u as=0.1598p ps=1.62u w=0.47u l=0.16u
X3052 cml_tlatch_21.xmux.xp.S1 A1_8_N A1_8_P VSS sg13_lv_nmos ad=56.9f pd=0.74u as=56.9f ps=0.74u w=0.17u l=0.17u
X3053 cml_tlatch_73.xmux.xp.S1 MOT17_N MOT17_P VSS sg13_lv_nmos ad=56.9f pd=0.74u as=56.9f ps=0.74u w=0.17u l=0.17u
X3054 stub_bi_32.BOTN stub_bi_32.BOTP cml_tlatch_48.xmux.xp.S1 VSS sg13_lv_nmos ad=56.9f pd=0.74u as=56.9f ps=0.74u w=0.17u l=0.17u
X3055 GB0_P CKA0_N cml_gate2_1.xrtail.R1 VSS sg13_lv_nmos ad=0.1007p pd=0.91u as=0.1802p ps=1.74u w=0.53u l=0.13u
X3056 cml_tlatch_38.xmux.xp.S1 cml_tlatch_38.OUTN cml_tlatch_38.OUTP VSS sg13_lv_nmos ad=56.9f pd=0.74u as=56.9f ps=0.74u w=0.17u l=0.17u
X3057 MOT25_P MOT25_N cml_tlatch_68.xmux.xp.S1 VSS sg13_lv_nmos ad=56.9f pd=0.74u as=56.9f ps=0.74u w=0.17u l=0.17u
X3058 stub_bi_42.BOTP B2_2_P cml_tlatch_43.xmux.xn.S1 VSS sg13_lv_nmos ad=63.19999f pd=0.74u as=63.19999f ps=0.74u w=0.26u l=0.38u
X3059 cml_tlatch_70.INN cml_tlatch_70.INP cml_tlatch_84.xmux.xp.S1 VSS sg13_lv_nmos ad=56.9f pd=0.74u as=56.9f ps=0.74u w=0.17u l=0.17u
X3060 cml_tlatch_30.xmux.xn.S1 A0_2_P cml_tlatch_30.OUTN VSS sg13_lv_nmos ad=63.19999f pd=0.74u as=63.19999f ps=0.74u w=0.26u l=0.38u
X3061 cml_tlatch_29.OUTP cml_tlatch_29.OUTN cml_tlatch_29.xmux.xp.S1 VSS sg13_lv_nmos ad=56.9f pd=0.74u as=56.9f ps=0.74u w=0.17u l=0.17u
X3062 cml_tlatch_22.xmux.xp.S1 cml_tlatch_22.OUTN cml_tlatch_22.OUTP VSS sg13_lv_nmos ad=56.9f pd=0.74u as=56.9f ps=0.74u w=0.17u l=0.17u
X3063 cml_tlatch_47.OUTN cml_tlatch_47.OUTP cml_tlatch_47.xmux.xp.S1 VSS sg13_lv_nmos ad=56.9f pd=0.74u as=56.9f ps=0.74u w=0.17u l=0.17u
X3064 cml_tlatch_63.xmux.xp.S1 CKB3_N cml_tlatch_63.xtail.S1 VSS sg13_lv_nmos ad=89.3f pd=0.85u as=89.3f ps=0.85u w=0.47u l=0.16u
X3065 cml_tlatch_60.xmux.xn.S1 cml_tlatch_61.OUTN B3_8_P VSS sg13_lv_nmos ad=63.19999f pd=0.74u as=0.1082p ps=1.34u w=0.26u l=0.38u
X3066 cml_tlatch_10.xtail.S1 CKB0_P cml_tlatch_10.xmux.xp.S1 VSS sg13_lv_nmos ad=89.3f pd=0.85u as=89.3f ps=0.85u w=0.47u l=0.16u
X3067 cml_tlatch_30.xmux.xn.S1 A0_2_N cml_tlatch_30.OUTP VSS sg13_lv_nmos ad=63.19999f pd=0.74u as=63.19999f ps=0.74u w=0.26u l=0.38u
X3068 MOT11_P cml_tlatch_5.INN cml_tlatch_5.xmux.xn.S1 VSS sg13_lv_nmos ad=63.19999f pd=0.74u as=63.19999f ps=0.74u w=0.26u l=0.38u
X3069 cml_tlatch_37.xmux.xn.S1 cml_tlatch_38.OUTN A1_2_P VSS sg13_lv_nmos ad=63.19999f pd=0.74u as=63.19999f ps=0.74u w=0.26u l=0.38u
X3070 B3_8_N cml_tlatch_61.OUTP cml_tlatch_60.xmux.xn.S1 VSS sg13_lv_nmos ad=63.19999f pd=0.74u as=63.19999f ps=0.74u w=0.26u l=0.38u
X3071 MOT20_N MOT20_P cml_tlatch_50.xmux.xp.S1 VSS sg13_lv_nmos ad=56.9f pd=0.74u as=56.9f ps=0.74u w=0.17u l=0.17u
X3072 B2_2_N B2_2_P cml_tlatch_44.xmux.xp.S1 VSS sg13_lv_nmos ad=56.9f pd=0.74u as=0.1019p ps=1.34u w=0.17u l=0.17u
X3073 cml_tlatch_45.xmux.xp.S1 cml_tlatch_45.OUTN cml_tlatch_45.OUTP VSS sg13_lv_nmos ad=56.9f pd=0.74u as=56.9f ps=0.74u w=0.17u l=0.17u
X3074 MOT1_N MOT1_P cml_tlatch_17.xmux.xp.S1 VSS sg13_lv_nmos ad=56.9f pd=0.74u as=56.9f ps=0.74u w=0.17u l=0.17u
X3075 cml_tlatch_65.OUTN cml_tlatch_65.OUTP cml_tlatch_65.xmux.xp.S1 VSS sg13_lv_nmos ad=56.9f pd=0.74u as=56.9f ps=0.74u w=0.17u l=0.17u
X3076 cml_tlatch_55.xmux.xp.S1 CKA2_N cml_tlatch_55.xtail.S1 VSS sg13_lv_nmos ad=89.3f pd=0.85u as=89.3f ps=0.85u w=0.47u l=0.16u
X3077 VDD cml_tlatch_40.INP VSS rppd l=5.17u w=1u
X3078 cml_tlatch_97.xtail.S1 CKHA0_N cml_tlatch_97.xmux.xp.S1 VSS sg13_lv_nmos ad=89.3f pd=0.85u as=89.3f ps=0.85u w=0.47u l=0.16u
X3079 VDD MOT6_N VSS rppd l=5.17u w=1u
X3080 cml_tlatch_22.xmux.xp.S1 cml_tlatch_22.OUTN cml_tlatch_22.OUTP VSS sg13_lv_nmos ad=56.9f pd=0.74u as=56.9f ps=0.74u w=0.17u l=0.17u
X3081 cml_tlatch_1.xmux.xn.S1 cml_tlatch_98.OUTN cml_tlatch_1.OUTP VSS sg13_lv_nmos ad=0.1082p pd=1.34u as=63.19999f ps=0.74u w=0.26u l=0.38u
X3082 cml_gate2_0.sg13_lv_nmos_FTPY57_0.D0 ENB1_P GB1_N VSS sg13_lv_nmos ad=0.1007p pd=0.91u as=0.1007p ps=0.91u w=0.53u l=0.13u
X3083 cml_tlatch_37.xmux.xn.S1 CKA1_N cml_tlatch_37.xtail.S1 VSS sg13_lv_nmos ad=89.3f pd=0.85u as=89.3f ps=0.85u w=0.47u l=0.16u
X3084 B3_8_N B3_8_P cml_tlatch_60.xmux.xp.S1 VSS sg13_lv_nmos ad=56.9f pd=0.74u as=56.9f ps=0.74u w=0.17u l=0.17u
X3085 cml_tlatch_29.xmux.xp.S1 CKB0_N cml_tlatch_29.xtail.S1 VSS sg13_lv_nmos ad=89.3f pd=0.85u as=89.3f ps=0.85u w=0.47u l=0.16u
X3086 GB2_P ENB0_N cml_gate2_7.sg13_lv_nmos_FTPY57_0.D0 VSS sg13_lv_nmos ad=0.1007p pd=0.91u as=0.1007p ps=0.91u w=0.53u l=0.13u
X3087 cml_tlatch_94.xmux.xp.S1 cml_tlatch_6.INP cml_tlatch_6.INN VSS sg13_lv_nmos ad=0.1019p pd=1.34u as=56.9f ps=0.74u w=0.17u l=0.17u
X3088 B3_2_P B3_2_N cml_tlatch_46.xmux.xp.S1 VSS sg13_lv_nmos ad=56.9f pd=0.74u as=56.9f ps=0.74u w=0.17u l=0.17u
X3089 cml_tlatch_1.xmux.xn.S1 CKB0_P cml_tlatch_1.xtail.S1 VSS sg13_lv_nmos ad=89.3f pd=0.85u as=89.3f ps=0.85u w=0.47u l=0.16u
X3090 cml_tlatch_56.xmux.xp.S1 A2_2_N A2_2_P VSS sg13_lv_nmos ad=56.9f pd=0.74u as=56.9f ps=0.74u w=0.17u l=0.17u
X3091 cml_tlatch_59.xmux.xp.S1 MOT30_P MOT30_N VSS sg13_lv_nmos ad=56.9f pd=0.74u as=56.9f ps=0.74u w=0.17u l=0.17u
X3092 cml_tlatch_71.xtail.S1 CKHB3_N cml_tlatch_71.xmux.xp.S1 VSS sg13_lv_nmos ad=89.3f pd=0.85u as=89.3f ps=0.85u w=0.47u l=0.16u
X3093 cml_tlatch_43.xmux.xp.S1 CKB2_N cml_tlatch_43.xtail.S1 VSS sg13_lv_nmos ad=89.3f pd=0.85u as=89.3f ps=0.85u w=0.47u l=0.16u
X3094 cml_tlatch_39.INN cml_tlatch_39.INP cml_tlatch_23.xmux.xp.S1 VSS sg13_lv_nmos ad=56.9f pd=0.74u as=56.9f ps=0.74u w=0.17u l=0.17u
X3095 cml_tlatch_85.xmux.xn.S1 cml_tlatch_52.OUTN cml_tlatch_58.INP VSS sg13_lv_nmos ad=63.19999f pd=0.74u as=63.19999f ps=0.74u w=0.26u l=0.38u
X3096 cml_tlatch_14.xmux.xp.S1 cml_tlatch_5.INP cml_tlatch_5.INN VSS sg13_lv_nmos ad=56.9f pd=0.74u as=56.9f ps=0.74u w=0.17u l=0.17u
X3097 cml_tlatch_14.xmux.xp.S1 cml_tlatch_5.INN cml_tlatch_5.INP VSS sg13_lv_nmos ad=56.9f pd=0.74u as=56.9f ps=0.74u w=0.17u l=0.17u
X3098 cml_tlatch_52.xmux.xp.S1 CKA3_N cml_tlatch_52.xtail.S1 VSS sg13_lv_nmos ad=89.3f pd=0.85u as=89.3f ps=0.85u w=0.47u l=0.16u
X3099 cml_tlatch_8.xmux.xp.S1 cml_tlatch_8.OUTP cml_tlatch_8.OUTN VSS sg13_lv_nmos ad=56.9f pd=0.74u as=56.9f ps=0.74u w=0.17u l=0.17u
X3100 cml_tlatch_5.xmux.xp.S1 MOT11_P MOT11_N VSS sg13_lv_nmos ad=56.9f pd=0.74u as=56.9f ps=0.74u w=0.17u l=0.17u
X3101 cml_tlatch_40.xmux.xn.S1 cml_tlatch_40.INN MOT12_P VSS sg13_lv_nmos ad=63.19999f pd=0.74u as=63.19999f ps=0.74u w=0.26u l=0.38u
X3102 cml_tlatch_6.INP cml_tlatch_6.INN cml_tlatch_94.xmux.xp.S1 VSS sg13_lv_nmos ad=56.9f pd=0.74u as=56.9f ps=0.74u w=0.17u l=0.17u
X3103 MOT14_N MOT14_P cml_tlatch_41.xmux.xp.S1 VSS sg13_lv_nmos ad=56.9f pd=0.74u as=56.9f ps=0.74u w=0.17u l=0.17u
X3104 cml_tlatch_3.xmux.xn.S1 cml_tlatch_8.OUTN cml_tlatch_3.OUTP VSS sg13_lv_nmos ad=63.19999f pd=0.74u as=63.19999f ps=0.74u w=0.26u l=0.38u
X3105 cml_tlatch_33.xmux.xn.S1 CKB1_N cml_tlatch_33.xtail.S1 VSS sg13_lv_nmos ad=89.3f pd=0.85u as=89.3f ps=0.85u w=0.47u l=0.16u
X3106 cml_tlatch_45.OUTP cml_tlatch_45.OUTN cml_tlatch_45.xmux.xp.S1 VSS sg13_lv_nmos ad=56.9f pd=0.74u as=56.9f ps=0.74u w=0.17u l=0.17u
X3107 cml_tlatch_29.xmux.xn.S1 D0_N cml_tlatch_29.OUTP VSS sg13_lv_nmos ad=63.19999f pd=0.74u as=63.19999f ps=0.74u w=0.26u l=0.38u
X3108 hs_to_clk_0.D2 POLN VSS VSS sg13_lv_nmos ad=3.4p pd=20.68u as=1.9p ps=10.38u w=10u l=0.13u
X3109 cml_tlatch_63.xmux.xp.S1 cml_tlatch_63.OUTN cml_tlatch_63.OUTP VSS sg13_lv_nmos ad=56.9f pd=0.74u as=56.9f ps=0.74u w=0.17u l=0.17u
X3110 VSS hs_to_clk_0.sg13_lv_nmos_2HGZLP_0.G VSS VSS sg13_lv_nmos ad=2.071p pd=11.28u as=0 ps=0 w=10.9u l=1.38u
X3111 MOT2_N MOT2_P cml_tlatch_24.xmux.xp.S1 VSS sg13_lv_nmos ad=56.9f pd=0.74u as=0.1019p ps=1.34u w=0.17u l=0.17u
X3112 A2_8_N cml_tlatch_82.OUTP cml_tlatch_81.xmux.xn.S1 VSS sg13_lv_nmos ad=0.1082p pd=1.34u as=63.19999f ps=0.74u w=0.26u l=0.38u
X3113 A3_8_P A3_8_N cml_tlatch_64.xmux.xp.S1 VSS sg13_lv_nmos ad=56.9f pd=0.74u as=56.9f ps=0.74u w=0.17u l=0.17u
X3114 GA3_P ENA1_N cml_gate2_5.sg13_lv_nmos_FTPY57_0.D0 VSS sg13_lv_nmos ad=0.1007p pd=0.91u as=0.1007p ps=0.91u w=0.53u l=0.13u
X3115 cml_tlatch_10.xmux.xp.S1 B0_8_N B0_8_P VSS sg13_lv_nmos ad=56.9f pd=0.74u as=56.9f ps=0.74u w=0.17u l=0.17u
X3116 cml_tlatch_12.xmux.xp.S1 B1_8_P B1_8_N VSS sg13_lv_nmos ad=56.9f pd=0.74u as=56.9f ps=0.74u w=0.17u l=0.17u
X3117 cml_tlatch_10.xmux.xn.S1 cml_tlatch_11.OUTP B0_8_N VSS sg13_lv_nmos ad=63.19999f pd=0.74u as=63.19999f ps=0.74u w=0.26u l=0.38u
X3118 cml_tlatch_35.xmux.xp.S1 cml_tlatch_35.OUTP cml_tlatch_35.OUTN VSS sg13_lv_nmos ad=56.9f pd=0.74u as=56.9f ps=0.74u w=0.17u l=0.17u
X3119 cml_tlatch_40.xtail.S1 CKHA1_N cml_tlatch_40.xmux.xp.S1 VSS sg13_lv_nmos ad=89.3f pd=0.85u as=89.3f ps=0.85u w=0.47u l=0.16u
X3120 cml_drv_3.xrtail.R1 ENA_P ENA0_N VSS sg13_lv_nmos ad=56.2f pd=0.74u as=0.1012p ps=1.34u w=0.16u l=0.19u
X3121 cml_tlatch_72.xmux.xp.S1 cml_tlatch_83.INP cml_tlatch_83.INN VSS sg13_lv_nmos ad=56.9f pd=0.74u as=56.9f ps=0.74u w=0.17u l=0.17u
X3122 cml_tlatch_38.xmux.xp.S1 cml_tlatch_38.OUTN cml_tlatch_38.OUTP VSS sg13_lv_nmos ad=56.9f pd=0.74u as=56.9f ps=0.74u w=0.17u l=0.17u
X3123 cml_tlatch_91.xmux.xp.S1 CLK_W_P CLK_W_N VSS sg13_lv_nmos ad=56.9f pd=0.74u as=56.9f ps=0.74u w=0.17u l=0.17u
X3124 cml_tlatch_10.xmux.xn.S1 cml_tlatch_11.OUTP B0_8_N VSS sg13_lv_nmos ad=63.19999f pd=0.74u as=63.19999f ps=0.74u w=0.26u l=0.38u
X3125 cml_gate2_8.sg13_lv_nmos_FTPY57_0.D0 J2_P ENB_N VSS sg13_lv_nmos ad=0.1007p pd=0.91u as=0.1007p ps=0.91u w=0.53u l=0.13u
X3126 MOT28_N MOT28_P cml_tlatch_58.xmux.xp.S1 VSS sg13_lv_nmos ad=56.9f pd=0.74u as=56.9f ps=0.74u w=0.17u l=0.17u
X3127 cml_tlatch_24.xmux.xn.S1 cml_tlatch_8.OUTN MOT2_P VSS sg13_lv_nmos ad=63.19999f pd=0.74u as=63.19999f ps=0.74u w=0.26u l=0.38u
X3128 cml_gate2_7.sg13_lv_nmos_FTPY57_0.D0 CKA2_P cml_gate2_7.xrtail.R1 VSS sg13_lv_nmos ad=0.1007p pd=0.91u as=0.1007p ps=0.91u w=0.53u l=0.13u
X3129 cml_tlatch_73.xmux.xp.S1 MOT17_P MOT17_N VSS sg13_lv_nmos ad=56.9f pd=0.74u as=56.9f ps=0.74u w=0.17u l=0.17u
X3130 cml_tlatch_32.xmux.xp.S1 stub_bi_29.BOTP stub_bi_29.BOTN VSS sg13_lv_nmos ad=56.9f pd=0.74u as=56.9f ps=0.74u w=0.17u l=0.17u
X3131 cml_tlatch_47.xmux.xn.S1 CKB3_P cml_tlatch_47.xtail.S1 VSS sg13_lv_nmos ad=89.3f pd=0.85u as=89.3f ps=0.85u w=0.47u l=0.16u
X3132 cml_tlatch_57.INP cml_tlatch_67.OUTN cml_tlatch_66.xmux.xn.S1 VSS sg13_lv_nmos ad=63.19999f pd=0.74u as=63.19999f ps=0.74u w=0.26u l=0.38u
X3133 MOT5_P MOT5_N cml_tlatch_19.xmux.xp.S1 VSS sg13_lv_nmos ad=56.9f pd=0.74u as=56.9f ps=0.74u w=0.17u l=0.17u
X3134 cml_tlatch_40.xmux.xp.S1 MOT12_P MOT12_N VSS sg13_lv_nmos ad=56.9f pd=0.74u as=56.9f ps=0.74u w=0.17u l=0.17u
X3135 ENB_N J2_P cml_gate2_8.sg13_lv_nmos_FTPY57_0.D0 VSS sg13_lv_nmos ad=0.1007p pd=0.91u as=0.1802p ps=1.74u w=0.53u l=0.13u
X3136 cml_tlatch_84.xmux.xn.S1 CKB3_N cml_tlatch_84.xtail.S1 VSS sg13_lv_nmos ad=89.3f pd=0.85u as=89.3f ps=0.85u w=0.47u l=0.16u
X3137 cml_tlatch_26.xmux.xp.S1 MOT6_N MOT6_P VSS sg13_lv_nmos ad=56.9f pd=0.74u as=56.9f ps=0.74u w=0.17u l=0.17u
X3138 A2_8_N A2_8_P cml_tlatch_81.xmux.xp.S1 VSS sg13_lv_nmos ad=56.9f pd=0.74u as=0.1019p ps=1.34u w=0.17u l=0.17u
X3139 cml_tlatch_97.xmux.xp.S1 MOT0_P MOT0_N VSS sg13_lv_nmos ad=56.9f pd=0.74u as=56.9f ps=0.74u w=0.17u l=0.17u
X3140 cml_tlatch_38.xmux.xp.S1 cml_tlatch_38.OUTN cml_tlatch_38.OUTP VSS sg13_lv_nmos ad=56.9f pd=0.74u as=56.9f ps=0.74u w=0.17u l=0.17u
X3141 VDD ENA_N VSS rppd l=7.42u w=1u
X3142 cml_tlatch_99.OUTP cml_tlatch_99.OUTN cml_tlatch_99.xmux.xp.S1 VSS sg13_lv_nmos ad=56.9f pd=0.74u as=56.9f ps=0.74u w=0.17u l=0.17u
X3143 cml_tlatch_52.OUTN cml_tlatch_52.OUTP cml_tlatch_52.xmux.xp.S1 VSS sg13_lv_nmos ad=56.9f pd=0.74u as=56.9f ps=0.74u w=0.17u l=0.17u
X3144 cml_tlatch_29.OUTP cml_tlatch_29.OUTN cml_tlatch_29.xmux.xp.S1 VSS sg13_lv_nmos ad=56.9f pd=0.74u as=56.9f ps=0.74u w=0.17u l=0.17u
X3145 interco_bi_19.INN cml_tlatch_40.INP cml_tlatch_0.xmux.xn.S1 VSS sg13_lv_nmos ad=0.1082p pd=1.34u as=63.19999f ps=0.74u w=0.26u l=0.38u
X3146 cml_tlatch_61.OUTP cml_tlatch_69.INN cml_tlatch_61.xmux.xn.S1 VSS sg13_lv_nmos ad=63.19999f pd=0.74u as=63.19999f ps=0.74u w=0.26u l=0.38u
X3147 cml_tlatch_41.xtail.S1 CKHA1_N cml_tlatch_41.xmux.xp.S1 VSS sg13_lv_nmos ad=89.3f pd=0.85u as=89.3f ps=0.85u w=0.47u l=0.16u
X3148 VSS POLN cml_tlatch_42.xtail.S1 VSS sg13_lv_nmos ad=1.5637p pd=8.61u as=1.5637p ps=8.61u w=8.23u l=0.13u
X3149 cml_tlatch_42.xtail.S1 CKA2_N cml_tlatch_42.xmux.xp.S1 VSS sg13_lv_nmos ad=89.3f pd=0.85u as=89.3f ps=0.85u w=0.47u l=0.16u
X3150 cml_tlatch_42.xmux.xp.S1 cml_tlatch_56.INP cml_tlatch_56.INN VSS sg13_lv_nmos ad=56.9f pd=0.74u as=56.9f ps=0.74u w=0.17u l=0.17u
X3151 VDD cml_tlatch_65.OUTN VSS rppd l=5.17u w=1u
X3152 cml_tlatch_74.xmux.xp.S1 MOT19_N MOT19_P VSS sg13_lv_nmos ad=56.9f pd=0.74u as=56.9f ps=0.74u w=0.17u l=0.17u
X3153 cml_tlatch_19.xmux.xn.S1 CKHB0_P cml_tlatch_19.xtail.S1 VSS sg13_lv_nmos ad=89.3f pd=0.85u as=89.3f ps=0.85u w=0.47u l=0.16u
X3154 cml_tlatch_6.INN stub_bi_29.BOTN cml_tlatch_94.xmux.xn.S1 VSS sg13_lv_nmos ad=63.19999f pd=0.74u as=63.19999f ps=0.74u w=0.26u l=0.38u
X3155 J4_P J4_N cml_tlatch_90.xmux.xp.S1 VSS sg13_lv_nmos ad=56.9f pd=0.74u as=56.9f ps=0.74u w=0.17u l=0.17u
X3156 cml_tlatch_44.xmux.xp.S1 CKB2_P cml_tlatch_44.xtail.S1 VSS sg13_lv_nmos ad=89.3f pd=0.85u as=89.3f ps=0.85u w=0.47u l=0.16u
X3157 MOT1_N MOT1_P cml_tlatch_17.xmux.xp.S1 VSS sg13_lv_nmos ad=56.9f pd=0.74u as=56.9f ps=0.74u w=0.17u l=0.17u
X3158 cml_tlatch_0.xmux.xn.S1 CKA1_P cml_tlatch_0.xtail.S1 VSS sg13_lv_nmos ad=89.3f pd=0.85u as=0.1598p ps=1.62u w=0.47u l=0.16u
X3159 cml_tlatch_89.INP cml_tlatch_89.INN cml_tlatch_55.xmux.xp.S1 VSS sg13_lv_nmos ad=56.9f pd=0.74u as=0.1019p ps=1.34u w=0.17u l=0.17u
X3160 cml_tlatch_16.xmux.xp.S1 CKB0_P cml_tlatch_16.xtail.S1 VSS sg13_lv_nmos ad=89.3f pd=0.85u as=89.3f ps=0.85u w=0.47u l=0.16u
X3161 cml_tlatch_30.xmux.xn.S1 CKA0_P cml_tlatch_30.xtail.S1 VSS sg13_lv_nmos ad=89.3f pd=0.85u as=89.3f ps=0.85u w=0.47u l=0.16u
X3162 cml_tlatch_48.xtail.S1 CKB2_N cml_tlatch_48.xmux.xp.S1 VSS sg13_lv_nmos ad=89.3f pd=0.85u as=89.3f ps=0.85u w=0.47u l=0.16u
X3163 cml_tlatch_10.xmux.xp.S1 B0_8_P B0_8_N VSS sg13_lv_nmos ad=56.9f pd=0.74u as=56.9f ps=0.74u w=0.17u l=0.17u
X3164 MOT3_N cml_tlatch_16.OUTP cml_tlatch_18.xmux.xn.S1 VSS sg13_lv_nmos ad=63.19999f pd=0.74u as=63.19999f ps=0.74u w=0.26u l=0.38u
X3165 cml_tlatch_89.xmux.xp.S1 cml_tlatch_89.OUTN cml_tlatch_89.OUTP VSS sg13_lv_nmos ad=56.9f pd=0.74u as=56.9f ps=0.74u w=0.17u l=0.17u
X3166 CLK_W_P CLK_W_N cml_tlatch_91.xmux.xp.S1 VSS sg13_lv_nmos ad=56.9f pd=0.74u as=56.9f ps=0.74u w=0.17u l=0.17u
X3167 MOT16_P MOT16_N cml_tlatch_87.xmux.xp.S1 VSS sg13_lv_nmos ad=56.9f pd=0.74u as=56.9f ps=0.74u w=0.17u l=0.17u
X3168 cml_tlatch_56.xmux.xp.S1 A2_2_N A2_2_P VSS sg13_lv_nmos ad=56.9f pd=0.74u as=56.9f ps=0.74u w=0.17u l=0.17u
X3169 cml_tlatch_10.xtail.S1 CKB0_N cml_tlatch_10.xmux.xn.S1 VSS sg13_lv_nmos ad=89.3f pd=0.85u as=89.3f ps=0.85u w=0.47u l=0.16u
X3170 cml_tlatch_58.xtail.S1 CKHA3_P cml_tlatch_58.xmux.xn.S1 VSS sg13_lv_nmos ad=89.3f pd=0.85u as=89.3f ps=0.85u w=0.47u l=0.16u
X3171 cml_tlatch_7.xmux.xn.S1 B1_2_N MOT15_P VSS sg13_lv_nmos ad=63.19999f pd=0.74u as=0.1082p ps=1.34u w=0.26u l=0.38u
X3172 cml_tlatch_36.xmux.xp.S1 cml_tlatch_95.INP cml_tlatch_95.INN VSS sg13_lv_nmos ad=56.9f pd=0.74u as=56.9f ps=0.74u w=0.17u l=0.17u
X3173 cml_tlatch_17.xmux.xn.S1 CKHB0_P cml_tlatch_17.xtail.S1 VSS sg13_lv_nmos ad=0.1598p pd=1.62u as=89.3f ps=0.85u w=0.47u l=0.16u
X3174 cml_tlatch_0.xmux.xn.S1 cml_tlatch_40.INN interco_bi_19.INP VSS sg13_lv_nmos ad=63.19999f pd=0.74u as=63.19999f ps=0.74u w=0.26u l=0.38u
X3175 cml_tlatch_30.xtail.S1 CKA0_N cml_tlatch_30.xmux.xp.S1 VSS sg13_lv_nmos ad=89.3f pd=0.85u as=89.3f ps=0.85u w=0.47u l=0.16u
X3176 cml_tlatch_31.xmux.xp.S1 A0_2_P A0_2_N VSS sg13_lv_nmos ad=56.9f pd=0.74u as=56.9f ps=0.74u w=0.17u l=0.17u
X3177 cml_tlatch_29.OUTN D0_P cml_tlatch_29.xmux.xn.S1 VSS sg13_lv_nmos ad=63.19999f pd=0.74u as=63.19999f ps=0.74u w=0.26u l=0.38u
X3178 A2_8_N A2_8_P cml_tlatch_81.xmux.xp.S1 VSS sg13_lv_nmos ad=56.9f pd=0.74u as=56.9f ps=0.74u w=0.17u l=0.17u
X3179 cml_tlatch_14.xmux.xp.S1 cml_tlatch_5.INP cml_tlatch_5.INN VSS sg13_lv_nmos ad=56.9f pd=0.74u as=56.9f ps=0.74u w=0.17u l=0.17u
X3180 cml_tlatch_90.xtail.S1 CKJ_P cml_tlatch_90.xmux.xp.S1 VSS sg13_lv_nmos ad=89.3f pd=0.85u as=89.3f ps=0.85u w=0.47u l=0.16u
X3181 cml_tlatch_3.xmux.xp.S1 CKA0_N cml_tlatch_3.xtail.S1 VSS sg13_lv_nmos ad=89.3f pd=0.85u as=89.3f ps=0.85u w=0.47u l=0.16u
X3182 VSS POLN cml_tlatch_27.xtail.S1 VSS sg13_lv_nmos ad=1.5637p pd=8.61u as=1.5637p ps=8.61u w=8.23u l=0.13u
X3183 MOT28_N MOT28_P cml_tlatch_58.xmux.xp.S1 VSS sg13_lv_nmos ad=56.9f pd=0.74u as=0.1019p ps=1.34u w=0.17u l=0.17u
X3184 MOT2_N MOT2_P cml_tlatch_24.xmux.xp.S1 VSS sg13_lv_nmos ad=56.9f pd=0.74u as=56.9f ps=0.74u w=0.17u l=0.17u
X3185 cml_gate2_2.sg13_lv_nmos_FTPY57_0.D0 CKB0_P cml_gate2_2.xrtail.R1 VSS sg13_lv_nmos ad=0.1007p pd=0.91u as=0.1007p ps=0.91u w=0.53u l=0.13u
X3186 MOT9_N MOT9_P cml_tlatch_4.xmux.xp.S1 VSS sg13_lv_nmos ad=56.9f pd=0.74u as=0.1019p ps=1.34u w=0.17u l=0.17u
X3187 cml_tlatch_75.xmux.xn.S1 stub_bi_55.BOTN MOT21_N VSS sg13_lv_nmos ad=63.19999f pd=0.74u as=63.19999f ps=0.74u w=0.26u l=0.38u
X3188 stub_bi_62.BOTP stub_bi_62.BOTN cml_tlatch_78.xmux.xp.S1 VSS sg13_lv_nmos ad=56.9f pd=0.74u as=56.9f ps=0.74u w=0.17u l=0.17u
X3189 cml_tlatch_89.INP cml_tlatch_89.INN cml_tlatch_55.xmux.xp.S1 VSS sg13_lv_nmos ad=56.9f pd=0.74u as=56.9f ps=0.74u w=0.17u l=0.17u
X3190 cml_tlatch_97.xmux.xp.S1 MOT0_N MOT0_P VSS sg13_lv_nmos ad=56.9f pd=0.74u as=56.9f ps=0.74u w=0.17u l=0.17u
X3191 cml_tlatch_59.xmux.xn.S1 A3_2_P MOT30_N VSS sg13_lv_nmos ad=63.19999f pd=0.74u as=0.1082p ps=1.34u w=0.26u l=0.38u
X3192 cml_tlatch_41.xmux.xn.S1 A1_2_N MOT14_P VSS sg13_lv_nmos ad=63.19999f pd=0.74u as=63.19999f ps=0.74u w=0.26u l=0.38u
X3193 cml_gate2_6.xrtail.R1 CKA3_N GB3_P VSS sg13_lv_nmos ad=0.1802p pd=1.74u as=0.1007p ps=0.91u w=0.53u l=0.13u
X3194 cml_tlatch_29.xtail.S1 CKB0_N cml_tlatch_29.xmux.xp.S1 VSS sg13_lv_nmos ad=89.3f pd=0.85u as=0.1598p ps=1.62u w=0.47u l=0.16u
X3195 cml_tlatch_9.OUTP cml_tlatch_9.OUTN cml_tlatch_9.xmux.xp.S1 VSS sg13_lv_nmos ad=56.9f pd=0.74u as=56.9f ps=0.74u w=0.17u l=0.17u
X3196 VSS POLN cml_tlatch_43.xtail.S1 VSS sg13_lv_nmos ad=1.5637p pd=8.61u as=1.5637p ps=8.61u w=8.23u l=0.13u
X3197 interco_bi_19.INN interco_bi_19.INP cml_tlatch_0.xmux.xp.S1 VSS sg13_lv_nmos ad=56.9f pd=0.74u as=56.9f ps=0.74u w=0.17u l=0.17u
X3198 MOT20_P MOT20_N cml_tlatch_50.xmux.xp.S1 VSS sg13_lv_nmos ad=56.9f pd=0.74u as=56.9f ps=0.74u w=0.17u l=0.17u
X3199 cml_tlatch_72.xtail.S1 CKA2_P cml_tlatch_72.xmux.xn.S1 VSS sg13_lv_nmos ad=89.3f pd=0.85u as=89.3f ps=0.85u w=0.47u l=0.16u
X3200 cml_tlatch_58.xmux.xp.S1 MOT28_N MOT28_P VSS sg13_lv_nmos ad=56.9f pd=0.74u as=56.9f ps=0.74u w=0.17u l=0.17u
X3201 cml_tlatch_8.OUTP cml_tlatch_9.OUTN cml_tlatch_8.xmux.xn.S1 VSS sg13_lv_nmos ad=63.19999f pd=0.74u as=0.1082p ps=1.34u w=0.26u l=0.38u
X3202 cml_tlatch_97.xtail.S1 CKHA0_P cml_tlatch_97.xmux.xn.S1 VSS sg13_lv_nmos ad=89.3f pd=0.85u as=89.3f ps=0.85u w=0.47u l=0.16u
X3203 cml_tlatch_12.xmux.xn.S1 CKB1_N cml_tlatch_12.xtail.S1 VSS sg13_lv_nmos ad=89.3f pd=0.85u as=89.3f ps=0.85u w=0.47u l=0.16u
X3204 cml_tlatch_38.xtail.S1 POLN VSS VSS sg13_lv_nmos ad=1.5637p pd=8.61u as=1.5637p ps=8.61u w=8.23u l=0.13u
X3205 cml_tlatch_53.xmux.xp.S1 A3_2_P A3_2_N VSS sg13_lv_nmos ad=56.9f pd=0.74u as=56.9f ps=0.74u w=0.17u l=0.17u
X3206 cml_tlatch_92.xmux.xp.S1 J2_P J2_N VSS sg13_lv_nmos ad=56.9f pd=0.74u as=56.9f ps=0.74u w=0.17u l=0.17u
X3207 cml_tlatch_16.xmux.xp.S1 cml_tlatch_16.OUTP cml_tlatch_16.OUTN VSS sg13_lv_nmos ad=56.9f pd=0.74u as=56.9f ps=0.74u w=0.17u l=0.17u
X3208 cml_tlatch_49.xmux.xp.S1 MOT18_N MOT18_P VSS sg13_lv_nmos ad=56.9f pd=0.74u as=56.9f ps=0.74u w=0.17u l=0.17u
X3209 cml_tlatch_99.OUTP cml_tlatch_99.OUTN cml_tlatch_99.xmux.xp.S1 VSS sg13_lv_nmos ad=56.9f pd=0.74u as=56.9f ps=0.74u w=0.17u l=0.17u
X3210 cml_tlatch_4.xtail.S1 CKHB1_N cml_tlatch_4.xmux.xp.S1 VSS sg13_lv_nmos ad=89.3f pd=0.85u as=89.3f ps=0.85u w=0.47u l=0.16u
X3211 stub_bi_49.BOTN stub_bi_49.BOTP cml_tlatch_80.xmux.xp.S1 VSS sg13_lv_nmos ad=56.9f pd=0.74u as=56.9f ps=0.74u w=0.17u l=0.17u
X3212 cml_gate2_2.sg13_lv_nmos_FTPY57_0.D0 ENA0_N GA0_P VSS sg13_lv_nmos ad=0.1007p pd=0.91u as=0.1007p ps=0.91u w=0.53u l=0.13u
X3213 B3_8_P B3_8_N cml_tlatch_60.xmux.xp.S1 VSS sg13_lv_nmos ad=56.9f pd=0.74u as=56.9f ps=0.74u w=0.17u l=0.17u
X3214 cml_tlatch_89.xtail.S1 CKA2_P cml_tlatch_89.xmux.xp.S1 VSS sg13_lv_nmos ad=89.3f pd=0.85u as=89.3f ps=0.85u w=0.47u l=0.16u
X3215 cml_tlatch_87.xmux.xp.S1 CKHA2_N cml_tlatch_87.xtail.S1 VSS sg13_lv_nmos ad=0.1598p pd=1.62u as=89.3f ps=0.85u w=0.47u l=0.16u
X3216 cml_tlatch_33.xmux.xp.S1 B1_2_P B1_2_N VSS sg13_lv_nmos ad=56.9f pd=0.74u as=56.9f ps=0.74u w=0.17u l=0.17u
X3217 cml_tlatch_71.xtail.S1 CKHB3_P cml_tlatch_71.xmux.xn.S1 VSS sg13_lv_nmos ad=89.3f pd=0.85u as=89.3f ps=0.85u w=0.47u l=0.16u
X3218 cml_tlatch_74.xmux.xp.S1 MOT19_N MOT19_P VSS sg13_lv_nmos ad=0.1019p pd=1.34u as=56.9f ps=0.74u w=0.17u l=0.17u
X3219 stub_bi_32.BOTP stub_bi_32.BOTN cml_tlatch_48.xmux.xp.S1 VSS sg13_lv_nmos ad=56.9f pd=0.74u as=56.9f ps=0.74u w=0.17u l=0.17u
X3220 B0_8_P cml_tlatch_11.OUTN cml_tlatch_10.xmux.xn.S1 VSS sg13_lv_nmos ad=63.19999f pd=0.74u as=63.19999f ps=0.74u w=0.26u l=0.38u
X3221 cml_tlatch_36.xmux.xn.S1 A1_2_N cml_tlatch_95.INP VSS sg13_lv_nmos ad=63.19999f pd=0.74u as=63.19999f ps=0.74u w=0.26u l=0.38u
X3222 cml_tlatch_60.xtail.S1 CKB3_P cml_tlatch_60.xmux.xp.S1 VSS sg13_lv_nmos ad=89.3f pd=0.85u as=89.3f ps=0.85u w=0.47u l=0.16u
X3223 MOT27_P MOT27_N cml_tlatch_69.xmux.xp.S1 VSS sg13_lv_nmos ad=56.9f pd=0.74u as=56.9f ps=0.74u w=0.17u l=0.17u
X3224 cml_tlatch_74.xmux.xn.S1 stub_bi_63.BOTP MOT19_P VSS sg13_lv_nmos ad=63.19999f pd=0.74u as=63.19999f ps=0.74u w=0.26u l=0.38u
X3225 VSS hs_to_clk_7.sg13_lv_nmos_2HGZLP_0.G VSS VSS sg13_lv_nmos ad=2.071p pd=11.28u as=0 ps=0 w=10.9u l=1.38u
X3226 cml_tlatch_5.xmux.xp.S1 MOT11_N MOT11_P VSS sg13_lv_nmos ad=56.9f pd=0.74u as=56.9f ps=0.74u w=0.17u l=0.17u
X3227 GB3_N ENB0_P cml_gate2_6.sg13_lv_nmos_FTPY57_0.D0 VSS sg13_lv_nmos ad=0.1007p pd=0.91u as=0.1007p ps=0.91u w=0.53u l=0.13u
X3228 cml_tlatch_83.OUTN cml_tlatch_83.OUTP cml_tlatch_83.xmux.xp.S1 VSS sg13_lv_nmos ad=56.9f pd=0.74u as=56.9f ps=0.74u w=0.17u l=0.17u
X3229 cml_tlatch_69.INN cml_tlatch_63.OUTP cml_tlatch_62.xmux.xn.S1 VSS sg13_lv_nmos ad=63.19999f pd=0.74u as=63.19999f ps=0.74u w=0.26u l=0.38u
X3230 cml_tlatch_89.xmux.xp.S1 cml_tlatch_89.OUTN cml_tlatch_89.OUTP VSS sg13_lv_nmos ad=56.9f pd=0.74u as=56.9f ps=0.74u w=0.17u l=0.17u
X3231 cml_tlatch_10.xmux.xp.S1 B0_8_P B0_8_N VSS sg13_lv_nmos ad=56.9f pd=0.74u as=56.9f ps=0.74u w=0.17u l=0.17u
X3232 cml_tlatch_88.xtail.S1 CKB2_P cml_tlatch_88.xmux.xp.S1 VSS sg13_lv_nmos ad=89.3f pd=0.85u as=89.3f ps=0.85u w=0.47u l=0.16u
X3233 cml_tlatch_95.INN A1_2_P cml_tlatch_36.xmux.xn.S1 VSS sg13_lv_nmos ad=63.19999f pd=0.74u as=63.19999f ps=0.74u w=0.26u l=0.38u
X3234 stub_bi_55.BOTN stub_bi_55.BOTP cml_tlatch_88.xmux.xp.S1 VSS sg13_lv_nmos ad=56.9f pd=0.74u as=56.9f ps=0.74u w=0.17u l=0.17u
X3235 cml_tlatch_3.xmux.xp.S1 cml_tlatch_3.OUTN cml_tlatch_3.OUTP VSS sg13_lv_nmos ad=56.9f pd=0.74u as=56.9f ps=0.74u w=0.17u l=0.17u
X3236 cml_tlatch_85.xtail.S1 CKA3_P cml_tlatch_85.xmux.xp.S1 VSS sg13_lv_nmos ad=89.3f pd=0.85u as=89.3f ps=0.85u w=0.47u l=0.16u
X3237 VDD MOT22_P VSS rppd l=5.17u w=1u
X3238 MOT16_P MOT16_N cml_tlatch_87.xmux.xp.S1 VSS sg13_lv_nmos ad=56.9f pd=0.74u as=56.9f ps=0.74u w=0.17u l=0.17u
X3239 MOT13_P MOT13_N cml_tlatch_6.xmux.xp.S1 VSS sg13_lv_nmos ad=56.9f pd=0.74u as=56.9f ps=0.74u w=0.17u l=0.17u
X3240 cml_tlatch_61.xtail.S1 CKB3_P cml_tlatch_61.xmux.xn.S1 VSS sg13_lv_nmos ad=89.3f pd=0.85u as=0.1598p ps=1.62u w=0.47u l=0.16u
X3241 cml_tlatch_86.xmux.xp.S1 MOT24_N MOT24_P VSS sg13_lv_nmos ad=56.9f pd=0.74u as=56.9f ps=0.74u w=0.17u l=0.17u
X3242 MOT23_P MOT23_N cml_tlatch_76.xmux.xp.S1 VSS sg13_lv_nmos ad=56.9f pd=0.74u as=56.9f ps=0.74u w=0.17u l=0.17u
X3243 cml_tlatch_32.xtail.S1 CKB1_P cml_tlatch_32.xmux.xn.S1 VSS sg13_lv_nmos ad=0.1598p pd=1.62u as=89.3f ps=0.85u w=0.47u l=0.16u
X3244 cml_tlatch_31.xmux.xn.S1 cml_tlatch_35.OUTN A0_2_P VSS sg13_lv_nmos ad=63.19999f pd=0.74u as=63.19999f ps=0.74u w=0.26u l=0.38u
X3245 cml_tlatch_71.xmux.xp.S1 MOT31_N MOT31_P VSS sg13_lv_nmos ad=56.9f pd=0.74u as=56.9f ps=0.74u w=0.17u l=0.17u
X3246 cml_tlatch_8.xmux.xp.S1 CKA0_P cml_tlatch_8.xtail.S1 VSS sg13_lv_nmos ad=89.3f pd=0.85u as=0.1598p ps=1.62u w=0.47u l=0.16u
X3247 cml_tlatch_58.xtail.S1 CKHA3_N cml_tlatch_58.xmux.xp.S1 VSS sg13_lv_nmos ad=0.1598p pd=1.62u as=89.3f ps=0.85u w=0.47u l=0.16u
X3248 cml_tlatch_30.OUTP cml_tlatch_30.OUTN cml_tlatch_30.xmux.xp.S1 VSS sg13_lv_nmos ad=56.9f pd=0.74u as=56.9f ps=0.74u w=0.17u l=0.17u
X3249 cml_tlatch_8.xmux.xn.S1 CKA0_N cml_tlatch_8.xtail.S1 VSS sg13_lv_nmos ad=89.3f pd=0.85u as=89.3f ps=0.85u w=0.47u l=0.16u
X3250 MOT14_P MOT14_N cml_tlatch_41.xmux.xp.S1 VSS sg13_lv_nmos ad=56.9f pd=0.74u as=56.9f ps=0.74u w=0.17u l=0.17u
X3251 cml_tlatch_3.OUTN cml_tlatch_8.OUTP cml_tlatch_3.xmux.xn.S1 VSS sg13_lv_nmos ad=0.1082p pd=1.34u as=63.19999f ps=0.74u w=0.26u l=0.38u
X3252 cml_tlatch_5.INP stub_bi_19.BOTP cml_tlatch_14.xmux.xn.S1 VSS sg13_lv_nmos ad=63.19999f pd=0.74u as=63.19999f ps=0.74u w=0.26u l=0.38u
X3253 cml_tlatch_82.OUTP cml_tlatch_82.OUTN cml_tlatch_82.xmux.xp.S1 VSS sg13_lv_nmos ad=56.9f pd=0.74u as=56.9f ps=0.74u w=0.17u l=0.17u
X3254 cml_tlatch_67.xmux.xp.S1 cml_tlatch_67.OUTP cml_tlatch_67.OUTN VSS sg13_lv_nmos ad=56.9f pd=0.74u as=56.9f ps=0.74u w=0.17u l=0.17u
X3255 cml_tlatch_78.xmux.xp.S1 stub_bi_62.BOTP stub_bi_62.BOTN VSS sg13_lv_nmos ad=56.9f pd=0.74u as=56.9f ps=0.74u w=0.17u l=0.17u
X3256 MOT15_N MOT15_P cml_tlatch_7.xmux.xp.S1 VSS sg13_lv_nmos ad=56.9f pd=0.74u as=56.9f ps=0.74u w=0.17u l=0.17u
X3257 cml_tlatch_3.OUTN cml_tlatch_8.OUTP cml_tlatch_3.xmux.xn.S1 VSS sg13_lv_nmos ad=63.19999f pd=0.74u as=63.19999f ps=0.74u w=0.26u l=0.38u
X3258 cml_tlatch_33.xmux.xn.S1 CKB1_N cml_tlatch_33.xtail.S1 VSS sg13_lv_nmos ad=89.3f pd=0.85u as=89.3f ps=0.85u w=0.47u l=0.16u
X3259 cml_tlatch_44.xtail.S1 CKB2_P cml_tlatch_44.xmux.xp.S1 VSS sg13_lv_nmos ad=89.3f pd=0.85u as=89.3f ps=0.85u w=0.47u l=0.16u
X3260 cml_gate2_9.sg13_lv_nmos_FTPY57_0.D0 NM1_P cml_gate2_9.xrtail.R1 VSS sg13_lv_nmos ad=0.1007p pd=0.91u as=0.1007p ps=0.91u w=0.53u l=0.13u
X3261 cml_gate2_5.xrtail.R1 CKB3_N GA3_P VSS sg13_lv_nmos ad=0.1007p pd=0.91u as=0.1007p ps=0.91u w=0.53u l=0.13u
X3262 MOT25_N B3_8_P cml_tlatch_68.xmux.xn.S1 VSS sg13_lv_nmos ad=63.19999f pd=0.74u as=63.19999f ps=0.74u w=0.26u l=0.38u
X3263 MOT17_P B2_8_N cml_tlatch_73.xmux.xn.S1 VSS sg13_lv_nmos ad=63.19999f pd=0.74u as=63.19999f ps=0.74u w=0.26u l=0.38u
X3264 cml_tlatch_32.xtail.S1 POLN VSS VSS sg13_lv_nmos ad=1.5637p pd=8.61u as=1.5637p ps=8.61u w=8.23u l=0.13u
X3265 cml_tlatch_82.xtail.S1 CKA2_P cml_tlatch_82.xmux.xn.S1 VSS sg13_lv_nmos ad=89.3f pd=0.85u as=89.3f ps=0.85u w=0.47u l=0.16u
X3266 cml_tlatch_60.xmux.xn.S1 cml_tlatch_61.OUTP B3_8_N VSS sg13_lv_nmos ad=63.19999f pd=0.74u as=63.19999f ps=0.74u w=0.26u l=0.38u
X3267 cml_tlatch_40.xtail.S1 CKHA1_N cml_tlatch_40.xmux.xp.S1 VSS sg13_lv_nmos ad=89.3f pd=0.85u as=89.3f ps=0.85u w=0.47u l=0.16u
X3268 cml_tlatch_87.xmux.xp.S1 MOT16_P MOT16_N VSS sg13_lv_nmos ad=56.9f pd=0.74u as=56.9f ps=0.74u w=0.17u l=0.17u
X3269 cml_tlatch_13.xmux.xn.S1 cml_tlatch_5.INN stub_bi_17.BOTN VSS sg13_lv_nmos ad=63.19999f pd=0.74u as=63.19999f ps=0.74u w=0.26u l=0.38u
X3270 MOT30_P MOT30_N cml_tlatch_59.xmux.xp.S1 VSS sg13_lv_nmos ad=56.9f pd=0.74u as=56.9f ps=0.74u w=0.17u l=0.17u
X3271 MOT24_N MOT24_P cml_tlatch_86.xmux.xp.S1 VSS sg13_lv_nmos ad=56.9f pd=0.74u as=56.9f ps=0.74u w=0.17u l=0.17u
X3272 cml_tlatch_27.OUTN cml_tlatch_27.OUTP cml_tlatch_27.xmux.xp.S1 VSS sg13_lv_nmos ad=56.9f pd=0.74u as=56.9f ps=0.74u w=0.17u l=0.17u
X3273 cml_tlatch_38.xmux.xn.S1 D1_N cml_tlatch_38.OUTP VSS sg13_lv_nmos ad=63.19999f pd=0.74u as=63.19999f ps=0.74u w=0.26u l=0.38u
X3274 cml_tlatch_9.xmux.xp.S1 cml_tlatch_9.OUTP cml_tlatch_9.OUTN VSS sg13_lv_nmos ad=56.9f pd=0.74u as=56.9f ps=0.74u w=0.17u l=0.17u
X3275 cml_tlatch_21.xmux.xp.S1 A1_8_P A1_8_N VSS sg13_lv_nmos ad=56.9f pd=0.74u as=56.9f ps=0.74u w=0.17u l=0.17u
X3276 cml_tlatch_75.xtail.S1 CKHB2_P cml_tlatch_75.xmux.xn.S1 VSS sg13_lv_nmos ad=89.3f pd=0.85u as=89.3f ps=0.85u w=0.47u l=0.16u
X3277 cml_tlatch_90.xmux.xp.S1 CKJ_P cml_tlatch_90.xtail.S1 VSS sg13_lv_nmos ad=89.3f pd=0.85u as=0.1598p ps=1.62u w=0.47u l=0.16u
X3278 B3_2_N B3_2_P cml_tlatch_46.xmux.xp.S1 VSS sg13_lv_nmos ad=56.9f pd=0.74u as=56.9f ps=0.74u w=0.17u l=0.17u
X3279 ENB0_P ENB_N cml_drv_2.xrtail.R1 VSS sg13_lv_nmos ad=56.2f pd=0.74u as=56.2f ps=0.74u w=0.16u l=0.19u
X3280 cml_tlatch_49.xmux.xp.S1 MOT18_N MOT18_P VSS sg13_lv_nmos ad=0.1019p pd=1.34u as=56.9f ps=0.74u w=0.17u l=0.17u
X3281 MOT6_N MOT6_P cml_tlatch_26.xmux.xp.S1 VSS sg13_lv_nmos ad=56.9f pd=0.74u as=56.9f ps=0.74u w=0.17u l=0.17u
X3282 MOT26_P MOT26_N cml_tlatch_57.xmux.xp.S1 VSS sg13_lv_nmos ad=56.9f pd=0.74u as=56.9f ps=0.74u w=0.17u l=0.17u
X3283 cml_tlatch_41.xtail.S1 POLN VSS VSS sg13_lv_nmos ad=1.5637p pd=8.61u as=1.5637p ps=8.61u w=8.23u l=0.13u
X3284 cml_tlatch_38.xmux.xn.S1 CKA1_P cml_tlatch_38.xtail.S1 VSS sg13_lv_nmos ad=89.3f pd=0.85u as=89.3f ps=0.85u w=0.47u l=0.16u
X3285 cml_tlatch_96.xmux.xn.S1 A1_8_N MOT8_P VSS sg13_lv_nmos ad=63.19999f pd=0.74u as=0.1082p ps=1.34u w=0.26u l=0.38u
X3286 cml_tlatch_95.xmux.xn.S1 CKA1_N cml_tlatch_95.xtail.S1 VSS sg13_lv_nmos ad=89.3f pd=0.85u as=0.1598p ps=1.62u w=0.47u l=0.16u
X3287 cml_tlatch_82.xtail.S1 CKA2_N cml_tlatch_82.xmux.xp.S1 VSS sg13_lv_nmos ad=89.3f pd=0.85u as=89.3f ps=0.85u w=0.47u l=0.16u
X3288 cml_tlatch_60.xtail.S1 CKB3_N cml_tlatch_60.xmux.xn.S1 VSS sg13_lv_nmos ad=89.3f pd=0.85u as=89.3f ps=0.85u w=0.47u l=0.16u
X3289 cml_tlatch_33.xmux.xp.S1 B1_2_P B1_2_N VSS sg13_lv_nmos ad=56.9f pd=0.74u as=56.9f ps=0.74u w=0.17u l=0.17u
X3290 cml_gate2_7.sg13_lv_nmos_FTPY57_0.D0 ENB0_N GB2_P VSS sg13_lv_nmos ad=0.1007p pd=0.91u as=0.1007p ps=0.91u w=0.53u l=0.13u
X3291 cml_tlatch_39.xmux.xp.S1 MOT10_N MOT10_P VSS sg13_lv_nmos ad=56.9f pd=0.74u as=56.9f ps=0.74u w=0.17u l=0.17u
X3292 cml_tlatch_36.xmux.xp.S1 cml_tlatch_95.INN cml_tlatch_95.INP VSS sg13_lv_nmos ad=56.9f pd=0.74u as=56.9f ps=0.74u w=0.17u l=0.17u
X3293 cml_tlatch_53.xmux.xp.S1 A3_2_N A3_2_P VSS sg13_lv_nmos ad=0.1019p pd=1.34u as=56.9f ps=0.74u w=0.17u l=0.17u
X3294 cml_tlatch_71.xmux.xp.S1 MOT31_P MOT31_N VSS sg13_lv_nmos ad=56.9f pd=0.74u as=56.9f ps=0.74u w=0.17u l=0.17u
X3295 MOT17_P MOT17_N cml_tlatch_73.xmux.xp.S1 VSS sg13_lv_nmos ad=56.9f pd=0.74u as=56.9f ps=0.74u w=0.17u l=0.17u
X3296 cml_tlatch_56.INP cml_tlatch_56.INN cml_tlatch_42.xmux.xp.S1 VSS sg13_lv_nmos ad=56.9f pd=0.74u as=56.9f ps=0.74u w=0.17u l=0.17u
X3297 cml_tlatch_83.xtail.S1 CKA2_N cml_tlatch_83.xmux.xn.S1 VSS sg13_lv_nmos ad=89.3f pd=0.85u as=89.3f ps=0.85u w=0.47u l=0.16u
X3298 cml_tlatch_68.xmux.xp.S1 MOT25_N MOT25_P VSS sg13_lv_nmos ad=56.9f pd=0.74u as=56.9f ps=0.74u w=0.17u l=0.17u
X3299 cml_tlatch_48.xmux.xp.S1 stub_bi_32.BOTP stub_bi_32.BOTN VSS sg13_lv_nmos ad=56.9f pd=0.74u as=56.9f ps=0.74u w=0.17u l=0.17u
X3300 cml_tlatch_34.xmux.xn.S1 CKB1_P cml_tlatch_34.xtail.S1 VSS sg13_lv_nmos ad=89.3f pd=0.85u as=89.3f ps=0.85u w=0.47u l=0.16u
X3301 cml_gate2_0.sg13_lv_nmos_FTPY57_0.D0 ENB1_N GB1_P VSS sg13_lv_nmos ad=0.1802p pd=1.74u as=0.1007p ps=0.91u w=0.53u l=0.13u
X3302 cml_tlatch_78.xtail.S1 CKB2_N cml_tlatch_78.xmux.xp.S1 VSS sg13_lv_nmos ad=89.3f pd=0.85u as=89.3f ps=0.85u w=0.47u l=0.16u
X3303 GA3_N ENA1_P cml_gate2_5.sg13_lv_nmos_FTPY57_0.D0 VSS sg13_lv_nmos ad=0.1007p pd=0.91u as=0.1007p ps=0.91u w=0.53u l=0.13u
X3304 cml_tlatch_70.xmux.xn.S1 cml_tlatch_70.INN MOT29_P VSS sg13_lv_nmos ad=63.19999f pd=0.74u as=63.19999f ps=0.74u w=0.26u l=0.38u
X3305 cml_tlatch_79.xmux.xp.S1 stub_bi_63.BOTN stub_bi_63.BOTP VSS sg13_lv_nmos ad=0.1019p pd=1.34u as=56.9f ps=0.74u w=0.17u l=0.17u
X3306 cml_tlatch_16.xmux.xp.S1 CKB0_P cml_tlatch_16.xtail.S1 VSS sg13_lv_nmos ad=89.3f pd=0.85u as=89.3f ps=0.85u w=0.47u l=0.16u
X3307 MOT23_P B2_2_N cml_tlatch_76.xmux.xn.S1 VSS sg13_lv_nmos ad=0.1082p pd=1.34u as=63.19999f ps=0.74u w=0.26u l=0.38u
X3308 stub_bi_19.BOTP stub_bi_19.BOTN cml_tlatch_15.xmux.xp.S1 VSS sg13_lv_nmos ad=56.9f pd=0.74u as=56.9f ps=0.74u w=0.17u l=0.17u
X3309 cml_tlatch_47.xmux.xp.S1 cml_tlatch_47.OUTP cml_tlatch_47.OUTN VSS sg13_lv_nmos ad=56.9f pd=0.74u as=56.9f ps=0.74u w=0.17u l=0.17u
X3310 MOT14_N A1_2_P cml_tlatch_41.xmux.xn.S1 VSS sg13_lv_nmos ad=63.19999f pd=0.74u as=63.19999f ps=0.74u w=0.26u l=0.38u
X3311 cml_tlatch_12.xtail.S1 CKB1_N cml_tlatch_12.xmux.xn.S1 VSS sg13_lv_nmos ad=89.3f pd=0.85u as=0.1598p ps=1.62u w=0.47u l=0.16u
X3312 cml_tlatch_82.OUTP cml_tlatch_83.OUTN cml_tlatch_82.xmux.xn.S1 VSS sg13_lv_nmos ad=63.19999f pd=0.74u as=63.19999f ps=0.74u w=0.26u l=0.38u
X3313 VSS POLN cml_tlatch_84.xtail.S1 VSS sg13_lv_nmos ad=1.5637p pd=8.61u as=1.5637p ps=8.61u w=8.23u l=0.13u
X3314 cml_tlatch_69.INP VDD VSS rppd l=5.17u w=1u
X3315 MOT20_P cml_tlatch_89.OUTN cml_tlatch_50.xmux.xn.S1 VSS sg13_lv_nmos ad=63.19999f pd=0.74u as=0.1082p ps=1.34u w=0.26u l=0.38u
X3316 cml_tlatch_10.xtail.S1 CKB0_N cml_tlatch_10.xmux.xn.S1 VSS sg13_lv_nmos ad=89.3f pd=0.85u as=89.3f ps=0.85u w=0.47u l=0.16u
X3317 cml_tlatch_57.xmux.xp.S1 MOT26_P MOT26_N VSS sg13_lv_nmos ad=0.1019p pd=1.34u as=56.9f ps=0.74u w=0.17u l=0.17u
X3318 cml_tlatch_17.xmux.xp.S1 MOT1_P MOT1_N VSS sg13_lv_nmos ad=56.9f pd=0.74u as=56.9f ps=0.74u w=0.17u l=0.17u
X3319 MOT14_N A1_2_P cml_tlatch_41.xmux.xn.S1 VSS sg13_lv_nmos ad=63.19999f pd=0.74u as=63.19999f ps=0.74u w=0.26u l=0.38u
X3320 cml_tlatch_79.xtail.S1 CKB2_N cml_tlatch_79.xmux.xn.S1 VSS sg13_lv_nmos ad=89.3f pd=0.85u as=89.3f ps=0.85u w=0.47u l=0.16u
X3321 cml_tlatch_92.xmux.xn.S1 CKJ_N cml_tlatch_92.xtail.S1 VSS sg13_lv_nmos ad=89.3f pd=0.85u as=89.3f ps=0.85u w=0.47u l=0.16u
X3322 cml_tlatch_17.xmux.xn.S1 CKHB0_P cml_tlatch_17.xtail.S1 VSS sg13_lv_nmos ad=89.3f pd=0.85u as=89.3f ps=0.85u w=0.47u l=0.16u
X3323 cml_tlatch_65.xmux.xp.S1 cml_tlatch_65.OUTP cml_tlatch_65.OUTN VSS sg13_lv_nmos ad=56.9f pd=0.74u as=56.9f ps=0.74u w=0.17u l=0.17u
X3324 cml_tlatch_93.xmux.xn.S1 J4_N J1_N VSS sg13_lv_nmos ad=63.19999f pd=0.74u as=63.19999f ps=0.74u w=0.26u l=0.38u
X3325 cml_tlatch_66.xtail.S1 CKA3_N cml_tlatch_66.xmux.xn.S1 VSS sg13_lv_nmos ad=89.3f pd=0.85u as=89.3f ps=0.85u w=0.47u l=0.16u
X3326 cml_tlatch_9.xtail.S1 POLN VSS VSS sg13_lv_nmos ad=1.5637p pd=8.61u as=2.7982p ps=17.14u w=8.23u l=0.13u
X3327 A3_2_N cml_tlatch_54.OUTP cml_tlatch_53.xmux.xn.S1 VSS sg13_lv_nmos ad=63.19999f pd=0.74u as=0.1082p ps=1.34u w=0.26u l=0.38u
X3328 stub_bi_49.BOTN stub_bi_55.BOTP cml_tlatch_80.xmux.xn.S1 VSS sg13_lv_nmos ad=63.19999f pd=0.74u as=63.19999f ps=0.74u w=0.26u l=0.38u
X3329 cml_tlatch_78.xmux.xp.S1 stub_bi_62.BOTP stub_bi_62.BOTN VSS sg13_lv_nmos ad=56.9f pd=0.74u as=56.9f ps=0.74u w=0.17u l=0.17u
X3330 VSS hs_to_clk_7.sg13_lv_nmos_2HGZLP_0.G VSS VSS sg13_lv_nmos ad=3.706p pd=22.48u as=0 ps=0 w=10.9u l=1.38u
X3331 VDD MOT20_N VSS rppd l=5.17u w=1u
X3332 cml_tlatch_27.xtail.S1 CKB0_P cml_tlatch_27.xmux.xn.S1 VSS sg13_lv_nmos ad=89.3f pd=0.85u as=89.3f ps=0.85u w=0.47u l=0.16u
X3333 cml_tlatch_31.xmux.xn.S1 CKA0_N cml_tlatch_31.xtail.S1 VSS sg13_lv_nmos ad=89.3f pd=0.85u as=89.3f ps=0.85u w=0.47u l=0.16u
X3334 cml_tlatch_6.INN cml_tlatch_6.INP cml_tlatch_94.xmux.xp.S1 VSS sg13_lv_nmos ad=56.9f pd=0.74u as=56.9f ps=0.74u w=0.17u l=0.17u
X3335 cml_tlatch_46.xmux.xp.S1 B3_2_N B3_2_P VSS sg13_lv_nmos ad=56.9f pd=0.74u as=56.9f ps=0.74u w=0.17u l=0.17u
X3336 cml_tlatch_51.xmux.xp.S1 MOT22_P MOT22_N VSS sg13_lv_nmos ad=56.9f pd=0.74u as=56.9f ps=0.74u w=0.17u l=0.17u
X3337 MOT30_N MOT30_P cml_tlatch_59.xmux.xp.S1 VSS sg13_lv_nmos ad=56.9f pd=0.74u as=56.9f ps=0.74u w=0.17u l=0.17u
X3338 cml_tlatch_29.xmux.xn.S1 CKB0_P cml_tlatch_29.xtail.S1 VSS sg13_lv_nmos ad=89.3f pd=0.85u as=89.3f ps=0.85u w=0.47u l=0.16u
X3339 cml_tlatch_31.xmux.xn.S1 cml_tlatch_35.OUTP A0_2_N VSS sg13_lv_nmos ad=63.19999f pd=0.74u as=63.19999f ps=0.74u w=0.26u l=0.38u
X3340 cml_gate2_1.sg13_lv_nmos_FTPY57_0.D0 ENB1_P GB0_N VSS sg13_lv_nmos ad=0.1007p pd=0.91u as=0.1007p ps=0.91u w=0.53u l=0.13u
X3341 cml_tlatch_47.OUTN cml_tlatch_47.OUTP cml_tlatch_47.xmux.xp.S1 VSS sg13_lv_nmos ad=56.9f pd=0.74u as=56.9f ps=0.74u w=0.17u l=0.17u
X3342 cml_tlatch_80.xmux.xn.S1 stub_bi_55.BOTN stub_bi_49.BOTP VSS sg13_lv_nmos ad=63.19999f pd=0.74u as=63.19999f ps=0.74u w=0.26u l=0.38u
X3343 MOT4_N MOT4_P cml_tlatch_25.xmux.xp.S1 VSS sg13_lv_nmos ad=56.9f pd=0.74u as=56.9f ps=0.74u w=0.17u l=0.17u
X3344 cml_tlatch_5.INP cml_tlatch_5.INN cml_tlatch_14.xmux.xp.S1 VSS sg13_lv_nmos ad=56.9f pd=0.74u as=0.1019p ps=1.34u w=0.17u l=0.17u
X3345 cml_tlatch_8.OUTN cml_tlatch_8.OUTP cml_tlatch_8.xmux.xp.S1 VSS sg13_lv_nmos ad=56.9f pd=0.74u as=56.9f ps=0.74u w=0.17u l=0.17u
X3346 MOT11_N MOT11_P cml_tlatch_5.xmux.xp.S1 VSS sg13_lv_nmos ad=56.9f pd=0.74u as=56.9f ps=0.74u w=0.17u l=0.17u
X3347 cml_tlatch_46.xtail.S1 CKB3_N cml_tlatch_46.xmux.xn.S1 VSS sg13_lv_nmos ad=89.3f pd=0.85u as=89.3f ps=0.85u w=0.47u l=0.16u
X3348 A3_8_N A3_8_P cml_tlatch_64.xmux.xp.S1 VSS sg13_lv_nmos ad=56.9f pd=0.74u as=56.9f ps=0.74u w=0.17u l=0.17u
X3349 cml_tlatch_27.OUTN cml_tlatch_27.OUTP cml_tlatch_27.xmux.xp.S1 VSS sg13_lv_nmos ad=56.9f pd=0.74u as=56.9f ps=0.74u w=0.17u l=0.17u
X3350 cml_tlatch_18.xtail.S1 CKHB0_N cml_tlatch_18.xmux.xp.S1 VSS sg13_lv_nmos ad=89.3f pd=0.85u as=89.3f ps=0.85u w=0.47u l=0.16u
X3351 cml_tlatch_41.xmux.xp.S1 MOT14_P MOT14_N VSS sg13_lv_nmos ad=56.9f pd=0.74u as=56.9f ps=0.74u w=0.17u l=0.17u
X3352 cml_tlatch_89.xtail.S1 CKA2_N cml_tlatch_89.xmux.xn.S1 VSS sg13_lv_nmos ad=89.3f pd=0.85u as=89.3f ps=0.85u w=0.47u l=0.16u
X3353 cml_tlatch_68.xtail.S1 CKHB3_N cml_tlatch_68.xmux.xp.S1 VSS sg13_lv_nmos ad=0.1598p pd=1.62u as=89.3f ps=0.85u w=0.47u l=0.16u
X3354 stub_bi_42.BOTN VDD VSS rppd l=5.17u w=1u
X3355 cml_tlatch_67.xmux.xp.S1 cml_tlatch_67.OUTN cml_tlatch_67.OUTP VSS sg13_lv_nmos ad=56.9f pd=0.74u as=56.9f ps=0.74u w=0.17u l=0.17u
X3356 cml_tlatch_63.OUTP cml_tlatch_63.OUTN cml_tlatch_63.xmux.xp.S1 VSS sg13_lv_nmos ad=56.9f pd=0.74u as=56.9f ps=0.74u w=0.17u l=0.17u
X3357 cml_tlatch_11.xtail.S1 CKB0_N cml_tlatch_11.xmux.xp.S1 VSS sg13_lv_nmos ad=89.3f pd=0.85u as=89.3f ps=0.85u w=0.47u l=0.16u
X3358 cml_tlatch_64.xmux.xp.S1 A3_8_N A3_8_P VSS sg13_lv_nmos ad=56.9f pd=0.74u as=56.9f ps=0.74u w=0.17u l=0.17u
X3359 cml_tlatch_70.INN cml_tlatch_70.INP cml_tlatch_84.xmux.xp.S1 VSS sg13_lv_nmos ad=56.9f pd=0.74u as=56.9f ps=0.74u w=0.17u l=0.17u
X3360 cml_tlatch_6.xmux.xn.S1 CKHB1_P cml_tlatch_6.xtail.S1 VSS sg13_lv_nmos ad=89.3f pd=0.85u as=89.3f ps=0.85u w=0.47u l=0.16u
X3361 B1_8_N B1_8_P cml_tlatch_12.xmux.xp.S1 VSS sg13_lv_nmos ad=56.9f pd=0.74u as=56.9f ps=0.74u w=0.17u l=0.17u
X3362 cml_tlatch_35.OUTN cml_tlatch_35.OUTP cml_tlatch_35.xmux.xp.S1 VSS sg13_lv_nmos ad=56.9f pd=0.74u as=56.9f ps=0.74u w=0.17u l=0.17u
X3363 B0_8_P cml_tlatch_11.OUTN cml_tlatch_10.xmux.xn.S1 VSS sg13_lv_nmos ad=63.19999f pd=0.74u as=63.19999f ps=0.74u w=0.26u l=0.38u
X3364 cml_tlatch_19.xmux.xp.S1 MOT5_P MOT5_N VSS sg13_lv_nmos ad=56.9f pd=0.74u as=56.9f ps=0.74u w=0.17u l=0.17u
X3365 cml_tlatch_97.xtail.S1 CKHA0_P cml_tlatch_97.xmux.xn.S1 VSS sg13_lv_nmos ad=89.3f pd=0.85u as=89.3f ps=0.85u w=0.47u l=0.16u
X3366 GB0_P ENB1_N cml_gate2_1.sg13_lv_nmos_FTPY57_0.D0 VSS sg13_lv_nmos ad=0.1007p pd=0.91u as=0.1007p ps=0.91u w=0.53u l=0.13u
X3367 cml_tlatch_52.OUTP cml_tlatch_52.OUTN cml_tlatch_52.xmux.xp.S1 VSS sg13_lv_nmos ad=56.9f pd=0.74u as=56.9f ps=0.74u w=0.17u l=0.17u
X3368 MOT0_N A0_8_P cml_tlatch_97.xmux.xn.S1 VSS sg13_lv_nmos ad=63.19999f pd=0.74u as=63.19999f ps=0.74u w=0.26u l=0.38u
X3369 cml_tlatch_7.xmux.xn.S1 B1_2_P MOT15_N VSS sg13_lv_nmos ad=63.19999f pd=0.74u as=63.19999f ps=0.74u w=0.26u l=0.38u
X3370 MOT8_N VDD VSS rppd l=5.17u w=1u
X3371 cml_tlatch_33.xtail.S1 CKB1_N cml_tlatch_33.xmux.xn.S1 VSS sg13_lv_nmos ad=89.3f pd=0.85u as=0.1598p ps=1.62u w=0.47u l=0.16u
X3372 cml_tlatch_34.xmux.xp.S1 stub_bi_31.BOTN stub_bi_31.BOTP VSS sg13_lv_nmos ad=56.9f pd=0.74u as=56.9f ps=0.74u w=0.17u l=0.17u
X3373 cml_tlatch_4.xtail.S1 CKHB1_N cml_tlatch_4.xmux.xp.S1 VSS sg13_lv_nmos ad=89.3f pd=0.85u as=89.3f ps=0.85u w=0.47u l=0.16u
X3374 cml_tlatch_85.xmux.xp.S1 cml_tlatch_58.INN cml_tlatch_58.INP VSS sg13_lv_nmos ad=56.9f pd=0.74u as=56.9f ps=0.74u w=0.17u l=0.17u
X3375 MOT31_N B3_2_P cml_tlatch_71.xmux.xn.S1 VSS sg13_lv_nmos ad=63.19999f pd=0.74u as=63.19999f ps=0.74u w=0.26u l=0.38u
X3376 cml_tlatch_24.xtail.S1 CKHA0_N cml_tlatch_24.xmux.xp.S1 VSS sg13_lv_nmos ad=89.3f pd=0.85u as=89.3f ps=0.85u w=0.47u l=0.16u
X3377 cml_gate2_3.sg13_lv_nmos_FTPY57_0.D0 ENA0_N GA1_P VSS sg13_lv_nmos ad=0.1007p pd=0.91u as=0.1007p ps=0.91u w=0.53u l=0.13u
X3378 cml_tlatch_23.xtail.S1 CKA1_P cml_tlatch_23.xmux.xp.S1 VSS sg13_lv_nmos ad=89.3f pd=0.85u as=89.3f ps=0.85u w=0.47u l=0.16u
X3379 VDD interco_bi_19.INN VSS rppd l=5.17u w=1u
X3380 stub_bi_29.BOTN stub_bi_29.BOTP cml_tlatch_32.xmux.xp.S1 VSS sg13_lv_nmos ad=56.9f pd=0.74u as=56.9f ps=0.74u w=0.17u l=0.17u
X3381 CKJ_P CK_P hs_to_clk_8.D2 VSS sg13_lv_nmos ad=0.408p pd=3.08u as=0.228p ps=1.58u w=1.2u l=0.2u
X3382 cml_tlatch_99.OUTN cml_tlatch_30.OUTP cml_tlatch_99.xmux.xn.S1 VSS sg13_lv_nmos ad=63.19999f pd=0.74u as=63.19999f ps=0.74u w=0.26u l=0.38u
X3383 A1_8_P A1_8_N cml_tlatch_21.xmux.xp.S1 VSS sg13_lv_nmos ad=56.9f pd=0.74u as=56.9f ps=0.74u w=0.17u l=0.17u
X3384 cml_tlatch_48.xmux.xp.S1 stub_bi_32.BOTP stub_bi_32.BOTN VSS sg13_lv_nmos ad=56.9f pd=0.74u as=56.9f ps=0.74u w=0.17u l=0.17u
X3385 stub_bi_42.BOTN B2_2_N cml_tlatch_43.xmux.xn.S1 VSS sg13_lv_nmos ad=63.19999f pd=0.74u as=63.19999f ps=0.74u w=0.26u l=0.38u
X3386 cml_tlatch_21.xtail.S1 CKA1_P cml_tlatch_21.xmux.xp.S1 VSS sg13_lv_nmos ad=89.3f pd=0.85u as=89.3f ps=0.85u w=0.47u l=0.16u
X3387 cml_tlatch_5.INP cml_tlatch_5.INN cml_tlatch_14.xmux.xp.S1 VSS sg13_lv_nmos ad=56.9f pd=0.74u as=56.9f ps=0.74u w=0.17u l=0.17u
X3388 cml_tlatch_13.xmux.xn.S1 cml_tlatch_5.INP stub_bi_17.BOTP VSS sg13_lv_nmos ad=0.1082p pd=1.34u as=63.19999f ps=0.74u w=0.26u l=0.38u
X3389 cml_tlatch_88.xtail.S1 POLN VSS VSS sg13_lv_nmos ad=1.5637p pd=8.61u as=1.5637p ps=8.61u w=8.23u l=0.13u
X3390 J4_N J4_P cml_tlatch_90.xmux.xp.S1 VSS sg13_lv_nmos ad=56.9f pd=0.74u as=56.9f ps=0.74u w=0.17u l=0.17u
X3391 cml_tlatch_84.xmux.xp.S1 cml_tlatch_70.INP cml_tlatch_70.INN VSS sg13_lv_nmos ad=56.9f pd=0.74u as=56.9f ps=0.74u w=0.17u l=0.17u
X3392 cml_gate2_6.xrtail.R1 CKA3_P cml_gate2_6.sg13_lv_nmos_FTPY57_0.D0 VSS sg13_lv_nmos ad=0.1007p pd=0.91u as=0.1007p ps=0.91u w=0.53u l=0.13u
X3393 cml_tlatch_1.xmux.xp.S1 cml_tlatch_1.OUTP cml_tlatch_1.OUTN VSS sg13_lv_nmos ad=56.9f pd=0.74u as=56.9f ps=0.74u w=0.17u l=0.17u
X3394 cml_tlatch_90.xmux.xn.S1 CLK_W_N J4_N VSS sg13_lv_nmos ad=63.19999f pd=0.74u as=63.19999f ps=0.74u w=0.26u l=0.38u
X3395 cml_tlatch_69.xmux.xn.S1 cml_tlatch_69.INP MOT27_N VSS sg13_lv_nmos ad=63.19999f pd=0.74u as=63.19999f ps=0.74u w=0.26u l=0.38u
X3396 cml_tlatch_65.OUTP cml_tlatch_65.OUTN cml_tlatch_65.xmux.xp.S1 VSS sg13_lv_nmos ad=56.9f pd=0.74u as=56.9f ps=0.74u w=0.17u l=0.17u
X3397 cml_tlatch_9.xmux.xn.S1 cml_tlatch_99.OUTP cml_tlatch_9.OUTN VSS sg13_lv_nmos ad=63.19999f pd=0.74u as=63.19999f ps=0.74u w=0.26u l=0.38u
X3398 MOT19_P MOT19_N cml_tlatch_74.xmux.xp.S1 VSS sg13_lv_nmos ad=56.9f pd=0.74u as=56.9f ps=0.74u w=0.17u l=0.17u
X3399 ENB1_P ENB_N cml_drv_0.xrtail.R1 VSS sg13_lv_nmos ad=56.2f pd=0.74u as=56.2f ps=0.74u w=0.16u l=0.19u
X3400 cml_tlatch_56.INN cml_tlatch_56.INP cml_tlatch_42.xmux.xp.S1 VSS sg13_lv_nmos ad=56.9f pd=0.74u as=0.1019p ps=1.34u w=0.17u l=0.17u
X3401 cml_tlatch_69.xmux.xn.S1 cml_tlatch_69.INP MOT27_N VSS sg13_lv_nmos ad=63.19999f pd=0.74u as=63.19999f ps=0.74u w=0.26u l=0.38u
X3402 cml_tlatch_75.xmux.xn.S1 CKHB2_P cml_tlatch_75.xtail.S1 VSS sg13_lv_nmos ad=89.3f pd=0.85u as=89.3f ps=0.85u w=0.47u l=0.16u
X3403 CKA2_P CK_P hs_to_clk_4.D2 VSS sg13_lv_nmos ad=0.408p pd=3.08u as=0.228p ps=1.58u w=1.2u l=0.2u
X3404 cml_tlatch_69.xmux.xp.S1 MOT27_P MOT27_N VSS sg13_lv_nmos ad=56.9f pd=0.74u as=56.9f ps=0.74u w=0.17u l=0.17u
X3405 cml_tlatch_43.xmux.xn.S1 B2_2_P stub_bi_42.BOTP VSS sg13_lv_nmos ad=63.19999f pd=0.74u as=0.1082p ps=1.34u w=0.26u l=0.38u
X3406 cml_tlatch_16.OUTN cml_tlatch_1.OUTP cml_tlatch_16.xmux.xn.S1 VSS sg13_lv_nmos ad=63.19999f pd=0.74u as=63.19999f ps=0.74u w=0.26u l=0.38u
X3407 cml_tlatch_17.xmux.xp.S1 MOT1_P MOT1_N VSS sg13_lv_nmos ad=56.9f pd=0.74u as=56.9f ps=0.74u w=0.17u l=0.17u
X3408 cml_tlatch_7.xtail.S1 CKHB1_P cml_tlatch_7.xmux.xn.S1 VSS sg13_lv_nmos ad=0.1598p pd=1.62u as=89.3f ps=0.85u w=0.47u l=0.16u
X3409 cml_tlatch_12.xtail.S1 CKB1_P cml_tlatch_12.xmux.xp.S1 VSS sg13_lv_nmos ad=89.3f pd=0.85u as=89.3f ps=0.85u w=0.47u l=0.16u
X3410 cml_tlatch_32.xtail.S1 CKB1_P cml_tlatch_32.xmux.xn.S1 VSS sg13_lv_nmos ad=89.3f pd=0.85u as=89.3f ps=0.85u w=0.47u l=0.16u
X3411 MOT4_P MOT4_N cml_tlatch_25.xmux.xp.S1 VSS sg13_lv_nmos ad=56.9f pd=0.74u as=56.9f ps=0.74u w=0.17u l=0.17u
X3412 cml_tlatch_81.xtail.S1 CKA2_P cml_tlatch_81.xmux.xp.S1 VSS sg13_lv_nmos ad=89.3f pd=0.85u as=89.3f ps=0.85u w=0.47u l=0.16u
X3413 cml_tlatch_69.INP cml_tlatch_69.INN cml_tlatch_62.xmux.xp.S1 VSS sg13_lv_nmos ad=56.9f pd=0.74u as=56.9f ps=0.74u w=0.17u l=0.17u
X3414 VSS POLN cml_tlatch_26.xtail.S1 VSS sg13_lv_nmos ad=1.5637p pd=8.61u as=1.5637p ps=8.61u w=8.23u l=0.13u
X3415 cml_gate2_9.sg13_lv_nmos_FTPY57_0.D0 J1_N ENA_P VSS sg13_lv_nmos ad=0.1007p pd=0.91u as=0.1007p ps=0.91u w=0.53u l=0.13u
X3416 GB3_P CKA3_N cml_gate2_6.xrtail.R1 VSS sg13_lv_nmos ad=0.1007p pd=0.91u as=0.1007p ps=0.91u w=0.53u l=0.13u
X3417 A1_2_P cml_tlatch_38.OUTN cml_tlatch_37.xmux.xn.S1 VSS sg13_lv_nmos ad=63.19999f pd=0.74u as=63.19999f ps=0.74u w=0.26u l=0.38u
X3418 stub_bi_19.BOTN stub_bi_19.BOTP cml_tlatch_15.xmux.xp.S1 VSS sg13_lv_nmos ad=56.9f pd=0.74u as=56.9f ps=0.74u w=0.17u l=0.17u
X3419 cml_tlatch_70.xmux.xn.S1 CKHB3_P cml_tlatch_70.xtail.S1 VSS sg13_lv_nmos ad=89.3f pd=0.85u as=89.3f ps=0.85u w=0.47u l=0.16u
X3420 GA2_P CKB2_N cml_gate2_4.xrtail.R1 VSS sg13_lv_nmos ad=0.1007p pd=0.91u as=0.1007p ps=0.91u w=0.53u l=0.13u
X3421 cml_tlatch_43.xmux.xp.S1 stub_bi_42.BOTN stub_bi_42.BOTP VSS sg13_lv_nmos ad=56.9f pd=0.74u as=56.9f ps=0.74u w=0.17u l=0.17u
X3422 cml_tlatch_95.INN cml_tlatch_95.INP cml_tlatch_36.xmux.xp.S1 VSS sg13_lv_nmos ad=56.9f pd=0.74u as=56.9f ps=0.74u w=0.17u l=0.17u
X3423 cml_tlatch_90.xmux.xn.S1 CKJ_N cml_tlatch_90.xtail.S1 VSS sg13_lv_nmos ad=89.3f pd=0.85u as=89.3f ps=0.85u w=0.47u l=0.16u
X3424 cml_tlatch_83.OUTN cml_tlatch_83.INP cml_tlatch_83.xmux.xn.S1 VSS sg13_lv_nmos ad=63.19999f pd=0.74u as=63.19999f ps=0.74u w=0.26u l=0.38u
X3425 cml_tlatch_45.xmux.xp.S1 CKB3_N cml_tlatch_45.xtail.S1 VSS sg13_lv_nmos ad=89.3f pd=0.85u as=89.3f ps=0.85u w=0.47u l=0.16u
X3426 cml_tlatch_18.xmux.xp.S1 MOT3_N MOT3_P VSS sg13_lv_nmos ad=56.9f pd=0.74u as=56.9f ps=0.74u w=0.17u l=0.17u
X3427 GB3_P ENB0_N cml_gate2_6.sg13_lv_nmos_FTPY57_0.D0 VSS sg13_lv_nmos ad=0.1007p pd=0.91u as=0.1007p ps=0.91u w=0.53u l=0.13u
X3428 MOT6_P MOT6_N cml_tlatch_26.xmux.xp.S1 VSS sg13_lv_nmos ad=56.9f pd=0.74u as=56.9f ps=0.74u w=0.17u l=0.17u
X3429 cml_tlatch_64.xmux.xn.S1 cml_tlatch_65.OUTN A3_8_P VSS sg13_lv_nmos ad=63.19999f pd=0.74u as=63.19999f ps=0.74u w=0.26u l=0.38u
X3430 cml_gate2_3.xrtail.R1 CKB1_P cml_gate2_3.sg13_lv_nmos_FTPY57_0.D0 VSS sg13_lv_nmos ad=0.1007p pd=0.91u as=0.1007p ps=0.91u w=0.53u l=0.13u
X3431 stub_bi_63.BOTN stub_bi_49.BOTP cml_tlatch_79.xmux.xn.S1 VSS sg13_lv_nmos ad=63.19999f pd=0.74u as=63.19999f ps=0.74u w=0.26u l=0.38u
X3432 cml_tlatch_16.xtail.S1 CKB0_P cml_tlatch_16.xmux.xp.S1 VSS sg13_lv_nmos ad=89.3f pd=0.85u as=0.1598p ps=1.62u w=0.47u l=0.16u
X3433 cml_tlatch_8.OUTN cml_tlatch_8.OUTP cml_tlatch_8.xmux.xp.S1 VSS sg13_lv_nmos ad=56.9f pd=0.74u as=56.9f ps=0.74u w=0.17u l=0.17u
X3434 cml_tlatch_82.xtail.S1 CKA2_P cml_tlatch_82.xmux.xn.S1 VSS sg13_lv_nmos ad=89.3f pd=0.85u as=89.3f ps=0.85u w=0.47u l=0.16u
X3435 cml_tlatch_53.xtail.S1 POLN VSS VSS sg13_lv_nmos ad=1.5637p pd=8.61u as=2.7982p ps=17.14u w=8.23u l=0.13u
X3436 cml_tlatch_29.xtail.S1 POLN VSS VSS sg13_lv_nmos ad=1.5637p pd=8.61u as=2.7982p ps=17.14u w=8.23u l=0.13u
X3437 cml_tlatch_23.xtail.S1 CKA1_P cml_tlatch_23.xmux.xp.S1 VSS sg13_lv_nmos ad=89.3f pd=0.85u as=89.3f ps=0.85u w=0.47u l=0.16u
X3438 GA0_P ENA0_N cml_gate2_2.sg13_lv_nmos_FTPY57_0.D0 VSS sg13_lv_nmos ad=0.1007p pd=0.91u as=0.1802p ps=1.74u w=0.53u l=0.13u
X3439 cml_tlatch_56.INN cml_tlatch_56.INP cml_tlatch_42.xmux.xp.S1 VSS sg13_lv_nmos ad=56.9f pd=0.74u as=56.9f ps=0.74u w=0.17u l=0.17u
X3440 cml_tlatch_11.OUTP cml_tlatch_11.OUTN cml_tlatch_11.xmux.xp.S1 VSS sg13_lv_nmos ad=56.9f pd=0.74u as=56.9f ps=0.74u w=0.17u l=0.17u
X3441 stub_bi_63.BOTP VDD VSS rppd l=5.17u w=1u
X3442 cml_tlatch_24.xmux.xp.S1 MOT2_P MOT2_N VSS sg13_lv_nmos ad=56.9f pd=0.74u as=56.9f ps=0.74u w=0.17u l=0.17u
X3443 cml_tlatch_44.xmux.xp.S1 B2_2_P B2_2_N VSS sg13_lv_nmos ad=56.9f pd=0.74u as=56.9f ps=0.74u w=0.17u l=0.17u
X3444 cml_tlatch_17.xtail.S1 CKHB0_P cml_tlatch_17.xmux.xn.S1 VSS sg13_lv_nmos ad=89.3f pd=0.85u as=89.3f ps=0.85u w=0.47u l=0.16u
X3445 B0_8_P B0_8_N cml_tlatch_10.xmux.xp.S1 VSS sg13_lv_nmos ad=56.9f pd=0.74u as=56.9f ps=0.74u w=0.17u l=0.17u
X3446 cml_tlatch_52.xtail.S1 CKA3_P cml_tlatch_52.xmux.xn.S1 VSS sg13_lv_nmos ad=89.3f pd=0.85u as=89.3f ps=0.85u w=0.47u l=0.16u
X3447 MOT0_P MOT0_N cml_tlatch_97.xmux.xp.S1 VSS sg13_lv_nmos ad=56.9f pd=0.74u as=56.9f ps=0.74u w=0.17u l=0.17u
X3448 cml_tlatch_58.INP cml_tlatch_52.OUTN cml_tlatch_85.xmux.xn.S1 VSS sg13_lv_nmos ad=63.19999f pd=0.74u as=0.1082p ps=1.34u w=0.26u l=0.38u
X3449 cml_tlatch_75.xmux.xp.S1 MOT21_N MOT21_P VSS sg13_lv_nmos ad=56.9f pd=0.74u as=56.9f ps=0.74u w=0.17u l=0.17u
X3450 cml_tlatch_78.xtail.S1 CKB2_P cml_tlatch_78.xmux.xn.S1 VSS sg13_lv_nmos ad=0.1598p pd=1.62u as=89.3f ps=0.85u w=0.47u l=0.16u
X3451 MOT7_P MOT7_N cml_tlatch_20.xmux.xp.S1 VSS sg13_lv_nmos ad=56.9f pd=0.74u as=56.9f ps=0.74u w=0.17u l=0.17u
X3452 MOT16_P A2_8_N cml_tlatch_87.xmux.xn.S1 VSS sg13_lv_nmos ad=0.1082p pd=1.34u as=63.19999f ps=0.74u w=0.26u l=0.38u
X3453 CLK_W_N CLK_W_P cml_tlatch_91.xmux.xp.S1 VSS sg13_lv_nmos ad=56.9f pd=0.74u as=56.9f ps=0.74u w=0.17u l=0.17u
X3454 cml_tlatch_54.OUTP cml_tlatch_54.OUTN cml_tlatch_54.xmux.xp.S1 VSS sg13_lv_nmos ad=56.9f pd=0.74u as=56.9f ps=0.74u w=0.17u l=0.17u
X3455 cml_tlatch_49.xtail.S1 POLN VSS VSS sg13_lv_nmos ad=1.5637p pd=8.61u as=2.7982p ps=17.14u w=8.23u l=0.13u
X3456 cml_tlatch_91.xtail.S1 POLN VSS VSS sg13_lv_nmos ad=1.5637p pd=8.61u as=1.5637p ps=8.61u w=8.23u l=0.13u
X3457 cml_tlatch_81.xmux.xn.S1 cml_tlatch_82.OUTP A2_8_N VSS sg13_lv_nmos ad=63.19999f pd=0.74u as=63.19999f ps=0.74u w=0.26u l=0.38u
X3458 B3_2_P cml_tlatch_47.OUTN cml_tlatch_46.xmux.xn.S1 VSS sg13_lv_nmos ad=63.19999f pd=0.74u as=63.19999f ps=0.74u w=0.26u l=0.38u
X3459 cml_tlatch_96.xtail.S1 CKHA1_N cml_tlatch_96.xmux.xp.S1 VSS sg13_lv_nmos ad=89.3f pd=0.85u as=89.3f ps=0.85u w=0.47u l=0.16u
X3460 cml_tlatch_81.xmux.xn.S1 cml_tlatch_82.OUTP A2_8_N VSS sg13_lv_nmos ad=63.19999f pd=0.74u as=63.19999f ps=0.74u w=0.26u l=0.38u
X3461 cml_tlatch_45.OUTN VDD VSS rppd l=5.17u w=1u
X3462 cml_tlatch_61.xmux.xp.S1 cml_tlatch_61.OUTN cml_tlatch_61.OUTP VSS sg13_lv_nmos ad=56.9f pd=0.74u as=56.9f ps=0.74u w=0.17u l=0.17u
X3463 stub_bi_49.BOTP stub_bi_49.BOTN cml_tlatch_80.xmux.xp.S1 VSS sg13_lv_nmos ad=56.9f pd=0.74u as=56.9f ps=0.74u w=0.17u l=0.17u
X3464 cml_tlatch_0.xmux.xp.S1 interco_bi_19.INP interco_bi_19.INN VSS sg13_lv_nmos ad=56.9f pd=0.74u as=56.9f ps=0.74u w=0.17u l=0.17u
X3465 ENB0_N ENB_P cml_drv_2.xrtail.R1 VSS sg13_lv_nmos ad=56.2f pd=0.74u as=56.2f ps=0.74u w=0.16u l=0.19u
X3466 B0_8_N cml_tlatch_11.OUTP cml_tlatch_10.xmux.xn.S1 VSS sg13_lv_nmos ad=63.19999f pd=0.74u as=63.19999f ps=0.74u w=0.26u l=0.38u
X3467 MOT12_N MOT12_P cml_tlatch_40.xmux.xp.S1 VSS sg13_lv_nmos ad=56.9f pd=0.74u as=56.9f ps=0.74u w=0.17u l=0.17u
X3468 J2_N J2_P cml_tlatch_92.xmux.xp.S1 VSS sg13_lv_nmos ad=56.9f pd=0.74u as=56.9f ps=0.74u w=0.17u l=0.17u
X3469 VSS POLN cml_tlatch_55.xtail.S1 VSS sg13_lv_nmos ad=2.7982p pd=17.14u as=1.5637p ps=8.61u w=8.23u l=0.13u
X3470 A3_2_N A3_2_P cml_tlatch_53.xmux.xp.S1 VSS sg13_lv_nmos ad=56.9f pd=0.74u as=0.1019p ps=1.34u w=0.17u l=0.17u
X3471 MOT25_N MOT25_P cml_tlatch_68.xmux.xp.S1 VSS sg13_lv_nmos ad=56.9f pd=0.74u as=56.9f ps=0.74u w=0.17u l=0.17u
X3472 MOT18_P MOT18_N cml_tlatch_49.xmux.xp.S1 VSS sg13_lv_nmos ad=56.9f pd=0.74u as=56.9f ps=0.74u w=0.17u l=0.17u
X3473 interco_bi_19.INP cml_tlatch_40.INN cml_tlatch_0.xmux.xn.S1 VSS sg13_lv_nmos ad=0.1082p pd=1.34u as=63.19999f ps=0.74u w=0.26u l=0.38u
X3474 cml_tlatch_73.xtail.S1 CKHB2_P cml_tlatch_73.xmux.xn.S1 VSS sg13_lv_nmos ad=89.3f pd=0.85u as=89.3f ps=0.85u w=0.47u l=0.16u
X3475 cml_tlatch_18.xmux.xn.S1 CKHB0_P cml_tlatch_18.xtail.S1 VSS sg13_lv_nmos ad=0.1598p pd=1.62u as=89.3f ps=0.85u w=0.47u l=0.16u
X3476 cml_tlatch_34.xmux.xn.S1 CKB1_P cml_tlatch_34.xtail.S1 VSS sg13_lv_nmos ad=89.3f pd=0.85u as=89.3f ps=0.85u w=0.47u l=0.16u
X3477 VSS hs_to_clk_6.sg13_lv_nmos_2HGZLP_0.G VSS VSS sg13_lv_nmos ad=2.071p pd=11.28u as=0 ps=0 w=10.9u l=1.38u
X3478 cml_tlatch_61.xmux.xp.S1 cml_tlatch_61.OUTN cml_tlatch_61.OUTP VSS sg13_lv_nmos ad=0.1019p pd=1.34u as=56.9f ps=0.74u w=0.17u l=0.17u
X3479 MOT19_P MOT19_N cml_tlatch_74.xmux.xp.S1 VSS sg13_lv_nmos ad=56.9f pd=0.74u as=56.9f ps=0.74u w=0.17u l=0.17u
X3480 cml_tlatch_69.xmux.xp.S1 MOT27_N MOT27_P VSS sg13_lv_nmos ad=56.9f pd=0.74u as=56.9f ps=0.74u w=0.17u l=0.17u
X3481 cml_tlatch_76.xmux.xn.S1 CKHB2_P cml_tlatch_76.xtail.S1 VSS sg13_lv_nmos ad=89.3f pd=0.85u as=89.3f ps=0.85u w=0.47u l=0.16u
X3482 cml_tlatch_89.xmux.xp.S1 cml_tlatch_89.OUTP cml_tlatch_89.OUTN VSS sg13_lv_nmos ad=0.1019p pd=1.34u as=56.9f ps=0.74u w=0.17u l=0.17u
X3483 cml_tlatch_97.xmux.xn.S1 CKHA0_P cml_tlatch_97.xtail.S1 VSS sg13_lv_nmos ad=89.3f pd=0.85u as=0.1598p ps=1.62u w=0.47u l=0.16u
X3484 cml_tlatch_37.xmux.xp.S1 CKA1_P cml_tlatch_37.xtail.S1 VSS sg13_lv_nmos ad=89.3f pd=0.85u as=89.3f ps=0.85u w=0.47u l=0.16u
X3485 B2_2_N stub_bi_32.BOTN cml_tlatch_44.xmux.xn.S1 VSS sg13_lv_nmos ad=63.19999f pd=0.74u as=63.19999f ps=0.74u w=0.26u l=0.38u
X3486 cml_tlatch_61.xmux.xn.S1 cml_tlatch_69.INN cml_tlatch_61.OUTP VSS sg13_lv_nmos ad=63.19999f pd=0.74u as=0.1082p ps=1.34u w=0.26u l=0.38u
X3487 MOT13_N MOT13_P cml_tlatch_6.xmux.xp.S1 VSS sg13_lv_nmos ad=56.9f pd=0.74u as=56.9f ps=0.74u w=0.17u l=0.17u
X3488 stub_bi_17.BOTN stub_bi_17.BOTP cml_tlatch_13.xmux.xp.S1 VSS sg13_lv_nmos ad=56.9f pd=0.74u as=56.9f ps=0.74u w=0.17u l=0.17u
X3489 cml_tlatch_47.xtail.S1 CKB3_N cml_tlatch_47.xmux.xp.S1 VSS sg13_lv_nmos ad=89.3f pd=0.85u as=89.3f ps=0.85u w=0.47u l=0.16u
X3490 cml_tlatch_83.xmux.xp.S1 cml_tlatch_83.OUTP cml_tlatch_83.OUTN VSS sg13_lv_nmos ad=56.9f pd=0.74u as=56.9f ps=0.74u w=0.17u l=0.17u
X3491 cml_tlatch_69.INN cml_tlatch_69.INP cml_tlatch_62.xmux.xp.S1 VSS sg13_lv_nmos ad=56.9f pd=0.74u as=56.9f ps=0.74u w=0.17u l=0.17u
X3492 A2_2_P cml_tlatch_56.INN cml_tlatch_56.xmux.xn.S1 VSS sg13_lv_nmos ad=0.1082p pd=1.34u as=63.19999f ps=0.74u w=0.26u l=0.38u
X3493 cml_tlatch_83.xmux.xp.S1 cml_tlatch_83.OUTN cml_tlatch_83.OUTP VSS sg13_lv_nmos ad=56.9f pd=0.74u as=56.9f ps=0.74u w=0.17u l=0.17u
X3494 cml_tlatch_89.OUTP cml_tlatch_89.OUTN cml_tlatch_89.xmux.xp.S1 VSS sg13_lv_nmos ad=56.9f pd=0.74u as=56.9f ps=0.74u w=0.17u l=0.17u
X3495 cml_tlatch_88.xmux.xp.S1 stub_bi_55.BOTP stub_bi_55.BOTN VSS sg13_lv_nmos ad=56.9f pd=0.74u as=56.9f ps=0.74u w=0.17u l=0.17u
X3496 cml_tlatch_24.xmux.xp.S1 MOT2_N MOT2_P VSS sg13_lv_nmos ad=56.9f pd=0.74u as=56.9f ps=0.74u w=0.17u l=0.17u
X3497 cml_tlatch_87.xtail.S1 CKHA2_N cml_tlatch_87.xmux.xp.S1 VSS sg13_lv_nmos ad=89.3f pd=0.85u as=89.3f ps=0.85u w=0.47u l=0.16u
X3498 cml_tlatch_80.xmux.xn.S1 CKB2_P cml_tlatch_80.xtail.S1 VSS sg13_lv_nmos ad=89.3f pd=0.85u as=89.3f ps=0.85u w=0.47u l=0.16u
X3499 cml_tlatch_87.xmux.xp.S1 MOT16_N MOT16_P VSS sg13_lv_nmos ad=56.9f pd=0.74u as=56.9f ps=0.74u w=0.17u l=0.17u
X3500 cml_tlatch_74.xmux.xp.S1 CKHB2_N cml_tlatch_74.xtail.S1 VSS sg13_lv_nmos ad=89.3f pd=0.85u as=89.3f ps=0.85u w=0.47u l=0.16u
X3501 cml_tlatch_27.xtail.S1 CKB0_P cml_tlatch_27.xmux.xn.S1 VSS sg13_lv_nmos ad=89.3f pd=0.85u as=89.3f ps=0.85u w=0.47u l=0.16u
X3502 cml_tlatch_39.xmux.xn.S1 cml_tlatch_39.INN MOT10_P VSS sg13_lv_nmos ad=63.19999f pd=0.74u as=63.19999f ps=0.74u w=0.26u l=0.38u
X3503 CKB3_P hs_to_clk_5.sg13_lv_nmos_2HGZLP_0.G VSS rppd l=4.25u w=1u
X3504 VSS POLN hs_to_clk_8.D2 VSS sg13_lv_nmos ad=1.9p pd=10.38u as=1.9p ps=10.38u w=10u l=0.13u
X3505 cml_tlatch_99.xtail.S1 CKA0_N cml_tlatch_99.xmux.xn.S1 VSS sg13_lv_nmos ad=89.3f pd=0.85u as=89.3f ps=0.85u w=0.47u l=0.16u
X3506 cml_tlatch_34.xmux.xn.S1 D1_P stub_bi_31.BOTP VSS sg13_lv_nmos ad=0.1082p pd=1.34u as=63.19999f ps=0.74u w=0.26u l=0.38u
X3507 cml_tlatch_81.xmux.xp.S1 A2_8_P A2_8_N VSS sg13_lv_nmos ad=56.9f pd=0.74u as=56.9f ps=0.74u w=0.17u l=0.17u
X3508 VDD A3_8_P VSS rppd l=5.17u w=1u
X3509 cml_gate2_0.sg13_lv_nmos_FTPY57_0.D0 ENB1_P GB1_N VSS sg13_lv_nmos ad=0.1007p pd=0.91u as=0.1007p ps=0.91u w=0.53u l=0.13u
X3510 cml_tlatch_41.xmux.xp.S1 MOT14_N MOT14_P VSS sg13_lv_nmos ad=56.9f pd=0.74u as=56.9f ps=0.74u w=0.17u l=0.17u
X3511 MOT29_N MOT29_P cml_tlatch_70.xmux.xp.S1 VSS sg13_lv_nmos ad=56.9f pd=0.74u as=56.9f ps=0.74u w=0.17u l=0.17u
X3512 cml_tlatch_24.xtail.S1 CKHA0_P cml_tlatch_24.xmux.xn.S1 VSS sg13_lv_nmos ad=89.3f pd=0.85u as=89.3f ps=0.85u w=0.47u l=0.16u
X3513 cml_tlatch_87.xmux.xn.S1 CKHA2_P cml_tlatch_87.xtail.S1 VSS sg13_lv_nmos ad=89.3f pd=0.85u as=89.3f ps=0.85u w=0.47u l=0.16u
X3514 cml_tlatch_4.xtail.S1 CKHB1_P cml_tlatch_4.xmux.xn.S1 VSS sg13_lv_nmos ad=89.3f pd=0.85u as=89.3f ps=0.85u w=0.47u l=0.16u
X3515 MOT1_P MOT1_N cml_tlatch_17.xmux.xp.S1 VSS sg13_lv_nmos ad=56.9f pd=0.74u as=56.9f ps=0.74u w=0.17u l=0.17u
X3516 cml_tlatch_47.xmux.xp.S1 cml_tlatch_47.OUTN cml_tlatch_47.OUTP VSS sg13_lv_nmos ad=56.9f pd=0.74u as=56.9f ps=0.74u w=0.17u l=0.17u
X3517 cml_tlatch_29.xmux.xn.S1 D0_P cml_tlatch_29.OUTN VSS sg13_lv_nmos ad=63.19999f pd=0.74u as=63.19999f ps=0.74u w=0.26u l=0.38u
X3518 cml_tlatch_7.xmux.xn.S1 CKHB1_P cml_tlatch_7.xtail.S1 VSS sg13_lv_nmos ad=89.3f pd=0.85u as=89.3f ps=0.85u w=0.47u l=0.16u
X3519 cml_tlatch_32.xmux.xn.S1 CKB1_P cml_tlatch_32.xtail.S1 VSS sg13_lv_nmos ad=89.3f pd=0.85u as=89.3f ps=0.85u w=0.47u l=0.16u
X3520 cml_tlatch_11.xtail.S1 CKB0_N cml_tlatch_11.xmux.xp.S1 VSS sg13_lv_nmos ad=89.3f pd=0.85u as=89.3f ps=0.85u w=0.47u l=0.16u
X3521 cml_tlatch_55.xmux.xp.S1 cml_tlatch_89.INN cml_tlatch_89.INP VSS sg13_lv_nmos ad=56.9f pd=0.74u as=56.9f ps=0.74u w=0.17u l=0.17u
X3522 cml_tlatch_28.xtail.S1 CKB0_N cml_tlatch_28.xmux.xn.S1 VSS sg13_lv_nmos ad=89.3f pd=0.85u as=89.3f ps=0.85u w=0.47u l=0.16u
X3523 cml_tlatch_0.xmux.xp.S1 interco_bi_19.INP interco_bi_19.INN VSS sg13_lv_nmos ad=56.9f pd=0.74u as=56.9f ps=0.74u w=0.17u l=0.17u
X3524 VDD GA2_N VSS rppd l=7.42u w=1u
X3525 cml_tlatch_29.xmux.xn.S1 D0_P cml_tlatch_29.OUTN VSS sg13_lv_nmos ad=63.19999f pd=0.74u as=63.19999f ps=0.74u w=0.26u l=0.38u
X3526 MOT0_P MOT0_N cml_tlatch_97.xmux.xp.S1 VSS sg13_lv_nmos ad=56.9f pd=0.74u as=56.9f ps=0.74u w=0.17u l=0.17u
X3527 cml_tlatch_66.xmux.xp.S1 CKA3_P cml_tlatch_66.xtail.S1 VSS sg13_lv_nmos ad=0.1598p pd=1.62u as=89.3f ps=0.85u w=0.47u l=0.16u
X3528 cml_tlatch_58.xmux.xp.S1 CKHA3_N cml_tlatch_58.xtail.S1 VSS sg13_lv_nmos ad=89.3f pd=0.85u as=89.3f ps=0.85u w=0.47u l=0.16u
X3529 cml_tlatch_49.xmux.xp.S1 CKHA2_N cml_tlatch_49.xtail.S1 VSS sg13_lv_nmos ad=0.1598p pd=1.62u as=89.3f ps=0.85u w=0.47u l=0.16u
X3530 cml_tlatch_75.xmux.xp.S1 MOT21_N MOT21_P VSS sg13_lv_nmos ad=0.1019p pd=1.34u as=56.9f ps=0.74u w=0.17u l=0.17u
X3531 MOT29_P MOT29_N cml_tlatch_70.xmux.xp.S1 VSS sg13_lv_nmos ad=56.9f pd=0.74u as=56.9f ps=0.74u w=0.17u l=0.17u
X3532 GB1_P ENB1_N cml_gate2_0.sg13_lv_nmos_FTPY57_0.D0 VSS sg13_lv_nmos ad=0.1007p pd=0.91u as=0.1007p ps=0.91u w=0.53u l=0.13u
X3533 cml_tlatch_47.xmux.xp.S1 cml_tlatch_47.OUTN cml_tlatch_47.OUTP VSS sg13_lv_nmos ad=0.1019p pd=1.34u as=56.9f ps=0.74u w=0.17u l=0.17u
X3534 cml_tlatch_59.xmux.xp.S1 MOT30_N MOT30_P VSS sg13_lv_nmos ad=56.9f pd=0.74u as=56.9f ps=0.74u w=0.17u l=0.17u
X3535 MOT16_N MOT16_P cml_tlatch_87.xmux.xp.S1 VSS sg13_lv_nmos ad=56.9f pd=0.74u as=56.9f ps=0.74u w=0.17u l=0.17u
X3536 cml_tlatch_2.xtail.S1 CKA0_P cml_tlatch_2.xmux.xp.S1 VSS sg13_lv_nmos ad=89.3f pd=0.85u as=89.3f ps=0.85u w=0.47u l=0.16u
X3537 cml_tlatch_86.xmux.xp.S1 MOT24_P MOT24_N VSS sg13_lv_nmos ad=56.9f pd=0.74u as=56.9f ps=0.74u w=0.17u l=0.17u
X3538 cml_tlatch_95.xtail.S1 CKA1_P cml_tlatch_95.xmux.xp.S1 VSS sg13_lv_nmos ad=89.3f pd=0.85u as=89.3f ps=0.85u w=0.47u l=0.16u
X3539 cml_tlatch_9.OUTN cml_tlatch_9.OUTP cml_tlatch_9.xmux.xp.S1 VSS sg13_lv_nmos ad=56.9f pd=0.74u as=56.9f ps=0.74u w=0.17u l=0.17u
X3540 cml_tlatch_6.xmux.xp.S1 MOT13_N MOT13_P VSS sg13_lv_nmos ad=56.9f pd=0.74u as=56.9f ps=0.74u w=0.17u l=0.17u
X3541 cml_tlatch_0.xmux.xp.S1 interco_bi_19.INP interco_bi_19.INN VSS sg13_lv_nmos ad=56.9f pd=0.74u as=56.9f ps=0.74u w=0.17u l=0.17u
X3542 cml_tlatch_76.xmux.xp.S1 MOT23_P MOT23_N VSS sg13_lv_nmos ad=56.9f pd=0.74u as=56.9f ps=0.74u w=0.17u l=0.17u
X3543 stub_bi_31.BOTN stub_bi_31.BOTP cml_tlatch_34.xmux.xp.S1 VSS sg13_lv_nmos ad=56.9f pd=0.74u as=56.9f ps=0.74u w=0.17u l=0.17u
X3544 MOT18_P MOT18_N cml_tlatch_49.xmux.xp.S1 VSS sg13_lv_nmos ad=56.9f pd=0.74u as=56.9f ps=0.74u w=0.17u l=0.17u
X3545 cml_tlatch_26.xmux.xp.S1 MOT6_P MOT6_N VSS sg13_lv_nmos ad=56.9f pd=0.74u as=56.9f ps=0.74u w=0.17u l=0.17u
X3546 cml_tlatch_57.xmux.xp.S1 MOT26_N MOT26_P VSS sg13_lv_nmos ad=56.9f pd=0.74u as=56.9f ps=0.74u w=0.17u l=0.17u
X3547 cml_gate2_7.sg13_lv_nmos_FTPY57_0.D0 CKA2_P cml_gate2_7.xrtail.R1 VSS sg13_lv_nmos ad=0.1007p pd=0.91u as=0.1007p ps=0.91u w=0.53u l=0.13u
X3548 cml_tlatch_9.xmux.xp.S1 CKA0_N cml_tlatch_9.xtail.S1 VSS sg13_lv_nmos ad=89.3f pd=0.85u as=89.3f ps=0.85u w=0.47u l=0.16u
X3549 cml_tlatch_38.xmux.xp.S1 cml_tlatch_38.OUTP cml_tlatch_38.OUTN VSS sg13_lv_nmos ad=56.9f pd=0.74u as=56.9f ps=0.74u w=0.17u l=0.17u
X3550 cml_tlatch_8.OUTP cml_tlatch_8.OUTN cml_tlatch_8.xmux.xp.S1 VSS sg13_lv_nmos ad=56.9f pd=0.74u as=56.9f ps=0.74u w=0.17u l=0.17u
X3551 B1_2_N B1_2_P cml_tlatch_33.xmux.xp.S1 VSS sg13_lv_nmos ad=56.9f pd=0.74u as=56.9f ps=0.74u w=0.17u l=0.17u
X3552 cml_tlatch_4.xmux.xp.S1 MOT9_P MOT9_N VSS sg13_lv_nmos ad=56.9f pd=0.74u as=56.9f ps=0.74u w=0.17u l=0.17u
X3553 MOT8_P MOT8_N cml_tlatch_96.xmux.xp.S1 VSS sg13_lv_nmos ad=56.9f pd=0.74u as=0.1019p ps=1.34u w=0.17u l=0.17u
X3554 VDD A3_2_P VSS rppd l=5.17u w=1u
X3555 cml_tlatch_45.xmux.xp.S1 cml_tlatch_45.OUTP cml_tlatch_45.OUTN VSS sg13_lv_nmos ad=56.9f pd=0.74u as=56.9f ps=0.74u w=0.17u l=0.17u
X3556 cml_tlatch_47.xtail.S1 CKB3_P cml_tlatch_47.xmux.xn.S1 VSS sg13_lv_nmos ad=89.3f pd=0.85u as=89.3f ps=0.85u w=0.47u l=0.16u
X3557 B2_8_P B2_8_N cml_tlatch_77.xmux.xp.S1 VSS sg13_lv_nmos ad=56.9f pd=0.74u as=56.9f ps=0.74u w=0.17u l=0.17u
X3558 GB0_N ENB1_P cml_gate2_1.sg13_lv_nmos_FTPY57_0.D0 VSS sg13_lv_nmos ad=0.1007p pd=0.91u as=0.1802p ps=1.74u w=0.53u l=0.13u
X3559 cml_tlatch_12.xtail.S1 CKB1_P cml_tlatch_12.xmux.xp.S1 VSS sg13_lv_nmos ad=89.3f pd=0.85u as=89.3f ps=0.85u w=0.47u l=0.16u
X3560 cml_tlatch_83.xmux.xp.S1 cml_tlatch_83.OUTP cml_tlatch_83.OUTN VSS sg13_lv_nmos ad=56.9f pd=0.74u as=56.9f ps=0.74u w=0.17u l=0.17u
X3561 cml_gate2_7.xrtail.R1 CKA2_N GB2_P VSS sg13_lv_nmos ad=0.1007p pd=0.91u as=0.1007p ps=0.91u w=0.53u l=0.13u
X3562 cml_tlatch_10.xmux.xn.S1 cml_tlatch_11.OUTN B0_8_P VSS sg13_lv_nmos ad=63.19999f pd=0.74u as=63.19999f ps=0.74u w=0.26u l=0.38u
X3563 cml_tlatch_95.INP A1_2_N cml_tlatch_36.xmux.xn.S1 VSS sg13_lv_nmos ad=63.19999f pd=0.74u as=63.19999f ps=0.74u w=0.26u l=0.38u
X3564 ENB1_N ENB_P cml_drv_0.xrtail.R1 VSS sg13_lv_nmos ad=56.2f pd=0.74u as=56.2f ps=0.74u w=0.16u l=0.19u
X3565 stub_bi_63.BOTN stub_bi_63.BOTP cml_tlatch_79.xmux.xp.S1 VSS sg13_lv_nmos ad=56.9f pd=0.74u as=56.9f ps=0.74u w=0.17u l=0.17u
X3566 MOT19_P stub_bi_63.BOTP cml_tlatch_74.xmux.xn.S1 VSS sg13_lv_nmos ad=63.19999f pd=0.74u as=63.19999f ps=0.74u w=0.26u l=0.38u
X3567 cml_tlatch_92.xmux.xp.S1 CKJ_P cml_tlatch_92.xtail.S1 VSS sg13_lv_nmos ad=89.3f pd=0.85u as=89.3f ps=0.85u w=0.47u l=0.16u
X3568 cml_gate2_8.sg13_lv_nmos_FTPY57_0.D0 J2_N ENB_P VSS sg13_lv_nmos ad=0.1007p pd=0.91u as=0.1007p ps=0.91u w=0.53u l=0.13u
X3569 cml_tlatch_80.xmux.xp.S1 CKB2_N cml_tlatch_80.xtail.S1 VSS sg13_lv_nmos ad=89.3f pd=0.85u as=89.3f ps=0.85u w=0.47u l=0.16u
X3570 cml_tlatch_77.xmux.xn.S1 stub_bi_62.BOTP B2_8_P VSS sg13_lv_nmos ad=0.1082p pd=1.34u as=63.19999f ps=0.74u w=0.26u l=0.38u
X3571 cml_tlatch_49.xmux.xp.S1 MOT18_P MOT18_N VSS sg13_lv_nmos ad=56.9f pd=0.74u as=56.9f ps=0.74u w=0.17u l=0.17u
X3572 MOT26_N MOT26_P cml_tlatch_57.xmux.xp.S1 VSS sg13_lv_nmos ad=56.9f pd=0.74u as=56.9f ps=0.74u w=0.17u l=0.17u
X3573 cml_tlatch_67.xmux.xp.S1 CKA3_N cml_tlatch_67.xtail.S1 VSS sg13_lv_nmos ad=89.3f pd=0.85u as=89.3f ps=0.85u w=0.47u l=0.16u
X3574 cml_tlatch_95.xmux.xp.S1 cml_tlatch_40.INN cml_tlatch_40.INP VSS sg13_lv_nmos ad=56.9f pd=0.74u as=56.9f ps=0.74u w=0.17u l=0.17u
X3575 cml_tlatch_65.OUTN cml_tlatch_65.OUTP cml_tlatch_65.xmux.xp.S1 VSS sg13_lv_nmos ad=56.9f pd=0.74u as=56.9f ps=0.74u w=0.17u l=0.17u
X3576 cml_tlatch_30.xmux.xp.S1 cml_tlatch_30.OUTN cml_tlatch_30.OUTP VSS sg13_lv_nmos ad=56.9f pd=0.74u as=56.9f ps=0.74u w=0.17u l=0.17u
X3577 cml_tlatch_34.xtail.S1 CKB1_P cml_tlatch_34.xmux.xn.S1 VSS sg13_lv_nmos ad=89.3f pd=0.85u as=0.1598p ps=1.62u w=0.47u l=0.16u
X3578 cml_tlatch_73.xmux.xn.S1 CKHB2_P cml_tlatch_73.xtail.S1 VSS sg13_lv_nmos ad=89.3f pd=0.85u as=89.3f ps=0.85u w=0.47u l=0.16u
X3579 VSS hs_to_clk_7.sg13_lv_nmos_2HGZLP_0.G VSS VSS sg13_lv_nmos ad=2.071p pd=11.28u as=0 ps=0 w=10.9u l=1.38u
X3580 cml_tlatch_36.xmux.xp.S1 CKA1_N cml_tlatch_36.xtail.S1 VSS sg13_lv_nmos ad=89.3f pd=0.85u as=89.3f ps=0.85u w=0.47u l=0.16u
X3581 interco_bi_19.INP interco_bi_19.INN cml_tlatch_0.xmux.xp.S1 VSS sg13_lv_nmos ad=56.9f pd=0.74u as=56.9f ps=0.74u w=0.17u l=0.17u
X3582 stub_bi_62.BOTN stub_bi_62.BOTP cml_tlatch_78.xmux.xp.S1 VSS sg13_lv_nmos ad=56.9f pd=0.74u as=56.9f ps=0.74u w=0.17u l=0.17u
X3583 cml_tlatch_40.INN cml_tlatch_40.INP cml_tlatch_95.xmux.xp.S1 VSS sg13_lv_nmos ad=56.9f pd=0.74u as=56.9f ps=0.74u w=0.17u l=0.17u
X3584 cml_tlatch_94.xmux.xp.S1 cml_tlatch_6.INP cml_tlatch_6.INN VSS sg13_lv_nmos ad=56.9f pd=0.74u as=56.9f ps=0.74u w=0.17u l=0.17u
X3585 stub_bi_55.BOTN stub_bi_42.BOTP cml_tlatch_88.xmux.xn.S1 VSS sg13_lv_nmos ad=63.19999f pd=0.74u as=63.19999f ps=0.74u w=0.26u l=0.38u
X3586 MOT22_N MOT22_P cml_tlatch_51.xmux.xp.S1 VSS sg13_lv_nmos ad=56.9f pd=0.74u as=0.1019p ps=1.34u w=0.17u l=0.17u
X3587 cml_tlatch_81.xmux.xn.S1 CKA2_N cml_tlatch_81.xtail.S1 VSS sg13_lv_nmos ad=89.3f pd=0.85u as=89.3f ps=0.85u w=0.47u l=0.16u
X3588 cml_tlatch_92.xmux.xp.S1 J2_N J2_P VSS sg13_lv_nmos ad=56.9f pd=0.74u as=56.9f ps=0.74u w=0.17u l=0.17u
X3589 cml_tlatch_68.xmux.xn.S1 CKHB3_P cml_tlatch_68.xtail.S1 VSS sg13_lv_nmos ad=89.3f pd=0.85u as=89.3f ps=0.85u w=0.47u l=0.16u
X3590 VSS POLN cml_tlatch_27.xtail.S1 VSS sg13_lv_nmos ad=2.7982p pd=17.14u as=1.5637p ps=8.61u w=8.23u l=0.13u
X3591 cml_tlatch_32.xmux.xp.S1 CKB1_N cml_tlatch_32.xtail.S1 VSS sg13_lv_nmos ad=89.3f pd=0.85u as=89.3f ps=0.85u w=0.47u l=0.16u
X3592 cml_tlatch_3.xmux.xn.S1 cml_tlatch_8.OUTP cml_tlatch_3.OUTN VSS sg13_lv_nmos ad=63.19999f pd=0.74u as=63.19999f ps=0.74u w=0.26u l=0.38u
X3593 cml_gate2_2.sg13_lv_nmos_FTPY57_0.D0 CKB0_P cml_gate2_2.xrtail.R1 VSS sg13_lv_nmos ad=0.1007p pd=0.91u as=0.1007p ps=0.91u w=0.53u l=0.13u
X3594 cml_tlatch_22.xmux.xp.S1 cml_tlatch_22.OUTP cml_tlatch_22.OUTN VSS sg13_lv_nmos ad=56.9f pd=0.74u as=56.9f ps=0.74u w=0.17u l=0.17u
X3595 cml_tlatch_67.OUTP cml_tlatch_67.OUTN cml_tlatch_67.xmux.xp.S1 VSS sg13_lv_nmos ad=56.9f pd=0.74u as=56.9f ps=0.74u w=0.17u l=0.17u
X3596 cml_tlatch_9.OUTN cml_tlatch_9.OUTP cml_tlatch_9.xmux.xp.S1 VSS sg13_lv_nmos ad=56.9f pd=0.74u as=56.9f ps=0.74u w=0.17u l=0.17u
X3597 cml_tlatch_73.xmux.xn.S1 B2_8_N MOT17_P VSS sg13_lv_nmos ad=63.19999f pd=0.74u as=63.19999f ps=0.74u w=0.26u l=0.38u
X3598 cml_tlatch_56.xmux.xp.S1 A2_2_P A2_2_N VSS sg13_lv_nmos ad=56.9f pd=0.74u as=56.9f ps=0.74u w=0.17u l=0.17u
X3599 cml_tlatch_54.OUTN cml_tlatch_54.OUTP cml_tlatch_54.xmux.xp.S1 VSS sg13_lv_nmos ad=56.9f pd=0.74u as=56.9f ps=0.74u w=0.17u l=0.17u
X3600 A1_8_N A1_8_P cml_tlatch_21.xmux.xp.S1 VSS sg13_lv_nmos ad=56.9f pd=0.74u as=56.9f ps=0.74u w=0.17u l=0.17u
X3601 cml_tlatch_98.xmux.xp.S1 cml_tlatch_98.OUTN cml_tlatch_98.OUTP VSS sg13_lv_nmos ad=56.9f pd=0.74u as=56.9f ps=0.74u w=0.17u l=0.17u
X3602 cml_tlatch_33.xmux.xp.S1 B1_2_N B1_2_P VSS sg13_lv_nmos ad=56.9f pd=0.74u as=56.9f ps=0.74u w=0.17u l=0.17u
X3603 cml_tlatch_87.xtail.S1 CKHA2_P cml_tlatch_87.xmux.xn.S1 VSS sg13_lv_nmos ad=89.3f pd=0.85u as=89.3f ps=0.85u w=0.47u l=0.16u
X3604 cml_tlatch_23.xtail.S1 CKA1_N cml_tlatch_23.xmux.xn.S1 VSS sg13_lv_nmos ad=89.3f pd=0.85u as=89.3f ps=0.85u w=0.47u l=0.16u
X3605 B3_8_N cml_tlatch_61.OUTP cml_tlatch_60.xmux.xn.S1 VSS sg13_lv_nmos ad=63.19999f pd=0.74u as=63.19999f ps=0.74u w=0.26u l=0.38u
X3606 cml_tlatch_38.OUTP D1_N cml_tlatch_38.xmux.xn.S1 VSS sg13_lv_nmos ad=63.19999f pd=0.74u as=63.19999f ps=0.74u w=0.26u l=0.38u
X3607 MOT5_P cml_tlatch_98.OUTN cml_tlatch_19.xmux.xn.S1 VSS sg13_lv_nmos ad=63.19999f pd=0.74u as=0.1082p ps=1.34u w=0.26u l=0.38u
X3608 VDD cml_tlatch_35.OUTP VSS rppd l=5.17u w=1u
X3609 cml_tlatch_68.xmux.xp.S1 CKHB3_N cml_tlatch_68.xtail.S1 VSS sg13_lv_nmos ad=89.3f pd=0.85u as=89.3f ps=0.85u w=0.47u l=0.16u
X3610 stub_bi_31.BOTP stub_bi_31.BOTN cml_tlatch_34.xmux.xp.S1 VSS sg13_lv_nmos ad=56.9f pd=0.74u as=56.9f ps=0.74u w=0.17u l=0.17u
X3611 cml_tlatch_79.xmux.xn.S1 stub_bi_49.BOTP stub_bi_63.BOTN VSS sg13_lv_nmos ad=63.19999f pd=0.74u as=63.19999f ps=0.74u w=0.26u l=0.38u
X3612 cml_tlatch_18.xmux.xn.S1 CKHB0_P cml_tlatch_18.xtail.S1 VSS sg13_lv_nmos ad=89.3f pd=0.85u as=89.3f ps=0.85u w=0.47u l=0.16u
X3613 cml_tlatch_19.xmux.xn.S1 cml_tlatch_98.OUTP MOT5_N VSS sg13_lv_nmos ad=63.19999f pd=0.74u as=63.19999f ps=0.74u w=0.26u l=0.38u
X3614 cml_tlatch_0.xmux.xn.S1 CKA1_P cml_tlatch_0.xtail.S1 VSS sg13_lv_nmos ad=89.3f pd=0.85u as=89.3f ps=0.85u w=0.47u l=0.16u
X3615 cml_tlatch_93.xmux.xn.S1 CKJ_P cml_tlatch_93.xtail.S1 VSS sg13_lv_nmos ad=89.3f pd=0.85u as=89.3f ps=0.85u w=0.47u l=0.16u
X3616 cml_tlatch_58.INP cml_tlatch_58.INN cml_tlatch_85.xmux.xp.S1 VSS sg13_lv_nmos ad=56.9f pd=0.74u as=56.9f ps=0.74u w=0.17u l=0.17u
X3617 cml_tlatch_74.xmux.xp.S1 MOT19_P MOT19_N VSS sg13_lv_nmos ad=56.9f pd=0.74u as=56.9f ps=0.74u w=0.17u l=0.17u
X3618 J2_P J2_N cml_tlatch_92.xmux.xp.S1 VSS sg13_lv_nmos ad=56.9f pd=0.74u as=0.1019p ps=1.34u w=0.17u l=0.17u
X3619 MOT22_N MOT22_P cml_tlatch_51.xmux.xp.S1 VSS sg13_lv_nmos ad=56.9f pd=0.74u as=56.9f ps=0.74u w=0.17u l=0.17u
X3620 A0_8_P A0_8_N cml_tlatch_2.xmux.xp.S1 VSS sg13_lv_nmos ad=56.9f pd=0.74u as=56.9f ps=0.74u w=0.17u l=0.17u
X3621 cml_tlatch_95.INP cml_tlatch_95.INN cml_tlatch_36.xmux.xp.S1 VSS sg13_lv_nmos ad=56.9f pd=0.74u as=56.9f ps=0.74u w=0.17u l=0.17u
X3622 ENA1_N ENA_P cml_drv_1.xrtail.R1 VSS sg13_lv_nmos ad=0.1012p pd=1.34u as=56.2f ps=0.74u w=0.16u l=0.19u
X3623 cml_tlatch_2.xmux.xp.S1 A0_8_P A0_8_N VSS sg13_lv_nmos ad=56.9f pd=0.74u as=56.9f ps=0.74u w=0.17u l=0.17u
X3624 cml_tlatch_98.xmux.xp.S1 CKB0_P cml_tlatch_98.xtail.S1 VSS sg13_lv_nmos ad=89.3f pd=0.85u as=89.3f ps=0.85u w=0.47u l=0.16u
X3625 cml_tlatch_0.xmux.xp.S1 interco_bi_19.INN interco_bi_19.INP VSS sg13_lv_nmos ad=0.1019p pd=1.34u as=56.9f ps=0.74u w=0.17u l=0.17u
X3626 cml_tlatch_86.xtail.S1 CKHA3_P cml_tlatch_86.xmux.xn.S1 VSS sg13_lv_nmos ad=89.3f pd=0.85u as=89.3f ps=0.85u w=0.47u l=0.16u
X3627 cml_tlatch_72.xmux.xn.S1 CKA2_P cml_tlatch_72.xtail.S1 VSS sg13_lv_nmos ad=0.1598p pd=1.62u as=89.3f ps=0.85u w=0.47u l=0.16u
X3628 cml_tlatch_5.INN stub_bi_19.BOTN cml_tlatch_14.xmux.xn.S1 VSS sg13_lv_nmos ad=63.19999f pd=0.74u as=63.19999f ps=0.74u w=0.26u l=0.38u
X3629 cml_tlatch_64.xmux.xp.S1 CKA3_P cml_tlatch_64.xtail.S1 VSS sg13_lv_nmos ad=89.3f pd=0.85u as=89.3f ps=0.85u w=0.47u l=0.16u
X3630 cml_tlatch_21.xmux.xp.S1 A1_8_N A1_8_P VSS sg13_lv_nmos ad=56.9f pd=0.74u as=56.9f ps=0.74u w=0.17u l=0.17u
X3631 B2_8_P B2_8_N cml_tlatch_77.xmux.xp.S1 VSS sg13_lv_nmos ad=56.9f pd=0.74u as=56.9f ps=0.74u w=0.17u l=0.17u
X3632 cml_tlatch_27.OUTP B0_2_N cml_tlatch_27.xmux.xn.S1 VSS sg13_lv_nmos ad=63.19999f pd=0.74u as=63.19999f ps=0.74u w=0.26u l=0.38u
X3633 cml_tlatch_61.xtail.S1 CKB3_N cml_tlatch_61.xmux.xp.S1 VSS sg13_lv_nmos ad=89.3f pd=0.85u as=89.3f ps=0.85u w=0.47u l=0.16u
X3634 stub_bi_32.BOTN stub_bi_32.BOTP cml_tlatch_48.xmux.xp.S1 VSS sg13_lv_nmos ad=56.9f pd=0.74u as=56.9f ps=0.74u w=0.17u l=0.17u
X3635 cml_tlatch_90.xmux.xp.S1 J4_P J4_N VSS sg13_lv_nmos ad=56.9f pd=0.74u as=56.9f ps=0.74u w=0.17u l=0.17u
X3636 cml_tlatch_88.xmux.xn.S1 CKB2_N cml_tlatch_88.xtail.S1 VSS sg13_lv_nmos ad=89.3f pd=0.85u as=89.3f ps=0.85u w=0.47u l=0.16u
X3637 cml_tlatch_3.xmux.xp.S1 cml_tlatch_3.OUTP cml_tlatch_3.OUTN VSS sg13_lv_nmos ad=56.9f pd=0.74u as=56.9f ps=0.74u w=0.17u l=0.17u
X3638 cml_tlatch_6.xmux.xn.S1 cml_tlatch_6.INN MOT13_P VSS sg13_lv_nmos ad=0.1082p pd=1.34u as=63.19999f ps=0.74u w=0.26u l=0.38u
X3639 cml_tlatch_58.INN cml_tlatch_52.OUTP cml_tlatch_85.xmux.xn.S1 VSS sg13_lv_nmos ad=63.19999f pd=0.74u as=63.19999f ps=0.74u w=0.26u l=0.38u
X3640 cml_tlatch_65.xmux.xp.S1 cml_tlatch_65.OUTN cml_tlatch_65.OUTP VSS sg13_lv_nmos ad=56.9f pd=0.74u as=56.9f ps=0.74u w=0.17u l=0.17u
X3641 cml_tlatch_56.xmux.xn.S1 CKA2_N cml_tlatch_56.xtail.S1 VSS sg13_lv_nmos ad=89.3f pd=0.85u as=89.3f ps=0.85u w=0.47u l=0.16u
X3642 cml_drvb_2.xrtail.R1 GA0_N CKHA0_P VSS sg13_lv_nmos ad=0.1463p pd=1.15u as=0.2618p ps=2.22u w=0.77u l=0.21u
X3643 cml_tlatch_38.xtail.S1 CKA1_N cml_tlatch_38.xmux.xp.S1 VSS sg13_lv_nmos ad=89.3f pd=0.85u as=89.3f ps=0.85u w=0.47u l=0.16u
X3644 cml_tlatch_46.xmux.xn.S1 cml_tlatch_47.OUTN B3_2_P VSS sg13_lv_nmos ad=63.19999f pd=0.74u as=63.19999f ps=0.74u w=0.26u l=0.38u
X3645 cml_tlatch_19.xtail.S1 CKHB0_N cml_tlatch_19.xmux.xp.S1 VSS sg13_lv_nmos ad=89.3f pd=0.85u as=89.3f ps=0.85u w=0.47u l=0.16u
X3646 cml_tlatch_60.xmux.xp.S1 CKB3_P cml_tlatch_60.xtail.S1 VSS sg13_lv_nmos ad=89.3f pd=0.85u as=89.3f ps=0.85u w=0.47u l=0.16u
X3647 MOT5_N MOT5_P cml_tlatch_19.xmux.xp.S1 VSS sg13_lv_nmos ad=56.9f pd=0.74u as=56.9f ps=0.74u w=0.17u l=0.17u
X3648 cml_tlatch_91.xmux.xn.S1 CKJ_P cml_tlatch_91.xtail.S1 VSS sg13_lv_nmos ad=89.3f pd=0.85u as=89.3f ps=0.85u w=0.47u l=0.16u
X3649 cml_tlatch_98.OUTN cml_tlatch_98.OUTP cml_tlatch_98.xmux.xp.S1 VSS sg13_lv_nmos ad=56.9f pd=0.74u as=56.9f ps=0.74u w=0.17u l=0.17u
X3650 cml_tlatch_22.OUTP cml_tlatch_22.OUTN cml_tlatch_22.xmux.xp.S1 VSS sg13_lv_nmos ad=56.9f pd=0.74u as=56.9f ps=0.74u w=0.17u l=0.17u
X3651 VSS hs_to_clk_1.sg13_lv_nmos_2HGZLP_0.G VSS VSS sg13_lv_nmos ad=2.071p pd=11.28u as=0 ps=0 w=10.9u l=1.38u
X3652 cml_tlatch_16.xtail.S1 POLN VSS VSS sg13_lv_nmos ad=1.5637p pd=8.61u as=2.7982p ps=17.14u w=8.23u l=0.13u
X3653 cml_tlatch_47.OUTP D3_N cml_tlatch_47.xmux.xn.S1 VSS sg13_lv_nmos ad=63.19999f pd=0.74u as=63.19999f ps=0.74u w=0.26u l=0.38u
X3654 cml_tlatch_62.xmux.xp.S1 cml_tlatch_69.INN cml_tlatch_69.INP VSS sg13_lv_nmos ad=56.9f pd=0.74u as=56.9f ps=0.74u w=0.17u l=0.17u
X3655 cml_tlatch_31.xmux.xp.S1 CKA0_P cml_tlatch_31.xtail.S1 VSS sg13_lv_nmos ad=89.3f pd=0.85u as=89.3f ps=0.85u w=0.47u l=0.16u
X3656 cml_tlatch_50.xmux.xp.S1 MOT20_P MOT20_N VSS sg13_lv_nmos ad=56.9f pd=0.74u as=56.9f ps=0.74u w=0.17u l=0.17u
X3657 MOT9_N B1_8_P cml_tlatch_4.xmux.xn.S1 VSS sg13_lv_nmos ad=63.19999f pd=0.74u as=63.19999f ps=0.74u w=0.26u l=0.38u
X3658 cml_tlatch_35.xtail.S1 POLN VSS VSS sg13_lv_nmos ad=1.5637p pd=8.61u as=2.7982p ps=17.14u w=8.23u l=0.13u
X3659 cml_tlatch_24.xtail.S1 CKHA0_P cml_tlatch_24.xmux.xn.S1 VSS sg13_lv_nmos ad=89.3f pd=0.85u as=89.3f ps=0.85u w=0.47u l=0.16u
X3660 cml_tlatch_34.xtail.S1 CKB1_N cml_tlatch_34.xmux.xp.S1 VSS sg13_lv_nmos ad=89.3f pd=0.85u as=89.3f ps=0.85u w=0.47u l=0.16u
X3661 MOT2_N cml_tlatch_8.OUTP cml_tlatch_24.xmux.xn.S1 VSS sg13_lv_nmos ad=63.19999f pd=0.74u as=63.19999f ps=0.74u w=0.26u l=0.38u
X3662 cml_tlatch_41.xmux.xn.S1 A1_2_P MOT14_N VSS sg13_lv_nmos ad=63.19999f pd=0.74u as=63.19999f ps=0.74u w=0.26u l=0.38u
X3663 A1_2_N cml_tlatch_38.OUTP cml_tlatch_37.xmux.xn.S1 VSS sg13_lv_nmos ad=63.19999f pd=0.74u as=63.19999f ps=0.74u w=0.26u l=0.38u
X3664 cml_tlatch_94.xmux.xp.S1 cml_tlatch_6.INP cml_tlatch_6.INN VSS sg13_lv_nmos ad=56.9f pd=0.74u as=56.9f ps=0.74u w=0.17u l=0.17u
X3665 stub_bi_42.BOTP stub_bi_42.BOTN cml_tlatch_43.xmux.xp.S1 VSS sg13_lv_nmos ad=56.9f pd=0.74u as=56.9f ps=0.74u w=0.17u l=0.17u
X3666 cml_tlatch_42.xtail.S1 CKA2_N cml_tlatch_42.xmux.xp.S1 VSS sg13_lv_nmos ad=89.3f pd=0.85u as=89.3f ps=0.85u w=0.47u l=0.16u
X3667 cml_tlatch_11.OUTP cml_tlatch_16.OUTN cml_tlatch_11.xmux.xn.S1 VSS sg13_lv_nmos ad=63.19999f pd=0.74u as=63.19999f ps=0.74u w=0.26u l=0.38u
X3668 cml_tlatch_7.xmux.xn.S1 CKHB1_P cml_tlatch_7.xtail.S1 VSS sg13_lv_nmos ad=89.3f pd=0.85u as=89.3f ps=0.85u w=0.47u l=0.16u
X3669 cml_tlatch_22.OUTP cml_tlatch_22.OUTN cml_tlatch_22.xmux.xp.S1 VSS sg13_lv_nmos ad=56.9f pd=0.74u as=56.9f ps=0.74u w=0.17u l=0.17u
X3670 cml_tlatch_56.xmux.xp.S1 CKA2_P cml_tlatch_56.xtail.S1 VSS sg13_lv_nmos ad=89.3f pd=0.85u as=0.1598p ps=1.62u w=0.47u l=0.16u
X3671 VSS hs_to_clk_0.sg13_lv_nmos_2HGZLP_0.G VSS VSS sg13_lv_nmos ad=2.071p pd=11.28u as=0 ps=0 w=10.9u l=1.38u
X3672 MOT3_P MOT3_N cml_tlatch_18.xmux.xp.S1 VSS sg13_lv_nmos ad=56.9f pd=0.74u as=56.9f ps=0.74u w=0.17u l=0.17u
X3673 cml_tlatch_60.xmux.xp.S1 B3_8_P B3_8_N VSS sg13_lv_nmos ad=56.9f pd=0.74u as=56.9f ps=0.74u w=0.17u l=0.17u
X3674 cml_tlatch_80.xmux.xn.S1 stub_bi_55.BOTP stub_bi_49.BOTN VSS sg13_lv_nmos ad=63.19999f pd=0.74u as=63.19999f ps=0.74u w=0.26u l=0.38u
X3675 cml_tlatch_28.xtail.S1 CKB0_N cml_tlatch_28.xmux.xn.S1 VSS sg13_lv_nmos ad=89.3f pd=0.85u as=89.3f ps=0.85u w=0.47u l=0.16u
X3676 cml_tlatch_66.xmux.xp.S1 CKA3_P cml_tlatch_66.xtail.S1 VSS sg13_lv_nmos ad=89.3f pd=0.85u as=89.3f ps=0.85u w=0.47u l=0.16u
X3677 cml_tlatch_8.xtail.S1 CKA0_N cml_tlatch_8.xmux.xn.S1 VSS sg13_lv_nmos ad=89.3f pd=0.85u as=89.3f ps=0.85u w=0.47u l=0.16u
X3678 cml_tlatch_92.xtail.S1 CKJ_P cml_tlatch_92.xmux.xp.S1 VSS sg13_lv_nmos ad=89.3f pd=0.85u as=89.3f ps=0.85u w=0.47u l=0.16u
X3679 B1_2_N VDD VSS rppd l=5.17u w=1u
X3680 cml_tlatch_11.xmux.xp.S1 cml_tlatch_11.OUTN cml_tlatch_11.OUTP VSS sg13_lv_nmos ad=56.9f pd=0.74u as=56.9f ps=0.74u w=0.17u l=0.17u
X3681 cml_tlatch_56.xmux.xp.S1 A2_2_P A2_2_N VSS sg13_lv_nmos ad=56.9f pd=0.74u as=56.9f ps=0.74u w=0.17u l=0.17u
X3682 cml_tlatch_69.INP cml_tlatch_69.INN cml_tlatch_62.xmux.xp.S1 VSS sg13_lv_nmos ad=56.9f pd=0.74u as=56.9f ps=0.74u w=0.17u l=0.17u
X3683 B2_2_N B2_2_P cml_tlatch_44.xmux.xp.S1 VSS sg13_lv_nmos ad=56.9f pd=0.74u as=56.9f ps=0.74u w=0.17u l=0.17u
X3684 cml_tlatch_10.xmux.xp.S1 B0_8_N B0_8_P VSS sg13_lv_nmos ad=56.9f pd=0.74u as=56.9f ps=0.74u w=0.17u l=0.17u
X3685 ENB0_N ENB_P cml_drv_2.xrtail.R1 VSS sg13_lv_nmos ad=56.2f pd=0.74u as=0.1012p ps=1.34u w=0.16u l=0.19u
X3686 cml_tlatch_45.xmux.xp.S1 cml_tlatch_45.OUTN cml_tlatch_45.OUTP VSS sg13_lv_nmos ad=56.9f pd=0.74u as=56.9f ps=0.74u w=0.17u l=0.17u
X3687 cml_tlatch_97.xmux.xp.S1 MOT0_N MOT0_P VSS sg13_lv_nmos ad=56.9f pd=0.74u as=56.9f ps=0.74u w=0.17u l=0.17u
X3688 MOT21_P MOT21_N cml_tlatch_75.xmux.xp.S1 VSS sg13_lv_nmos ad=56.9f pd=0.74u as=56.9f ps=0.74u w=0.17u l=0.17u
X3689 cml_tlatch_56.INP D2_N cml_tlatch_42.xmux.xn.S1 VSS sg13_lv_nmos ad=0.1082p pd=1.34u as=63.19999f ps=0.74u w=0.26u l=0.38u
X3690 GA0_P CKB0_N cml_gate2_2.xrtail.R1 VSS sg13_lv_nmos ad=0.1007p pd=0.91u as=0.1007p ps=0.91u w=0.53u l=0.13u
X3691 cml_tlatch_54.xmux.xp.S1 cml_tlatch_54.OUTN cml_tlatch_54.OUTP VSS sg13_lv_nmos ad=56.9f pd=0.74u as=56.9f ps=0.74u w=0.17u l=0.17u
X3692 cml_tlatch_86.xmux.xp.S1 CKHA3_N cml_tlatch_86.xtail.S1 VSS sg13_lv_nmos ad=89.3f pd=0.85u as=89.3f ps=0.85u w=0.47u l=0.16u
X3693 cml_tlatch_9.xmux.xp.S1 CKA0_N cml_tlatch_9.xtail.S1 VSS sg13_lv_nmos ad=89.3f pd=0.85u as=89.3f ps=0.85u w=0.47u l=0.16u
X3694 cml_tlatch_66.xmux.xp.S1 cml_tlatch_57.INP cml_tlatch_57.INN VSS sg13_lv_nmos ad=0.1019p pd=1.34u as=56.9f ps=0.74u w=0.17u l=0.17u
X3695 cml_tlatch_69.xtail.S1 CKHB3_N cml_tlatch_69.xmux.xp.S1 VSS sg13_lv_nmos ad=89.3f pd=0.85u as=89.3f ps=0.85u w=0.47u l=0.16u
X3696 cml_tlatch_9.xmux.xn.S1 CKA0_P cml_tlatch_9.xtail.S1 VSS sg13_lv_nmos ad=89.3f pd=0.85u as=89.3f ps=0.85u w=0.47u l=0.16u
X3697 cml_tlatch_83.INN cml_tlatch_83.INP cml_tlatch_72.xmux.xp.S1 VSS sg13_lv_nmos ad=56.9f pd=0.74u as=56.9f ps=0.74u w=0.17u l=0.17u
X3698 cml_tlatch_80.xmux.xp.S1 stub_bi_49.BOTN stub_bi_49.BOTP VSS sg13_lv_nmos ad=56.9f pd=0.74u as=56.9f ps=0.74u w=0.17u l=0.17u
X3699 cml_tlatch_38.OUTP cml_tlatch_38.OUTN cml_tlatch_38.xmux.xp.S1 VSS sg13_lv_nmos ad=56.9f pd=0.74u as=56.9f ps=0.74u w=0.17u l=0.17u
X3700 MOT15_N B1_2_P cml_tlatch_7.xmux.xn.S1 VSS sg13_lv_nmos ad=63.19999f pd=0.74u as=63.19999f ps=0.74u w=0.26u l=0.38u
X3701 cml_tlatch_93.xmux.xp.S1 J1_N J1_P VSS sg13_lv_nmos ad=56.9f pd=0.74u as=56.9f ps=0.74u w=0.17u l=0.17u
X3702 VDD ENA0_P VSS rppd l=8.13u w=1u
X3703 MOT17_N MOT17_P cml_tlatch_73.xmux.xp.S1 VSS sg13_lv_nmos ad=56.9f pd=0.74u as=56.9f ps=0.74u w=0.17u l=0.17u
X3704 cml_tlatch_97.xmux.xn.S1 A0_8_P MOT0_N VSS sg13_lv_nmos ad=63.19999f pd=0.74u as=63.19999f ps=0.74u w=0.26u l=0.38u
X3705 cml_tlatch_14.xmux.xp.S1 cml_tlatch_5.INN cml_tlatch_5.INP VSS sg13_lv_nmos ad=56.9f pd=0.74u as=56.9f ps=0.74u w=0.17u l=0.17u
X3706 cml_tlatch_68.xmux.xp.S1 MOT25_P MOT25_N VSS sg13_lv_nmos ad=56.9f pd=0.74u as=56.9f ps=0.74u w=0.17u l=0.17u
X3707 VSS POLN cml_tlatch_19.xtail.S1 VSS sg13_lv_nmos ad=1.5637p pd=8.61u as=1.5637p ps=8.61u w=8.23u l=0.13u
X3708 cml_tlatch_14.xmux.xp.S1 CKB1_P cml_tlatch_14.xtail.S1 VSS sg13_lv_nmos ad=89.3f pd=0.85u as=89.3f ps=0.85u w=0.47u l=0.16u
X3709 cml_tlatch_19.xmux.xp.S1 MOT5_N MOT5_P VSS sg13_lv_nmos ad=56.9f pd=0.74u as=56.9f ps=0.74u w=0.17u l=0.17u
X3710 cml_tlatch_65.xmux.xp.S1 cml_tlatch_65.OUTN cml_tlatch_65.OUTP VSS sg13_lv_nmos ad=56.9f pd=0.74u as=56.9f ps=0.74u w=0.17u l=0.17u
X3711 cml_tlatch_3.xmux.xp.S1 cml_tlatch_3.OUTP cml_tlatch_3.OUTN VSS sg13_lv_nmos ad=0.1019p pd=1.34u as=56.9f ps=0.74u w=0.17u l=0.17u
X3712 cml_tlatch_74.xmux.xp.S1 MOT19_N MOT19_P VSS sg13_lv_nmos ad=56.9f pd=0.74u as=56.9f ps=0.74u w=0.17u l=0.17u
X3713 cml_tlatch_61.OUTP cml_tlatch_61.OUTN cml_tlatch_61.xmux.xp.S1 VSS sg13_lv_nmos ad=56.9f pd=0.74u as=56.9f ps=0.74u w=0.17u l=0.17u
X3714 MOT0_N MOT0_P cml_tlatch_97.xmux.xp.S1 VSS sg13_lv_nmos ad=56.9f pd=0.74u as=56.9f ps=0.74u w=0.17u l=0.17u
X3715 cml_tlatch_38.OUTP cml_tlatch_38.OUTN cml_tlatch_38.xmux.xp.S1 VSS sg13_lv_nmos ad=56.9f pd=0.74u as=56.9f ps=0.74u w=0.17u l=0.17u
X3716 cml_tlatch_89.OUTN cml_tlatch_89.OUTP cml_tlatch_89.xmux.xp.S1 VSS sg13_lv_nmos ad=56.9f pd=0.74u as=56.9f ps=0.74u w=0.17u l=0.17u
X3717 cml_tlatch_53.xtail.S1 CKA3_P cml_tlatch_53.xmux.xp.S1 VSS sg13_lv_nmos ad=89.3f pd=0.85u as=89.3f ps=0.85u w=0.47u l=0.16u
X3718 cml_tlatch_43.xmux.xn.S1 B2_2_N stub_bi_42.BOTN VSS sg13_lv_nmos ad=63.19999f pd=0.74u as=0.1082p ps=1.34u w=0.26u l=0.38u
X3719 CKA0_N CK_N hs_to_clk_0.D2 VSS sg13_lv_nmos ad=0.408p pd=3.08u as=0.228p ps=1.58u w=1.2u l=0.2u
X3720 cml_tlatch_80.xmux.xp.S1 CKB2_N cml_tlatch_80.xtail.S1 VSS sg13_lv_nmos ad=89.3f pd=0.85u as=89.3f ps=0.85u w=0.47u l=0.16u
X3721 cml_tlatch_20.xtail.S1 CKHB0_N cml_tlatch_20.xmux.xp.S1 VSS sg13_lv_nmos ad=89.3f pd=0.85u as=89.3f ps=0.85u w=0.47u l=0.16u
X3722 cml_tlatch_5.xmux.xn.S1 cml_tlatch_5.INP MOT11_N VSS sg13_lv_nmos ad=63.19999f pd=0.74u as=63.19999f ps=0.74u w=0.26u l=0.38u
X3723 interco_bi_19.INN cml_tlatch_40.INP cml_tlatch_0.xmux.xn.S1 VSS sg13_lv_nmos ad=63.19999f pd=0.74u as=0.1082p ps=1.34u w=0.26u l=0.38u
X3724 cml_tlatch_25.xmux.xp.S1 MOT4_N MOT4_P VSS sg13_lv_nmos ad=56.9f pd=0.74u as=56.9f ps=0.74u w=0.17u l=0.17u
X3725 cml_tlatch_6.xmux.xp.S1 MOT13_P MOT13_N VSS sg13_lv_nmos ad=56.9f pd=0.74u as=56.9f ps=0.74u w=0.17u l=0.17u
X3726 stub_bi_17.BOTP cml_tlatch_5.INP cml_tlatch_13.xmux.xn.S1 VSS sg13_lv_nmos ad=63.19999f pd=0.74u as=63.19999f ps=0.74u w=0.26u l=0.38u
X3727 cml_tlatch_13.xmux.xp.S1 stub_bi_17.BOTP stub_bi_17.BOTN VSS sg13_lv_nmos ad=56.9f pd=0.74u as=56.9f ps=0.74u w=0.17u l=0.17u
X3728 cml_tlatch_62.xmux.xp.S1 cml_tlatch_69.INP cml_tlatch_69.INN VSS sg13_lv_nmos ad=56.9f pd=0.74u as=56.9f ps=0.74u w=0.17u l=0.17u
X3729 cml_tlatch_18.xtail.S1 CKHB0_P cml_tlatch_18.xmux.xn.S1 VSS sg13_lv_nmos ad=89.3f pd=0.85u as=89.3f ps=0.85u w=0.47u l=0.16u
X3730 cml_tlatch_83.OUTP cml_tlatch_83.OUTN cml_tlatch_83.xmux.xp.S1 VSS sg13_lv_nmos ad=56.9f pd=0.74u as=0.1019p ps=1.34u w=0.17u l=0.17u
X3731 cml_tlatch_50.xmux.xp.S1 MOT20_P MOT20_N VSS sg13_lv_nmos ad=0.1019p pd=1.34u as=56.9f ps=0.74u w=0.17u l=0.17u
X3732 cml_tlatch_70.INP cml_tlatch_70.INN cml_tlatch_84.xmux.xp.S1 VSS sg13_lv_nmos ad=56.9f pd=0.74u as=56.9f ps=0.74u w=0.17u l=0.17u
X3733 MOT28_N MOT28_P cml_tlatch_58.xmux.xp.S1 VSS sg13_lv_nmos ad=56.9f pd=0.74u as=56.9f ps=0.74u w=0.17u l=0.17u
X3734 MOT27_N cml_tlatch_69.INP cml_tlatch_69.xmux.xn.S1 VSS sg13_lv_nmos ad=63.19999f pd=0.74u as=63.19999f ps=0.74u w=0.26u l=0.38u
X3735 VDD GA2_P VSS rppd l=7.42u w=1u
X3736 MOT2_P MOT2_N cml_tlatch_24.xmux.xp.S1 VSS sg13_lv_nmos ad=56.9f pd=0.74u as=56.9f ps=0.74u w=0.17u l=0.17u
X3737 cml_tlatch_16.xmux.xn.S1 cml_tlatch_1.OUTP cml_tlatch_16.OUTN VSS sg13_lv_nmos ad=63.19999f pd=0.74u as=63.19999f ps=0.74u w=0.26u l=0.38u
X3738 cml_tlatch_94.xtail.S1 CKB1_P cml_tlatch_94.xmux.xp.S1 VSS sg13_lv_nmos ad=0.1598p pd=1.62u as=89.3f ps=0.85u w=0.47u l=0.16u
X3739 cml_tlatch_50.xtail.S1 POLN VSS VSS sg13_lv_nmos ad=1.5637p pd=8.61u as=2.7982p ps=17.14u w=8.23u l=0.13u
X3740 cml_tlatch_16.xmux.xn.S1 cml_tlatch_1.OUTP cml_tlatch_16.OUTN VSS sg13_lv_nmos ad=63.19999f pd=0.74u as=63.19999f ps=0.74u w=0.26u l=0.38u
X3741 cml_tlatch_40.xmux.xp.S1 MOT12_P MOT12_N VSS sg13_lv_nmos ad=56.9f pd=0.74u as=56.9f ps=0.74u w=0.17u l=0.17u
X3742 MOT3_P MOT3_N cml_tlatch_18.xmux.xp.S1 VSS sg13_lv_nmos ad=56.9f pd=0.74u as=56.9f ps=0.74u w=0.17u l=0.17u
X3743 cml_tlatch_39.xtail.S1 CKHA1_N cml_tlatch_39.xmux.xp.S1 VSS sg13_lv_nmos ad=89.3f pd=0.85u as=89.3f ps=0.85u w=0.47u l=0.16u
X3744 cml_tlatch_12.xmux.xn.S1 stub_bi_17.BOTN B1_8_N VSS sg13_lv_nmos ad=63.19999f pd=0.74u as=63.19999f ps=0.74u w=0.26u l=0.38u
X3745 cml_tlatch_9.xtail.S1 POLN VSS VSS sg13_lv_nmos ad=1.5637p pd=8.61u as=1.5637p ps=8.61u w=8.23u l=0.13u
X3746 cml_tlatch_81.xmux.xn.S1 CKA2_N cml_tlatch_81.xtail.S1 VSS sg13_lv_nmos ad=89.3f pd=0.85u as=89.3f ps=0.85u w=0.47u l=0.16u
X3747 A2_8_N A2_8_P cml_tlatch_81.xmux.xp.S1 VSS sg13_lv_nmos ad=56.9f pd=0.74u as=56.9f ps=0.74u w=0.17u l=0.17u
X3748 cml_tlatch_68.xmux.xn.S1 CKHB3_P cml_tlatch_68.xtail.S1 VSS sg13_lv_nmos ad=89.3f pd=0.85u as=89.3f ps=0.85u w=0.47u l=0.16u
X3749 CKA0_P CK_P hs_to_clk_0.D2 VSS sg13_lv_nmos ad=0.408p pd=3.08u as=0.228p ps=1.58u w=1.2u l=0.2u
X3750 cml_tlatch_92.xtail.S1 CKJ_N cml_tlatch_92.xmux.xn.S1 VSS sg13_lv_nmos ad=89.3f pd=0.85u as=89.3f ps=0.85u w=0.47u l=0.16u
X3751 cml_tlatch_21.xmux.xn.S1 cml_tlatch_22.OUTN A1_8_P VSS sg13_lv_nmos ad=63.19999f pd=0.74u as=63.19999f ps=0.74u w=0.26u l=0.38u
X3752 cml_tlatch_70.xmux.xp.S1 MOT29_P MOT29_N VSS sg13_lv_nmos ad=56.9f pd=0.74u as=56.9f ps=0.74u w=0.17u l=0.17u
X3753 cml_tlatch_26.xtail.S1 CKHA0_N cml_tlatch_26.xmux.xp.S1 VSS sg13_lv_nmos ad=89.3f pd=0.85u as=89.3f ps=0.85u w=0.47u l=0.16u
X3754 cml_tlatch_32.xmux.xp.S1 CKB1_N cml_tlatch_32.xtail.S1 VSS sg13_lv_nmos ad=89.3f pd=0.85u as=89.3f ps=0.85u w=0.47u l=0.16u
X3755 VSS POLN cml_tlatch_60.xtail.S1 VSS sg13_lv_nmos ad=1.5637p pd=8.61u as=1.5637p ps=8.61u w=8.23u l=0.13u
X3756 cml_tlatch_42.xmux.xp.S1 cml_tlatch_56.INP cml_tlatch_56.INN VSS sg13_lv_nmos ad=56.9f pd=0.74u as=56.9f ps=0.74u w=0.17u l=0.17u
X3757 A0_2_N A0_2_P cml_tlatch_31.xmux.xp.S1 VSS sg13_lv_nmos ad=56.9f pd=0.74u as=56.9f ps=0.74u w=0.17u l=0.17u
X3758 cml_tlatch_45.xtail.S1 CKB3_P cml_tlatch_45.xmux.xn.S1 VSS sg13_lv_nmos ad=89.3f pd=0.85u as=0.1598p ps=1.62u w=0.47u l=0.16u
X3759 VDD cml_tlatch_54.OUTP VSS rppd l=5.17u w=1u
X3760 cml_tlatch_3.xmux.xn.S1 CKA0_P cml_tlatch_3.xtail.S1 VSS sg13_lv_nmos ad=89.3f pd=0.85u as=89.3f ps=0.85u w=0.47u l=0.16u
X3761 cml_tlatch_91.xtail.S1 CKJ_P cml_tlatch_91.xmux.xn.S1 VSS sg13_lv_nmos ad=89.3f pd=0.85u as=89.3f ps=0.85u w=0.47u l=0.16u
X3762 cml_tlatch_74.xtail.S1 CKHB2_P cml_tlatch_74.xmux.xn.S1 VSS sg13_lv_nmos ad=89.3f pd=0.85u as=89.3f ps=0.85u w=0.47u l=0.16u
X3763 VSS POLN cml_tlatch_90.xtail.S1 VSS sg13_lv_nmos ad=1.5637p pd=8.61u as=1.5637p ps=8.61u w=8.23u l=0.13u
X3764 cml_tlatch_89.INP cml_tlatch_89.INN cml_tlatch_55.xmux.xp.S1 VSS sg13_lv_nmos ad=56.9f pd=0.74u as=56.9f ps=0.74u w=0.17u l=0.17u
X3765 cml_tlatch_97.xmux.xp.S1 MOT0_N MOT0_P VSS sg13_lv_nmos ad=56.9f pd=0.74u as=56.9f ps=0.74u w=0.17u l=0.17u
X3766 cml_tlatch_95.xmux.xn.S1 CKA1_N cml_tlatch_95.xtail.S1 VSS sg13_lv_nmos ad=89.3f pd=0.85u as=89.3f ps=0.85u w=0.47u l=0.16u
X3767 MOT21_P MOT21_N cml_tlatch_75.xmux.xp.S1 VSS sg13_lv_nmos ad=56.9f pd=0.74u as=56.9f ps=0.74u w=0.17u l=0.17u
X3768 cml_tlatch_70.xmux.xp.S1 MOT29_N MOT29_P VSS sg13_lv_nmos ad=56.9f pd=0.74u as=56.9f ps=0.74u w=0.17u l=0.17u
X3769 cml_tlatch_20.xmux.xp.S1 MOT7_N MOT7_P VSS sg13_lv_nmos ad=56.9f pd=0.74u as=56.9f ps=0.74u w=0.17u l=0.17u
X3770 cml_tlatch_40.INP cml_tlatch_95.INN cml_tlatch_95.xmux.xn.S1 VSS sg13_lv_nmos ad=63.19999f pd=0.74u as=63.19999f ps=0.74u w=0.26u l=0.38u
X3771 cml_tlatch_54.xmux.xp.S1 cml_tlatch_54.OUTN cml_tlatch_54.OUTP VSS sg13_lv_nmos ad=56.9f pd=0.74u as=56.9f ps=0.74u w=0.17u l=0.17u
X3772 cml_tlatch_83.OUTP cml_tlatch_83.OUTN cml_tlatch_83.xmux.xp.S1 VSS sg13_lv_nmos ad=56.9f pd=0.74u as=56.9f ps=0.74u w=0.17u l=0.17u
X3773 cml_tlatch_24.xmux.xn.S1 CKHA0_P cml_tlatch_24.xtail.S1 VSS sg13_lv_nmos ad=89.3f pd=0.85u as=0.1598p ps=1.62u w=0.47u l=0.16u
X3774 B3_8_P B3_8_N cml_tlatch_60.xmux.xp.S1 VSS sg13_lv_nmos ad=56.9f pd=0.74u as=56.9f ps=0.74u w=0.17u l=0.17u
X3775 cml_tlatch_47.OUTP cml_tlatch_47.OUTN cml_tlatch_47.xmux.xp.S1 VSS sg13_lv_nmos ad=56.9f pd=0.74u as=56.9f ps=0.74u w=0.17u l=0.17u
X3776 cml_tlatch_89.xmux.xn.S1 CKA2_N cml_tlatch_89.xtail.S1 VSS sg13_lv_nmos ad=0.1598p pd=1.62u as=89.3f ps=0.85u w=0.47u l=0.16u
X3777 cml_tlatch_18.xmux.xp.S1 CKHB0_N cml_tlatch_18.xtail.S1 VSS sg13_lv_nmos ad=89.3f pd=0.85u as=89.3f ps=0.85u w=0.47u l=0.16u
X3778 cml_tlatch_2.xtail.S1 CKA0_N cml_tlatch_2.xmux.xn.S1 VSS sg13_lv_nmos ad=89.3f pd=0.85u as=89.3f ps=0.85u w=0.47u l=0.16u
X3779 cml_tlatch_80.xmux.xp.S1 stub_bi_49.BOTN stub_bi_49.BOTP VSS sg13_lv_nmos ad=56.9f pd=0.74u as=56.9f ps=0.74u w=0.17u l=0.17u
X3780 MOT11_P MOT11_N cml_tlatch_5.xmux.xp.S1 VSS sg13_lv_nmos ad=56.9f pd=0.74u as=0.1019p ps=1.34u w=0.17u l=0.17u
X3781 MOT23_N MOT23_P cml_tlatch_76.xmux.xp.S1 VSS sg13_lv_nmos ad=56.9f pd=0.74u as=56.9f ps=0.74u w=0.17u l=0.17u
X3782 GB0_P ENB1_N cml_gate2_1.sg13_lv_nmos_FTPY57_0.D0 VSS sg13_lv_nmos ad=0.1007p pd=0.91u as=0.1007p ps=0.91u w=0.53u l=0.13u
X3783 cml_tlatch_12.xmux.xp.S1 B1_8_N B1_8_P VSS sg13_lv_nmos ad=56.9f pd=0.74u as=56.9f ps=0.74u w=0.17u l=0.17u
X3784 cml_tlatch_34.xmux.xp.S1 stub_bi_31.BOTP stub_bi_31.BOTN VSS sg13_lv_nmos ad=56.9f pd=0.74u as=56.9f ps=0.74u w=0.17u l=0.17u
X3785 cml_tlatch_55.xtail.S1 CKA2_P cml_tlatch_55.xmux.xn.S1 VSS sg13_lv_nmos ad=89.3f pd=0.85u as=89.3f ps=0.85u w=0.47u l=0.16u
X3786 cml_tlatch_6.xtail.S1 CKHB1_P cml_tlatch_6.xmux.xn.S1 VSS sg13_lv_nmos ad=89.3f pd=0.85u as=89.3f ps=0.85u w=0.47u l=0.16u
X3787 VSS POLN cml_tlatch_66.xtail.S1 VSS sg13_lv_nmos ad=1.5637p pd=8.61u as=1.5637p ps=8.61u w=8.23u l=0.13u
X3788 cml_tlatch_49.xtail.S1 CKHA2_N cml_tlatch_49.xmux.xp.S1 VSS sg13_lv_nmos ad=89.3f pd=0.85u as=89.3f ps=0.85u w=0.47u l=0.16u
X3789 cml_tlatch_9.xmux.xp.S1 cml_tlatch_9.OUTN cml_tlatch_9.OUTP VSS sg13_lv_nmos ad=56.9f pd=0.74u as=56.9f ps=0.74u w=0.17u l=0.17u
X3790 cml_tlatch_86.xtail.S1 CKHA3_P cml_tlatch_86.xmux.xn.S1 VSS sg13_lv_nmos ad=89.3f pd=0.85u as=89.3f ps=0.85u w=0.47u l=0.16u
X3791 cml_tlatch_68.xmux.xp.S1 MOT25_P MOT25_N VSS sg13_lv_nmos ad=56.9f pd=0.74u as=56.9f ps=0.74u w=0.17u l=0.17u
X3792 cml_tlatch_49.xmux.xp.S1 MOT18_N MOT18_P VSS sg13_lv_nmos ad=56.9f pd=0.74u as=56.9f ps=0.74u w=0.17u l=0.17u
X3793 cml_tlatch_75.xmux.xp.S1 CKHB2_N cml_tlatch_75.xtail.S1 VSS sg13_lv_nmos ad=89.3f pd=0.85u as=89.3f ps=0.85u w=0.47u l=0.16u
X3794 A2_8_N cml_tlatch_82.OUTP cml_tlatch_81.xmux.xn.S1 VSS sg13_lv_nmos ad=63.19999f pd=0.74u as=63.19999f ps=0.74u w=0.26u l=0.38u
X3795 cml_tlatch_8.xmux.xp.S1 cml_tlatch_8.OUTN cml_tlatch_8.OUTP VSS sg13_lv_nmos ad=56.9f pd=0.74u as=56.9f ps=0.74u w=0.17u l=0.17u
X3796 ENB1_N ENB_P cml_drv_0.xrtail.R1 VSS sg13_lv_nmos ad=56.2f pd=0.74u as=0.1012p ps=1.34u w=0.16u l=0.19u
X3797 cml_tlatch_83.INP cml_tlatch_83.INN cml_tlatch_72.xmux.xp.S1 VSS sg13_lv_nmos ad=56.9f pd=0.74u as=56.9f ps=0.74u w=0.17u l=0.17u
X3798 B0_2_P B0_2_N cml_tlatch_28.xmux.xp.S1 VSS sg13_lv_nmos ad=56.9f pd=0.74u as=56.9f ps=0.74u w=0.17u l=0.17u
X3799 MOT9_N MOT9_P cml_tlatch_4.xmux.xp.S1 VSS sg13_lv_nmos ad=56.9f pd=0.74u as=56.9f ps=0.74u w=0.17u l=0.17u
X3800 cml_tlatch_22.xtail.S1 CKA1_N cml_tlatch_22.xmux.xp.S1 VSS sg13_lv_nmos ad=89.3f pd=0.85u as=89.3f ps=0.85u w=0.47u l=0.16u
X3801 B2_8_N B2_8_P cml_tlatch_77.xmux.xp.S1 VSS sg13_lv_nmos ad=56.9f pd=0.74u as=56.9f ps=0.74u w=0.17u l=0.17u
X3802 cml_tlatch_49.xmux.xn.S1 CKHA2_P cml_tlatch_49.xtail.S1 VSS sg13_lv_nmos ad=89.3f pd=0.85u as=89.3f ps=0.85u w=0.47u l=0.16u
X3803 VSS hs_to_clk_6.sg13_lv_nmos_2HGZLP_0.G VSS VSS sg13_lv_nmos ad=2.071p pd=11.28u as=0 ps=0 w=10.9u l=1.38u
X3804 cml_tlatch_99.xmux.xp.S1 cml_tlatch_99.OUTN cml_tlatch_99.OUTP VSS sg13_lv_nmos ad=56.9f pd=0.74u as=56.9f ps=0.74u w=0.17u l=0.17u
X3805 cml_tlatch_25.xtail.S1 CKHA0_P cml_tlatch_25.xmux.xn.S1 VSS sg13_lv_nmos ad=89.3f pd=0.85u as=89.3f ps=0.85u w=0.47u l=0.16u
X3806 cml_tlatch_5.xtail.S1 CKHB1_P cml_tlatch_5.xmux.xn.S1 VSS sg13_lv_nmos ad=89.3f pd=0.85u as=89.3f ps=0.85u w=0.47u l=0.16u
X3807 cml_tlatch_56.xmux.xn.S1 CKA2_N cml_tlatch_56.xtail.S1 VSS sg13_lv_nmos ad=89.3f pd=0.85u as=89.3f ps=0.85u w=0.47u l=0.16u
X3808 cml_tlatch_52.xmux.xp.S1 cml_tlatch_52.OUTP cml_tlatch_52.OUTN VSS sg13_lv_nmos ad=56.9f pd=0.74u as=56.9f ps=0.74u w=0.17u l=0.17u
X3809 cml_tlatch_88.xmux.xp.S1 stub_bi_55.BOTN stub_bi_55.BOTP VSS sg13_lv_nmos ad=0.1019p pd=1.34u as=56.9f ps=0.74u w=0.17u l=0.17u
X3810 VSS POLN cml_tlatch_18.xtail.S1 VSS sg13_lv_nmos ad=1.5637p pd=8.61u as=1.5637p ps=8.61u w=8.23u l=0.13u
X3811 cml_tlatch_45.OUTN cml_tlatch_45.OUTP cml_tlatch_45.xmux.xp.S1 VSS sg13_lv_nmos ad=56.9f pd=0.74u as=56.9f ps=0.74u w=0.17u l=0.17u
X3812 cml_tlatch_23.xmux.xn.S1 interco_bi_19.INN cml_tlatch_39.INP VSS sg13_lv_nmos ad=63.19999f pd=0.74u as=63.19999f ps=0.74u w=0.26u l=0.38u
X3813 cml_tlatch_27.xmux.xp.S1 CKB0_N cml_tlatch_27.xtail.S1 VSS sg13_lv_nmos ad=89.3f pd=0.85u as=89.3f ps=0.85u w=0.47u l=0.16u
X3814 cml_tlatch_11.OUTP cml_tlatch_16.OUTN cml_tlatch_11.xmux.xn.S1 VSS sg13_lv_nmos ad=63.19999f pd=0.74u as=63.19999f ps=0.74u w=0.26u l=0.38u
X3815 cml_tlatch_51.xmux.xn.S1 CKHA2_P cml_tlatch_51.xtail.S1 VSS sg13_lv_nmos ad=89.3f pd=0.85u as=0.1598p ps=1.62u w=0.47u l=0.16u
X3816 B0_2_P cml_tlatch_29.OUTN cml_tlatch_28.xmux.xn.S1 VSS sg13_lv_nmos ad=63.19999f pd=0.74u as=63.19999f ps=0.74u w=0.26u l=0.38u
X3817 MOT2_P MOT2_N cml_tlatch_24.xmux.xp.S1 VSS sg13_lv_nmos ad=56.9f pd=0.74u as=56.9f ps=0.74u w=0.17u l=0.17u
X3818 cml_tlatch_13.xtail.S1 CKB1_N cml_tlatch_13.xmux.xp.S1 VSS sg13_lv_nmos ad=89.3f pd=0.85u as=89.3f ps=0.85u w=0.47u l=0.16u
X3819 cml_tlatch_73.xmux.xn.S1 B2_8_P MOT17_N VSS sg13_lv_nmos ad=63.19999f pd=0.74u as=63.19999f ps=0.74u w=0.26u l=0.38u
X3820 MOT7_P B0_2_N cml_tlatch_20.xmux.xn.S1 VSS sg13_lv_nmos ad=63.19999f pd=0.74u as=63.19999f ps=0.74u w=0.26u l=0.38u
X3821 stub_bi_42.BOTN stub_bi_42.BOTP cml_tlatch_43.xmux.xp.S1 VSS sg13_lv_nmos ad=56.9f pd=0.74u as=56.9f ps=0.74u w=0.17u l=0.17u
X3822 cml_tlatch_82.xtail.S1 CKA2_N cml_tlatch_82.xmux.xp.S1 VSS sg13_lv_nmos ad=89.3f pd=0.85u as=89.3f ps=0.85u w=0.47u l=0.16u
X3823 cml_gate2_1.sg13_lv_nmos_FTPY57_0.D0 CKA0_P cml_gate2_1.xrtail.R1 VSS sg13_lv_nmos ad=0.1007p pd=0.91u as=0.1007p ps=0.91u w=0.53u l=0.13u
X3824 cml_tlatch_34.xtail.S1 CKB1_N cml_tlatch_34.xmux.xp.S1 VSS sg13_lv_nmos ad=89.3f pd=0.85u as=89.3f ps=0.85u w=0.47u l=0.16u
X3825 MOT18_N MOT18_P cml_tlatch_49.xmux.xp.S1 VSS sg13_lv_nmos ad=56.9f pd=0.74u as=56.9f ps=0.74u w=0.17u l=0.17u
X3826 cml_tlatch_57.xmux.xp.S1 MOT26_P MOT26_N VSS sg13_lv_nmos ad=56.9f pd=0.74u as=56.9f ps=0.74u w=0.17u l=0.17u
X3827 cml_tlatch_53.xmux.xp.S1 A3_2_P A3_2_N VSS sg13_lv_nmos ad=56.9f pd=0.74u as=56.9f ps=0.74u w=0.17u l=0.17u
X3828 GA3_P ENA1_N cml_gate2_5.sg13_lv_nmos_FTPY57_0.D0 VSS sg13_lv_nmos ad=0.1007p pd=0.91u as=0.1007p ps=0.91u w=0.53u l=0.13u
X3829 B0_8_N B0_8_P cml_tlatch_10.xmux.xp.S1 VSS sg13_lv_nmos ad=56.9f pd=0.74u as=56.9f ps=0.74u w=0.17u l=0.17u
X3830 cml_tlatch_77.xtail.S1 POLN VSS VSS sg13_lv_nmos ad=1.5637p pd=8.61u as=1.5637p ps=8.61u w=8.23u l=0.13u
X3831 cml_tlatch_56.xmux.xn.S1 cml_tlatch_56.INN A2_2_P VSS sg13_lv_nmos ad=63.19999f pd=0.74u as=63.19999f ps=0.74u w=0.26u l=0.38u
X3832 cml_tlatch_16.xmux.xp.S1 cml_tlatch_16.OUTP cml_tlatch_16.OUTN VSS sg13_lv_nmos ad=56.9f pd=0.74u as=56.9f ps=0.74u w=0.17u l=0.17u
X3833 cml_tlatch_30.OUTP cml_tlatch_30.OUTN cml_tlatch_30.xmux.xp.S1 VSS sg13_lv_nmos ad=56.9f pd=0.74u as=56.9f ps=0.74u w=0.17u l=0.17u
X3834 cml_gate2_9.sg13_lv_nmos_FTPY57_0.D0 J1_N ENA_P VSS sg13_lv_nmos ad=0.1007p pd=0.91u as=0.1007p ps=0.91u w=0.53u l=0.13u
X3835 cml_tlatch_14.xtail.S1 CKB1_N cml_tlatch_14.xmux.xn.S1 VSS sg13_lv_nmos ad=0.1598p pd=1.62u as=89.3f ps=0.85u w=0.47u l=0.16u
X3836 cml_tlatch_59.xmux.xn.S1 CKHA3_P cml_tlatch_59.xtail.S1 VSS sg13_lv_nmos ad=89.3f pd=0.85u as=89.3f ps=0.85u w=0.47u l=0.16u
X3837 MOT24_P MOT24_N cml_tlatch_86.xmux.xp.S1 VSS sg13_lv_nmos ad=56.9f pd=0.74u as=56.9f ps=0.74u w=0.17u l=0.17u
X3838 cml_tlatch_56.xmux.xn.S1 cml_tlatch_56.INN A2_2_P VSS sg13_lv_nmos ad=63.19999f pd=0.74u as=63.19999f ps=0.74u w=0.26u l=0.38u
X3839 cml_tlatch_99.OUTP cml_tlatch_30.OUTN cml_tlatch_99.xmux.xn.S1 VSS sg13_lv_nmos ad=63.19999f pd=0.74u as=0.1082p ps=1.34u w=0.26u l=0.38u
X3840 CKB1_P hs_to_clk_2.sg13_lv_nmos_2HGZLP_0.G VSS rppd l=4.25u w=1u
X3841 cml_tlatch_17.xmux.xp.S1 MOT1_N MOT1_P VSS sg13_lv_nmos ad=56.9f pd=0.74u as=56.9f ps=0.74u w=0.17u l=0.17u
X3842 cml_tlatch_65.xmux.xn.S1 cml_tlatch_57.INN cml_tlatch_65.OUTP VSS sg13_lv_nmos ad=63.19999f pd=0.74u as=63.19999f ps=0.74u w=0.26u l=0.38u
X3843 cml_tlatch_1.xtail.S1 POLN VSS VSS sg13_lv_nmos ad=1.5637p pd=8.61u as=2.7982p ps=17.14u w=8.23u l=0.13u
X3844 cml_tlatch_80.xtail.S1 CKB2_N cml_tlatch_80.xmux.xp.S1 VSS sg13_lv_nmos ad=89.3f pd=0.85u as=0.1598p ps=1.62u w=0.47u l=0.16u
X3845 cml_gate2_3.xrtail.R1 CKB1_P cml_gate2_3.sg13_lv_nmos_FTPY57_0.D0 VSS sg13_lv_nmos ad=0.1007p pd=0.91u as=0.1007p ps=0.91u w=0.53u l=0.13u
X3846 cml_tlatch_67.OUTN cml_tlatch_67.OUTP cml_tlatch_67.xmux.xp.S1 VSS sg13_lv_nmos ad=56.9f pd=0.74u as=56.9f ps=0.74u w=0.17u l=0.17u
X3847 cml_tlatch_29.xtail.S1 POLN VSS VSS sg13_lv_nmos ad=1.5637p pd=8.61u as=1.5637p ps=8.61u w=8.23u l=0.13u
X3848 stub_bi_31.BOTP D1_P cml_tlatch_34.xmux.xn.S1 VSS sg13_lv_nmos ad=63.19999f pd=0.74u as=63.19999f ps=0.74u w=0.26u l=0.38u
X3849 cml_tlatch_90.xtail.S1 CKJ_N cml_tlatch_90.xmux.xn.S1 VSS sg13_lv_nmos ad=89.3f pd=0.85u as=89.3f ps=0.85u w=0.47u l=0.16u
X3850 cml_tlatch_45.xtail.S1 CKB3_N cml_tlatch_45.xmux.xp.S1 VSS sg13_lv_nmos ad=89.3f pd=0.85u as=89.3f ps=0.85u w=0.47u l=0.16u
X3851 VDD cml_tlatch_8.OUTP VSS rppd l=5.17u w=1u
X3852 MOT12_P MOT12_N cml_tlatch_40.xmux.xp.S1 VSS sg13_lv_nmos ad=56.9f pd=0.74u as=56.9f ps=0.74u w=0.17u l=0.17u
X3853 cml_tlatch_42.xmux.xn.S1 CKA2_P cml_tlatch_42.xtail.S1 VSS sg13_lv_nmos ad=89.3f pd=0.85u as=89.3f ps=0.85u w=0.47u l=0.16u
X3854 cml_tlatch_16.xmux.xn.S1 cml_tlatch_1.OUTN cml_tlatch_16.OUTP VSS sg13_lv_nmos ad=0.1082p pd=1.34u as=63.19999f ps=0.74u w=0.26u l=0.38u
X3855 MOT10_P MOT10_N cml_tlatch_39.xmux.xp.S1 VSS sg13_lv_nmos ad=56.9f pd=0.74u as=0.1019p ps=1.34u w=0.17u l=0.17u
X3856 cml_tlatch_62.xmux.xp.S1 CKB3_P cml_tlatch_62.xtail.S1 VSS sg13_lv_nmos ad=89.3f pd=0.85u as=89.3f ps=0.85u w=0.47u l=0.16u
X3857 cml_tlatch_78.xmux.xp.S1 stub_bi_62.BOTN stub_bi_62.BOTP VSS sg13_lv_nmos ad=56.9f pd=0.74u as=56.9f ps=0.74u w=0.17u l=0.17u
X3858 cml_tlatch_22.OUTN cml_tlatch_22.OUTP cml_tlatch_22.xmux.xp.S1 VSS sg13_lv_nmos ad=56.9f pd=0.74u as=56.9f ps=0.74u w=0.17u l=0.17u
X3859 cml_tlatch_47.xmux.xn.S1 D3_N cml_tlatch_47.OUTP VSS sg13_lv_nmos ad=63.19999f pd=0.74u as=63.19999f ps=0.74u w=0.26u l=0.38u
X3860 cml_tlatch_16.xmux.xn.S1 CKB0_N cml_tlatch_16.xtail.S1 VSS sg13_lv_nmos ad=89.3f pd=0.85u as=89.3f ps=0.85u w=0.47u l=0.16u
X3861 cml_tlatch_70.xmux.xn.S1 cml_tlatch_70.INN MOT29_P VSS sg13_lv_nmos ad=63.19999f pd=0.74u as=0.1082p ps=1.34u w=0.26u l=0.38u
X3862 cml_tlatch_29.OUTN D0_P cml_tlatch_29.xmux.xn.S1 VSS sg13_lv_nmos ad=63.19999f pd=0.74u as=63.19999f ps=0.74u w=0.26u l=0.38u
X3863 cml_tlatch_63.xtail.S1 CKB3_N cml_tlatch_63.xmux.xp.S1 VSS sg13_lv_nmos ad=89.3f pd=0.85u as=89.3f ps=0.85u w=0.47u l=0.16u
X3864 cml_tlatch_0.xmux.xp.S1 CKA1_N cml_tlatch_0.xtail.S1 VSS sg13_lv_nmos ad=0.1598p pd=1.62u as=89.3f ps=0.85u w=0.47u l=0.16u
X3865 stub_bi_29.BOTP stub_bi_29.BOTN cml_tlatch_32.xmux.xp.S1 VSS sg13_lv_nmos ad=56.9f pd=0.74u as=56.9f ps=0.74u w=0.17u l=0.17u
X3866 MOT29_N cml_tlatch_70.INP cml_tlatch_70.xmux.xn.S1 VSS sg13_lv_nmos ad=63.19999f pd=0.74u as=63.19999f ps=0.74u w=0.26u l=0.38u
X3867 cml_tlatch_71.xmux.xp.S1 MOT31_P MOT31_N VSS sg13_lv_nmos ad=56.9f pd=0.74u as=56.9f ps=0.74u w=0.17u l=0.17u
X3868 cml_tlatch_98.OUTP cml_tlatch_98.OUTN cml_tlatch_98.xmux.xp.S1 VSS sg13_lv_nmos ad=56.9f pd=0.74u as=56.9f ps=0.74u w=0.17u l=0.17u
X3869 cml_tlatch_49.xtail.S1 POLN VSS VSS sg13_lv_nmos ad=1.5637p pd=8.61u as=1.5637p ps=8.61u w=8.23u l=0.13u
X3870 cml_tlatch_9.xmux.xp.S1 cml_tlatch_9.OUTN cml_tlatch_9.OUTP VSS sg13_lv_nmos ad=0.1019p pd=1.34u as=56.9f ps=0.74u w=0.17u l=0.17u
X3871 B1_2_P B1_2_N cml_tlatch_33.xmux.xp.S1 VSS sg13_lv_nmos ad=56.9f pd=0.74u as=0.1019p ps=1.34u w=0.17u l=0.17u
X3872 cml_tlatch_93.xmux.xp.S1 CKJ_N cml_tlatch_93.xtail.S1 VSS sg13_lv_nmos ad=89.3f pd=0.85u as=89.3f ps=0.85u w=0.47u l=0.16u
X3873 cml_tlatch_26.xmux.xp.S1 CKHA0_N cml_tlatch_26.xtail.S1 VSS sg13_lv_nmos ad=89.3f pd=0.85u as=89.3f ps=0.85u w=0.47u l=0.16u
X3874 cml_tlatch_32.xtail.S1 CKB1_N cml_tlatch_32.xmux.xp.S1 VSS sg13_lv_nmos ad=89.3f pd=0.85u as=0.1598p ps=1.62u w=0.47u l=0.16u
X3875 cml_tlatch_82.OUTP cml_tlatch_82.OUTN cml_tlatch_82.xmux.xp.S1 VSS sg13_lv_nmos ad=56.9f pd=0.74u as=56.9f ps=0.74u w=0.17u l=0.17u
X3876 cml_tlatch_38.OUTN cml_tlatch_38.OUTP cml_tlatch_38.xmux.xp.S1 VSS sg13_lv_nmos ad=56.9f pd=0.74u as=56.9f ps=0.74u w=0.17u l=0.17u
X3877 MOT28_P MOT28_N cml_tlatch_58.xmux.xp.S1 VSS sg13_lv_nmos ad=56.9f pd=0.74u as=56.9f ps=0.74u w=0.17u l=0.17u
X3878 MOT15_N MOT15_P cml_tlatch_7.xmux.xp.S1 VSS sg13_lv_nmos ad=56.9f pd=0.74u as=56.9f ps=0.74u w=0.17u l=0.17u
X3879 cml_tlatch_16.OUTP cml_tlatch_16.OUTN cml_tlatch_16.xmux.xp.S1 VSS sg13_lv_nmos ad=56.9f pd=0.74u as=0.1019p ps=1.34u w=0.17u l=0.17u
X3880 cml_tlatch_85.xmux.xp.S1 cml_tlatch_58.INN cml_tlatch_58.INP VSS sg13_lv_nmos ad=56.9f pd=0.74u as=56.9f ps=0.74u w=0.17u l=0.17u
X3881 cml_tlatch_74.xmux.xn.S1 CKHB2_P cml_tlatch_74.xtail.S1 VSS sg13_lv_nmos ad=89.3f pd=0.85u as=89.3f ps=0.85u w=0.47u l=0.16u
X3882 MOT19_N MOT19_P cml_tlatch_74.xmux.xp.S1 VSS sg13_lv_nmos ad=56.9f pd=0.74u as=56.9f ps=0.74u w=0.17u l=0.17u
X3883 cml_tlatch_2.xmux.xp.S1 A0_8_N A0_8_P VSS sg13_lv_nmos ad=56.9f pd=0.74u as=56.9f ps=0.74u w=0.17u l=0.17u
X3884 cml_tlatch_96.xmux.xp.S1 CKHA1_N cml_tlatch_96.xtail.S1 VSS sg13_lv_nmos ad=89.3f pd=0.85u as=89.3f ps=0.85u w=0.47u l=0.16u
X3885 cml_tlatch_22.xtail.S1 CKA1_P cml_tlatch_22.xmux.xn.S1 VSS sg13_lv_nmos ad=89.3f pd=0.85u as=89.3f ps=0.85u w=0.47u l=0.16u
X3886 interco_bi_19.INP interco_bi_19.INN cml_tlatch_0.xmux.xp.S1 VSS sg13_lv_nmos ad=56.9f pd=0.74u as=56.9f ps=0.74u w=0.17u l=0.17u
X3887 cml_tlatch_20.xtail.S1 CKHB0_N cml_tlatch_20.xmux.xp.S1 VSS sg13_lv_nmos ad=89.3f pd=0.85u as=89.3f ps=0.85u w=0.47u l=0.16u
X3888 cml_tlatch_23.xmux.xp.S1 cml_tlatch_39.INN cml_tlatch_39.INP VSS sg13_lv_nmos ad=56.9f pd=0.74u as=56.9f ps=0.74u w=0.17u l=0.17u
X3889 cml_tlatch_77.xmux.xp.S1 B2_8_N B2_8_P VSS sg13_lv_nmos ad=56.9f pd=0.74u as=56.9f ps=0.74u w=0.17u l=0.17u
X3890 MOT22_N A2_2_P cml_tlatch_51.xmux.xn.S1 VSS sg13_lv_nmos ad=63.19999f pd=0.74u as=0.1082p ps=1.34u w=0.26u l=0.38u
X3891 MOT15_P MOT15_N cml_tlatch_7.xmux.xp.S1 VSS sg13_lv_nmos ad=56.9f pd=0.74u as=56.9f ps=0.74u w=0.17u l=0.17u
X3892 cml_tlatch_69.xmux.xn.S1 CKHB3_P cml_tlatch_69.xtail.S1 VSS sg13_lv_nmos ad=89.3f pd=0.85u as=89.3f ps=0.85u w=0.47u l=0.16u
X3893 cml_tlatch_54.xmux.xp.S1 CKA3_N cml_tlatch_54.xtail.S1 VSS sg13_lv_nmos ad=89.3f pd=0.85u as=89.3f ps=0.85u w=0.47u l=0.16u
X3894 cml_tlatch_3.OUTN cml_tlatch_3.OUTP cml_tlatch_3.xmux.xp.S1 VSS sg13_lv_nmos ad=56.9f pd=0.74u as=56.9f ps=0.74u w=0.17u l=0.17u
X3895 MOT31_N MOT31_P cml_tlatch_71.xmux.xp.S1 VSS sg13_lv_nmos ad=56.9f pd=0.74u as=56.9f ps=0.74u w=0.17u l=0.17u
X3896 MOT13_N VDD VSS rppd l=5.17u w=1u
X3897 cml_tlatch_94.xtail.S1 CKB1_P cml_tlatch_94.xmux.xp.S1 VSS sg13_lv_nmos ad=89.3f pd=0.85u as=89.3f ps=0.85u w=0.47u l=0.16u
X3898 cml_tlatch_46.xtail.S1 CKB3_P cml_tlatch_46.xmux.xp.S1 VSS sg13_lv_nmos ad=89.3f pd=0.85u as=89.3f ps=0.85u w=0.47u l=0.16u
X3899 cml_tlatch_72.xtail.S1 CKA2_P cml_tlatch_72.xmux.xn.S1 VSS sg13_lv_nmos ad=89.3f pd=0.85u as=89.3f ps=0.85u w=0.47u l=0.16u
X3900 cml_tlatch_40.INP cml_tlatch_40.INN cml_tlatch_95.xmux.xp.S1 VSS sg13_lv_nmos ad=56.9f pd=0.74u as=56.9f ps=0.74u w=0.17u l=0.17u
X3901 B1_2_P B1_2_N cml_tlatch_33.xmux.xp.S1 VSS sg13_lv_nmos ad=56.9f pd=0.74u as=56.9f ps=0.74u w=0.17u l=0.17u
X3902 cml_tlatch_32.xmux.xn.S1 B1_2_P stub_bi_29.BOTP VSS sg13_lv_nmos ad=0.1082p pd=1.34u as=63.19999f ps=0.74u w=0.26u l=0.38u
X3903 cml_tlatch_63.xmux.xp.S1 cml_tlatch_63.OUTP cml_tlatch_63.OUTN VSS sg13_lv_nmos ad=56.9f pd=0.74u as=56.9f ps=0.74u w=0.17u l=0.17u
X3904 cml_tlatch_74.xmux.xn.S1 stub_bi_63.BOTP MOT19_P VSS sg13_lv_nmos ad=63.19999f pd=0.74u as=63.19999f ps=0.74u w=0.26u l=0.38u
X3905 cml_tlatch_47.xmux.xp.S1 CKB3_N cml_tlatch_47.xtail.S1 VSS sg13_lv_nmos ad=89.3f pd=0.85u as=89.3f ps=0.85u w=0.47u l=0.16u
X3906 MOT20_N MOT20_P cml_tlatch_50.xmux.xp.S1 VSS sg13_lv_nmos ad=56.9f pd=0.74u as=56.9f ps=0.74u w=0.17u l=0.17u
X3907 B0_2_N cml_tlatch_29.OUTP cml_tlatch_28.xmux.xn.S1 VSS sg13_lv_nmos ad=63.19999f pd=0.74u as=63.19999f ps=0.74u w=0.26u l=0.38u
X3908 MOT31_P MOT31_N cml_tlatch_71.xmux.xp.S1 VSS sg13_lv_nmos ad=56.9f pd=0.74u as=56.9f ps=0.74u w=0.17u l=0.17u
X3909 cml_tlatch_16.OUTP cml_tlatch_16.OUTN cml_tlatch_16.xmux.xp.S1 VSS sg13_lv_nmos ad=56.9f pd=0.74u as=56.9f ps=0.74u w=0.17u l=0.17u
X3910 cml_tlatch_49.xtail.S1 CKHA2_P cml_tlatch_49.xmux.xn.S1 VSS sg13_lv_nmos ad=89.3f pd=0.85u as=89.3f ps=0.85u w=0.47u l=0.16u
X3911 B2_8_P stub_bi_62.BOTP cml_tlatch_77.xmux.xn.S1 VSS sg13_lv_nmos ad=63.19999f pd=0.74u as=63.19999f ps=0.74u w=0.26u l=0.38u
X3912 cml_tlatch_71.xtail.S1 CKHB3_P cml_tlatch_71.xmux.xn.S1 VSS sg13_lv_nmos ad=89.3f pd=0.85u as=0.1598p ps=1.62u w=0.47u l=0.16u
X3913 cml_tlatch_80.xtail.S1 CKB2_P cml_tlatch_80.xmux.xn.S1 VSS sg13_lv_nmos ad=89.3f pd=0.85u as=89.3f ps=0.85u w=0.47u l=0.16u
X3914 cml_tlatch_96.xmux.xp.S1 MOT8_N MOT8_P VSS sg13_lv_nmos ad=56.9f pd=0.74u as=56.9f ps=0.74u w=0.17u l=0.17u
X3915 cml_tlatch_3.xmux.xn.S1 CKA0_P cml_tlatch_3.xtail.S1 VSS sg13_lv_nmos ad=89.3f pd=0.85u as=89.3f ps=0.85u w=0.47u l=0.16u
X3916 cml_tlatch_74.xtail.S1 CKHB2_N cml_tlatch_74.xmux.xp.S1 VSS sg13_lv_nmos ad=89.3f pd=0.85u as=89.3f ps=0.85u w=0.47u l=0.16u
X3917 cml_tlatch_22.xmux.xp.S1 cml_tlatch_22.OUTN cml_tlatch_22.OUTP VSS sg13_lv_nmos ad=56.9f pd=0.74u as=56.9f ps=0.74u w=0.17u l=0.17u
X3918 cml_tlatch_63.xmux.xp.S1 cml_tlatch_63.OUTP cml_tlatch_63.OUTN VSS sg13_lv_nmos ad=0.1019p pd=1.34u as=56.9f ps=0.74u w=0.17u l=0.17u
X3919 cml_tlatch_18.xmux.xp.S1 MOT3_N MOT3_P VSS sg13_lv_nmos ad=56.9f pd=0.74u as=56.9f ps=0.74u w=0.17u l=0.17u
X3920 VSS cml_drvb_9.xrtail.R1 VSS rppd l=2.72u w=1u
X3921 cml_tlatch_56.INP cml_tlatch_56.INN cml_tlatch_42.xmux.xp.S1 VSS sg13_lv_nmos ad=56.9f pd=0.74u as=56.9f ps=0.74u w=0.17u l=0.17u
X3922 J1_N J1_P cml_tlatch_93.xmux.xp.S1 VSS sg13_lv_nmos ad=56.9f pd=0.74u as=56.9f ps=0.74u w=0.17u l=0.17u
X3923 cml_gate2_0.xrtail.R1 VSS VSS rppd l=4.86u w=1u
X3924 B3_2_P B3_2_N cml_tlatch_46.xmux.xp.S1 VSS sg13_lv_nmos ad=56.9f pd=0.74u as=56.9f ps=0.74u w=0.17u l=0.17u
X3925 cml_tlatch_99.xmux.xn.S1 CKA0_N cml_tlatch_99.xtail.S1 VSS sg13_lv_nmos ad=89.3f pd=0.85u as=89.3f ps=0.85u w=0.47u l=0.16u
X3926 cml_tlatch_59.xmux.xp.S1 MOT30_P MOT30_N VSS sg13_lv_nmos ad=56.9f pd=0.74u as=56.9f ps=0.74u w=0.17u l=0.17u
X3927 cml_tlatch_22.xtail.S1 CKA1_P cml_tlatch_22.xmux.xn.S1 VSS sg13_lv_nmos ad=89.3f pd=0.85u as=89.3f ps=0.85u w=0.47u l=0.16u
X3928 cml_tlatch_66.xmux.xn.S1 cml_tlatch_67.OUTP cml_tlatch_57.INN VSS sg13_lv_nmos ad=63.19999f pd=0.74u as=63.19999f ps=0.74u w=0.26u l=0.38u
X3929 cml_tlatch_57.xtail.S1 CKHA3_P cml_tlatch_57.xmux.xn.S1 VSS sg13_lv_nmos ad=89.3f pd=0.85u as=89.3f ps=0.85u w=0.47u l=0.16u
X3930 stub_bi_19.BOTP stub_bi_19.BOTN cml_tlatch_15.xmux.xp.S1 VSS sg13_lv_nmos ad=56.9f pd=0.74u as=56.9f ps=0.74u w=0.17u l=0.17u
X3931 cml_tlatch_4.xmux.xn.S1 CKHB1_P cml_tlatch_4.xtail.S1 VSS sg13_lv_nmos ad=89.3f pd=0.85u as=89.3f ps=0.85u w=0.47u l=0.16u
X3932 cml_tlatch_47.xmux.xp.S1 cml_tlatch_47.OUTP cml_tlatch_47.OUTN VSS sg13_lv_nmos ad=56.9f pd=0.74u as=56.9f ps=0.74u w=0.17u l=0.17u
X3933 cml_tlatch_11.OUTP cml_tlatch_11.OUTN cml_tlatch_11.xmux.xp.S1 VSS sg13_lv_nmos ad=56.9f pd=0.74u as=56.9f ps=0.74u w=0.17u l=0.17u
X3934 cml_tlatch_25.xmux.xp.S1 MOT4_P MOT4_N VSS sg13_lv_nmos ad=56.9f pd=0.74u as=56.9f ps=0.74u w=0.17u l=0.17u
X3935 cml_gate2_3.xrtail.R1 CKB1_N GA1_P VSS sg13_lv_nmos ad=0.1007p pd=0.91u as=0.1007p ps=0.91u w=0.53u l=0.13u
X3936 A2_2_N A2_2_P cml_tlatch_56.xmux.xp.S1 VSS sg13_lv_nmos ad=56.9f pd=0.74u as=56.9f ps=0.74u w=0.17u l=0.17u
X3937 cml_tlatch_85.xtail.S1 CKA3_P cml_tlatch_85.xmux.xp.S1 VSS sg13_lv_nmos ad=89.3f pd=0.85u as=89.3f ps=0.85u w=0.47u l=0.16u
X3938 cml_tlatch_44.xmux.xp.S1 B2_2_P B2_2_N VSS sg13_lv_nmos ad=56.9f pd=0.74u as=56.9f ps=0.74u w=0.17u l=0.17u
X3939 VSS POLN cml_tlatch_59.xtail.S1 VSS sg13_lv_nmos ad=1.5637p pd=8.61u as=1.5637p ps=8.61u w=8.23u l=0.13u
X3940 cml_tlatch_98.xmux.xp.S1 cml_tlatch_98.OUTP cml_tlatch_98.OUTN VSS sg13_lv_nmos ad=56.9f pd=0.74u as=56.9f ps=0.74u w=0.17u l=0.17u
X3941 cml_tlatch_39.xtail.S1 POLN VSS VSS sg13_lv_nmos ad=1.5637p pd=8.61u as=2.7982p ps=17.14u w=8.23u l=0.13u
X3942 cml_tlatch_55.xtail.S1 CKA2_P cml_tlatch_55.xmux.xn.S1 VSS sg13_lv_nmos ad=89.3f pd=0.85u as=89.3f ps=0.85u w=0.47u l=0.16u
X3943 A3_8_P A3_8_N cml_tlatch_64.xmux.xp.S1 VSS sg13_lv_nmos ad=56.9f pd=0.74u as=56.9f ps=0.74u w=0.17u l=0.17u
X3944 cml_tlatch_30.OUTN A0_2_P cml_tlatch_30.xmux.xn.S1 VSS sg13_lv_nmos ad=63.19999f pd=0.74u as=0.1082p ps=1.34u w=0.26u l=0.38u
X3945 MOT0_P A0_8_N cml_tlatch_97.xmux.xn.S1 VSS sg13_lv_nmos ad=63.19999f pd=0.74u as=63.19999f ps=0.74u w=0.26u l=0.38u
X3946 GB3_N ENB0_P cml_gate2_6.sg13_lv_nmos_FTPY57_0.D0 VSS sg13_lv_nmos ad=0.1007p pd=0.91u as=0.1007p ps=0.91u w=0.53u l=0.13u
X3947 cml_tlatch_12.xmux.xp.S1 B1_8_P B1_8_N VSS sg13_lv_nmos ad=56.9f pd=0.74u as=56.9f ps=0.74u w=0.17u l=0.17u
X3948 cml_tlatch_35.xmux.xp.S1 cml_tlatch_35.OUTP cml_tlatch_35.OUTN VSS sg13_lv_nmos ad=56.9f pd=0.74u as=56.9f ps=0.74u w=0.17u l=0.17u
X3949 cml_tlatch_30.xtail.S1 CKA0_P cml_tlatch_30.xmux.xn.S1 VSS sg13_lv_nmos ad=89.3f pd=0.85u as=89.3f ps=0.85u w=0.47u l=0.16u
X3950 cml_tlatch_57.INP cml_tlatch_57.INN cml_tlatch_66.xmux.xp.S1 VSS sg13_lv_nmos ad=56.9f pd=0.74u as=56.9f ps=0.74u w=0.17u l=0.17u
X3951 cml_tlatch_2.xmux.xp.S1 CKA0_P cml_tlatch_2.xtail.S1 VSS sg13_lv_nmos ad=0.1598p pd=1.62u as=89.3f ps=0.85u w=0.47u l=0.16u
X3952 MOT9_P MOT9_N cml_tlatch_4.xmux.xp.S1 VSS sg13_lv_nmos ad=56.9f pd=0.74u as=56.9f ps=0.74u w=0.17u l=0.17u
X3953 cml_tlatch_90.xmux.xp.S1 J4_N J4_P VSS sg13_lv_nmos ad=56.9f pd=0.74u as=56.9f ps=0.74u w=0.17u l=0.17u
X3954 cml_tlatch_69.xmux.xp.S1 MOT27_P MOT27_N VSS sg13_lv_nmos ad=56.9f pd=0.74u as=56.9f ps=0.74u w=0.17u l=0.17u
X3955 ENA0_P ENA_N cml_drv_3.xrtail.R1 VSS sg13_lv_nmos ad=56.2f pd=0.74u as=56.2f ps=0.74u w=0.16u l=0.19u
X3956 cml_tlatch_60.xmux.xn.S1 cml_tlatch_61.OUTP B3_8_N VSS sg13_lv_nmos ad=63.19999f pd=0.74u as=0.1082p ps=1.34u w=0.26u l=0.38u
X3957 VSS cml_drvb_5.xrtail.R1 VSS rppd l=2.72u w=1u
X3958 cml_tlatch_77.xtail.S1 CKB2_N cml_tlatch_77.xmux.xn.S1 VSS sg13_lv_nmos ad=89.3f pd=0.85u as=89.3f ps=0.85u w=0.47u l=0.16u
X3959 cml_tlatch_37.xmux.xn.S1 cml_tlatch_38.OUTP A1_2_N VSS sg13_lv_nmos ad=63.19999f pd=0.74u as=63.19999f ps=0.74u w=0.26u l=0.38u
X3960 cml_tlatch_25.xtail.S1 CKHA0_P cml_tlatch_25.xmux.xn.S1 VSS sg13_lv_nmos ad=89.3f pd=0.85u as=89.3f ps=0.85u w=0.47u l=0.16u
X3961 cml_tlatch_43.xtail.S1 CKB2_P cml_tlatch_43.xmux.xn.S1 VSS sg13_lv_nmos ad=0.1598p pd=1.62u as=89.3f ps=0.85u w=0.47u l=0.16u
X3962 cml_tlatch_1.OUTN cml_tlatch_98.OUTP cml_tlatch_1.xmux.xn.S1 VSS sg13_lv_nmos ad=63.19999f pd=0.74u as=63.19999f ps=0.74u w=0.26u l=0.38u
X3963 cml_tlatch_62.xtail.S1 CKB3_P cml_tlatch_62.xmux.xp.S1 VSS sg13_lv_nmos ad=89.3f pd=0.85u as=89.3f ps=0.85u w=0.47u l=0.16u
X3964 MOT4_N cml_tlatch_99.OUTP cml_tlatch_25.xmux.xn.S1 VSS sg13_lv_nmos ad=63.19999f pd=0.74u as=63.19999f ps=0.74u w=0.26u l=0.38u
X3965 cml_tlatch_5.INP cml_tlatch_5.INN cml_tlatch_14.xmux.xp.S1 VSS sg13_lv_nmos ad=56.9f pd=0.74u as=56.9f ps=0.74u w=0.17u l=0.17u
X3966 MOT11_N MOT11_P cml_tlatch_5.xmux.xp.S1 VSS sg13_lv_nmos ad=56.9f pd=0.74u as=56.9f ps=0.74u w=0.17u l=0.17u
X3967 cml_tlatch_32.xmux.xp.S1 stub_bi_29.BOTP stub_bi_29.BOTN VSS sg13_lv_nmos ad=56.9f pd=0.74u as=56.9f ps=0.74u w=0.17u l=0.17u
X3968 MOT5_P MOT5_N cml_tlatch_19.xmux.xp.S1 VSS sg13_lv_nmos ad=56.9f pd=0.74u as=56.9f ps=0.74u w=0.17u l=0.17u
X3969 stub_bi_63.BOTN stub_bi_49.BOTP cml_tlatch_79.xmux.xn.S1 VSS sg13_lv_nmos ad=63.19999f pd=0.74u as=63.19999f ps=0.74u w=0.26u l=0.38u
X3970 cml_tlatch_3.OUTN cml_tlatch_3.OUTP cml_tlatch_3.xmux.xp.S1 VSS sg13_lv_nmos ad=56.9f pd=0.74u as=56.9f ps=0.74u w=0.17u l=0.17u
X3971 cml_tlatch_63.OUTP cml_tlatch_63.OUTN cml_tlatch_63.xmux.xp.S1 VSS sg13_lv_nmos ad=56.9f pd=0.74u as=56.9f ps=0.74u w=0.17u l=0.17u
X3972 cml_tlatch_65.OUTP cml_tlatch_65.OUTN cml_tlatch_65.xmux.xp.S1 VSS sg13_lv_nmos ad=56.9f pd=0.74u as=56.9f ps=0.74u w=0.17u l=0.17u
X3973 cml_tlatch_3.xtail.S1 CKA0_N cml_tlatch_3.xmux.xp.S1 VSS sg13_lv_nmos ad=89.3f pd=0.85u as=89.3f ps=0.85u w=0.47u l=0.16u
X3974 cml_tlatch_65.xtail.S1 POLN VSS VSS sg13_lv_nmos ad=1.5637p pd=8.61u as=1.5637p ps=8.61u w=8.23u l=0.13u
X3975 cml_tlatch_38.xmux.xp.S1 cml_tlatch_38.OUTN cml_tlatch_38.OUTP VSS sg13_lv_nmos ad=56.9f pd=0.74u as=56.9f ps=0.74u w=0.17u l=0.17u
X3976 cml_tlatch_13.xtail.S1 CKB1_N cml_tlatch_13.xmux.xp.S1 VSS sg13_lv_nmos ad=89.3f pd=0.85u as=89.3f ps=0.85u w=0.47u l=0.16u
X3977 MOT25_P MOT25_N cml_tlatch_68.xmux.xp.S1 VSS sg13_lv_nmos ad=56.9f pd=0.74u as=56.9f ps=0.74u w=0.17u l=0.17u
X3978 cml_tlatch_70.INN cml_tlatch_70.INP cml_tlatch_84.xmux.xp.S1 VSS sg13_lv_nmos ad=56.9f pd=0.74u as=56.9f ps=0.74u w=0.17u l=0.17u
X3979 cml_tlatch_27.xmux.xn.S1 B0_2_N cml_tlatch_27.OUTP VSS sg13_lv_nmos ad=63.19999f pd=0.74u as=63.19999f ps=0.74u w=0.26u l=0.38u
X3980 cml_tlatch_93.xtail.S1 CKJ_N cml_tlatch_93.xmux.xp.S1 VSS sg13_lv_nmos ad=89.3f pd=0.85u as=89.3f ps=0.85u w=0.47u l=0.16u
X3981 ENB0_P VDD VSS rppd l=8.13u w=1u
X3982 cml_tlatch_89.xmux.xp.S1 cml_tlatch_89.OUTP cml_tlatch_89.OUTN VSS sg13_lv_nmos ad=56.9f pd=0.74u as=56.9f ps=0.74u w=0.17u l=0.17u
X3983 cml_tlatch_29.OUTP cml_tlatch_29.OUTN cml_tlatch_29.xmux.xp.S1 VSS sg13_lv_nmos ad=56.9f pd=0.74u as=56.9f ps=0.74u w=0.17u l=0.17u
X3984 cml_tlatch_14.xmux.xn.S1 stub_bi_19.BOTN cml_tlatch_5.INN VSS sg13_lv_nmos ad=63.19999f pd=0.74u as=0.1082p ps=1.34u w=0.26u l=0.38u
X3985 cml_gate2_7.xrtail.R1 CKA2_N GB2_P VSS sg13_lv_nmos ad=0.1007p pd=0.91u as=0.1007p ps=0.91u w=0.53u l=0.13u
X3986 cml_tlatch_27.xmux.xn.S1 B0_2_N cml_tlatch_27.OUTP VSS sg13_lv_nmos ad=63.19999f pd=0.74u as=63.19999f ps=0.74u w=0.26u l=0.38u
X3987 cml_tlatch_22.xmux.xp.S1 cml_tlatch_22.OUTN cml_tlatch_22.OUTP VSS sg13_lv_nmos ad=56.9f pd=0.74u as=56.9f ps=0.74u w=0.17u l=0.17u
X3988 stub_bi_17.BOTN stub_bi_17.BOTP cml_tlatch_13.xmux.xp.S1 VSS sg13_lv_nmos ad=56.9f pd=0.74u as=56.9f ps=0.74u w=0.17u l=0.17u
X3989 cml_tlatch_78.xmux.xn.S1 stub_bi_63.BOTP stub_bi_62.BOTN VSS sg13_lv_nmos ad=0.1082p pd=1.34u as=63.19999f ps=0.74u w=0.26u l=0.38u
X3990 MOT13_P cml_tlatch_6.INN cml_tlatch_6.xmux.xn.S1 VSS sg13_lv_nmos ad=63.19999f pd=0.74u as=63.19999f ps=0.74u w=0.26u l=0.38u
X3991 cml_tlatch_85.xmux.xn.S1 cml_tlatch_52.OUTP cml_tlatch_58.INN VSS sg13_lv_nmos ad=63.19999f pd=0.74u as=63.19999f ps=0.74u w=0.26u l=0.38u
X3992 MOT20_N MOT20_P cml_tlatch_50.xmux.xp.S1 VSS sg13_lv_nmos ad=56.9f pd=0.74u as=56.9f ps=0.74u w=0.17u l=0.17u
X3993 cml_tlatch_14.xtail.S1 CKB1_N cml_tlatch_14.xmux.xn.S1 VSS sg13_lv_nmos ad=89.3f pd=0.85u as=89.3f ps=0.85u w=0.47u l=0.16u
X3994 J4_P J4_N cml_tlatch_90.xmux.xp.S1 VSS sg13_lv_nmos ad=56.9f pd=0.74u as=0.1019p ps=1.34u w=0.17u l=0.17u
X3995 cml_tlatch_58.xmux.xp.S1 MOT28_P MOT28_N VSS sg13_lv_nmos ad=56.9f pd=0.74u as=56.9f ps=0.74u w=0.17u l=0.17u
X3996 MOT27_N MOT27_P cml_tlatch_69.xmux.xp.S1 VSS sg13_lv_nmos ad=56.9f pd=0.74u as=56.9f ps=0.74u w=0.17u l=0.17u
X3997 MOT1_N MOT1_P cml_tlatch_17.xmux.xp.S1 VSS sg13_lv_nmos ad=56.9f pd=0.74u as=56.9f ps=0.74u w=0.17u l=0.17u
X3998 cml_tlatch_24.xmux.xp.S1 MOT2_N MOT2_P VSS sg13_lv_nmos ad=56.9f pd=0.74u as=56.9f ps=0.74u w=0.17u l=0.17u
X3999 MOT13_P cml_tlatch_6.INN cml_tlatch_6.xmux.xn.S1 VSS sg13_lv_nmos ad=63.19999f pd=0.74u as=63.19999f ps=0.74u w=0.26u l=0.38u
X4000 cml_tlatch_61.xmux.xp.S1 cml_tlatch_61.OUTP cml_tlatch_61.OUTN VSS sg13_lv_nmos ad=56.9f pd=0.74u as=56.9f ps=0.74u w=0.17u l=0.17u
X4001 B3_2_P cml_tlatch_47.OUTN cml_tlatch_46.xmux.xn.S1 VSS sg13_lv_nmos ad=63.19999f pd=0.74u as=63.19999f ps=0.74u w=0.26u l=0.38u
X4002 cml_tlatch_20.xmux.xp.S1 CKHB0_N cml_tlatch_20.xtail.S1 VSS sg13_lv_nmos ad=89.3f pd=0.85u as=0.1598p ps=1.62u w=0.47u l=0.16u
X4003 cml_tlatch_57.xmux.xp.S1 CKHA3_N cml_tlatch_57.xtail.S1 VSS sg13_lv_nmos ad=89.3f pd=0.85u as=89.3f ps=0.85u w=0.47u l=0.16u
X4004 cml_tlatch_15.xmux.xp.S1 stub_bi_19.BOTP stub_bi_19.BOTN VSS sg13_lv_nmos ad=0.1019p pd=1.34u as=56.9f ps=0.74u w=0.17u l=0.17u
X4005 cml_tlatch_18.xmux.xp.S1 MOT3_N MOT3_P VSS sg13_lv_nmos ad=56.9f pd=0.74u as=56.9f ps=0.74u w=0.17u l=0.17u
X4006 B3_8_N B3_8_P cml_tlatch_60.xmux.xp.S1 VSS sg13_lv_nmos ad=56.9f pd=0.74u as=56.9f ps=0.74u w=0.17u l=0.17u
X4007 cml_tlatch_70.xtail.S1 CKHB3_N cml_tlatch_70.xmux.xp.S1 VSS sg13_lv_nmos ad=89.3f pd=0.85u as=89.3f ps=0.85u w=0.47u l=0.16u
X4008 cml_tlatch_56.xmux.xp.S1 A2_2_N A2_2_P VSS sg13_lv_nmos ad=56.9f pd=0.74u as=56.9f ps=0.74u w=0.17u l=0.17u
X4009 cml_tlatch_1.xmux.xp.S1 cml_tlatch_1.OUTP cml_tlatch_1.OUTN VSS sg13_lv_nmos ad=56.9f pd=0.74u as=56.9f ps=0.74u w=0.17u l=0.17u
X4010 cml_tlatch_51.xtail.S1 CKHA2_N cml_tlatch_51.xmux.xp.S1 VSS sg13_lv_nmos ad=89.3f pd=0.85u as=89.3f ps=0.85u w=0.47u l=0.16u
X4011 MOT15_P VDD VSS rppd l=5.17u w=1u
X4012 NS1_P VDD VSS rppd l=13.09u w=1u
X4013 cml_tlatch_42.xmux.xn.S1 CKA2_P cml_tlatch_42.xtail.S1 VSS sg13_lv_nmos ad=89.3f pd=0.85u as=89.3f ps=0.85u w=0.47u l=0.16u
X4014 cml_tlatch_56.INN cml_tlatch_56.INP cml_tlatch_42.xmux.xp.S1 VSS sg13_lv_nmos ad=56.9f pd=0.74u as=56.9f ps=0.74u w=0.17u l=0.17u
X4015 cml_tlatch_11.xmux.xn.S1 cml_tlatch_16.OUTN cml_tlatch_11.OUTP VSS sg13_lv_nmos ad=63.19999f pd=0.74u as=63.19999f ps=0.74u w=0.26u l=0.38u
X4016 cml_tlatch_11.OUTP cml_tlatch_11.OUTN cml_tlatch_11.xmux.xp.S1 VSS sg13_lv_nmos ad=56.9f pd=0.74u as=56.9f ps=0.74u w=0.17u l=0.17u
X4017 cml_tlatch_94.xmux.xp.S1 CKB1_P cml_tlatch_94.xtail.S1 VSS sg13_lv_nmos ad=89.3f pd=0.85u as=89.3f ps=0.85u w=0.47u l=0.16u
X4018 cml_tlatch_44.xtail.S1 CKB2_N cml_tlatch_44.xmux.xn.S1 VSS sg13_lv_nmos ad=89.3f pd=0.85u as=89.3f ps=0.85u w=0.47u l=0.16u
X4019 cml_tlatch_24.xmux.xn.S1 cml_tlatch_8.OUTP MOT2_N VSS sg13_lv_nmos ad=63.19999f pd=0.74u as=63.19999f ps=0.74u w=0.26u l=0.38u
X4020 cml_tlatch_14.xmux.xp.S1 cml_tlatch_5.INP cml_tlatch_5.INN VSS sg13_lv_nmos ad=56.9f pd=0.74u as=56.9f ps=0.74u w=0.17u l=0.17u
X4021 cml_tlatch_46.xmux.xp.S1 CKB3_P cml_tlatch_46.xtail.S1 VSS sg13_lv_nmos ad=89.3f pd=0.85u as=89.3f ps=0.85u w=0.47u l=0.16u
X4022 cml_tlatch_8.xmux.xp.S1 cml_tlatch_8.OUTP cml_tlatch_8.OUTN VSS sg13_lv_nmos ad=56.9f pd=0.74u as=56.9f ps=0.74u w=0.17u l=0.17u
X4023 VSS POLN cml_tlatch_47.xtail.S1 VSS sg13_lv_nmos ad=1.5637p pd=8.61u as=1.5637p ps=8.61u w=8.23u l=0.13u
X4024 cml_tlatch_45.OUTP cml_tlatch_45.OUTN cml_tlatch_45.xmux.xp.S1 VSS sg13_lv_nmos ad=56.9f pd=0.74u as=56.9f ps=0.74u w=0.17u l=0.17u
X4025 cml_tlatch_65.xmux.xn.S1 CKA3_P cml_tlatch_65.xtail.S1 VSS sg13_lv_nmos ad=0.1598p pd=1.62u as=89.3f ps=0.85u w=0.47u l=0.16u
X4026 cml_tlatch_75.xmux.xp.S1 MOT21_N MOT21_P VSS sg13_lv_nmos ad=56.9f pd=0.74u as=56.9f ps=0.74u w=0.17u l=0.17u
X4027 MOT4_P MOT4_N cml_tlatch_25.xmux.xp.S1 VSS sg13_lv_nmos ad=56.9f pd=0.74u as=56.9f ps=0.74u w=0.17u l=0.17u
X4028 MOT2_N MOT2_P cml_tlatch_24.xmux.xp.S1 VSS sg13_lv_nmos ad=56.9f pd=0.74u as=56.9f ps=0.74u w=0.17u l=0.17u
X4029 cml_tlatch_0.xtail.S1 CKA1_N cml_tlatch_0.xmux.xp.S1 VSS sg13_lv_nmos ad=89.3f pd=0.85u as=89.3f ps=0.85u w=0.47u l=0.16u
X4030 A3_8_P A3_8_N cml_tlatch_64.xmux.xp.S1 VSS sg13_lv_nmos ad=56.9f pd=0.74u as=56.9f ps=0.74u w=0.17u l=0.17u
X4031 cml_tlatch_60.xmux.xp.S1 B3_8_N B3_8_P VSS sg13_lv_nmos ad=56.9f pd=0.74u as=56.9f ps=0.74u w=0.17u l=0.17u
X4032 cml_tlatch_54.OUTP cml_tlatch_54.OUTN cml_tlatch_54.xmux.xp.S1 VSS sg13_lv_nmos ad=56.9f pd=0.74u as=56.9f ps=0.74u w=0.17u l=0.17u
X4033 cml_tlatch_37.xmux.xp.S1 A1_2_P A1_2_N VSS sg13_lv_nmos ad=56.9f pd=0.74u as=56.9f ps=0.74u w=0.17u l=0.17u
X4034 cml_tlatch_66.xtail.S1 CKA3_N cml_tlatch_66.xmux.xn.S1 VSS sg13_lv_nmos ad=89.3f pd=0.85u as=89.3f ps=0.85u w=0.47u l=0.16u
X4035 cml_tlatch_76.xmux.xp.S1 CKHB2_N cml_tlatch_76.xtail.S1 VSS sg13_lv_nmos ad=89.3f pd=0.85u as=89.3f ps=0.85u w=0.47u l=0.16u
X4036 cml_tlatch_91.xmux.xp.S1 CLK_W_N CLK_W_P VSS sg13_lv_nmos ad=56.9f pd=0.74u as=56.9f ps=0.74u w=0.17u l=0.17u
X4037 cml_tlatch_35.xmux.xp.S1 cml_tlatch_35.OUTP cml_tlatch_35.OUTN VSS sg13_lv_nmos ad=0.1019p pd=1.34u as=56.9f ps=0.74u w=0.17u l=0.17u
X4038 MOT22_P A2_2_N cml_tlatch_51.xmux.xn.S1 VSS sg13_lv_nmos ad=63.19999f pd=0.74u as=63.19999f ps=0.74u w=0.26u l=0.38u
X4039 cml_tlatch_95.INN cml_tlatch_95.INP cml_tlatch_36.xmux.xp.S1 VSS sg13_lv_nmos ad=56.9f pd=0.74u as=56.9f ps=0.74u w=0.17u l=0.17u
X4040 stub_bi_49.BOTP stub_bi_49.BOTN cml_tlatch_80.xmux.xp.S1 VSS sg13_lv_nmos ad=56.9f pd=0.74u as=56.9f ps=0.74u w=0.17u l=0.17u
X4041 cml_tlatch_76.xmux.xp.S1 MOT23_P MOT23_N VSS sg13_lv_nmos ad=56.9f pd=0.74u as=56.9f ps=0.74u w=0.17u l=0.17u
X4042 cml_tlatch_42.xmux.xn.S1 D2_N cml_tlatch_56.INP VSS sg13_lv_nmos ad=63.19999f pd=0.74u as=63.19999f ps=0.74u w=0.26u l=0.38u
X4043 cml_tlatch_38.xmux.xp.S1 cml_tlatch_38.OUTN cml_tlatch_38.OUTP VSS sg13_lv_nmos ad=56.9f pd=0.74u as=56.9f ps=0.74u w=0.17u l=0.17u
X4044 B1_8_P B1_8_N cml_tlatch_12.xmux.xp.S1 VSS sg13_lv_nmos ad=56.9f pd=0.74u as=56.9f ps=0.74u w=0.17u l=0.17u
X4045 stub_bi_31.BOTN stub_bi_31.BOTP cml_tlatch_34.xmux.xp.S1 VSS sg13_lv_nmos ad=56.9f pd=0.74u as=56.9f ps=0.74u w=0.17u l=0.17u
X4046 cml_tlatch_9.OUTP cml_tlatch_9.OUTN cml_tlatch_9.xmux.xp.S1 VSS sg13_lv_nmos ad=56.9f pd=0.74u as=56.9f ps=0.74u w=0.17u l=0.17u
X4047 cml_tlatch_42.xmux.xn.S1 D2_N cml_tlatch_56.INP VSS sg13_lv_nmos ad=63.19999f pd=0.74u as=63.19999f ps=0.74u w=0.26u l=0.38u
X4048 cml_tlatch_73.xmux.xp.S1 MOT17_P MOT17_N VSS sg13_lv_nmos ad=56.9f pd=0.74u as=56.9f ps=0.74u w=0.17u l=0.17u
X4049 MOT25_N MOT25_P cml_tlatch_68.xmux.xp.S1 VSS sg13_lv_nmos ad=56.9f pd=0.74u as=56.9f ps=0.74u w=0.17u l=0.17u
X4050 cml_tlatch_17.xmux.xn.S1 B0_8_N MOT1_P VSS sg13_lv_nmos ad=63.19999f pd=0.74u as=63.19999f ps=0.74u w=0.26u l=0.38u
X4051 cml_tlatch_8.OUTP cml_tlatch_8.OUTN cml_tlatch_8.xmux.xp.S1 VSS sg13_lv_nmos ad=56.9f pd=0.74u as=0.1019p ps=1.34u w=0.17u l=0.17u
X4052 cml_tlatch_65.xmux.xp.S1 CKA3_N cml_tlatch_65.xtail.S1 VSS sg13_lv_nmos ad=89.3f pd=0.85u as=89.3f ps=0.85u w=0.47u l=0.16u
X4053 VSS hs_to_clk_6.sg13_lv_nmos_2HGZLP_0.G VSS VSS sg13_lv_nmos ad=2.071p pd=11.28u as=0 ps=0 w=10.9u l=1.38u
X4054 MOT5_P MOT5_N cml_tlatch_19.xmux.xp.S1 VSS sg13_lv_nmos ad=56.9f pd=0.74u as=56.9f ps=0.74u w=0.17u l=0.17u
X4055 cml_tlatch_89.xtail.S1 CKA2_N cml_tlatch_89.xmux.xn.S1 VSS sg13_lv_nmos ad=89.3f pd=0.85u as=89.3f ps=0.85u w=0.47u l=0.16u
X4056 A1_8_P cml_tlatch_22.OUTN cml_tlatch_21.xmux.xn.S1 VSS sg13_lv_nmos ad=0.1082p pd=1.34u as=63.19999f ps=0.74u w=0.26u l=0.38u
X4057 cml_tlatch_69.xmux.xn.S1 CKHB3_P cml_tlatch_69.xtail.S1 VSS sg13_lv_nmos ad=89.3f pd=0.85u as=89.3f ps=0.85u w=0.47u l=0.16u
X4058 cml_tlatch_77.xmux.xp.S1 B2_8_P B2_8_N VSS sg13_lv_nmos ad=56.9f pd=0.74u as=56.9f ps=0.74u w=0.17u l=0.17u
X4059 hs_to_clk_0.sg13_lv_nmos_2HGZLP_0.G CKA0_N VSS rppd l=4.25u w=1u
X4060 cml_tlatch_97.xmux.xp.S1 MOT0_P MOT0_N VSS sg13_lv_nmos ad=56.9f pd=0.74u as=56.9f ps=0.74u w=0.17u l=0.17u
X4061 cml_tlatch_4.xmux.xp.S1 MOT9_P MOT9_N VSS sg13_lv_nmos ad=56.9f pd=0.74u as=56.9f ps=0.74u w=0.17u l=0.17u
X4062 cml_tlatch_93.xtail.S1 CKJ_P cml_tlatch_93.xmux.xn.S1 VSS sg13_lv_nmos ad=89.3f pd=0.85u as=89.3f ps=0.85u w=0.47u l=0.16u
X4063 cml_tlatch_89.xmux.xp.S1 cml_tlatch_89.OUTP cml_tlatch_89.OUTN VSS sg13_lv_nmos ad=56.9f pd=0.74u as=56.9f ps=0.74u w=0.17u l=0.17u
X4064 B0_2_N cml_tlatch_29.OUTP cml_tlatch_28.xmux.xn.S1 VSS sg13_lv_nmos ad=63.19999f pd=0.74u as=63.19999f ps=0.74u w=0.26u l=0.38u
X4065 cml_tlatch_99.OUTP cml_tlatch_99.OUTN cml_tlatch_99.xmux.xp.S1 VSS sg13_lv_nmos ad=56.9f pd=0.74u as=56.9f ps=0.74u w=0.17u l=0.17u
X4066 cml_tlatch_13.xtail.S1 POLN VSS VSS sg13_lv_nmos ad=1.5637p pd=8.61u as=2.7982p ps=17.14u w=8.23u l=0.13u
X4067 cml_tlatch_52.OUTN cml_tlatch_52.OUTP cml_tlatch_52.xmux.xp.S1 VSS sg13_lv_nmos ad=56.9f pd=0.74u as=56.9f ps=0.74u w=0.17u l=0.17u
X4068 cml_tlatch_7.xmux.xn.S1 B1_2_P MOT15_N VSS sg13_lv_nmos ad=63.19999f pd=0.74u as=0.1082p ps=1.34u w=0.26u l=0.38u
X4069 cml_gate2_3.sg13_lv_nmos_FTPY57_0.D0 CKB1_P cml_gate2_3.xrtail.R1 VSS sg13_lv_nmos ad=0.1007p pd=0.91u as=0.1802p ps=1.74u w=0.53u l=0.13u
X4070 interco_bi_19.INP cml_tlatch_40.INN cml_tlatch_0.xmux.xn.S1 VSS sg13_lv_nmos ad=63.19999f pd=0.74u as=0.1082p ps=1.34u w=0.26u l=0.38u
X4071 cml_tlatch_83.xtail.S1 POLN VSS VSS sg13_lv_nmos ad=1.5637p pd=8.61u as=2.7982p ps=17.14u w=8.23u l=0.13u
X4072 MOT7_P MOT7_N cml_tlatch_20.xmux.xp.S1 VSS sg13_lv_nmos ad=56.9f pd=0.74u as=56.9f ps=0.74u w=0.17u l=0.17u
X4073 MOT7_N MOT7_P cml_tlatch_20.xmux.xp.S1 VSS sg13_lv_nmos ad=56.9f pd=0.74u as=56.9f ps=0.74u w=0.17u l=0.17u
X4074 MOT27_P MOT27_N cml_tlatch_69.xmux.xp.S1 VSS sg13_lv_nmos ad=56.9f pd=0.74u as=56.9f ps=0.74u w=0.17u l=0.17u
X4075 stub_bi_32.BOTP stub_bi_32.BOTN cml_tlatch_48.xmux.xp.S1 VSS sg13_lv_nmos ad=56.9f pd=0.74u as=56.9f ps=0.74u w=0.17u l=0.17u
X4076 cml_gate2_0.xrtail.R1 CKA1_P cml_gate2_0.sg13_lv_nmos_FTPY57_0.D0 VSS sg13_lv_nmos ad=0.1007p pd=0.91u as=0.1007p ps=0.91u w=0.53u l=0.13u
X4077 cml_tlatch_61.xmux.xp.S1 CKB3_N cml_tlatch_61.xtail.S1 VSS sg13_lv_nmos ad=89.3f pd=0.85u as=89.3f ps=0.85u w=0.47u l=0.16u
X4078 cml_tlatch_88.xtail.S1 CKB2_N cml_tlatch_88.xmux.xn.S1 VSS sg13_lv_nmos ad=89.3f pd=0.85u as=89.3f ps=0.85u w=0.47u l=0.16u
X4079 cml_tlatch_24.xmux.xp.S1 MOT2_N MOT2_P VSS sg13_lv_nmos ad=56.9f pd=0.74u as=56.9f ps=0.74u w=0.17u l=0.17u
X4080 GA1_N ENA0_P cml_gate2_3.sg13_lv_nmos_FTPY57_0.D0 VSS sg13_lv_nmos ad=0.1007p pd=0.91u as=0.1007p ps=0.91u w=0.53u l=0.13u
X4081 cml_tlatch_43.xmux.xp.S1 stub_bi_42.BOTP stub_bi_42.BOTN VSS sg13_lv_nmos ad=56.9f pd=0.74u as=56.9f ps=0.74u w=0.17u l=0.17u
X4082 MOT11_N cml_tlatch_5.INP cml_tlatch_5.xmux.xn.S1 VSS sg13_lv_nmos ad=63.19999f pd=0.74u as=63.19999f ps=0.74u w=0.26u l=0.38u
X4083 cml_tlatch_95.xmux.xn.S1 cml_tlatch_95.INN cml_tlatch_40.INP VSS sg13_lv_nmos ad=63.19999f pd=0.74u as=63.19999f ps=0.74u w=0.26u l=0.38u
X4084 cml_tlatch_77.xmux.xn.S1 CKB2_N cml_tlatch_77.xtail.S1 VSS sg13_lv_nmos ad=89.3f pd=0.85u as=89.3f ps=0.85u w=0.47u l=0.16u
X4085 cml_tlatch_25.xmux.xn.S1 CKHA0_P cml_tlatch_25.xtail.S1 VSS sg13_lv_nmos ad=89.3f pd=0.85u as=0.1598p ps=1.62u w=0.47u l=0.16u
X4086 cml_tlatch_64.xmux.xn.S1 CKA3_N cml_tlatch_64.xtail.S1 VSS sg13_lv_nmos ad=89.3f pd=0.85u as=0.1598p ps=1.62u w=0.47u l=0.16u
X4087 cml_tlatch_10.xmux.xp.S1 B0_8_P B0_8_N VSS sg13_lv_nmos ad=56.9f pd=0.74u as=56.9f ps=0.74u w=0.17u l=0.17u
X4088 cml_tlatch_16.xtail.S1 POLN VSS VSS sg13_lv_nmos ad=1.5637p pd=8.61u as=1.5637p ps=8.61u w=8.23u l=0.13u
X4089 A3_2_N A3_2_P cml_tlatch_53.xmux.xp.S1 VSS sg13_lv_nmos ad=56.9f pd=0.74u as=56.9f ps=0.74u w=0.17u l=0.17u
X4090 stub_bi_55.BOTN stub_bi_55.BOTP cml_tlatch_88.xmux.xp.S1 VSS sg13_lv_nmos ad=56.9f pd=0.74u as=56.9f ps=0.74u w=0.17u l=0.17u
X4091 cml_tlatch_16.OUTN cml_tlatch_16.OUTP cml_tlatch_16.xmux.xp.S1 VSS sg13_lv_nmos ad=56.9f pd=0.74u as=56.9f ps=0.74u w=0.17u l=0.17u
X4092 cml_tlatch_19.xmux.xp.S1 CKHB0_N cml_tlatch_19.xtail.S1 VSS sg13_lv_nmos ad=89.3f pd=0.85u as=89.3f ps=0.85u w=0.47u l=0.16u
X4093 cml_tlatch_35.xtail.S1 POLN VSS VSS sg13_lv_nmos ad=1.5637p pd=8.61u as=1.5637p ps=8.61u w=8.23u l=0.13u
X4094 MOT16_P MOT16_N cml_tlatch_87.xmux.xp.S1 VSS sg13_lv_nmos ad=56.9f pd=0.74u as=56.9f ps=0.74u w=0.17u l=0.17u
X4095 cml_tlatch_86.xmux.xp.S1 MOT24_N MOT24_P VSS sg13_lv_nmos ad=56.9f pd=0.74u as=56.9f ps=0.74u w=0.17u l=0.17u
X4096 B2_2_P B2_2_N cml_tlatch_44.xmux.xp.S1 VSS sg13_lv_nmos ad=56.9f pd=0.74u as=56.9f ps=0.74u w=0.17u l=0.17u
X4097 cml_tlatch_35.xmux.xp.S1 CKA0_N cml_tlatch_35.xtail.S1 VSS sg13_lv_nmos ad=89.3f pd=0.85u as=89.3f ps=0.85u w=0.47u l=0.16u
X4098 MOT13_P MOT13_N cml_tlatch_6.xmux.xp.S1 VSS sg13_lv_nmos ad=56.9f pd=0.74u as=0.1019p ps=1.34u w=0.17u l=0.17u
X4099 cml_tlatch_36.xmux.xp.S1 cml_tlatch_95.INP cml_tlatch_95.INN VSS sg13_lv_nmos ad=0.1019p pd=1.34u as=56.9f ps=0.74u w=0.17u l=0.17u
X4100 cml_tlatch_96.xmux.xn.S1 A1_8_P MOT8_N VSS sg13_lv_nmos ad=63.19999f pd=0.74u as=63.19999f ps=0.74u w=0.26u l=0.38u
X4101 cml_drv_3.xrtail.R1 ENA_N ENA0_P VSS sg13_lv_nmos ad=56.2f pd=0.74u as=56.2f ps=0.74u w=0.16u l=0.19u
X4102 cml_tlatch_48.xtail.S1 POLN VSS VSS sg13_lv_nmos ad=1.5637p pd=8.61u as=1.5637p ps=8.61u w=8.23u l=0.13u
X4103 cml_tlatch_31.xtail.S1 CKA0_P cml_tlatch_31.xmux.xp.S1 VSS sg13_lv_nmos ad=89.3f pd=0.85u as=89.3f ps=0.85u w=0.47u l=0.16u
X4104 cml_tlatch_28.xmux.xp.S1 B0_2_N B0_2_P VSS sg13_lv_nmos ad=56.9f pd=0.74u as=56.9f ps=0.74u w=0.17u l=0.17u
X4105 cml_tlatch_16.OUTN cml_tlatch_1.OUTP cml_tlatch_16.xmux.xn.S1 VSS sg13_lv_nmos ad=63.19999f pd=0.74u as=63.19999f ps=0.74u w=0.26u l=0.38u
X4106 cml_tlatch_57.xtail.S1 CKHA3_P cml_tlatch_57.xmux.xn.S1 VSS sg13_lv_nmos ad=89.3f pd=0.85u as=89.3f ps=0.85u w=0.47u l=0.16u
X4107 cml_tlatch_77.xmux.xp.S1 B2_8_P B2_8_N VSS sg13_lv_nmos ad=56.9f pd=0.74u as=56.9f ps=0.74u w=0.17u l=0.17u
X4108 cml_drv_3.xrtail.R1 ENA_P ENA0_N VSS sg13_lv_nmos ad=0.1012p pd=1.34u as=56.2f ps=0.74u w=0.16u l=0.19u
X4109 cml_tlatch_67.xmux.xp.S1 cml_tlatch_67.OUTP cml_tlatch_67.OUTN VSS sg13_lv_nmos ad=56.9f pd=0.74u as=56.9f ps=0.74u w=0.17u l=0.17u
X4110 cml_tlatch_14.xmux.xn.S1 CKB1_N cml_tlatch_14.xtail.S1 VSS sg13_lv_nmos ad=89.3f pd=0.85u as=89.3f ps=0.85u w=0.47u l=0.16u
X4111 cml_drv_2.xrtail.R1 ENB_P ENB0_N VSS sg13_lv_nmos ad=56.2f pd=0.74u as=56.2f ps=0.74u w=0.16u l=0.19u
X4112 cml_gate2_8.xrtail.R1 NS1_P cml_gate2_8.sg13_lv_nmos_FTPY57_0.D0 VSS sg13_lv_nmos ad=0.1802p pd=1.74u as=0.1007p ps=0.91u w=0.53u l=0.13u
X4113 cml_tlatch_40.xmux.xp.S1 MOT12_N MOT12_P VSS sg13_lv_nmos ad=56.9f pd=0.74u as=56.9f ps=0.74u w=0.17u l=0.17u
X4114 cml_tlatch_50.xmux.xn.S1 CKHA2_P cml_tlatch_50.xtail.S1 VSS sg13_lv_nmos ad=89.3f pd=0.85u as=89.3f ps=0.85u w=0.47u l=0.16u
X4115 cml_tlatch_83.xmux.xp.S1 cml_tlatch_83.OUTN cml_tlatch_83.OUTP VSS sg13_lv_nmos ad=56.9f pd=0.74u as=56.9f ps=0.74u w=0.17u l=0.17u
X4116 cml_tlatch_98.xtail.S1 CKB0_N cml_tlatch_98.xmux.xn.S1 VSS sg13_lv_nmos ad=89.3f pd=0.85u as=89.3f ps=0.85u w=0.47u l=0.16u
X4117 interco_bi_19.INN interco_bi_19.INP cml_tlatch_0.xmux.xp.S1 VSS sg13_lv_nmos ad=56.9f pd=0.74u as=56.9f ps=0.74u w=0.17u l=0.17u
X4118 stub_bi_62.BOTP stub_bi_62.BOTN cml_tlatch_78.xmux.xp.S1 VSS sg13_lv_nmos ad=56.9f pd=0.74u as=56.9f ps=0.74u w=0.17u l=0.17u
X4119 cml_tlatch_1.OUTN cml_tlatch_98.OUTP cml_tlatch_1.xmux.xn.S1 VSS sg13_lv_nmos ad=63.19999f pd=0.74u as=63.19999f ps=0.74u w=0.26u l=0.38u
X4120 cml_tlatch_43.xmux.xp.S1 stub_bi_42.BOTP stub_bi_42.BOTN VSS sg13_lv_nmos ad=56.9f pd=0.74u as=56.9f ps=0.74u w=0.17u l=0.17u
X4121 cml_tlatch_76.xmux.xp.S1 MOT23_P MOT23_N VSS sg13_lv_nmos ad=56.9f pd=0.74u as=56.9f ps=0.74u w=0.17u l=0.17u
X4122 cml_tlatch_2.xmux.xn.S1 cml_tlatch_3.OUTP A0_8_N VSS sg13_lv_nmos ad=63.19999f pd=0.74u as=63.19999f ps=0.74u w=0.26u l=0.38u
X4123 GA0_P CKB0_N cml_gate2_2.xrtail.R1 VSS sg13_lv_nmos ad=0.1007p pd=0.91u as=0.1007p ps=0.91u w=0.53u l=0.13u
X4124 cml_tlatch_98.xmux.xp.S1 cml_tlatch_98.OUTN cml_tlatch_98.OUTP VSS sg13_lv_nmos ad=56.9f pd=0.74u as=56.9f ps=0.74u w=0.17u l=0.17u
X4125 cml_tlatch_9.OUTP cml_tlatch_9.OUTN cml_tlatch_9.xmux.xp.S1 VSS sg13_lv_nmos ad=56.9f pd=0.74u as=56.9f ps=0.74u w=0.17u l=0.17u
X4126 cml_tlatch_41.xmux.xp.S1 MOT14_N MOT14_P VSS sg13_lv_nmos ad=56.9f pd=0.74u as=56.9f ps=0.74u w=0.17u l=0.17u
X4127 VSS POLN cml_tlatch_30.xtail.S1 VSS sg13_lv_nmos ad=1.5637p pd=8.61u as=1.5637p ps=8.61u w=8.23u l=0.13u
X4128 cml_tlatch_41.xtail.S1 CKHA1_P cml_tlatch_41.xmux.xn.S1 VSS sg13_lv_nmos ad=89.3f pd=0.85u as=89.3f ps=0.85u w=0.47u l=0.16u
X4129 interco_bi_19.INN interco_bi_19.INP cml_tlatch_0.xmux.xp.S1 VSS sg13_lv_nmos ad=56.9f pd=0.74u as=56.9f ps=0.74u w=0.17u l=0.17u
X4130 cml_tlatch_82.xmux.xp.S1 cml_tlatch_82.OUTN cml_tlatch_82.OUTP VSS sg13_lv_nmos ad=56.9f pd=0.74u as=56.9f ps=0.74u w=0.17u l=0.17u
X4131 cml_tlatch_58.xmux.xp.S1 MOT28_N MOT28_P VSS sg13_lv_nmos ad=56.9f pd=0.74u as=56.9f ps=0.74u w=0.17u l=0.17u
X4132 cml_tlatch_7.xmux.xp.S1 MOT15_P MOT15_N VSS sg13_lv_nmos ad=56.9f pd=0.74u as=56.9f ps=0.74u w=0.17u l=0.17u
X4133 cml_tlatch_44.xmux.xn.S1 CKB2_N cml_tlatch_44.xtail.S1 VSS sg13_lv_nmos ad=89.3f pd=0.85u as=89.3f ps=0.85u w=0.47u l=0.16u
X4134 MOT1_P MOT1_N cml_tlatch_17.xmux.xp.S1 VSS sg13_lv_nmos ad=56.9f pd=0.74u as=56.9f ps=0.74u w=0.17u l=0.17u
X4135 VSS POLN cml_tlatch_23.xtail.S1 VSS sg13_lv_nmos ad=1.5637p pd=8.61u as=1.5637p ps=8.61u w=8.23u l=0.13u
X4136 cml_tlatch_23.xtail.S1 CKA1_P cml_tlatch_23.xmux.xp.S1 VSS sg13_lv_nmos ad=89.3f pd=0.85u as=89.3f ps=0.85u w=0.47u l=0.16u
X4137 cml_tlatch_53.xmux.xn.S1 CKA3_N cml_tlatch_53.xtail.S1 VSS sg13_lv_nmos ad=89.3f pd=0.85u as=0.1598p ps=1.62u w=0.47u l=0.16u
X4138 cml_tlatch_74.xmux.xp.S1 MOT19_P MOT19_N VSS sg13_lv_nmos ad=56.9f pd=0.74u as=56.9f ps=0.74u w=0.17u l=0.17u
X4139 cml_tlatch_33.xmux.xn.S1 stub_bi_31.BOTP B1_2_P VSS sg13_lv_nmos ad=63.19999f pd=0.74u as=63.19999f ps=0.74u w=0.26u l=0.38u
X4140 A0_8_P A0_8_N cml_tlatch_2.xmux.xp.S1 VSS sg13_lv_nmos ad=56.9f pd=0.74u as=56.9f ps=0.74u w=0.17u l=0.17u
X4141 cml_tlatch_57.INN cml_tlatch_67.OUTP cml_tlatch_66.xmux.xn.S1 VSS sg13_lv_nmos ad=0.1082p pd=1.34u as=63.19999f ps=0.74u w=0.26u l=0.38u
X4142 MOT26_P MOT26_N cml_tlatch_57.xmux.xp.S1 VSS sg13_lv_nmos ad=56.9f pd=0.74u as=56.9f ps=0.74u w=0.17u l=0.17u
X4143 cml_tlatch_31.xtail.S1 CKA0_N cml_tlatch_31.xmux.xn.S1 VSS sg13_lv_nmos ad=89.3f pd=0.85u as=89.3f ps=0.85u w=0.47u l=0.16u
X4144 cml_tlatch_9.xtail.S1 CKA0_P cml_tlatch_9.xmux.xn.S1 VSS sg13_lv_nmos ad=89.3f pd=0.85u as=89.3f ps=0.85u w=0.47u l=0.16u
X4145 ENA_N J1_P cml_gate2_9.sg13_lv_nmos_FTPY57_0.D0 VSS sg13_lv_nmos ad=0.1007p pd=0.91u as=0.1007p ps=0.91u w=0.53u l=0.13u
X4146 cml_tlatch_76.xtail.S1 CKHB2_N cml_tlatch_76.xmux.xp.S1 VSS sg13_lv_nmos ad=89.3f pd=0.85u as=89.3f ps=0.85u w=0.47u l=0.16u
X4147 cml_tlatch_7.xmux.xp.S1 MOT15_N MOT15_P VSS sg13_lv_nmos ad=56.9f pd=0.74u as=56.9f ps=0.74u w=0.17u l=0.17u
X4148 cml_tlatch_55.xmux.xp.S1 CKA2_N cml_tlatch_55.xtail.S1 VSS sg13_lv_nmos ad=89.3f pd=0.85u as=89.3f ps=0.85u w=0.47u l=0.16u
X4149 cml_tlatch_14.xtail.S1 CKB1_P cml_tlatch_14.xmux.xp.S1 VSS sg13_lv_nmos ad=89.3f pd=0.85u as=89.3f ps=0.85u w=0.47u l=0.16u
X4150 cml_tlatch_39.INP interco_bi_19.INN cml_tlatch_23.xmux.xn.S1 VSS sg13_lv_nmos ad=63.19999f pd=0.74u as=63.19999f ps=0.74u w=0.26u l=0.38u
X4151 cml_tlatch_5.xmux.xp.S1 MOT11_N MOT11_P VSS sg13_lv_nmos ad=56.9f pd=0.74u as=56.9f ps=0.74u w=0.17u l=0.17u
X4152 cml_tlatch_5.xmux.xp.S1 CKHB1_N cml_tlatch_5.xtail.S1 VSS sg13_lv_nmos ad=89.3f pd=0.85u as=89.3f ps=0.85u w=0.47u l=0.16u
X4153 cml_tlatch_95.xmux.xp.S1 cml_tlatch_40.INN cml_tlatch_40.INP VSS sg13_lv_nmos ad=56.9f pd=0.74u as=56.9f ps=0.74u w=0.17u l=0.17u
X4154 cml_tlatch_71.xtail.S1 CKHB3_N cml_tlatch_71.xmux.xp.S1 VSS sg13_lv_nmos ad=89.3f pd=0.85u as=89.3f ps=0.85u w=0.47u l=0.16u
X4155 stub_bi_55.BOTN stub_bi_55.BOTP cml_tlatch_88.xmux.xp.S1 VSS sg13_lv_nmos ad=56.9f pd=0.74u as=56.9f ps=0.74u w=0.17u l=0.17u
X4156 MOT3_N MOT3_P cml_tlatch_18.xmux.xp.S1 VSS sg13_lv_nmos ad=56.9f pd=0.74u as=56.9f ps=0.74u w=0.17u l=0.17u
X4157 cml_tlatch_77.xmux.xp.S1 CKB2_P cml_tlatch_77.xtail.S1 VSS sg13_lv_nmos ad=89.3f pd=0.85u as=89.3f ps=0.85u w=0.47u l=0.16u
X4158 cml_tlatch_28.xmux.xn.S1 cml_tlatch_29.OUTN B0_2_P VSS sg13_lv_nmos ad=63.19999f pd=0.74u as=63.19999f ps=0.74u w=0.26u l=0.38u
X4159 cml_tlatch_25.xmux.xp.S1 CKHA0_N cml_tlatch_25.xtail.S1 VSS sg13_lv_nmos ad=89.3f pd=0.85u as=89.3f ps=0.85u w=0.47u l=0.16u
X4160 cml_tlatch_26.xmux.xp.S1 MOT6_P MOT6_N VSS sg13_lv_nmos ad=56.9f pd=0.74u as=56.9f ps=0.74u w=0.17u l=0.17u
X4161 MOT17_N B2_8_P cml_tlatch_73.xmux.xn.S1 VSS sg13_lv_nmos ad=63.19999f pd=0.74u as=63.19999f ps=0.74u w=0.26u l=0.38u
X4162 cml_tlatch_64.xmux.xp.S1 CKA3_P cml_tlatch_64.xtail.S1 VSS sg13_lv_nmos ad=89.3f pd=0.85u as=89.3f ps=0.85u w=0.47u l=0.16u
X4163 cml_tlatch_86.xmux.xp.S1 MOT24_N MOT24_P VSS sg13_lv_nmos ad=56.9f pd=0.74u as=56.9f ps=0.74u w=0.17u l=0.17u
X4164 cml_tlatch_28.xmux.xn.S1 cml_tlatch_29.OUTN B0_2_P VSS sg13_lv_nmos ad=63.19999f pd=0.74u as=63.19999f ps=0.74u w=0.26u l=0.38u
X4165 cml_tlatch_71.xmux.xp.S1 MOT31_N MOT31_P VSS sg13_lv_nmos ad=56.9f pd=0.74u as=56.9f ps=0.74u w=0.17u l=0.17u
X4166 cml_tlatch_50.xtail.S1 POLN VSS VSS sg13_lv_nmos ad=1.5637p pd=8.61u as=1.5637p ps=8.61u w=8.23u l=0.13u
X4167 cml_tlatch_16.xmux.xp.S1 cml_tlatch_16.OUTN cml_tlatch_16.OUTP VSS sg13_lv_nmos ad=56.9f pd=0.74u as=56.9f ps=0.74u w=0.17u l=0.17u
X4168 cml_tlatch_11.OUTN cml_tlatch_16.OUTP cml_tlatch_11.xmux.xn.S1 VSS sg13_lv_nmos ad=63.19999f pd=0.74u as=63.19999f ps=0.74u w=0.26u l=0.38u
X4169 MOT8_P MOT8_N cml_tlatch_96.xmux.xp.S1 VSS sg13_lv_nmos ad=56.9f pd=0.74u as=56.9f ps=0.74u w=0.17u l=0.17u
X4170 MOT8_N MOT8_P cml_tlatch_96.xmux.xp.S1 VSS sg13_lv_nmos ad=56.9f pd=0.74u as=56.9f ps=0.74u w=0.17u l=0.17u
X4171 cml_tlatch_22.xmux.xn.S1 cml_tlatch_39.INN cml_tlatch_22.OUTP VSS sg13_lv_nmos ad=63.19999f pd=0.74u as=63.19999f ps=0.74u w=0.26u l=0.38u
X4172 cml_tlatch_67.xmux.xp.S1 cml_tlatch_67.OUTP cml_tlatch_67.OUTN VSS sg13_lv_nmos ad=56.9f pd=0.74u as=56.9f ps=0.74u w=0.17u l=0.17u
X4173 cml_tlatch_63.OUTN cml_tlatch_63.OUTP cml_tlatch_63.xmux.xp.S1 VSS sg13_lv_nmos ad=56.9f pd=0.74u as=56.9f ps=0.74u w=0.17u l=0.17u
X4174 cml_tlatch_78.xmux.xp.S1 stub_bi_62.BOTP stub_bi_62.BOTN VSS sg13_lv_nmos ad=56.9f pd=0.74u as=56.9f ps=0.74u w=0.17u l=0.17u
X4175 cml_tlatch_81.xmux.xp.S1 A2_8_N A2_8_P VSS sg13_lv_nmos ad=56.9f pd=0.74u as=56.9f ps=0.74u w=0.17u l=0.17u
X4176 A2_2_P cml_tlatch_56.INN cml_tlatch_56.xmux.xn.S1 VSS sg13_lv_nmos ad=63.19999f pd=0.74u as=63.19999f ps=0.74u w=0.26u l=0.38u
X4177 cml_tlatch_42.xmux.xp.S1 cml_tlatch_56.INN cml_tlatch_56.INP VSS sg13_lv_nmos ad=56.9f pd=0.74u as=56.9f ps=0.74u w=0.17u l=0.17u
X4178 cml_tlatch_37.xmux.xp.S1 CKA1_P cml_tlatch_37.xtail.S1 VSS sg13_lv_nmos ad=89.3f pd=0.85u as=89.3f ps=0.85u w=0.47u l=0.16u
X4179 cml_tlatch_46.xmux.xp.S1 B3_2_N B3_2_P VSS sg13_lv_nmos ad=56.9f pd=0.74u as=56.9f ps=0.74u w=0.17u l=0.17u
X4180 cml_tlatch_39.xmux.xp.S1 CKHA1_N cml_tlatch_39.xtail.S1 VSS sg13_lv_nmos ad=89.3f pd=0.85u as=89.3f ps=0.85u w=0.47u l=0.16u
X4181 cml_tlatch_65.xmux.xn.S1 CKA3_P cml_tlatch_65.xtail.S1 VSS sg13_lv_nmos ad=89.3f pd=0.85u as=89.3f ps=0.85u w=0.47u l=0.16u
X4182 cml_tlatch_51.xmux.xp.S1 MOT22_P MOT22_N VSS sg13_lv_nmos ad=56.9f pd=0.74u as=56.9f ps=0.74u w=0.17u l=0.17u
X4183 J2_P J2_N cml_tlatch_92.xmux.xp.S1 VSS sg13_lv_nmos ad=56.9f pd=0.74u as=56.9f ps=0.74u w=0.17u l=0.17u
X4184 cml_tlatch_83.xmux.xp.S1 CKA2_P cml_tlatch_83.xtail.S1 VSS sg13_lv_nmos ad=89.3f pd=0.85u as=89.3f ps=0.85u w=0.47u l=0.16u
X4185 cml_tlatch_59.xtail.S1 CKHA3_N cml_tlatch_59.xmux.xp.S1 VSS sg13_lv_nmos ad=89.3f pd=0.85u as=89.3f ps=0.85u w=0.47u l=0.16u
X4186 cml_tlatch_15.xmux.xp.S1 stub_bi_19.BOTN stub_bi_19.BOTP VSS sg13_lv_nmos ad=56.9f pd=0.74u as=56.9f ps=0.74u w=0.17u l=0.17u
X4187 cml_tlatch_27.OUTP VDD VSS rppd l=5.17u w=1u
X4188 B3_2_N B3_2_P cml_tlatch_46.xmux.xp.S1 VSS sg13_lv_nmos ad=56.9f pd=0.74u as=56.9f ps=0.74u w=0.17u l=0.17u
X4189 MOT4_N MOT4_P cml_tlatch_25.xmux.xp.S1 VSS sg13_lv_nmos ad=56.9f pd=0.74u as=56.9f ps=0.74u w=0.17u l=0.17u
X4190 A3_8_N A3_8_P cml_tlatch_64.xmux.xp.S1 VSS sg13_lv_nmos ad=56.9f pd=0.74u as=56.9f ps=0.74u w=0.17u l=0.17u
X4191 MOT24_N MOT24_P cml_tlatch_86.xmux.xp.S1 VSS sg13_lv_nmos ad=56.9f pd=0.74u as=56.9f ps=0.74u w=0.17u l=0.17u
X4192 cml_tlatch_27.OUTN cml_tlatch_27.OUTP cml_tlatch_27.xmux.xp.S1 VSS sg13_lv_nmos ad=56.9f pd=0.74u as=56.9f ps=0.74u w=0.17u l=0.17u
X4193 cml_tlatch_85.xmux.xp.S1 cml_tlatch_58.INP cml_tlatch_58.INN VSS sg13_lv_nmos ad=0.1019p pd=1.34u as=56.9f ps=0.74u w=0.17u l=0.17u
X4194 cml_tlatch_33.xmux.xp.S1 CKB1_P cml_tlatch_33.xtail.S1 VSS sg13_lv_nmos ad=89.3f pd=0.85u as=89.3f ps=0.85u w=0.47u l=0.16u
X4195 cml_tlatch_9.xmux.xp.S1 cml_tlatch_9.OUTP cml_tlatch_9.OUTN VSS sg13_lv_nmos ad=56.9f pd=0.74u as=56.9f ps=0.74u w=0.17u l=0.17u
X4196 cml_tlatch_21.xmux.xp.S1 A1_8_P A1_8_N VSS sg13_lv_nmos ad=56.9f pd=0.74u as=56.9f ps=0.74u w=0.17u l=0.17u
X4197 B1_8_N B1_8_P cml_tlatch_12.xmux.xp.S1 VSS sg13_lv_nmos ad=56.9f pd=0.74u as=56.9f ps=0.74u w=0.17u l=0.17u
X4198 cml_tlatch_35.OUTN cml_tlatch_35.OUTP cml_tlatch_35.xmux.xp.S1 VSS sg13_lv_nmos ad=56.9f pd=0.74u as=56.9f ps=0.74u w=0.17u l=0.17u
X4199 cml_gate2_9.sg13_lv_nmos_FTPY57_0.D0 J1_P ENA_N VSS sg13_lv_nmos ad=0.1007p pd=0.91u as=0.1007p ps=0.91u w=0.53u l=0.13u
X4200 CKB3_N CK_P hs_to_clk_5.D2 VSS sg13_lv_nmos ad=0.228p pd=1.58u as=0.228p ps=1.58u w=1.2u l=0.2u
X4201 cml_tlatch_47.OUTP D3_N cml_tlatch_47.xmux.xn.S1 VSS sg13_lv_nmos ad=63.19999f pd=0.74u as=63.19999f ps=0.74u w=0.26u l=0.38u
X4202 cml_tlatch_70.xmux.xn.S1 cml_tlatch_70.INP MOT29_N VSS sg13_lv_nmos ad=63.19999f pd=0.74u as=63.19999f ps=0.74u w=0.26u l=0.38u
X4203 cml_tlatch_4.xmux.xp.S1 MOT9_N MOT9_P VSS sg13_lv_nmos ad=56.9f pd=0.74u as=56.9f ps=0.74u w=0.17u l=0.17u
X4204 cml_drv_0.xrtail.R1 ENB_P ENB1_N VSS sg13_lv_nmos ad=56.2f pd=0.74u as=56.2f ps=0.74u w=0.16u l=0.19u
X4205 B3_2_P B3_2_N cml_tlatch_46.xmux.xp.S1 VSS sg13_lv_nmos ad=56.9f pd=0.74u as=56.9f ps=0.74u w=0.17u l=0.17u
X4206 cml_tlatch_74.xmux.xp.S1 MOT19_P MOT19_N VSS sg13_lv_nmos ad=56.9f pd=0.74u as=56.9f ps=0.74u w=0.17u l=0.17u
X4207 MOT23_N B2_2_P cml_tlatch_76.xmux.xn.S1 VSS sg13_lv_nmos ad=0.1082p pd=1.34u as=63.19999f ps=0.74u w=0.26u l=0.38u
X4208 cml_tlatch_52.OUTP cml_tlatch_52.OUTN cml_tlatch_52.xmux.xp.S1 VSS sg13_lv_nmos ad=56.9f pd=0.74u as=56.9f ps=0.74u w=0.17u l=0.17u
X4209 cml_tlatch_2.xmux.xn.S1 CKA0_N cml_tlatch_2.xtail.S1 VSS sg13_lv_nmos ad=89.3f pd=0.85u as=89.3f ps=0.85u w=0.47u l=0.16u
X4210 cml_tlatch_34.xmux.xp.S1 stub_bi_31.BOTN stub_bi_31.BOTP VSS sg13_lv_nmos ad=56.9f pd=0.74u as=56.9f ps=0.74u w=0.17u l=0.17u
X4211 cml_tlatch_50.xtail.S1 CKHA2_P cml_tlatch_50.xmux.xn.S1 VSS sg13_lv_nmos ad=89.3f pd=0.85u as=89.3f ps=0.85u w=0.47u l=0.16u
X4212 cml_tlatch_39.INP cml_tlatch_39.INN cml_tlatch_23.xmux.xp.S1 VSS sg13_lv_nmos ad=56.9f pd=0.74u as=56.9f ps=0.74u w=0.17u l=0.17u
X4213 cml_tlatch_5.xmux.xp.S1 MOT11_P MOT11_N VSS sg13_lv_nmos ad=56.9f pd=0.74u as=56.9f ps=0.74u w=0.17u l=0.17u
X4214 cml_tlatch_39.xmux.xp.S1 MOT10_N MOT10_P VSS sg13_lv_nmos ad=56.9f pd=0.74u as=56.9f ps=0.74u w=0.17u l=0.17u
X4215 cml_tlatch_36.xmux.xp.S1 cml_tlatch_95.INN cml_tlatch_95.INP VSS sg13_lv_nmos ad=56.9f pd=0.74u as=56.9f ps=0.74u w=0.17u l=0.17u
X4216 stub_bi_29.BOTN stub_bi_29.BOTP cml_tlatch_32.xmux.xp.S1 VSS sg13_lv_nmos ad=56.9f pd=0.74u as=56.9f ps=0.74u w=0.17u l=0.17u
X4217 cml_tlatch_13.xmux.xn.S1 CKB1_P cml_tlatch_13.xtail.S1 VSS sg13_lv_nmos ad=89.3f pd=0.85u as=89.3f ps=0.85u w=0.47u l=0.16u
X4218 cml_tlatch_75.xtail.S1 CKHB2_N cml_tlatch_75.xmux.xp.S1 VSS sg13_lv_nmos ad=89.3f pd=0.85u as=89.3f ps=0.85u w=0.47u l=0.16u
X4219 cml_tlatch_48.xtail.S1 CKB2_P cml_tlatch_48.xmux.xn.S1 VSS sg13_lv_nmos ad=89.3f pd=0.85u as=89.3f ps=0.85u w=0.47u l=0.16u
X4220 cml_tlatch_19.xmux.xp.S1 MOT5_N MOT5_P VSS sg13_lv_nmos ad=56.9f pd=0.74u as=56.9f ps=0.74u w=0.17u l=0.17u
X4221 cml_tlatch_2.xtail.S1 CKA0_P cml_tlatch_2.xmux.xp.S1 VSS sg13_lv_nmos ad=89.3f pd=0.85u as=89.3f ps=0.85u w=0.47u l=0.16u
X4222 cml_tlatch_3.xmux.xp.S1 cml_tlatch_3.OUTP cml_tlatch_3.OUTN VSS sg13_lv_nmos ad=56.9f pd=0.74u as=56.9f ps=0.74u w=0.17u l=0.17u
X4223 A1_8_P A1_8_N cml_tlatch_21.xmux.xp.S1 VSS sg13_lv_nmos ad=56.9f pd=0.74u as=56.9f ps=0.74u w=0.17u l=0.17u
X4224 cml_tlatch_68.xmux.xp.S1 MOT25_N MOT25_P VSS sg13_lv_nmos ad=56.9f pd=0.74u as=56.9f ps=0.74u w=0.17u l=0.17u
X4225 cml_tlatch_48.xmux.xp.S1 stub_bi_32.BOTP stub_bi_32.BOTN VSS sg13_lv_nmos ad=56.9f pd=0.74u as=56.9f ps=0.74u w=0.17u l=0.17u
X4226 cml_tlatch_84.xmux.xp.S1 cml_tlatch_70.INP cml_tlatch_70.INN VSS sg13_lv_nmos ad=56.9f pd=0.74u as=56.9f ps=0.74u w=0.17u l=0.17u
X4227 cml_tlatch_65.OUTN cml_tlatch_57.INP cml_tlatch_65.xmux.xn.S1 VSS sg13_lv_nmos ad=63.19999f pd=0.74u as=63.19999f ps=0.74u w=0.26u l=0.38u
X4228 cml_tlatch_58.xtail.S1 CKHA3_P cml_tlatch_58.xmux.xn.S1 VSS sg13_lv_nmos ad=89.3f pd=0.85u as=89.3f ps=0.85u w=0.47u l=0.16u
X4229 cml_tlatch_51.xmux.xn.S1 A2_2_N MOT22_P VSS sg13_lv_nmos ad=63.19999f pd=0.74u as=63.19999f ps=0.74u w=0.26u l=0.38u
X4230 VSS POLN cml_tlatch_10.xtail.S1 VSS sg13_lv_nmos ad=1.5637p pd=8.61u as=1.5637p ps=8.61u w=8.23u l=0.13u
X4231 cml_tlatch_5.xmux.xn.S1 CKHB1_P cml_tlatch_5.xtail.S1 VSS sg13_lv_nmos ad=89.3f pd=0.85u as=89.3f ps=0.85u w=0.47u l=0.16u
X4232 cml_tlatch_33.xmux.xp.S1 B1_2_N B1_2_P VSS sg13_lv_nmos ad=56.9f pd=0.74u as=56.9f ps=0.74u w=0.17u l=0.17u
X4233 cml_tlatch_32.xmux.xn.S1 B1_2_N stub_bi_29.BOTN VSS sg13_lv_nmos ad=0.1082p pd=1.34u as=63.19999f ps=0.74u w=0.26u l=0.38u
X4234 cml_tlatch_50.xmux.xp.S1 MOT20_P MOT20_N VSS sg13_lv_nmos ad=56.9f pd=0.74u as=56.9f ps=0.74u w=0.17u l=0.17u
X4235 cml_gate2_1.sg13_lv_nmos_FTPY57_0.D0 CKA0_P cml_gate2_1.xrtail.R1 VSS sg13_lv_nmos ad=0.1007p pd=0.91u as=0.1007p ps=0.91u w=0.53u l=0.13u
X4236 cml_tlatch_16.xmux.xp.S1 cml_tlatch_16.OUTN cml_tlatch_16.OUTP VSS sg13_lv_nmos ad=56.9f pd=0.74u as=56.9f ps=0.74u w=0.17u l=0.17u
X4237 cml_tlatch_35.xmux.xp.S1 CKA0_N cml_tlatch_35.xtail.S1 VSS sg13_lv_nmos ad=89.3f pd=0.85u as=89.3f ps=0.85u w=0.47u l=0.16u
X4238 cml_tlatch_17.xmux.xp.S1 MOT1_P MOT1_N VSS sg13_lv_nmos ad=56.9f pd=0.74u as=56.9f ps=0.74u w=0.17u l=0.17u
X4239 cml_tlatch_40.xtail.S1 POLN VSS VSS sg13_lv_nmos ad=1.5637p pd=8.61u as=2.7982p ps=17.14u w=8.23u l=0.13u
X4240 J2_P J2_N cml_tlatch_92.xmux.xp.S1 VSS sg13_lv_nmos ad=56.9f pd=0.74u as=56.9f ps=0.74u w=0.17u l=0.17u
X4241 cml_tlatch_63.xtail.S1 CKB3_P cml_tlatch_63.xmux.xn.S1 VSS sg13_lv_nmos ad=89.3f pd=0.85u as=89.3f ps=0.85u w=0.47u l=0.16u
X4242 cml_tlatch_65.xmux.xp.S1 cml_tlatch_65.OUTP cml_tlatch_65.OUTN VSS sg13_lv_nmos ad=56.9f pd=0.74u as=56.9f ps=0.74u w=0.17u l=0.17u
X4243 VSS POLN cml_tlatch_82.xtail.S1 VSS sg13_lv_nmos ad=1.5637p pd=8.61u as=1.5637p ps=8.61u w=8.23u l=0.13u
X4244 cml_tlatch_61.OUTN cml_tlatch_61.OUTP cml_tlatch_61.xmux.xp.S1 VSS sg13_lv_nmos ad=56.9f pd=0.74u as=56.9f ps=0.74u w=0.17u l=0.17u
X4245 cml_tlatch_99.xmux.xp.S1 CKA0_P cml_tlatch_99.xtail.S1 VSS sg13_lv_nmos ad=89.3f pd=0.85u as=89.3f ps=0.85u w=0.47u l=0.16u
X4246 NS1_N J4_N cml_drvb_8.xrtail.R1 VSS sg13_lv_nmos ad=0.2618p pd=2.22u as=0.1463p ps=1.15u w=0.77u l=0.21u
X4247 cml_tlatch_89.INN cml_tlatch_89.INP cml_tlatch_55.xmux.xp.S1 VSS sg13_lv_nmos ad=56.9f pd=0.74u as=56.9f ps=0.74u w=0.17u l=0.17u
X4248 cml_tlatch_22.OUTP cml_tlatch_22.OUTN cml_tlatch_22.xmux.xp.S1 VSS sg13_lv_nmos ad=56.9f pd=0.74u as=56.9f ps=0.74u w=0.17u l=0.17u
X4249 stub_bi_19.BOTN stub_bi_19.BOTP cml_tlatch_15.xmux.xp.S1 VSS sg13_lv_nmos ad=56.9f pd=0.74u as=56.9f ps=0.74u w=0.17u l=0.17u
X4250 cml_tlatch_28.xmux.xn.S1 cml_tlatch_29.OUTP B0_2_N VSS sg13_lv_nmos ad=63.19999f pd=0.74u as=63.19999f ps=0.74u w=0.26u l=0.38u
X4251 stub_bi_29.BOTP B1_2_P cml_tlatch_32.xmux.xn.S1 VSS sg13_lv_nmos ad=63.19999f pd=0.74u as=63.19999f ps=0.74u w=0.26u l=0.38u
X4252 cml_tlatch_91.xmux.xp.S1 CLK_W_P CLK_W_N VSS sg13_lv_nmos ad=56.9f pd=0.74u as=56.9f ps=0.74u w=0.17u l=0.17u
X4253 cml_tlatch_21.xmux.xn.S1 CKA1_N cml_tlatch_21.xtail.S1 VSS sg13_lv_nmos ad=89.3f pd=0.85u as=89.3f ps=0.85u w=0.47u l=0.16u
X4254 A2_2_P A2_2_N cml_tlatch_56.xmux.xp.S1 VSS sg13_lv_nmos ad=56.9f pd=0.74u as=0.1019p ps=1.34u w=0.17u l=0.17u
X4255 cml_tlatch_1.xtail.S1 POLN VSS VSS sg13_lv_nmos ad=1.5637p pd=8.61u as=1.5637p ps=8.61u w=8.23u l=0.13u
X4256 cml_tlatch_1.OUTN cml_tlatch_1.OUTP cml_tlatch_1.xmux.xp.S1 VSS sg13_lv_nmos ad=56.9f pd=0.74u as=56.9f ps=0.74u w=0.17u l=0.17u
X4257 cml_tlatch_59.xtail.S1 CKHA3_P cml_tlatch_59.xmux.xn.S1 VSS sg13_lv_nmos ad=0.1598p pd=1.62u as=89.3f ps=0.85u w=0.47u l=0.16u
X4258 MOT30_N MOT30_P cml_tlatch_59.xmux.xp.S1 VSS sg13_lv_nmos ad=56.9f pd=0.74u as=56.9f ps=0.74u w=0.17u l=0.17u
X4259 cml_tlatch_77.xmux.xn.S1 stub_bi_62.BOTP B2_8_P VSS sg13_lv_nmos ad=63.19999f pd=0.74u as=63.19999f ps=0.74u w=0.26u l=0.38u
X4260 cml_tlatch_17.xmux.xp.S1 CKHB0_N cml_tlatch_17.xtail.S1 VSS sg13_lv_nmos ad=89.3f pd=0.85u as=89.3f ps=0.85u w=0.47u l=0.16u
X4261 cml_tlatch_84.xtail.S1 CKB3_P cml_tlatch_84.xmux.xp.S1 VSS sg13_lv_nmos ad=89.3f pd=0.85u as=0.1598p ps=1.62u w=0.47u l=0.16u
X4262 cml_gate2_1.xrtail.R1 CKA0_N GB0_P VSS sg13_lv_nmos ad=0.1007p pd=0.91u as=0.1007p ps=0.91u w=0.53u l=0.13u
X4263 cml_tlatch_47.OUTN cml_tlatch_47.OUTP cml_tlatch_47.xmux.xp.S1 VSS sg13_lv_nmos ad=56.9f pd=0.74u as=56.9f ps=0.74u w=0.17u l=0.17u
X4264 cml_tlatch_98.xtail.S1 CKB0_N cml_tlatch_98.xmux.xn.S1 VSS sg13_lv_nmos ad=89.3f pd=0.85u as=89.3f ps=0.85u w=0.47u l=0.16u
X4265 VSS hs_to_clk_8.sg13_lv_nmos_2HGZLP_0.G VSS VSS sg13_lv_nmos ad=2.071p pd=11.28u as=0 ps=0 w=10.9u l=1.38u
X4266 MOT4_N MOT4_P cml_tlatch_25.xmux.xp.S1 VSS sg13_lv_nmos ad=56.9f pd=0.74u as=56.9f ps=0.74u w=0.17u l=0.17u
X4267 cml_tlatch_5.INN cml_tlatch_5.INP cml_tlatch_14.xmux.xp.S1 VSS sg13_lv_nmos ad=56.9f pd=0.74u as=0.1019p ps=1.34u w=0.17u l=0.17u
X4268 cml_tlatch_28.xmux.xp.S1 CKB0_P cml_tlatch_28.xtail.S1 VSS sg13_lv_nmos ad=89.3f pd=0.85u as=89.3f ps=0.85u w=0.47u l=0.16u
X4269 cml_tlatch_8.OUTN cml_tlatch_8.OUTP cml_tlatch_8.xmux.xp.S1 VSS sg13_lv_nmos ad=56.9f pd=0.74u as=56.9f ps=0.74u w=0.17u l=0.17u
X4270 cml_tlatch_29.xmux.xp.S1 cml_tlatch_29.OUTN cml_tlatch_29.OUTP VSS sg13_lv_nmos ad=56.9f pd=0.74u as=56.9f ps=0.74u w=0.17u l=0.17u
X4271 cml_tlatch_60.xmux.xp.S1 B3_8_P B3_8_N VSS sg13_lv_nmos ad=56.9f pd=0.74u as=56.9f ps=0.74u w=0.17u l=0.17u
X4272 cml_tlatch_98.OUTN cml_tlatch_98.OUTP cml_tlatch_98.xmux.xp.S1 VSS sg13_lv_nmos ad=56.9f pd=0.74u as=56.9f ps=0.74u w=0.17u l=0.17u
X4273 cml_tlatch_67.xmux.xp.S1 CKA3_N cml_tlatch_67.xtail.S1 VSS sg13_lv_nmos ad=89.3f pd=0.85u as=89.3f ps=0.85u w=0.47u l=0.16u
X4274 cml_tlatch_63.OUTP cml_tlatch_63.OUTN cml_tlatch_63.xmux.xp.S1 VSS sg13_lv_nmos ad=56.9f pd=0.74u as=56.9f ps=0.74u w=0.17u l=0.17u
X4275 cml_tlatch_64.xmux.xp.S1 A3_8_N A3_8_P VSS sg13_lv_nmos ad=56.9f pd=0.74u as=56.9f ps=0.74u w=0.17u l=0.17u
X4276 cml_tlatch_96.xtail.S1 CKHA1_P cml_tlatch_96.xmux.xn.S1 VSS sg13_lv_nmos ad=89.3f pd=0.85u as=0.1598p ps=1.62u w=0.47u l=0.16u
X4277 cml_tlatch_62.xmux.xp.S1 cml_tlatch_69.INN cml_tlatch_69.INP VSS sg13_lv_nmos ad=56.9f pd=0.74u as=56.9f ps=0.74u w=0.17u l=0.17u
X4278 B0_8_P B0_8_N cml_tlatch_10.xmux.xp.S1 VSS sg13_lv_nmos ad=56.9f pd=0.74u as=56.9f ps=0.74u w=0.17u l=0.17u
X4279 cml_tlatch_41.xtail.S1 CKHA1_P cml_tlatch_41.xmux.xn.S1 VSS sg13_lv_nmos ad=89.3f pd=0.85u as=89.3f ps=0.85u w=0.47u l=0.16u
X4280 B1_8_N B1_8_P cml_tlatch_12.xmux.xp.S1 VSS sg13_lv_nmos ad=56.9f pd=0.74u as=56.9f ps=0.74u w=0.17u l=0.17u
X4281 cml_tlatch_35.OUTN cml_tlatch_35.OUTP cml_tlatch_35.xmux.xp.S1 VSS sg13_lv_nmos ad=56.9f pd=0.74u as=56.9f ps=0.74u w=0.17u l=0.17u
X4282 VDD NM1_P VSS rppd l=13.09u w=1u
X4283 MOT25_P B3_8_N cml_tlatch_68.xmux.xn.S1 VSS sg13_lv_nmos ad=63.19999f pd=0.74u as=63.19999f ps=0.74u w=0.26u l=0.38u
X4284 cml_tlatch_31.xtail.S1 POLN VSS VSS sg13_lv_nmos ad=1.5637p pd=8.61u as=2.7982p ps=17.14u w=8.23u l=0.13u
X4285 cml_tlatch_89.xtail.S1 CKA2_P cml_tlatch_89.xmux.xp.S1 VSS sg13_lv_nmos ad=89.3f pd=0.85u as=89.3f ps=0.85u w=0.47u l=0.16u
X4286 CLK_W_N CLK_W_P cml_tlatch_91.xmux.xp.S1 VSS sg13_lv_nmos ad=56.9f pd=0.74u as=0.1019p ps=1.34u w=0.17u l=0.17u
X4287 cml_tlatch_45.xmux.xp.S1 cml_tlatch_45.OUTN cml_tlatch_45.OUTP VSS sg13_lv_nmos ad=56.9f pd=0.74u as=56.9f ps=0.74u w=0.17u l=0.17u
X4288 cml_tlatch_12.xmux.xp.S1 B1_8_N B1_8_P VSS sg13_lv_nmos ad=56.9f pd=0.74u as=56.9f ps=0.74u w=0.17u l=0.17u
X4289 cml_tlatch_63.xmux.xp.S1 CKB3_N cml_tlatch_63.xtail.S1 VSS sg13_lv_nmos ad=89.3f pd=0.85u as=89.3f ps=0.85u w=0.47u l=0.16u
X4290 MOT4_P cml_tlatch_99.OUTN cml_tlatch_25.xmux.xn.S1 VSS sg13_lv_nmos ad=63.19999f pd=0.74u as=63.19999f ps=0.74u w=0.26u l=0.38u
X4291 MOT17_N MOT17_P cml_tlatch_73.xmux.xp.S1 VSS sg13_lv_nmos ad=56.9f pd=0.74u as=0.1019p ps=1.34u w=0.17u l=0.17u
X4292 A2_2_P A2_2_N cml_tlatch_56.xmux.xp.S1 VSS sg13_lv_nmos ad=56.9f pd=0.74u as=56.9f ps=0.74u w=0.17u l=0.17u
X4293 cml_tlatch_70.INP cml_tlatch_70.INN cml_tlatch_84.xmux.xp.S1 VSS sg13_lv_nmos ad=56.9f pd=0.74u as=56.9f ps=0.74u w=0.17u l=0.17u
X4294 hs_to_clk_1.D2 CK_P CKB0_N VSS sg13_lv_nmos ad=0.408p pd=3.08u as=0.228p ps=1.58u w=1.2u l=0.2u
X4295 stub_bi_29.BOTN stub_bi_29.BOTP cml_tlatch_32.xmux.xp.S1 VSS sg13_lv_nmos ad=56.9f pd=0.74u as=56.9f ps=0.74u w=0.17u l=0.17u
X4296 J1_P J1_N cml_tlatch_93.xmux.xp.S1 VSS sg13_lv_nmos ad=56.9f pd=0.74u as=56.9f ps=0.74u w=0.17u l=0.17u
X4297 cml_tlatch_19.xmux.xp.S1 MOT5_N MOT5_P VSS sg13_lv_nmos ad=56.9f pd=0.74u as=56.9f ps=0.74u w=0.17u l=0.17u
X4298 MOT12_N MOT12_P cml_tlatch_40.xmux.xp.S1 VSS sg13_lv_nmos ad=56.9f pd=0.74u as=0.1019p ps=1.34u w=0.17u l=0.17u
X4299 stub_bi_17.BOTP stub_bi_17.BOTN cml_tlatch_13.xmux.xp.S1 VSS sg13_lv_nmos ad=56.9f pd=0.74u as=56.9f ps=0.74u w=0.17u l=0.17u
X4300 cml_tlatch_55.xmux.xp.S1 CKA2_N cml_tlatch_55.xtail.S1 VSS sg13_lv_nmos ad=89.3f pd=0.85u as=89.3f ps=0.85u w=0.47u l=0.16u
X4301 cml_tlatch_63.xmux.xp.S1 cml_tlatch_63.OUTN cml_tlatch_63.OUTP VSS sg13_lv_nmos ad=56.9f pd=0.74u as=56.9f ps=0.74u w=0.17u l=0.17u
X4302 A1_2_N cml_tlatch_38.OUTP cml_tlatch_37.xmux.xn.S1 VSS sg13_lv_nmos ad=63.19999f pd=0.74u as=63.19999f ps=0.74u w=0.26u l=0.38u
X4303 cml_tlatch_5.INN cml_tlatch_5.INP cml_tlatch_14.xmux.xp.S1 VSS sg13_lv_nmos ad=56.9f pd=0.74u as=56.9f ps=0.74u w=0.17u l=0.17u
X4304 cml_tlatch_38.OUTP cml_tlatch_38.OUTN cml_tlatch_38.xmux.xp.S1 VSS sg13_lv_nmos ad=56.9f pd=0.74u as=56.9f ps=0.74u w=0.17u l=0.17u
X4305 cml_tlatch_1.xmux.xn.S1 cml_tlatch_98.OUTP cml_tlatch_1.OUTN VSS sg13_lv_nmos ad=63.19999f pd=0.74u as=63.19999f ps=0.74u w=0.26u l=0.38u
X4306 cml_tlatch_37.xtail.S1 POLN VSS VSS sg13_lv_nmos ad=1.5637p pd=8.61u as=2.7982p ps=17.14u w=8.23u l=0.13u
X4307 cml_tlatch_94.xmux.xp.S1 cml_tlatch_6.INN cml_tlatch_6.INP VSS sg13_lv_nmos ad=56.9f pd=0.74u as=56.9f ps=0.74u w=0.17u l=0.17u
X4308 cml_tlatch_99.xmux.xp.S1 cml_tlatch_99.OUTN cml_tlatch_99.OUTP VSS sg13_lv_nmos ad=56.9f pd=0.74u as=56.9f ps=0.74u w=0.17u l=0.17u
X4309 cml_tlatch_37.xmux.xn.S1 CKA1_N cml_tlatch_37.xtail.S1 VSS sg13_lv_nmos ad=89.3f pd=0.85u as=89.3f ps=0.85u w=0.47u l=0.16u
X4310 cml_tlatch_25.xmux.xn.S1 cml_tlatch_99.OUTP MOT4_N VSS sg13_lv_nmos ad=63.19999f pd=0.74u as=63.19999f ps=0.74u w=0.26u l=0.38u
X4311 cml_tlatch_79.xmux.xn.S1 stub_bi_49.BOTP stub_bi_63.BOTN VSS sg13_lv_nmos ad=63.19999f pd=0.74u as=0.1082p ps=1.34u w=0.26u l=0.38u
X4312 cml_tlatch_8.xmux.xp.S1 CKA0_P cml_tlatch_8.xtail.S1 VSS sg13_lv_nmos ad=89.3f pd=0.85u as=89.3f ps=0.85u w=0.47u l=0.16u
X4313 cml_tlatch_20.xmux.xp.S1 MOT7_P MOT7_N VSS sg13_lv_nmos ad=56.9f pd=0.74u as=56.9f ps=0.74u w=0.17u l=0.17u
X4314 cml_tlatch_22.xtail.S1 POLN VSS VSS sg13_lv_nmos ad=1.5637p pd=8.61u as=1.5637p ps=8.61u w=8.23u l=0.13u
X4315 cml_tlatch_61.xmux.xp.S1 cml_tlatch_61.OUTN cml_tlatch_61.OUTP VSS sg13_lv_nmos ad=56.9f pd=0.74u as=56.9f ps=0.74u w=0.17u l=0.17u
X4316 cml_tlatch_71.xtail.S1 CKHB3_N cml_tlatch_71.xmux.xp.S1 VSS sg13_lv_nmos ad=89.3f pd=0.85u as=89.3f ps=0.85u w=0.47u l=0.16u
X4317 MOT19_P MOT19_N cml_tlatch_74.xmux.xp.S1 VSS sg13_lv_nmos ad=56.9f pd=0.74u as=56.9f ps=0.74u w=0.17u l=0.17u
X4318 cml_tlatch_48.xmux.xp.S1 stub_bi_32.BOTN stub_bi_32.BOTP VSS sg13_lv_nmos ad=56.9f pd=0.74u as=56.9f ps=0.74u w=0.17u l=0.17u
X4319 cml_gate2_8.sg13_lv_nmos_FTPY57_0.D0 NS1_P cml_gate2_8.xrtail.R1 VSS sg13_lv_nmos ad=0.1007p pd=0.91u as=0.1007p ps=0.91u w=0.53u l=0.13u
X4320 cml_tlatch_64.xmux.xn.S1 cml_tlatch_65.OUTP A3_8_N VSS sg13_lv_nmos ad=63.19999f pd=0.74u as=63.19999f ps=0.74u w=0.26u l=0.38u
X4321 cml_tlatch_69.xmux.xp.S1 MOT27_N MOT27_P VSS sg13_lv_nmos ad=56.9f pd=0.74u as=56.9f ps=0.74u w=0.17u l=0.17u
X4322 cml_tlatch_77.xmux.xp.S1 CKB2_P cml_tlatch_77.xtail.S1 VSS sg13_lv_nmos ad=89.3f pd=0.85u as=89.3f ps=0.85u w=0.47u l=0.16u
X4323 cml_tlatch_25.xmux.xp.S1 CKHA0_N cml_tlatch_25.xtail.S1 VSS sg13_lv_nmos ad=89.3f pd=0.85u as=89.3f ps=0.85u w=0.47u l=0.16u
X4324 cml_tlatch_83.INN cml_tlatch_83.INP cml_tlatch_72.xmux.xp.S1 VSS sg13_lv_nmos ad=56.9f pd=0.74u as=56.9f ps=0.74u w=0.17u l=0.17u
X4325 hs_to_clk_1.D2 CK_N CKB0_P VSS sg13_lv_nmos ad=0.408p pd=3.08u as=0.228p ps=1.58u w=1.2u l=0.2u
X4326 cml_tlatch_27.OUTP B0_2_N cml_tlatch_27.xmux.xn.S1 VSS sg13_lv_nmos ad=63.19999f pd=0.74u as=63.19999f ps=0.74u w=0.26u l=0.38u
X4327 cml_tlatch_69.INN cml_tlatch_69.INP cml_tlatch_62.xmux.xp.S1 VSS sg13_lv_nmos ad=56.9f pd=0.74u as=56.9f ps=0.74u w=0.17u l=0.17u
X4328 ENB_N J2_P cml_gate2_8.sg13_lv_nmos_FTPY57_0.D0 VSS sg13_lv_nmos ad=0.1007p pd=0.91u as=0.1007p ps=0.91u w=0.53u l=0.13u
X4329 B0_8_N B0_8_P cml_tlatch_10.xmux.xp.S1 VSS sg13_lv_nmos ad=56.9f pd=0.74u as=56.9f ps=0.74u w=0.17u l=0.17u
X4330 cml_tlatch_92.xmux.xp.S1 J2_P J2_N VSS sg13_lv_nmos ad=56.9f pd=0.74u as=56.9f ps=0.74u w=0.17u l=0.17u
X4331 cml_tlatch_53.xmux.xp.S1 A3_2_P A3_2_N VSS sg13_lv_nmos ad=56.9f pd=0.74u as=56.9f ps=0.74u w=0.17u l=0.17u
X4332 cml_tlatch_16.xmux.xp.S1 cml_tlatch_16.OUTP cml_tlatch_16.OUTN VSS sg13_lv_nmos ad=56.9f pd=0.74u as=56.9f ps=0.74u w=0.17u l=0.17u
X4333 cml_drvb_3.xrtail.R1 GA1_P CKHA1_N VSS sg13_lv_nmos ad=0.1463p pd=1.15u as=0.2618p ps=2.22u w=0.77u l=0.21u
X4334 MOT17_N MOT17_P cml_tlatch_73.xmux.xp.S1 VSS sg13_lv_nmos ad=56.9f pd=0.74u as=56.9f ps=0.74u w=0.17u l=0.17u
X4335 MOT18_P cml_tlatch_83.OUTN cml_tlatch_49.xmux.xn.S1 VSS sg13_lv_nmos ad=63.19999f pd=0.74u as=63.19999f ps=0.74u w=0.26u l=0.38u
X4336 cml_tlatch_48.xmux.xn.S1 CKB2_P cml_tlatch_48.xtail.S1 VSS sg13_lv_nmos ad=89.3f pd=0.85u as=89.3f ps=0.85u w=0.47u l=0.16u
X4337 cml_tlatch_6.xmux.xn.S1 cml_tlatch_6.INN MOT13_P VSS sg13_lv_nmos ad=63.19999f pd=0.74u as=63.19999f ps=0.74u w=0.26u l=0.38u
X4338 cml_tlatch_58.INN cml_tlatch_52.OUTP cml_tlatch_85.xmux.xn.S1 VSS sg13_lv_nmos ad=63.19999f pd=0.74u as=0.1082p ps=1.34u w=0.26u l=0.38u
X4339 stub_bi_62.BOTN stub_bi_63.BOTP cml_tlatch_78.xmux.xn.S1 VSS sg13_lv_nmos ad=63.19999f pd=0.74u as=63.19999f ps=0.74u w=0.26u l=0.38u
X4340 cml_tlatch_95.INN cml_tlatch_95.INP cml_tlatch_36.xmux.xp.S1 VSS sg13_lv_nmos ad=56.9f pd=0.74u as=56.9f ps=0.74u w=0.17u l=0.17u
X4341 cml_tlatch_54.xmux.xn.S1 CKA3_P cml_tlatch_54.xtail.S1 VSS sg13_lv_nmos ad=89.3f pd=0.85u as=0.1598p ps=1.62u w=0.47u l=0.16u
X4342 cml_tlatch_46.xmux.xn.S1 cml_tlatch_47.OUTN B3_2_P VSS sg13_lv_nmos ad=63.19999f pd=0.74u as=0.1082p ps=1.34u w=0.26u l=0.38u
X4343 cml_tlatch_34.xmux.xn.S1 D1_N stub_bi_31.BOTN VSS sg13_lv_nmos ad=63.19999f pd=0.74u as=63.19999f ps=0.74u w=0.26u l=0.38u
X4344 VSS POLN cml_tlatch_45.xtail.S1 VSS sg13_lv_nmos ad=2.7982p pd=17.14u as=1.5637p ps=8.61u w=8.23u l=0.13u
X4345 cml_tlatch_97.xmux.xp.S1 CKHA0_N cml_tlatch_97.xtail.S1 VSS sg13_lv_nmos ad=0.1598p pd=1.62u as=89.3f ps=0.85u w=0.47u l=0.16u
X4346 cml_tlatch_63.OUTN cml_tlatch_70.INP cml_tlatch_63.xmux.xn.S1 VSS sg13_lv_nmos ad=63.19999f pd=0.74u as=63.19999f ps=0.74u w=0.26u l=0.38u
X4347 cml_tlatch_81.xmux.xp.S1 A2_8_P A2_8_N VSS sg13_lv_nmos ad=56.9f pd=0.74u as=56.9f ps=0.74u w=0.17u l=0.17u
X4348 MOT0_N MOT0_P cml_tlatch_97.xmux.xp.S1 VSS sg13_lv_nmos ad=56.9f pd=0.74u as=56.9f ps=0.74u w=0.17u l=0.17u
X4349 B3_2_N cml_tlatch_47.OUTP cml_tlatch_46.xmux.xn.S1 VSS sg13_lv_nmos ad=63.19999f pd=0.74u as=63.19999f ps=0.74u w=0.26u l=0.38u
X4350 cml_tlatch_1.xtail.S1 CKB0_N cml_tlatch_1.xmux.xp.S1 VSS sg13_lv_nmos ad=89.3f pd=0.85u as=89.3f ps=0.85u w=0.47u l=0.16u
X4351 cml_tlatch_18.xmux.xn.S1 cml_tlatch_16.OUTN MOT3_P VSS sg13_lv_nmos ad=63.19999f pd=0.74u as=63.19999f ps=0.74u w=0.26u l=0.38u
X4352 cml_tlatch_54.OUTN D3_P cml_tlatch_54.xmux.xn.S1 VSS sg13_lv_nmos ad=63.19999f pd=0.74u as=63.19999f ps=0.74u w=0.26u l=0.38u
X4353 cml_tlatch_15.xtail.S1 CKB1_N cml_tlatch_15.xmux.xp.S1 VSS sg13_lv_nmos ad=89.3f pd=0.85u as=89.3f ps=0.85u w=0.47u l=0.16u
X4354 cml_tlatch_64.xtail.S1 CKA3_N cml_tlatch_64.xmux.xn.S1 VSS sg13_lv_nmos ad=89.3f pd=0.85u as=89.3f ps=0.85u w=0.47u l=0.16u
X4355 cml_tlatch_1.xtail.S1 CKB0_P cml_tlatch_1.xmux.xn.S1 VSS sg13_lv_nmos ad=0.1598p pd=1.62u as=89.3f ps=0.85u w=0.47u l=0.16u
X4356 cml_tlatch_62.xtail.S1 CKB3_N cml_tlatch_62.xmux.xn.S1 VSS sg13_lv_nmos ad=89.3f pd=0.85u as=0.1598p ps=1.62u w=0.47u l=0.16u
X4357 cml_tlatch_6.xmux.xp.S1 MOT13_P MOT13_N VSS sg13_lv_nmos ad=56.9f pd=0.74u as=56.9f ps=0.74u w=0.17u l=0.17u
X4358 cml_tlatch_48.xmux.xp.S1 stub_bi_32.BOTN stub_bi_32.BOTP VSS sg13_lv_nmos ad=56.9f pd=0.74u as=56.9f ps=0.74u w=0.17u l=0.17u
X4359 cml_tlatch_24.xmux.xp.S1 MOT2_P MOT2_N VSS sg13_lv_nmos ad=56.9f pd=0.74u as=56.9f ps=0.74u w=0.17u l=0.17u
X4360 cml_tlatch_83.OUTP cml_tlatch_83.OUTN cml_tlatch_83.xmux.xp.S1 VSS sg13_lv_nmos ad=56.9f pd=0.74u as=56.9f ps=0.74u w=0.17u l=0.17u
X4361 A1_2_N A1_2_P cml_tlatch_37.xmux.xp.S1 VSS sg13_lv_nmos ad=56.9f pd=0.74u as=56.9f ps=0.74u w=0.17u l=0.17u
X4362 cml_tlatch_61.xmux.xn.S1 CKB3_P cml_tlatch_61.xtail.S1 VSS sg13_lv_nmos ad=89.3f pd=0.85u as=89.3f ps=0.85u w=0.47u l=0.16u
X4363 cml_tlatch_55.xmux.xp.S1 cml_tlatch_89.INN cml_tlatch_89.INP VSS sg13_lv_nmos ad=56.9f pd=0.74u as=56.9f ps=0.74u w=0.17u l=0.17u
X4364 cml_gate2_3.xrtail.R1 CKB1_N GA1_P VSS sg13_lv_nmos ad=0.1007p pd=0.91u as=0.1007p ps=0.91u w=0.53u l=0.13u
X4365 MOT0_P MOT0_N cml_tlatch_97.xmux.xp.S1 VSS sg13_lv_nmos ad=56.9f pd=0.74u as=56.9f ps=0.74u w=0.17u l=0.17u
X4366 VSS POLN cml_tlatch_59.xtail.S1 VSS sg13_lv_nmos ad=2.7982p pd=17.14u as=1.5637p ps=8.61u w=8.23u l=0.13u
X4367 MOT29_P MOT29_N cml_tlatch_70.xmux.xp.S1 VSS sg13_lv_nmos ad=56.9f pd=0.74u as=56.9f ps=0.74u w=0.17u l=0.17u
X4368 cml_tlatch_41.xtail.S1 CKHA1_N cml_tlatch_41.xmux.xp.S1 VSS sg13_lv_nmos ad=0.1598p pd=1.62u as=89.3f ps=0.85u w=0.47u l=0.16u
X4369 cml_tlatch_47.xmux.xp.S1 cml_tlatch_47.OUTN cml_tlatch_47.OUTP VSS sg13_lv_nmos ad=56.9f pd=0.74u as=56.9f ps=0.74u w=0.17u l=0.17u
X4370 B0_2_P VDD VSS rppd l=5.17u w=1u
X4371 cml_tlatch_9.xmux.xp.S1 cml_tlatch_9.OUTN cml_tlatch_9.OUTP VSS sg13_lv_nmos ad=56.9f pd=0.74u as=56.9f ps=0.74u w=0.17u l=0.17u
X4372 cml_tlatch_91.xmux.xn.S1 J2_N CLK_W_N VSS sg13_lv_nmos ad=63.19999f pd=0.74u as=63.19999f ps=0.74u w=0.26u l=0.38u
X4373 cml_tlatch_0.xmux.xp.S1 interco_bi_19.INP interco_bi_19.INN VSS sg13_lv_nmos ad=56.9f pd=0.74u as=56.9f ps=0.74u w=0.17u l=0.17u
X4374 cml_tlatch_82.OUTP cml_tlatch_82.OUTN cml_tlatch_82.xmux.xp.S1 VSS sg13_lv_nmos ad=56.9f pd=0.74u as=56.9f ps=0.74u w=0.17u l=0.17u
X4375 cml_tlatch_61.xmux.xp.S1 cml_tlatch_61.OUTN cml_tlatch_61.OUTP VSS sg13_lv_nmos ad=56.9f pd=0.74u as=56.9f ps=0.74u w=0.17u l=0.17u
X4376 cml_tlatch_83.xtail.S1 CKA2_N cml_tlatch_83.xmux.xn.S1 VSS sg13_lv_nmos ad=89.3f pd=0.85u as=89.3f ps=0.85u w=0.47u l=0.16u
X4377 A2_2_N cml_tlatch_56.INP cml_tlatch_56.xmux.xn.S1 VSS sg13_lv_nmos ad=0.1082p pd=1.34u as=63.19999f ps=0.74u w=0.26u l=0.38u
X4378 A0_2_N A0_2_P cml_tlatch_31.xmux.xp.S1 VSS sg13_lv_nmos ad=56.9f pd=0.74u as=56.9f ps=0.74u w=0.17u l=0.17u
X4379 MOT18_P MOT18_N cml_tlatch_49.xmux.xp.S1 VSS sg13_lv_nmos ad=56.9f pd=0.74u as=56.9f ps=0.74u w=0.17u l=0.17u
X4380 cml_tlatch_30.xmux.xn.S1 CKA0_P cml_tlatch_30.xtail.S1 VSS sg13_lv_nmos ad=0.1598p pd=1.62u as=89.3f ps=0.85u w=0.47u l=0.16u
X4381 cml_tlatch_57.xmux.xp.S1 MOT26_N MOT26_P VSS sg13_lv_nmos ad=56.9f pd=0.74u as=56.9f ps=0.74u w=0.17u l=0.17u
X4382 VSS hs_to_clk_6.sg13_lv_nmos_2HGZLP_0.G VSS VSS sg13_lv_nmos ad=2.071p pd=11.28u as=0 ps=0 w=10.9u l=1.38u
X4383 cml_tlatch_99.xmux.xp.S1 cml_tlatch_99.OUTN cml_tlatch_99.OUTP VSS sg13_lv_nmos ad=56.9f pd=0.74u as=56.9f ps=0.74u w=0.17u l=0.17u
X4384 cml_tlatch_56.INP D2_N cml_tlatch_42.xmux.xn.S1 VSS sg13_lv_nmos ad=63.19999f pd=0.74u as=63.19999f ps=0.74u w=0.26u l=0.38u
X4385 cml_gate2_4.sg13_lv_nmos_FTPY57_0.D0 ENA1_P GA2_N VSS sg13_lv_nmos ad=0.1007p pd=0.91u as=0.1007p ps=0.91u w=0.53u l=0.13u
X4386 cml_tlatch_39.xmux.xn.S1 cml_tlatch_39.INP MOT10_N VSS sg13_lv_nmos ad=63.19999f pd=0.74u as=63.19999f ps=0.74u w=0.26u l=0.38u
X4387 cml_tlatch_58.xtail.S1 CKHA3_P cml_tlatch_58.xmux.xn.S1 VSS sg13_lv_nmos ad=89.3f pd=0.85u as=89.3f ps=0.85u w=0.47u l=0.16u
X4388 cml_tlatch_72.xmux.xp.S1 cml_tlatch_83.INN cml_tlatch_83.INP VSS sg13_lv_nmos ad=0.1019p pd=1.34u as=56.9f ps=0.74u w=0.17u l=0.17u
X4389 cml_tlatch_10.xtail.S1 CKB0_N cml_tlatch_10.xmux.xn.S1 VSS sg13_lv_nmos ad=89.3f pd=0.85u as=89.3f ps=0.85u w=0.47u l=0.16u
X4390 cml_tlatch_20.xmux.xp.S1 MOT7_P MOT7_N VSS sg13_lv_nmos ad=0.1019p pd=1.34u as=56.9f ps=0.74u w=0.17u l=0.17u
X4391 cml_tlatch_84.xtail.S1 CKB3_N cml_tlatch_84.xmux.xn.S1 VSS sg13_lv_nmos ad=89.3f pd=0.85u as=89.3f ps=0.85u w=0.47u l=0.16u
X4392 cml_gate2_6.sg13_lv_nmos_FTPY57_0.D0 ENB0_N GB3_P VSS sg13_lv_nmos ad=0.1007p pd=0.91u as=0.1007p ps=0.91u w=0.53u l=0.13u
X4393 cml_tlatch_69.xmux.xp.S1 MOT27_N MOT27_P VSS sg13_lv_nmos ad=56.9f pd=0.74u as=56.9f ps=0.74u w=0.17u l=0.17u
X4394 cml_tlatch_62.xtail.S1 POLN VSS VSS sg13_lv_nmos ad=1.5637p pd=8.61u as=2.7982p ps=17.14u w=8.23u l=0.13u
X4395 cml_tlatch_53.xtail.S1 CKA3_N cml_tlatch_53.xmux.xn.S1 VSS sg13_lv_nmos ad=89.3f pd=0.85u as=89.3f ps=0.85u w=0.47u l=0.16u
X4396 VDD CKHB2_N VSS rppd l=13.09u w=1u
X4397 cml_tlatch_90.xtail.S1 CKJ_P cml_tlatch_90.xmux.xp.S1 VSS sg13_lv_nmos ad=89.3f pd=0.85u as=89.3f ps=0.85u w=0.47u l=0.16u
X4398 cml_tlatch_69.xtail.S1 CKHB3_N cml_tlatch_69.xmux.xp.S1 VSS sg13_lv_nmos ad=89.3f pd=0.85u as=89.3f ps=0.85u w=0.47u l=0.16u
X4399 MOT11_P MOT11_N cml_tlatch_5.xmux.xp.S1 VSS sg13_lv_nmos ad=56.9f pd=0.74u as=56.9f ps=0.74u w=0.17u l=0.17u
X4400 cml_tlatch_36.xtail.S1 CKA1_P cml_tlatch_36.xmux.xn.S1 VSS sg13_lv_nmos ad=89.3f pd=0.85u as=89.3f ps=0.85u w=0.47u l=0.16u
X4401 cml_tlatch_3.xmux.xp.S1 CKA0_N cml_tlatch_3.xtail.S1 VSS sg13_lv_nmos ad=0.1598p pd=1.62u as=89.3f ps=0.85u w=0.47u l=0.16u
X4402 cml_tlatch_83.xmux.xp.S1 cml_tlatch_83.OUTP cml_tlatch_83.OUTN VSS sg13_lv_nmos ad=56.9f pd=0.74u as=56.9f ps=0.74u w=0.17u l=0.17u
X4403 cml_tlatch_19.xtail.S1 CKHB0_P cml_tlatch_19.xmux.xn.S1 VSS sg13_lv_nmos ad=89.3f pd=0.85u as=89.3f ps=0.85u w=0.47u l=0.16u
X4404 stub_bi_63.BOTN stub_bi_63.BOTP cml_tlatch_79.xmux.xp.S1 VSS sg13_lv_nmos ad=56.9f pd=0.74u as=56.9f ps=0.74u w=0.17u l=0.17u
X4405 B0_8_N B0_8_P cml_tlatch_10.xmux.xp.S1 VSS sg13_lv_nmos ad=56.9f pd=0.74u as=56.9f ps=0.74u w=0.17u l=0.17u
X4406 cml_tlatch_37.xmux.xp.S1 A1_2_N A1_2_P VSS sg13_lv_nmos ad=56.9f pd=0.74u as=56.9f ps=0.74u w=0.17u l=0.17u
X4407 cml_tlatch_88.xmux.xp.S1 stub_bi_55.BOTP stub_bi_55.BOTN VSS sg13_lv_nmos ad=56.9f pd=0.74u as=56.9f ps=0.74u w=0.17u l=0.17u
X4408 cml_tlatch_29.xmux.xn.S1 CKB0_P cml_tlatch_29.xtail.S1 VSS sg13_lv_nmos ad=89.3f pd=0.85u as=89.3f ps=0.85u w=0.47u l=0.16u
X4409 cml_tlatch_18.xmux.xp.S1 MOT3_P MOT3_N VSS sg13_lv_nmos ad=56.9f pd=0.74u as=56.9f ps=0.74u w=0.17u l=0.17u
X4410 MOT6_N MOT6_P cml_tlatch_26.xmux.xp.S1 VSS sg13_lv_nmos ad=56.9f pd=0.74u as=56.9f ps=0.74u w=0.17u l=0.17u
X4411 cml_tlatch_0.xtail.S1 CKA1_P cml_tlatch_0.xmux.xn.S1 VSS sg13_lv_nmos ad=89.3f pd=0.85u as=89.3f ps=0.85u w=0.47u l=0.16u
X4412 cml_tlatch_87.xmux.xp.S1 MOT16_N MOT16_P VSS sg13_lv_nmos ad=56.9f pd=0.74u as=56.9f ps=0.74u w=0.17u l=0.17u
X4413 MOT24_P MOT24_N cml_tlatch_86.xmux.xp.S1 VSS sg13_lv_nmos ad=56.9f pd=0.74u as=56.9f ps=0.74u w=0.17u l=0.17u
X4414 cml_tlatch_40.INP cml_tlatch_95.INN cml_tlatch_95.xmux.xn.S1 VSS sg13_lv_nmos ad=63.19999f pd=0.74u as=63.19999f ps=0.74u w=0.26u l=0.38u
X4415 cml_tlatch_48.xmux.xp.S1 CKB2_N cml_tlatch_48.xtail.S1 VSS sg13_lv_nmos ad=89.3f pd=0.85u as=89.3f ps=0.85u w=0.47u l=0.16u
X4416 B0_2_P B0_2_N cml_tlatch_28.xmux.xp.S1 VSS sg13_lv_nmos ad=56.9f pd=0.74u as=56.9f ps=0.74u w=0.17u l=0.17u
X4417 cml_tlatch_30.xmux.xp.S1 cml_tlatch_30.OUTN cml_tlatch_30.OUTP VSS sg13_lv_nmos ad=56.9f pd=0.74u as=56.9f ps=0.74u w=0.17u l=0.17u
X4418 cml_tlatch_17.xmux.xp.S1 CKHB0_N cml_tlatch_17.xtail.S1 VSS sg13_lv_nmos ad=89.3f pd=0.85u as=89.3f ps=0.85u w=0.47u l=0.16u
X4419 cml_tlatch_5.xmux.xn.S1 cml_tlatch_5.INP MOT11_N VSS sg13_lv_nmos ad=63.19999f pd=0.74u as=0.1082p ps=1.34u w=0.26u l=0.38u
X4420 B2_8_N B2_8_P cml_tlatch_77.xmux.xp.S1 VSS sg13_lv_nmos ad=56.9f pd=0.74u as=56.9f ps=0.74u w=0.17u l=0.17u
X4421 cml_tlatch_54.xmux.xp.S1 CKA3_N cml_tlatch_54.xtail.S1 VSS sg13_lv_nmos ad=89.3f pd=0.85u as=89.3f ps=0.85u w=0.47u l=0.16u
X4422 cml_tlatch_96.xmux.xp.S1 MOT8_N MOT8_P VSS sg13_lv_nmos ad=56.9f pd=0.74u as=56.9f ps=0.74u w=0.17u l=0.17u
X4423 cml_tlatch_96.xmux.xp.S1 MOT8_P MOT8_N VSS sg13_lv_nmos ad=56.9f pd=0.74u as=56.9f ps=0.74u w=0.17u l=0.17u
X4424 cml_tlatch_45.OUTN cml_tlatch_45.OUTP cml_tlatch_45.xmux.xp.S1 VSS sg13_lv_nmos ad=56.9f pd=0.74u as=56.9f ps=0.74u w=0.17u l=0.17u
X4425 cml_tlatch_67.OUTN cml_tlatch_67.OUTP cml_tlatch_67.xmux.xp.S1 VSS sg13_lv_nmos ad=56.9f pd=0.74u as=56.9f ps=0.74u w=0.17u l=0.17u
X4426 stub_bi_62.BOTN stub_bi_62.BOTP cml_tlatch_78.xmux.xp.S1 VSS sg13_lv_nmos ad=56.9f pd=0.74u as=0.1019p ps=1.34u w=0.17u l=0.17u
X4427 cml_tlatch_15.xtail.S1 CKB1_P cml_tlatch_15.xmux.xn.S1 VSS sg13_lv_nmos ad=89.3f pd=0.85u as=89.3f ps=0.85u w=0.47u l=0.16u
X4428 A2_8_P A2_8_N cml_tlatch_81.xmux.xp.S1 VSS sg13_lv_nmos ad=56.9f pd=0.74u as=56.9f ps=0.74u w=0.17u l=0.17u
X4429 cml_tlatch_53.xtail.S1 CKA3_P cml_tlatch_53.xmux.xp.S1 VSS sg13_lv_nmos ad=89.3f pd=0.85u as=89.3f ps=0.85u w=0.47u l=0.16u
X4430 cml_tlatch_77.xtail.S1 CKB2_P cml_tlatch_77.xmux.xp.S1 VSS sg13_lv_nmos ad=89.3f pd=0.85u as=0.1598p ps=1.62u w=0.47u l=0.16u
X4431 cml_tlatch_56.INP cml_tlatch_56.INN cml_tlatch_42.xmux.xp.S1 VSS sg13_lv_nmos ad=56.9f pd=0.74u as=56.9f ps=0.74u w=0.17u l=0.17u
X4432 cml_tlatch_47.xmux.xp.S1 cml_tlatch_47.OUTN cml_tlatch_47.OUTP VSS sg13_lv_nmos ad=56.9f pd=0.74u as=56.9f ps=0.74u w=0.17u l=0.17u
X4433 cml_tlatch_85.xtail.S1 POLN VSS VSS sg13_lv_nmos ad=1.5637p pd=8.61u as=2.7982p ps=17.14u w=8.23u l=0.13u
X4434 cml_tlatch_72.xtail.S1 CKA2_P cml_tlatch_72.xmux.xn.S1 VSS sg13_lv_nmos ad=89.3f pd=0.85u as=89.3f ps=0.85u w=0.47u l=0.16u
X4435 cml_tlatch_30.xmux.xp.S1 CKA0_N cml_tlatch_30.xtail.S1 VSS sg13_lv_nmos ad=89.3f pd=0.85u as=89.3f ps=0.85u w=0.47u l=0.16u
X4436 cml_tlatch_0.xmux.xp.S1 interco_bi_19.INP interco_bi_19.INN VSS sg13_lv_nmos ad=56.9f pd=0.74u as=56.9f ps=0.74u w=0.17u l=0.17u
X4437 stub_bi_19.BOTP stub_bi_19.BOTN cml_tlatch_15.xmux.xp.S1 VSS sg13_lv_nmos ad=56.9f pd=0.74u as=56.9f ps=0.74u w=0.17u l=0.17u
X4438 stub_bi_42.BOTN stub_bi_42.BOTP cml_tlatch_43.xmux.xp.S1 VSS sg13_lv_nmos ad=56.9f pd=0.74u as=56.9f ps=0.74u w=0.17u l=0.17u
X4439 cml_tlatch_51.xmux.xp.S1 CKHA2_N cml_tlatch_51.xtail.S1 VSS sg13_lv_nmos ad=89.3f pd=0.85u as=89.3f ps=0.85u w=0.47u l=0.16u
X4440 VSS hs_to_clk_0.sg13_lv_nmos_2HGZLP_0.G VSS VSS sg13_lv_nmos ad=2.071p pd=11.28u as=0 ps=0 w=10.9u l=1.38u
X4441 cml_tlatch_25.xmux.xp.S1 MOT4_P MOT4_N VSS sg13_lv_nmos ad=56.9f pd=0.74u as=56.9f ps=0.74u w=0.17u l=0.17u
X4442 VSS POLN cml_tlatch_87.xtail.S1 VSS sg13_lv_nmos ad=1.5637p pd=8.61u as=1.5637p ps=8.61u w=8.23u l=0.13u
X4443 cml_tlatch_64.xmux.xp.S1 A3_8_P A3_8_N VSS sg13_lv_nmos ad=56.9f pd=0.74u as=56.9f ps=0.74u w=0.17u l=0.17u
X4444 cml_tlatch_35.OUTP D0_N cml_tlatch_35.xmux.xn.S1 VSS sg13_lv_nmos ad=63.19999f pd=0.74u as=63.19999f ps=0.74u w=0.26u l=0.38u
X4445 cml_tlatch_86.xmux.xp.S1 MOT24_P MOT24_N VSS sg13_lv_nmos ad=56.9f pd=0.74u as=56.9f ps=0.74u w=0.17u l=0.17u
X4446 cml_tlatch_89.xtail.S1 CKA2_P cml_tlatch_89.xmux.xp.S1 VSS sg13_lv_nmos ad=89.3f pd=0.85u as=89.3f ps=0.85u w=0.47u l=0.16u
X4447 cml_tlatch_60.xtail.S1 CKB3_P cml_tlatch_60.xmux.xp.S1 VSS sg13_lv_nmos ad=89.3f pd=0.85u as=89.3f ps=0.85u w=0.47u l=0.16u
X4448 cml_tlatch_9.OUTN cml_tlatch_9.OUTP cml_tlatch_9.xmux.xp.S1 VSS sg13_lv_nmos ad=56.9f pd=0.74u as=56.9f ps=0.74u w=0.17u l=0.17u
X4449 cml_tlatch_21.xmux.xp.S1 CKA1_P cml_tlatch_21.xtail.S1 VSS sg13_lv_nmos ad=0.1598p pd=1.62u as=89.3f ps=0.85u w=0.47u l=0.16u
X4450 CKJ_P CK_P hs_to_clk_8.D2 VSS sg13_lv_nmos ad=0.228p pd=1.58u as=0.408p ps=3.08u w=1.2u l=0.2u
X4451 cml_tlatch_6.xmux.xp.S1 MOT13_N MOT13_P VSS sg13_lv_nmos ad=56.9f pd=0.74u as=56.9f ps=0.74u w=0.17u l=0.17u
X4452 cml_tlatch_70.INP cml_tlatch_45.OUTN cml_tlatch_84.xmux.xn.S1 VSS sg13_lv_nmos ad=63.19999f pd=0.74u as=63.19999f ps=0.74u w=0.26u l=0.38u
X4453 cml_tlatch_6.xmux.xp.S1 CKHB1_N cml_tlatch_6.xtail.S1 VSS sg13_lv_nmos ad=89.3f pd=0.85u as=89.3f ps=0.85u w=0.47u l=0.16u
X4454 cml_tlatch_36.xtail.S1 CKA1_P cml_tlatch_36.xmux.xn.S1 VSS sg13_lv_nmos ad=89.3f pd=0.85u as=89.3f ps=0.85u w=0.47u l=0.16u
X4455 cml_tlatch_32.xmux.xp.S1 stub_bi_29.BOTN stub_bi_29.BOTP VSS sg13_lv_nmos ad=0.1019p pd=1.34u as=56.9f ps=0.74u w=0.17u l=0.17u
X4456 cml_tlatch_54.OUTN cml_tlatch_54.OUTP cml_tlatch_54.xmux.xp.S1 VSS sg13_lv_nmos ad=56.9f pd=0.74u as=56.9f ps=0.74u w=0.17u l=0.17u
X4457 cml_tlatch_50.xtail.S1 CKHA2_N cml_tlatch_50.xmux.xp.S1 VSS sg13_lv_nmos ad=89.3f pd=0.85u as=89.3f ps=0.85u w=0.47u l=0.16u
X4458 cml_tlatch_52.xmux.xp.S1 cml_tlatch_52.OUTN cml_tlatch_52.OUTP VSS sg13_lv_nmos ad=56.9f pd=0.74u as=56.9f ps=0.74u w=0.17u l=0.17u
X4459 cml_tlatch_57.xmux.xp.S1 MOT26_N MOT26_P VSS sg13_lv_nmos ad=56.9f pd=0.74u as=56.9f ps=0.74u w=0.17u l=0.17u
X4460 VDD MOT16_P VSS rppd l=5.17u w=1u
X4461 cml_tlatch_88.xtail.S1 CKB2_P cml_tlatch_88.xmux.xp.S1 VSS sg13_lv_nmos ad=0.1598p pd=1.62u as=89.3f ps=0.85u w=0.47u l=0.16u
X4462 cml_tlatch_99.OUTN cml_tlatch_99.OUTP cml_tlatch_99.xmux.xp.S1 VSS sg13_lv_nmos ad=56.9f pd=0.74u as=56.9f ps=0.74u w=0.17u l=0.17u
X4463 cml_tlatch_38.xmux.xp.S1 cml_tlatch_38.OUTP cml_tlatch_38.OUTN VSS sg13_lv_nmos ad=56.9f pd=0.74u as=56.9f ps=0.74u w=0.17u l=0.17u
X4464 cml_tlatch_77.xmux.xn.S1 stub_bi_62.BOTN B2_8_N VSS sg13_lv_nmos ad=0.1082p pd=1.34u as=63.19999f ps=0.74u w=0.26u l=0.38u
X4465 stub_bi_31.BOTP stub_bi_31.BOTN cml_tlatch_34.xmux.xp.S1 VSS sg13_lv_nmos ad=56.9f pd=0.74u as=56.9f ps=0.74u w=0.17u l=0.17u
X4466 cml_tlatch_22.OUTP cml_tlatch_39.INN cml_tlatch_22.xmux.xn.S1 VSS sg13_lv_nmos ad=0.1082p pd=1.34u as=63.19999f ps=0.74u w=0.26u l=0.38u
X4467 cml_tlatch_58.INP cml_tlatch_58.INN cml_tlatch_85.xmux.xp.S1 VSS sg13_lv_nmos ad=56.9f pd=0.74u as=56.9f ps=0.74u w=0.17u l=0.17u
X4468 cml_tlatch_67.xtail.S1 POLN VSS VSS sg13_lv_nmos ad=1.5637p pd=8.61u as=1.5637p ps=8.61u w=8.23u l=0.13u
X4469 cml_gate2_9.xrtail.R1 NM1_P cml_gate2_9.sg13_lv_nmos_FTPY57_0.D0 VSS sg13_lv_nmos ad=0.1007p pd=0.91u as=0.1007p ps=0.91u w=0.53u l=0.13u
X4470 cml_tlatch_61.xtail.S1 CKB3_P cml_tlatch_61.xmux.xn.S1 VSS sg13_lv_nmos ad=89.3f pd=0.85u as=89.3f ps=0.85u w=0.47u l=0.16u
X4471 cml_tlatch_79.xtail.S1 CKB2_P cml_tlatch_79.xmux.xp.S1 VSS sg13_lv_nmos ad=89.3f pd=0.85u as=89.3f ps=0.85u w=0.47u l=0.16u
X4472 MOT10_P MOT10_N cml_tlatch_39.xmux.xp.S1 VSS sg13_lv_nmos ad=56.9f pd=0.74u as=56.9f ps=0.74u w=0.17u l=0.17u
X4473 MOT10_N MOT10_P cml_tlatch_39.xmux.xp.S1 VSS sg13_lv_nmos ad=56.9f pd=0.74u as=56.9f ps=0.74u w=0.17u l=0.17u
X4474 cml_tlatch_8.xmux.xp.S1 CKA0_P cml_tlatch_8.xtail.S1 VSS sg13_lv_nmos ad=89.3f pd=0.85u as=89.3f ps=0.85u w=0.47u l=0.16u
X4475 A3_2_P A3_2_N cml_tlatch_53.xmux.xp.S1 VSS sg13_lv_nmos ad=56.9f pd=0.74u as=56.9f ps=0.74u w=0.17u l=0.17u
X4476 cml_tlatch_22.OUTN cml_tlatch_22.OUTP cml_tlatch_22.xmux.xp.S1 VSS sg13_lv_nmos ad=56.9f pd=0.74u as=56.9f ps=0.74u w=0.17u l=0.17u
X4477 cml_tlatch_8.xmux.xn.S1 CKA0_N cml_tlatch_8.xtail.S1 VSS sg13_lv_nmos ad=89.3f pd=0.85u as=89.3f ps=0.85u w=0.47u l=0.16u
X4478 cml_tlatch_41.xmux.xp.S1 CKHA1_N cml_tlatch_41.xtail.S1 VSS sg13_lv_nmos ad=89.3f pd=0.85u as=89.3f ps=0.85u w=0.47u l=0.16u
X4479 stub_bi_32.BOTN stub_bi_32.BOTP cml_tlatch_48.xmux.xp.S1 VSS sg13_lv_nmos ad=56.9f pd=0.74u as=0.1019p ps=1.34u w=0.17u l=0.17u
X4480 cml_tlatch_90.xmux.xp.S1 J4_P J4_N VSS sg13_lv_nmos ad=56.9f pd=0.74u as=56.9f ps=0.74u w=0.17u l=0.17u
X4481 cml_tlatch_66.xmux.xn.S1 cml_tlatch_67.OUTP cml_tlatch_57.INN VSS sg13_lv_nmos ad=63.19999f pd=0.74u as=63.19999f ps=0.74u w=0.26u l=0.38u
X4482 cml_tlatch_64.xmux.xp.S1 A3_8_P A3_8_N VSS sg13_lv_nmos ad=56.9f pd=0.74u as=56.9f ps=0.74u w=0.17u l=0.17u
X4483 cml_tlatch_98.xmux.xn.S1 cml_tlatch_27.OUTN cml_tlatch_98.OUTP VSS sg13_lv_nmos ad=0.1082p pd=1.34u as=63.19999f ps=0.74u w=0.26u l=0.38u
X4484 stub_bi_55.BOTP stub_bi_42.BOTN cml_tlatch_88.xmux.xn.S1 VSS sg13_lv_nmos ad=63.19999f pd=0.74u as=63.19999f ps=0.74u w=0.26u l=0.38u
X4485 stub_bi_63.BOTP stub_bi_63.BOTN cml_tlatch_79.xmux.xp.S1 VSS sg13_lv_nmos ad=56.9f pd=0.74u as=56.9f ps=0.74u w=0.17u l=0.17u
X4486 cml_tlatch_27.xmux.xp.S1 cml_tlatch_27.OUTP cml_tlatch_27.OUTN VSS sg13_lv_nmos ad=56.9f pd=0.74u as=56.9f ps=0.74u w=0.17u l=0.17u
X4487 cml_gate2_0.xrtail.R1 CKA1_P cml_gate2_0.sg13_lv_nmos_FTPY57_0.D0 VSS sg13_lv_nmos ad=0.1007p pd=0.91u as=0.1007p ps=0.91u w=0.53u l=0.13u
X4488 cml_tlatch_18.xmux.xp.S1 MOT3_P MOT3_N VSS sg13_lv_nmos ad=0.1019p pd=1.34u as=56.9f ps=0.74u w=0.17u l=0.17u
X4489 B1_2_P B1_2_N cml_tlatch_33.xmux.xp.S1 VSS sg13_lv_nmos ad=56.9f pd=0.74u as=56.9f ps=0.74u w=0.17u l=0.17u
X4490 cml_tlatch_89.OUTP cml_tlatch_89.INN cml_tlatch_89.xmux.xn.S1 VSS sg13_lv_nmos ad=0.1082p pd=1.34u as=63.19999f ps=0.74u w=0.26u l=0.38u
X4491 GA1_N ENA0_P cml_gate2_3.sg13_lv_nmos_FTPY57_0.D0 VSS sg13_lv_nmos ad=0.1007p pd=0.91u as=0.1007p ps=0.91u w=0.53u l=0.13u
X4492 MOT26_N MOT26_P cml_tlatch_57.xmux.xp.S1 VSS sg13_lv_nmos ad=56.9f pd=0.74u as=56.9f ps=0.74u w=0.17u l=0.17u
X4493 cml_gate2_5.sg13_lv_nmos_FTPY57_0.D0 CKB3_P cml_gate2_5.xrtail.R1 VSS sg13_lv_nmos ad=0.1007p pd=0.91u as=0.1007p ps=0.91u w=0.53u l=0.13u
X4494 cml_tlatch_92.xmux.xp.S1 J2_N J2_P VSS sg13_lv_nmos ad=56.9f pd=0.74u as=56.9f ps=0.74u w=0.17u l=0.17u
X4495 cml_tlatch_65.OUTN cml_tlatch_65.OUTP cml_tlatch_65.xmux.xp.S1 VSS sg13_lv_nmos ad=56.9f pd=0.74u as=56.9f ps=0.74u w=0.17u l=0.17u
X4496 cml_tlatch_30.xmux.xp.S1 cml_tlatch_30.OUTN cml_tlatch_30.OUTP VSS sg13_lv_nmos ad=0.1019p pd=1.34u as=56.9f ps=0.74u w=0.17u l=0.17u
X4497 cml_tlatch_52.xmux.xp.S1 cml_tlatch_52.OUTN cml_tlatch_52.OUTP VSS sg13_lv_nmos ad=56.9f pd=0.74u as=56.9f ps=0.74u w=0.17u l=0.17u
X4498 cml_tlatch_35.xmux.xn.S1 CKA0_P cml_tlatch_35.xtail.S1 VSS sg13_lv_nmos ad=89.3f pd=0.85u as=0.1598p ps=1.62u w=0.47u l=0.16u
X4499 cml_tlatch_97.xmux.xp.S1 CKHA0_N cml_tlatch_97.xtail.S1 VSS sg13_lv_nmos ad=89.3f pd=0.85u as=89.3f ps=0.85u w=0.47u l=0.16u
X4500 cml_tlatch_73.xmux.xn.S1 B2_8_P MOT17_N VSS sg13_lv_nmos ad=63.19999f pd=0.74u as=63.19999f ps=0.74u w=0.26u l=0.38u
X4501 cml_tlatch_1.xtail.S1 CKB0_N cml_tlatch_1.xmux.xp.S1 VSS sg13_lv_nmos ad=89.3f pd=0.85u as=89.3f ps=0.85u w=0.47u l=0.16u
X4502 interco_bi_19.INP interco_bi_19.INN cml_tlatch_0.xmux.xp.S1 VSS sg13_lv_nmos ad=56.9f pd=0.74u as=56.9f ps=0.74u w=0.17u l=0.17u
X4503 cml_tlatch_15.xmux.xp.S1 stub_bi_19.BOTP stub_bi_19.BOTN VSS sg13_lv_nmos ad=56.9f pd=0.74u as=56.9f ps=0.74u w=0.17u l=0.17u
X4504 GB1_P CKA1_N cml_gate2_0.xrtail.R1 VSS sg13_lv_nmos ad=0.1007p pd=0.91u as=0.1007p ps=0.91u w=0.53u l=0.13u
X4505 cml_tlatch_64.xtail.S1 CKA3_N cml_tlatch_64.xmux.xn.S1 VSS sg13_lv_nmos ad=89.3f pd=0.85u as=89.3f ps=0.85u w=0.47u l=0.16u
X4506 GB2_P ENB0_N cml_gate2_7.sg13_lv_nmos_FTPY57_0.D0 VSS sg13_lv_nmos ad=0.1007p pd=0.91u as=0.1007p ps=0.91u w=0.53u l=0.13u
X4507 B0_2_P cml_tlatch_29.OUTN cml_tlatch_28.xmux.xn.S1 VSS sg13_lv_nmos ad=63.19999f pd=0.74u as=63.19999f ps=0.74u w=0.26u l=0.38u
X4508 cml_tlatch_94.xmux.xp.S1 cml_tlatch_6.INP cml_tlatch_6.INN VSS sg13_lv_nmos ad=56.9f pd=0.74u as=56.9f ps=0.74u w=0.17u l=0.17u
X4509 cml_tlatch_1.xmux.xp.S1 cml_tlatch_1.OUTP cml_tlatch_1.OUTN VSS sg13_lv_nmos ad=56.9f pd=0.74u as=56.9f ps=0.74u w=0.17u l=0.17u
X4510 cml_tlatch_43.xtail.S1 CKB2_N cml_tlatch_43.xmux.xp.S1 VSS sg13_lv_nmos ad=89.3f pd=0.85u as=89.3f ps=0.85u w=0.47u l=0.16u
X4511 cml_tlatch_90.xmux.xp.S1 CKJ_P cml_tlatch_90.xtail.S1 VSS sg13_lv_nmos ad=89.3f pd=0.85u as=89.3f ps=0.85u w=0.47u l=0.16u
X4512 cml_tlatch_11.xmux.xn.S1 cml_tlatch_16.OUTP cml_tlatch_11.OUTN VSS sg13_lv_nmos ad=63.19999f pd=0.74u as=63.19999f ps=0.74u w=0.26u l=0.38u
X4513 cml_tlatch_35.xmux.xn.S1 D0_P cml_tlatch_35.OUTN VSS sg13_lv_nmos ad=63.19999f pd=0.74u as=63.19999f ps=0.74u w=0.26u l=0.38u
X4514 MOT5_N cml_tlatch_98.OUTP cml_tlatch_19.xmux.xn.S1 VSS sg13_lv_nmos ad=63.19999f pd=0.74u as=0.1082p ps=1.34u w=0.26u l=0.38u
X4515 cml_tlatch_92.xmux.xp.S1 J2_N J2_P VSS sg13_lv_nmos ad=0.1019p pd=1.34u as=56.9f ps=0.74u w=0.17u l=0.17u
X4516 cml_tlatch_19.xmux.xn.S1 CKHB0_P cml_tlatch_19.xtail.S1 VSS sg13_lv_nmos ad=89.3f pd=0.85u as=89.3f ps=0.85u w=0.47u l=0.16u
X4517 cml_tlatch_38.xmux.xn.S1 CKA1_P cml_tlatch_38.xtail.S1 VSS sg13_lv_nmos ad=89.3f pd=0.85u as=89.3f ps=0.85u w=0.47u l=0.16u
X4518 cml_tlatch_11.xmux.xn.S1 cml_tlatch_16.OUTP cml_tlatch_11.OUTN VSS sg13_lv_nmos ad=63.19999f pd=0.74u as=63.19999f ps=0.74u w=0.26u l=0.38u
X4519 cml_tlatch_25.xmux.xp.S1 MOT4_P MOT4_N VSS sg13_lv_nmos ad=56.9f pd=0.74u as=56.9f ps=0.74u w=0.17u l=0.17u
X4520 cml_tlatch_8.xmux.xp.S1 cml_tlatch_8.OUTP cml_tlatch_8.OUTN VSS sg13_lv_nmos ad=56.9f pd=0.74u as=56.9f ps=0.74u w=0.17u l=0.17u
X4521 cml_tlatch_60.xtail.S1 CKB3_N cml_tlatch_60.xmux.xn.S1 VSS sg13_lv_nmos ad=0.1598p pd=1.62u as=89.3f ps=0.85u w=0.47u l=0.16u
X4522 cml_tlatch_98.xmux.xp.S1 cml_tlatch_98.OUTP cml_tlatch_98.OUTN VSS sg13_lv_nmos ad=56.9f pd=0.74u as=56.9f ps=0.74u w=0.17u l=0.17u
X4523 cml_tlatch_22.xmux.xp.S1 cml_tlatch_22.OUTP cml_tlatch_22.OUTN VSS sg13_lv_nmos ad=0.1019p pd=1.34u as=56.9f ps=0.74u w=0.17u l=0.17u
X4524 cml_tlatch_83.INN cml_tlatch_89.OUTP cml_tlatch_72.xmux.xn.S1 VSS sg13_lv_nmos ad=63.19999f pd=0.74u as=63.19999f ps=0.74u w=0.26u l=0.38u
X4525 VDD cml_tlatch_99.OUTN VSS rppd l=5.17u w=1u
X4526 cml_tlatch_59.xmux.xn.S1 CKHA3_P cml_tlatch_59.xtail.S1 VSS sg13_lv_nmos ad=89.3f pd=0.85u as=89.3f ps=0.85u w=0.47u l=0.16u
X4527 B2_2_N B2_2_P cml_tlatch_44.xmux.xp.S1 VSS sg13_lv_nmos ad=56.9f pd=0.74u as=56.9f ps=0.74u w=0.17u l=0.17u
X4528 cml_tlatch_40.xmux.xp.S1 CKHA1_N cml_tlatch_40.xtail.S1 VSS sg13_lv_nmos ad=89.3f pd=0.85u as=89.3f ps=0.85u w=0.47u l=0.16u
X4529 cml_tlatch_12.xmux.xp.S1 B1_8_P B1_8_N VSS sg13_lv_nmos ad=56.9f pd=0.74u as=56.9f ps=0.74u w=0.17u l=0.17u
X4530 cml_tlatch_47.xmux.xp.S1 cml_tlatch_47.OUTP cml_tlatch_47.OUTN VSS sg13_lv_nmos ad=56.9f pd=0.74u as=56.9f ps=0.74u w=0.17u l=0.17u
X4531 cml_tlatch_49.xmux.xn.S1 cml_tlatch_83.OUTN MOT18_P VSS sg13_lv_nmos ad=63.19999f pd=0.74u as=63.19999f ps=0.74u w=0.26u l=0.38u
X4532 cml_tlatch_10.xmux.xp.S1 B0_8_N B0_8_P VSS sg13_lv_nmos ad=56.9f pd=0.74u as=56.9f ps=0.74u w=0.17u l=0.17u
X4533 cml_tlatch_35.xmux.xp.S1 cml_tlatch_35.OUTP cml_tlatch_35.OUTN VSS sg13_lv_nmos ad=56.9f pd=0.74u as=56.9f ps=0.74u w=0.17u l=0.17u
X4534 cml_tlatch_98.xmux.xp.S1 cml_tlatch_98.OUTN cml_tlatch_98.OUTP VSS sg13_lv_nmos ad=0.1019p pd=1.34u as=56.9f ps=0.74u w=0.17u l=0.17u
X4535 cml_tlatch_83.xtail.S1 CKA2_N cml_tlatch_83.xmux.xn.S1 VSS sg13_lv_nmos ad=89.3f pd=0.85u as=89.3f ps=0.85u w=0.47u l=0.16u
X4536 cml_tlatch_6.xmux.xn.S1 cml_tlatch_6.INP MOT13_N VSS sg13_lv_nmos ad=0.1082p pd=1.34u as=63.19999f ps=0.74u w=0.26u l=0.38u
X4537 cml_tlatch_46.xmux.xn.S1 cml_tlatch_47.OUTP B3_2_N VSS sg13_lv_nmos ad=63.19999f pd=0.74u as=63.19999f ps=0.74u w=0.26u l=0.38u
X4538 VSS POLN cml_tlatch_30.xtail.S1 VSS sg13_lv_nmos ad=2.7982p pd=17.14u as=1.5637p ps=8.61u w=8.23u l=0.13u
X4539 stub_bi_31.BOTP stub_bi_31.BOTN cml_tlatch_34.xmux.xp.S1 VSS sg13_lv_nmos ad=56.9f pd=0.74u as=56.9f ps=0.74u w=0.17u l=0.17u
X4540 cml_tlatch_52.xmux.xn.S1 CKA3_P cml_tlatch_52.xtail.S1 VSS sg13_lv_nmos ad=0.1598p pd=1.62u as=89.3f ps=0.85u w=0.47u l=0.16u
X4541 J1_N J1_P cml_tlatch_93.xmux.xp.S1 VSS sg13_lv_nmos ad=56.9f pd=0.74u as=56.9f ps=0.74u w=0.17u l=0.17u
X4542 cml_tlatch_58.INP cml_tlatch_58.INN cml_tlatch_85.xmux.xp.S1 VSS sg13_lv_nmos ad=56.9f pd=0.74u as=56.9f ps=0.74u w=0.17u l=0.17u
X4543 VSS POLN cml_tlatch_23.xtail.S1 VSS sg13_lv_nmos ad=2.7982p pd=17.14u as=1.5637p ps=8.61u w=8.23u l=0.13u
X4544 J4_P J4_N cml_tlatch_90.xmux.xp.S1 VSS sg13_lv_nmos ad=56.9f pd=0.74u as=56.9f ps=0.74u w=0.17u l=0.17u
X4545 cml_tlatch_47.xmux.xn.S1 D3_N cml_tlatch_47.OUTP VSS sg13_lv_nmos ad=63.19999f pd=0.74u as=0.1082p ps=1.34u w=0.26u l=0.38u
X4546 cml_tlatch_84.xmux.xp.S1 cml_tlatch_70.INN cml_tlatch_70.INP VSS sg13_lv_nmos ad=56.9f pd=0.74u as=56.9f ps=0.74u w=0.17u l=0.17u
X4547 MOT22_N MOT22_P cml_tlatch_51.xmux.xp.S1 VSS sg13_lv_nmos ad=56.9f pd=0.74u as=56.9f ps=0.74u w=0.17u l=0.17u
X4548 cml_tlatch_10.xtail.S1 CKB0_N cml_tlatch_10.xmux.xn.S1 VSS sg13_lv_nmos ad=89.3f pd=0.85u as=89.3f ps=0.85u w=0.47u l=0.16u
X4549 cml_tlatch_15.xtail.S1 POLN VSS VSS sg13_lv_nmos ad=1.5637p pd=8.61u as=2.7982p ps=17.14u w=8.23u l=0.13u
X4550 cml_tlatch_32.xmux.xp.S1 stub_bi_29.BOTP stub_bi_29.BOTN VSS sg13_lv_nmos ad=56.9f pd=0.74u as=56.9f ps=0.74u w=0.17u l=0.17u
X4551 cml_tlatch_59.xmux.xp.S1 MOT30_P MOT30_N VSS sg13_lv_nmos ad=56.9f pd=0.74u as=56.9f ps=0.74u w=0.17u l=0.17u
X4552 cml_tlatch_79.xtail.S1 CKB2_N cml_tlatch_79.xmux.xn.S1 VSS sg13_lv_nmos ad=0.1598p pd=1.62u as=89.3f ps=0.85u w=0.47u l=0.16u
X4553 cml_gate2_8.xrtail.R1 NS1_N ENB_P VSS sg13_lv_nmos ad=0.1007p pd=0.91u as=0.1007p ps=0.91u w=0.53u l=0.13u
X4554 cml_tlatch_93.xmux.xp.S1 J1_N J1_P VSS sg13_lv_nmos ad=56.9f pd=0.74u as=56.9f ps=0.74u w=0.17u l=0.17u
X4555 cml_tlatch_21.xmux.xp.S1 A1_8_N A1_8_P VSS sg13_lv_nmos ad=56.9f pd=0.74u as=56.9f ps=0.74u w=0.17u l=0.17u
X4556 cml_tlatch_14.xmux.xp.S1 cml_tlatch_5.INN cml_tlatch_5.INP VSS sg13_lv_nmos ad=56.9f pd=0.74u as=56.9f ps=0.74u w=0.17u l=0.17u
X4557 VDD cml_tlatch_58.INP VSS rppd l=5.17u w=1u
X4558 cml_tlatch_95.xtail.S1 CKA1_N cml_tlatch_95.xmux.xn.S1 VSS sg13_lv_nmos ad=89.3f pd=0.85u as=89.3f ps=0.85u w=0.47u l=0.16u
X4559 cml_tlatch_6.INP cml_tlatch_6.INN cml_tlatch_94.xmux.xp.S1 VSS sg13_lv_nmos ad=56.9f pd=0.74u as=56.9f ps=0.74u w=0.17u l=0.17u
X4560 MOT21_P stub_bi_55.BOTP cml_tlatch_75.xmux.xn.S1 VSS sg13_lv_nmos ad=63.19999f pd=0.74u as=0.1082p ps=1.34u w=0.26u l=0.38u
X4561 cml_tlatch_53.xtail.S1 CKA3_N cml_tlatch_53.xmux.xn.S1 VSS sg13_lv_nmos ad=89.3f pd=0.85u as=89.3f ps=0.85u w=0.47u l=0.16u
X4562 cml_tlatch_20.xtail.S1 CKHB0_P cml_tlatch_20.xmux.xn.S1 VSS sg13_lv_nmos ad=89.3f pd=0.85u as=89.3f ps=0.85u w=0.47u l=0.16u
X4563 cml_tlatch_73.xtail.S1 CKHB2_N cml_tlatch_73.xmux.xp.S1 VSS sg13_lv_nmos ad=89.3f pd=0.85u as=89.3f ps=0.85u w=0.47u l=0.16u
X4564 cml_tlatch_31.xmux.xn.S1 CKA0_N cml_tlatch_31.xtail.S1 VSS sg13_lv_nmos ad=0.1598p pd=1.62u as=89.3f ps=0.85u w=0.47u l=0.16u
X4565 cml_tlatch_65.xmux.xp.S1 cml_tlatch_65.OUTN cml_tlatch_65.OUTP VSS sg13_lv_nmos ad=56.9f pd=0.74u as=56.9f ps=0.74u w=0.17u l=0.17u
X4566 cml_tlatch_11.xtail.S1 CKB0_P cml_tlatch_11.xmux.xn.S1 VSS sg13_lv_nmos ad=89.3f pd=0.85u as=89.3f ps=0.85u w=0.47u l=0.16u
X4567 cml_tlatch_29.xmux.xn.S1 CKB0_P cml_tlatch_29.xtail.S1 VSS sg13_lv_nmos ad=89.3f pd=0.85u as=89.3f ps=0.85u w=0.47u l=0.16u
X4568 MOT7_N MOT7_P cml_tlatch_20.xmux.xp.S1 VSS sg13_lv_nmos ad=56.9f pd=0.74u as=56.9f ps=0.74u w=0.17u l=0.17u
X4569 cml_tlatch_50.xmux.xp.S1 CKHA2_N cml_tlatch_50.xtail.S1 VSS sg13_lv_nmos ad=89.3f pd=0.85u as=89.3f ps=0.85u w=0.47u l=0.16u
X4570 MOT19_N stub_bi_63.BOTN cml_tlatch_74.xmux.xn.S1 VSS sg13_lv_nmos ad=0.1082p pd=1.34u as=63.19999f ps=0.74u w=0.26u l=0.38u
X4571 cml_tlatch_78.xmux.xp.S1 CKB2_N cml_tlatch_78.xtail.S1 VSS sg13_lv_nmos ad=89.3f pd=0.85u as=89.3f ps=0.85u w=0.47u l=0.16u
X4572 GA1_P CKB1_N cml_gate2_3.xrtail.R1 VSS sg13_lv_nmos ad=0.1007p pd=0.91u as=0.1802p ps=1.74u w=0.53u l=0.13u
X4573 cml_tlatch_94.xtail.S1 CKB1_N cml_tlatch_94.xmux.xn.S1 VSS sg13_lv_nmos ad=89.3f pd=0.85u as=89.3f ps=0.85u w=0.47u l=0.16u
X4574 cml_tlatch_65.xmux.xn.S1 cml_tlatch_57.INP cml_tlatch_65.OUTN VSS sg13_lv_nmos ad=63.19999f pd=0.74u as=63.19999f ps=0.74u w=0.26u l=0.38u
X4575 cml_tlatch_72.xmux.xp.S1 cml_tlatch_83.INP cml_tlatch_83.INN VSS sg13_lv_nmos ad=56.9f pd=0.74u as=56.9f ps=0.74u w=0.17u l=0.17u
X4576 cml_tlatch_13.xmux.xp.S1 stub_bi_17.BOTP stub_bi_17.BOTN VSS sg13_lv_nmos ad=56.9f pd=0.74u as=56.9f ps=0.74u w=0.17u l=0.17u
X4577 cml_tlatch_46.xtail.S1 CKB3_N cml_tlatch_46.xmux.xn.S1 VSS sg13_lv_nmos ad=0.1598p pd=1.62u as=89.3f ps=0.85u w=0.47u l=0.16u
X4578 cml_tlatch_65.xmux.xp.S1 CKA3_N cml_tlatch_65.xtail.S1 VSS sg13_lv_nmos ad=89.3f pd=0.85u as=89.3f ps=0.85u w=0.47u l=0.16u
X4579 cml_tlatch_48.xmux.xp.S1 CKB2_N cml_tlatch_48.xtail.S1 VSS sg13_lv_nmos ad=89.3f pd=0.85u as=89.3f ps=0.85u w=0.47u l=0.16u
X4580 cml_tlatch_39.xtail.S1 CKHA1_P cml_tlatch_39.xmux.xn.S1 VSS sg13_lv_nmos ad=89.3f pd=0.85u as=0.1598p ps=1.62u w=0.47u l=0.16u
X4581 cml_tlatch_89.xtail.S1 CKA2_N cml_tlatch_89.xmux.xn.S1 VSS sg13_lv_nmos ad=89.3f pd=0.85u as=89.3f ps=0.85u w=0.47u l=0.16u
X4582 cml_tlatch_62.xmux.xp.S1 cml_tlatch_69.INP cml_tlatch_69.INN VSS sg13_lv_nmos ad=56.9f pd=0.74u as=56.9f ps=0.74u w=0.17u l=0.17u
X4583 MOT28_N MOT28_P cml_tlatch_58.xmux.xp.S1 VSS sg13_lv_nmos ad=56.9f pd=0.74u as=56.9f ps=0.74u w=0.17u l=0.17u
X4584 MOT22_P A2_2_N cml_tlatch_51.xmux.xn.S1 VSS sg13_lv_nmos ad=63.19999f pd=0.74u as=63.19999f ps=0.74u w=0.26u l=0.38u
X4585 cml_tlatch_15.xmux.xp.S1 stub_bi_19.BOTP stub_bi_19.BOTN VSS sg13_lv_nmos ad=56.9f pd=0.74u as=56.9f ps=0.74u w=0.17u l=0.17u
X4586 stub_bi_29.BOTN B1_2_N cml_tlatch_32.xmux.xn.S1 VSS sg13_lv_nmos ad=63.19999f pd=0.74u as=63.19999f ps=0.74u w=0.26u l=0.38u
X4587 MOT27_P cml_tlatch_69.INN cml_tlatch_69.xmux.xn.S1 VSS sg13_lv_nmos ad=63.19999f pd=0.74u as=63.19999f ps=0.74u w=0.26u l=0.38u
X4588 GA1_P ENA0_N cml_gate2_3.sg13_lv_nmos_FTPY57_0.D0 VSS sg13_lv_nmos ad=0.1007p pd=0.91u as=0.1007p ps=0.91u w=0.53u l=0.13u
X4589 cml_tlatch_15.xtail.S1 CKB1_P cml_tlatch_15.xmux.xn.S1 VSS sg13_lv_nmos ad=89.3f pd=0.85u as=89.3f ps=0.85u w=0.47u l=0.16u
X4590 cml_tlatch_58.xmux.xp.S1 CKHA3_N cml_tlatch_58.xtail.S1 VSS sg13_lv_nmos ad=89.3f pd=0.85u as=89.3f ps=0.85u w=0.47u l=0.16u
X4591 cml_tlatch_91.xmux.xp.S1 CKJ_N cml_tlatch_91.xtail.S1 VSS sg13_lv_nmos ad=89.3f pd=0.85u as=89.3f ps=0.85u w=0.47u l=0.16u
X4592 CKHA3_N VDD VSS rppd l=13.09u w=1u
X4593 MOT3_P MOT3_N cml_tlatch_18.xmux.xp.S1 VSS sg13_lv_nmos ad=56.9f pd=0.74u as=56.9f ps=0.74u w=0.17u l=0.17u
X4594 A2_8_N A2_8_P cml_tlatch_81.xmux.xp.S1 VSS sg13_lv_nmos ad=56.9f pd=0.74u as=56.9f ps=0.74u w=0.17u l=0.17u
X4595 cml_tlatch_27.xmux.xn.S1 B0_2_P cml_tlatch_27.OUTN VSS sg13_lv_nmos ad=0.1082p pd=1.34u as=63.19999f ps=0.74u w=0.26u l=0.38u
X4596 cml_tlatch_8.xmux.xp.S1 cml_tlatch_8.OUTP cml_tlatch_8.OUTN VSS sg13_lv_nmos ad=56.9f pd=0.74u as=56.9f ps=0.74u w=0.17u l=0.17u
X4597 cml_tlatch_29.OUTP cml_tlatch_29.OUTN cml_tlatch_29.xmux.xp.S1 VSS sg13_lv_nmos ad=56.9f pd=0.74u as=56.9f ps=0.74u w=0.17u l=0.17u
X4598 cml_tlatch_42.xmux.xp.S1 cml_tlatch_56.INP cml_tlatch_56.INN VSS sg13_lv_nmos ad=56.9f pd=0.74u as=56.9f ps=0.74u w=0.17u l=0.17u
X4599 cml_tlatch_69.INN cml_tlatch_69.INP cml_tlatch_62.xmux.xp.S1 VSS sg13_lv_nmos ad=56.9f pd=0.74u as=56.9f ps=0.74u w=0.17u l=0.17u
X4600 cml_tlatch_69.INP cml_tlatch_69.INN cml_tlatch_62.xmux.xp.S1 VSS sg13_lv_nmos ad=56.9f pd=0.74u as=56.9f ps=0.74u w=0.17u l=0.17u
X4601 cml_tlatch_37.xmux.xp.S1 A1_2_P A1_2_N VSS sg13_lv_nmos ad=56.9f pd=0.74u as=56.9f ps=0.74u w=0.17u l=0.17u
X4602 J4_P J4_N cml_tlatch_90.xmux.xp.S1 VSS sg13_lv_nmos ad=56.9f pd=0.74u as=56.9f ps=0.74u w=0.17u l=0.17u
X4603 cml_tlatch_54.xtail.S1 CKA3_P cml_tlatch_54.xmux.xn.S1 VSS sg13_lv_nmos ad=89.3f pd=0.85u as=89.3f ps=0.85u w=0.47u l=0.16u
X4604 B2_2_N B2_2_P cml_tlatch_44.xmux.xp.S1 VSS sg13_lv_nmos ad=56.9f pd=0.74u as=56.9f ps=0.74u w=0.17u l=0.17u
X4605 A0_2_P A0_2_N cml_tlatch_31.xmux.xp.S1 VSS sg13_lv_nmos ad=56.9f pd=0.74u as=56.9f ps=0.74u w=0.17u l=0.17u
X4606 CKHB1_P VDD VSS rppd l=13.09u w=1u
X4607 cml_tlatch_10.xmux.xp.S1 B0_8_N B0_8_P VSS sg13_lv_nmos ad=56.9f pd=0.74u as=56.9f ps=0.74u w=0.17u l=0.17u
X4608 cml_tlatch_97.xtail.S1 CKHA0_N cml_tlatch_97.xmux.xp.S1 VSS sg13_lv_nmos ad=89.3f pd=0.85u as=89.3f ps=0.85u w=0.47u l=0.16u
X4609 cml_tlatch_89.INP cml_tlatch_89.INN cml_tlatch_55.xmux.xp.S1 VSS sg13_lv_nmos ad=56.9f pd=0.74u as=56.9f ps=0.74u w=0.17u l=0.17u
X4610 cml_tlatch_21.xtail.S1 CKA1_P cml_tlatch_21.xmux.xp.S1 VSS sg13_lv_nmos ad=89.3f pd=0.85u as=89.3f ps=0.85u w=0.47u l=0.16u
X4611 cml_tlatch_97.xmux.xp.S1 MOT0_N MOT0_P VSS sg13_lv_nmos ad=56.9f pd=0.74u as=56.9f ps=0.74u w=0.17u l=0.17u
X4612 MOT21_P MOT21_N cml_tlatch_75.xmux.xp.S1 VSS sg13_lv_nmos ad=56.9f pd=0.74u as=56.9f ps=0.74u w=0.17u l=0.17u
X4613 cml_tlatch_70.xmux.xp.S1 MOT29_N MOT29_P VSS sg13_lv_nmos ad=56.9f pd=0.74u as=56.9f ps=0.74u w=0.17u l=0.17u
X4614 cml_tlatch_54.xmux.xp.S1 cml_tlatch_54.OUTN cml_tlatch_54.OUTP VSS sg13_lv_nmos ad=56.9f pd=0.74u as=56.9f ps=0.74u w=0.17u l=0.17u
X4615 cml_tlatch_1.xmux.xn.S1 CKB0_P cml_tlatch_1.xtail.S1 VSS sg13_lv_nmos ad=89.3f pd=0.85u as=89.3f ps=0.85u w=0.47u l=0.16u
X4616 CLK_W_P CLK_W_N cml_tlatch_91.xmux.xp.S1 VSS sg13_lv_nmos ad=56.9f pd=0.74u as=56.9f ps=0.74u w=0.17u l=0.17u
X4617 cml_tlatch_43.xmux.xp.S1 CKB2_N cml_tlatch_43.xtail.S1 VSS sg13_lv_nmos ad=89.3f pd=0.85u as=89.3f ps=0.85u w=0.47u l=0.16u
X4618 cml_tlatch_56.xmux.xp.S1 A2_2_N A2_2_P VSS sg13_lv_nmos ad=56.9f pd=0.74u as=56.9f ps=0.74u w=0.17u l=0.17u
X4619 cml_tlatch_9.xmux.xn.S1 cml_tlatch_99.OUTN cml_tlatch_9.OUTP VSS sg13_lv_nmos ad=63.19999f pd=0.74u as=63.19999f ps=0.74u w=0.26u l=0.38u
X4620 cml_tlatch_68.xmux.xn.S1 B3_8_N MOT25_P VSS sg13_lv_nmos ad=63.19999f pd=0.74u as=63.19999f ps=0.74u w=0.26u l=0.38u
X4621 cml_tlatch_80.xmux.xp.S1 stub_bi_49.BOTN stub_bi_49.BOTP VSS sg13_lv_nmos ad=56.9f pd=0.74u as=56.9f ps=0.74u w=0.17u l=0.17u
X4622 cml_tlatch_52.xmux.xp.S1 CKA3_N cml_tlatch_52.xtail.S1 VSS sg13_lv_nmos ad=89.3f pd=0.85u as=0.1598p ps=1.62u w=0.47u l=0.16u
X4623 cml_tlatch_34.xmux.xp.S1 stub_bi_31.BOTP stub_bi_31.BOTN VSS sg13_lv_nmos ad=56.9f pd=0.74u as=56.9f ps=0.74u w=0.17u l=0.17u
X4624 cml_tlatch_93.xmux.xp.S1 J1_N J1_P VSS sg13_lv_nmos ad=56.9f pd=0.74u as=56.9f ps=0.74u w=0.17u l=0.17u
X4625 VSS hs_to_clk_6.sg13_lv_nmos_2HGZLP_0.G VSS VSS sg13_lv_nmos ad=2.071p pd=11.28u as=0 ps=0 w=10.9u l=1.38u
X4626 cml_tlatch_31.xmux.xp.S1 A0_2_P A0_2_N VSS sg13_lv_nmos ad=56.9f pd=0.74u as=56.9f ps=0.74u w=0.17u l=0.17u
X4627 cml_tlatch_22.xtail.S1 CKA1_P cml_tlatch_22.xmux.xn.S1 VSS sg13_lv_nmos ad=89.3f pd=0.85u as=89.3f ps=0.85u w=0.47u l=0.16u
X4628 cml_tlatch_14.xmux.xp.S1 cml_tlatch_5.INP cml_tlatch_5.INN VSS sg13_lv_nmos ad=56.9f pd=0.74u as=56.9f ps=0.74u w=0.17u l=0.17u
X4629 cml_tlatch_4.xmux.xp.S1 CKHB1_N cml_tlatch_4.xtail.S1 VSS sg13_lv_nmos ad=89.3f pd=0.85u as=89.3f ps=0.85u w=0.47u l=0.16u
X4630 cml_tlatch_68.xmux.xp.S1 MOT25_P MOT25_N VSS sg13_lv_nmos ad=56.9f pd=0.74u as=56.9f ps=0.74u w=0.17u l=0.17u
X4631 VDD GA0_N VSS rppd l=7.42u w=1u
X4632 cml_tlatch_41.xmux.xp.S1 CKHA1_N cml_tlatch_41.xtail.S1 VSS sg13_lv_nmos ad=89.3f pd=0.85u as=89.3f ps=0.85u w=0.47u l=0.16u
X4633 cml_tlatch_8.xmux.xp.S1 cml_tlatch_8.OUTN cml_tlatch_8.OUTP VSS sg13_lv_nmos ad=56.9f pd=0.74u as=56.9f ps=0.74u w=0.17u l=0.17u
X4634 cml_tlatch_24.xmux.xp.S1 CKHA0_N cml_tlatch_24.xtail.S1 VSS sg13_lv_nmos ad=0.1598p pd=1.62u as=89.3f ps=0.85u w=0.47u l=0.16u
X4635 cml_tlatch_87.xtail.S1 CKHA2_N cml_tlatch_87.xmux.xp.S1 VSS sg13_lv_nmos ad=89.3f pd=0.85u as=89.3f ps=0.85u w=0.47u l=0.16u
X4636 cml_tlatch_25.xmux.xn.S1 cml_tlatch_99.OUTN MOT4_P VSS sg13_lv_nmos ad=63.19999f pd=0.74u as=63.19999f ps=0.74u w=0.26u l=0.38u
X4637 cml_tlatch_74.xmux.xp.S1 MOT19_N MOT19_P VSS sg13_lv_nmos ad=56.9f pd=0.74u as=56.9f ps=0.74u w=0.17u l=0.17u
X4638 cml_tlatch_83.INP cml_tlatch_83.INN cml_tlatch_72.xmux.xp.S1 VSS sg13_lv_nmos ad=56.9f pd=0.74u as=56.9f ps=0.74u w=0.17u l=0.17u
X4639 MOT2_N MOT2_P cml_tlatch_24.xmux.xp.S1 VSS sg13_lv_nmos ad=56.9f pd=0.74u as=56.9f ps=0.74u w=0.17u l=0.17u
X4640 cml_tlatch_61.OUTP cml_tlatch_61.OUTN cml_tlatch_61.xmux.xp.S1 VSS sg13_lv_nmos ad=56.9f pd=0.74u as=56.9f ps=0.74u w=0.17u l=0.17u
X4641 cml_tlatch_98.xmux.xn.S1 cml_tlatch_27.OUTP cml_tlatch_98.OUTN VSS sg13_lv_nmos ad=63.19999f pd=0.74u as=0.1082p ps=1.34u w=0.26u l=0.38u
X4642 A1_8_P cml_tlatch_22.OUTN cml_tlatch_21.xmux.xn.S1 VSS sg13_lv_nmos ad=63.19999f pd=0.74u as=0.1082p ps=1.34u w=0.26u l=0.38u
X4643 MOT27_P MOT27_N cml_tlatch_69.xmux.xp.S1 VSS sg13_lv_nmos ad=56.9f pd=0.74u as=56.9f ps=0.74u w=0.17u l=0.17u
X4644 cml_tlatch_21.xmux.xn.S1 cml_tlatch_22.OUTP A1_8_N VSS sg13_lv_nmos ad=63.19999f pd=0.74u as=63.19999f ps=0.74u w=0.26u l=0.38u
X4645 cml_gate2_4.xrtail.R1 CKB2_P cml_gate2_4.sg13_lv_nmos_FTPY57_0.D0 VSS sg13_lv_nmos ad=0.1802p pd=1.74u as=0.1007p ps=0.91u w=0.53u l=0.13u
X4646 cml_tlatch_13.xtail.S1 CKB1_P cml_tlatch_13.xmux.xn.S1 VSS sg13_lv_nmos ad=89.3f pd=0.85u as=89.3f ps=0.85u w=0.47u l=0.16u
X4647 cml_tlatch_84.xmux.xn.S1 cml_tlatch_45.OUTN cml_tlatch_70.INP VSS sg13_lv_nmos ad=63.19999f pd=0.74u as=63.19999f ps=0.74u w=0.26u l=0.38u
X4648 cml_tlatch_30.xtail.S1 CKA0_P cml_tlatch_30.xmux.xn.S1 VSS sg13_lv_nmos ad=89.3f pd=0.85u as=89.3f ps=0.85u w=0.47u l=0.16u
X4649 VSS POLN cml_tlatch_10.xtail.S1 VSS sg13_lv_nmos ad=2.7982p pd=17.14u as=1.5637p ps=8.61u w=8.23u l=0.13u
X4650 cml_tlatch_13.xmux.xp.S1 stub_bi_17.BOTP stub_bi_17.BOTN VSS sg13_lv_nmos ad=56.9f pd=0.74u as=56.9f ps=0.74u w=0.17u l=0.17u
X4651 cml_tlatch_5.xmux.xp.S1 MOT11_N MOT11_P VSS sg13_lv_nmos ad=56.9f pd=0.74u as=56.9f ps=0.74u w=0.17u l=0.17u
X4652 cml_tlatch_83.OUTN cml_tlatch_83.OUTP cml_tlatch_83.xmux.xp.S1 VSS sg13_lv_nmos ad=56.9f pd=0.74u as=0.1019p ps=1.34u w=0.17u l=0.17u
X4653 cml_tlatch_79.xmux.xp.S1 stub_bi_63.BOTP stub_bi_63.BOTN VSS sg13_lv_nmos ad=56.9f pd=0.74u as=56.9f ps=0.74u w=0.17u l=0.17u
X4654 cml_tlatch_67.xmux.xn.S1 CKA3_P cml_tlatch_67.xtail.S1 VSS sg13_lv_nmos ad=89.3f pd=0.85u as=89.3f ps=0.85u w=0.47u l=0.16u
X4655 cml_tlatch_75.xtail.S1 CKHB2_P cml_tlatch_75.xmux.xn.S1 VSS sg13_lv_nmos ad=89.3f pd=0.85u as=89.3f ps=0.85u w=0.47u l=0.16u
X4656 MOT3_N MOT3_P cml_tlatch_18.xmux.xp.S1 VSS sg13_lv_nmos ad=56.9f pd=0.74u as=56.9f ps=0.74u w=0.17u l=0.17u
X4657 MOT2_P MOT2_N cml_tlatch_24.xmux.xp.S1 VSS sg13_lv_nmos ad=56.9f pd=0.74u as=56.9f ps=0.74u w=0.17u l=0.17u
X4658 MOT16_P MOT16_N cml_tlatch_87.xmux.xp.S1 VSS sg13_lv_nmos ad=56.9f pd=0.74u as=0.1019p ps=1.34u w=0.17u l=0.17u
X4659 cml_tlatch_17.xtail.S1 CKHB0_P cml_tlatch_17.xmux.xn.S1 VSS sg13_lv_nmos ad=89.3f pd=0.85u as=89.3f ps=0.85u w=0.47u l=0.16u
X4660 cml_tlatch_40.INN cml_tlatch_95.INP cml_tlatch_95.xmux.xn.S1 VSS sg13_lv_nmos ad=63.19999f pd=0.74u as=63.19999f ps=0.74u w=0.26u l=0.38u
X4661 cml_tlatch_40.xmux.xp.S1 MOT12_P MOT12_N VSS sg13_lv_nmos ad=56.9f pd=0.74u as=56.9f ps=0.74u w=0.17u l=0.17u
X4662 cml_tlatch_63.OUTP cml_tlatch_70.INN cml_tlatch_63.xmux.xn.S1 VSS sg13_lv_nmos ad=63.19999f pd=0.74u as=63.19999f ps=0.74u w=0.26u l=0.38u
X4663 A2_8_N A2_8_P cml_tlatch_81.xmux.xp.S1 VSS sg13_lv_nmos ad=56.9f pd=0.74u as=56.9f ps=0.74u w=0.17u l=0.17u
X4664 cml_tlatch_28.xmux.xp.S1 B0_2_N B0_2_P VSS sg13_lv_nmos ad=56.9f pd=0.74u as=56.9f ps=0.74u w=0.17u l=0.17u
X4665 cml_tlatch_30.OUTP cml_tlatch_30.OUTN cml_tlatch_30.xmux.xp.S1 VSS sg13_lv_nmos ad=56.9f pd=0.74u as=56.9f ps=0.74u w=0.17u l=0.17u
X4666 cml_tlatch_77.xmux.xp.S1 B2_8_P B2_8_N VSS sg13_lv_nmos ad=56.9f pd=0.74u as=56.9f ps=0.74u w=0.17u l=0.17u
X4667 cml_tlatch_73.xmux.xp.S1 CKHB2_N cml_tlatch_73.xtail.S1 VSS sg13_lv_nmos ad=89.3f pd=0.85u as=89.3f ps=0.85u w=0.47u l=0.16u
X4668 cml_tlatch_3.xtail.S1 CKA0_N cml_tlatch_3.xmux.xp.S1 VSS sg13_lv_nmos ad=89.3f pd=0.85u as=89.3f ps=0.85u w=0.47u l=0.16u
X4669 cml_tlatch_92.xmux.xn.S1 J1_N J2_P VSS sg13_lv_nmos ad=63.19999f pd=0.74u as=63.19999f ps=0.74u w=0.26u l=0.38u
X4670 cml_tlatch_71.xmux.xn.S1 B3_2_N MOT31_P VSS sg13_lv_nmos ad=0.1082p pd=1.34u as=63.19999f ps=0.74u w=0.26u l=0.38u
X4671 cml_tlatch_63.xmux.xn.S1 CKB3_P cml_tlatch_63.xtail.S1 VSS sg13_lv_nmos ad=89.3f pd=0.85u as=89.3f ps=0.85u w=0.47u l=0.16u
X4672 cml_tlatch_78.xmux.xn.S1 stub_bi_63.BOTP stub_bi_62.BOTN VSS sg13_lv_nmos ad=63.19999f pd=0.74u as=63.19999f ps=0.74u w=0.26u l=0.38u
X4673 cml_tlatch_96.xtail.S1 CKHA1_N cml_tlatch_96.xmux.xp.S1 VSS sg13_lv_nmos ad=89.3f pd=0.85u as=89.3f ps=0.85u w=0.47u l=0.16u
X4674 cml_tlatch_29.xtail.S1 CKB0_P cml_tlatch_29.xmux.xn.S1 VSS sg13_lv_nmos ad=89.3f pd=0.85u as=0.1598p ps=1.62u w=0.47u l=0.16u
X4675 cml_tlatch_81.xmux.xp.S1 A2_8_N A2_8_P VSS sg13_lv_nmos ad=56.9f pd=0.74u as=56.9f ps=0.74u w=0.17u l=0.17u
X4676 cml_tlatch_99.xtail.S1 CKA0_P cml_tlatch_99.xmux.xp.S1 VSS sg13_lv_nmos ad=89.3f pd=0.85u as=89.3f ps=0.85u w=0.47u l=0.16u
X4677 stub_bi_32.BOTP stub_bi_32.BOTN cml_tlatch_48.xmux.xp.S1 VSS sg13_lv_nmos ad=56.9f pd=0.74u as=56.9f ps=0.74u w=0.17u l=0.17u
X4678 cml_tlatch_6.INN VDD VSS rppd l=5.17u w=1u
X4679 cml_gate2_1.xrtail.R1 CKA0_N GB0_P VSS sg13_lv_nmos ad=0.1007p pd=0.91u as=0.1007p ps=0.91u w=0.53u l=0.13u
X4680 cml_tlatch_40.xmux.xn.S1 cml_tlatch_40.INP MOT12_N VSS sg13_lv_nmos ad=63.19999f pd=0.74u as=63.19999f ps=0.74u w=0.26u l=0.38u
X4681 cml_tlatch_89.INP cml_tlatch_89.INN cml_tlatch_55.xmux.xp.S1 VSS sg13_lv_nmos ad=56.9f pd=0.74u as=56.9f ps=0.74u w=0.17u l=0.17u
X4682 cml_tlatch_82.xmux.xn.S1 CKA2_P cml_tlatch_82.xtail.S1 VSS sg13_lv_nmos ad=89.3f pd=0.85u as=89.3f ps=0.85u w=0.47u l=0.16u
X4683 cml_tlatch_54.xmux.xn.S1 D3_P cml_tlatch_54.OUTN VSS sg13_lv_nmos ad=63.19999f pd=0.74u as=63.19999f ps=0.74u w=0.26u l=0.38u
X4684 cml_tlatch_48.xtail.S1 CKB2_N cml_tlatch_48.xmux.xp.S1 VSS sg13_lv_nmos ad=89.3f pd=0.85u as=0.1598p ps=1.62u w=0.47u l=0.16u
X4685 cml_tlatch_43.xmux.xp.S1 stub_bi_42.BOTP stub_bi_42.BOTN VSS sg13_lv_nmos ad=56.9f pd=0.74u as=56.9f ps=0.74u w=0.17u l=0.17u
X4686 cml_tlatch_68.xmux.xp.S1 CKHB3_N cml_tlatch_68.xtail.S1 VSS sg13_lv_nmos ad=89.3f pd=0.85u as=89.3f ps=0.85u w=0.47u l=0.16u
X4687 cml_tlatch_82.OUTN cml_tlatch_82.OUTP cml_tlatch_82.xmux.xp.S1 VSS sg13_lv_nmos ad=56.9f pd=0.74u as=56.9f ps=0.74u w=0.17u l=0.17u
X4688 cml_tlatch_70.xmux.xp.S1 MOT29_N MOT29_P VSS sg13_lv_nmos ad=56.9f pd=0.74u as=56.9f ps=0.74u w=0.17u l=0.17u
X4689 cml_tlatch_83.OUTN cml_tlatch_83.OUTP cml_tlatch_83.xmux.xp.S1 VSS sg13_lv_nmos ad=56.9f pd=0.74u as=56.9f ps=0.74u w=0.17u l=0.17u
X4690 cml_tlatch_79.xmux.xp.S1 stub_bi_63.BOTP stub_bi_63.BOTN VSS sg13_lv_nmos ad=56.9f pd=0.74u as=56.9f ps=0.74u w=0.17u l=0.17u
X4691 cml_tlatch_89.xmux.xp.S1 cml_tlatch_89.OUTN cml_tlatch_89.OUTP VSS sg13_lv_nmos ad=56.9f pd=0.74u as=56.9f ps=0.74u w=0.17u l=0.17u
X4692 cml_tlatch_47.OUTP cml_tlatch_47.OUTN cml_tlatch_47.xmux.xp.S1 VSS sg13_lv_nmos ad=56.9f pd=0.74u as=56.9f ps=0.74u w=0.17u l=0.17u
X4693 cml_tlatch_53.xmux.xn.S1 cml_tlatch_54.OUTN A3_2_P VSS sg13_lv_nmos ad=63.19999f pd=0.74u as=63.19999f ps=0.74u w=0.26u l=0.38u
X4694 cml_gate2_0.sg13_lv_nmos_FTPY57_0.D0 CKA1_P cml_gate2_0.xrtail.R1 VSS sg13_lv_nmos ad=0.1007p pd=0.91u as=0.1802p ps=1.74u w=0.53u l=0.13u
X4695 cml_tlatch_9.xmux.xp.S1 cml_tlatch_9.OUTP cml_tlatch_9.OUTN VSS sg13_lv_nmos ad=56.9f pd=0.74u as=56.9f ps=0.74u w=0.17u l=0.17u
X4696 MOT16_P MOT16_N cml_tlatch_87.xmux.xp.S1 VSS sg13_lv_nmos ad=56.9f pd=0.74u as=56.9f ps=0.74u w=0.17u l=0.17u
X4697 cml_tlatch_76.xmux.xn.S1 CKHB2_P cml_tlatch_76.xtail.S1 VSS sg13_lv_nmos ad=0.1598p pd=1.62u as=89.3f ps=0.85u w=0.47u l=0.16u
X4698 cml_tlatch_52.xmux.xn.S1 CKA3_P cml_tlatch_52.xtail.S1 VSS sg13_lv_nmos ad=89.3f pd=0.85u as=89.3f ps=0.85u w=0.47u l=0.16u
X4699 cml_tlatch_70.xtail.S1 CKHB3_N cml_tlatch_70.xmux.xp.S1 VSS sg13_lv_nmos ad=89.3f pd=0.85u as=89.3f ps=0.85u w=0.47u l=0.16u
X4700 MOT13_P MOT13_N cml_tlatch_6.xmux.xp.S1 VSS sg13_lv_nmos ad=56.9f pd=0.74u as=56.9f ps=0.74u w=0.17u l=0.17u
X4701 interco_bi_19.INN interco_bi_19.INP cml_tlatch_0.xmux.xp.S1 VSS sg13_lv_nmos ad=56.9f pd=0.74u as=56.9f ps=0.74u w=0.17u l=0.17u
X4702 stub_bi_29.BOTP stub_bi_29.BOTN cml_tlatch_32.xmux.xp.S1 VSS sg13_lv_nmos ad=56.9f pd=0.74u as=56.9f ps=0.74u w=0.17u l=0.17u
X4703 ENA_P NM1_N cml_gate2_9.xrtail.R1 VSS sg13_lv_nmos ad=0.1007p pd=0.91u as=0.1007p ps=0.91u w=0.53u l=0.13u
X4704 cml_tlatch_54.xmux.xp.S1 cml_tlatch_54.OUTP cml_tlatch_54.OUTN VSS sg13_lv_nmos ad=56.9f pd=0.74u as=56.9f ps=0.74u w=0.17u l=0.17u
X4705 MOT23_N MOT23_P cml_tlatch_76.xmux.xp.S1 VSS sg13_lv_nmos ad=56.9f pd=0.74u as=56.9f ps=0.74u w=0.17u l=0.17u
X4706 cml_tlatch_31.xtail.S1 POLN VSS VSS sg13_lv_nmos ad=1.5637p pd=8.61u as=1.5637p ps=8.61u w=8.23u l=0.13u
X4707 cml_tlatch_34.xmux.xp.S1 stub_bi_31.BOTP stub_bi_31.BOTN VSS sg13_lv_nmos ad=56.9f pd=0.74u as=56.9f ps=0.74u w=0.17u l=0.17u
X4708 cml_tlatch_98.OUTP cml_tlatch_98.OUTN cml_tlatch_98.xmux.xp.S1 VSS sg13_lv_nmos ad=56.9f pd=0.74u as=56.9f ps=0.74u w=0.17u l=0.17u
X4709 cml_tlatch_47.xtail.S1 CKB3_N cml_tlatch_47.xmux.xp.S1 VSS sg13_lv_nmos ad=89.3f pd=0.85u as=89.3f ps=0.85u w=0.47u l=0.16u
X4710 B0_2_N B0_2_P cml_tlatch_28.xmux.xp.S1 VSS sg13_lv_nmos ad=56.9f pd=0.74u as=0.1019p ps=1.34u w=0.17u l=0.17u
X4711 VDD cml_tlatch_30.OUTN VSS rppd l=5.17u w=1u
X4712 GB1_N ENB1_P cml_gate2_0.sg13_lv_nmos_FTPY57_0.D0 VSS sg13_lv_nmos ad=0.1007p pd=0.91u as=0.1007p ps=0.91u w=0.53u l=0.13u
X4713 cml_tlatch_38.xmux.xp.S1 CKA1_N cml_tlatch_38.xtail.S1 VSS sg13_lv_nmos ad=0.1598p pd=1.62u as=89.3f ps=0.85u w=0.47u l=0.16u
X4714 cml_tlatch_49.xmux.xp.S1 MOT18_N MOT18_P VSS sg13_lv_nmos ad=56.9f pd=0.74u as=56.9f ps=0.74u w=0.17u l=0.17u
X4715 MOT7_N B0_2_P cml_tlatch_20.xmux.xn.S1 VSS sg13_lv_nmos ad=63.19999f pd=0.74u as=63.19999f ps=0.74u w=0.26u l=0.38u
X4716 MOT14_P MOT14_N cml_tlatch_41.xmux.xp.S1 VSS sg13_lv_nmos ad=56.9f pd=0.74u as=56.9f ps=0.74u w=0.17u l=0.17u
X4717 MOT26_P MOT26_N cml_tlatch_57.xmux.xp.S1 VSS sg13_lv_nmos ad=56.9f pd=0.74u as=56.9f ps=0.74u w=0.17u l=0.17u
X4718 cml_tlatch_99.xmux.xp.S1 cml_tlatch_99.OUTP cml_tlatch_99.OUTN VSS sg13_lv_nmos ad=56.9f pd=0.74u as=56.9f ps=0.74u w=0.17u l=0.17u
X4719 MOT15_N MOT15_P cml_tlatch_7.xmux.xp.S1 VSS sg13_lv_nmos ad=56.9f pd=0.74u as=56.9f ps=0.74u w=0.17u l=0.17u
X4720 cml_tlatch_80.xmux.xp.S1 stub_bi_49.BOTP stub_bi_49.BOTN VSS sg13_lv_nmos ad=0.1019p pd=1.34u as=56.9f ps=0.74u w=0.17u l=0.17u
X4721 cml_tlatch_56.xmux.xn.S1 cml_tlatch_56.INP A2_2_N VSS sg13_lv_nmos ad=63.19999f pd=0.74u as=63.19999f ps=0.74u w=0.26u l=0.38u
X4722 cml_tlatch_40.xmux.xp.S1 MOT12_N MOT12_P VSS sg13_lv_nmos ad=56.9f pd=0.74u as=56.9f ps=0.74u w=0.17u l=0.17u
X4723 cml_tlatch_39.xmux.xp.S1 MOT10_N MOT10_P VSS sg13_lv_nmos ad=56.9f pd=0.74u as=56.9f ps=0.74u w=0.17u l=0.17u
X4724 cml_tlatch_39.xmux.xp.S1 MOT10_P MOT10_N VSS sg13_lv_nmos ad=56.9f pd=0.74u as=56.9f ps=0.74u w=0.17u l=0.17u
X4725 cml_tlatch_11.xtail.S1 CKB0_P cml_tlatch_11.xmux.xn.S1 VSS sg13_lv_nmos ad=89.3f pd=0.85u as=89.3f ps=0.85u w=0.47u l=0.16u
X4726 cml_tlatch_99.xtail.S1 CKA0_N cml_tlatch_99.xmux.xn.S1 VSS sg13_lv_nmos ad=89.3f pd=0.85u as=89.3f ps=0.85u w=0.47u l=0.16u
X4727 cml_tlatch_45.OUTN cml_tlatch_45.OUTP cml_tlatch_45.xmux.xp.S1 VSS sg13_lv_nmos ad=56.9f pd=0.74u as=56.9f ps=0.74u w=0.17u l=0.17u
X4728 cml_tlatch_56.xmux.xn.S1 cml_tlatch_56.INP A2_2_N VSS sg13_lv_nmos ad=63.19999f pd=0.74u as=63.19999f ps=0.74u w=0.26u l=0.38u
X4729 cml_tlatch_78.xmux.xp.S1 CKB2_N cml_tlatch_78.xtail.S1 VSS sg13_lv_nmos ad=89.3f pd=0.85u as=89.3f ps=0.85u w=0.47u l=0.16u
X4730 cml_tlatch_94.xtail.S1 CKB1_N cml_tlatch_94.xmux.xn.S1 VSS sg13_lv_nmos ad=89.3f pd=0.85u as=89.3f ps=0.85u w=0.47u l=0.16u
X4731 MOT30_P MOT30_N cml_tlatch_59.xmux.xp.S1 VSS sg13_lv_nmos ad=56.9f pd=0.74u as=56.9f ps=0.74u w=0.17u l=0.17u
X4732 A1_2_P A1_2_N cml_tlatch_37.xmux.xp.S1 VSS sg13_lv_nmos ad=56.9f pd=0.74u as=56.9f ps=0.74u w=0.17u l=0.17u
X4733 cml_gate2_8.sg13_lv_nmos_FTPY57_0.D0 NS1_P cml_gate2_8.xrtail.R1 VSS sg13_lv_nmos ad=0.1007p pd=0.91u as=0.1007p ps=0.91u w=0.53u l=0.13u
X4734 VSS hs_to_clk_6.sg13_lv_nmos_2HGZLP_0.G VSS VSS sg13_lv_nmos ad=3.706p pd=22.48u as=0 ps=0 w=10.9u l=1.38u
X4735 VSS POLN cml_tlatch_72.xtail.S1 VSS sg13_lv_nmos ad=1.5637p pd=8.61u as=1.5637p ps=8.61u w=8.23u l=0.13u
X4736 cml_tlatch_32.xmux.xn.S1 CKB1_P cml_tlatch_32.xtail.S1 VSS sg13_lv_nmos ad=89.3f pd=0.85u as=89.3f ps=0.85u w=0.47u l=0.16u
X4737 stub_bi_19.BOTP cml_tlatch_6.INP cml_tlatch_15.xmux.xn.S1 VSS sg13_lv_nmos ad=63.19999f pd=0.74u as=63.19999f ps=0.74u w=0.26u l=0.38u
X4738 cml_tlatch_54.xmux.xp.S1 cml_tlatch_54.OUTP cml_tlatch_54.OUTN VSS sg13_lv_nmos ad=56.9f pd=0.74u as=56.9f ps=0.74u w=0.17u l=0.17u
X4739 cml_tlatch_8.xmux.xn.S1 cml_tlatch_9.OUTP cml_tlatch_8.OUTN VSS sg13_lv_nmos ad=63.19999f pd=0.74u as=63.19999f ps=0.74u w=0.26u l=0.38u
X4740 cml_tlatch_57.xmux.xp.S1 MOT26_P MOT26_N VSS sg13_lv_nmos ad=56.9f pd=0.74u as=56.9f ps=0.74u w=0.17u l=0.17u
X4741 ENB0_P ENB_N cml_drv_2.xrtail.R1 VSS sg13_lv_nmos ad=56.2f pd=0.74u as=56.2f ps=0.74u w=0.16u l=0.19u
X4742 cml_tlatch_40.INP cml_tlatch_40.INN cml_tlatch_95.xmux.xp.S1 VSS sg13_lv_nmos ad=56.9f pd=0.74u as=56.9f ps=0.74u w=0.17u l=0.17u
X4743 cml_tlatch_16.xmux.xp.S1 cml_tlatch_16.OUTP cml_tlatch_16.OUTN VSS sg13_lv_nmos ad=0.1019p pd=1.34u as=56.9f ps=0.74u w=0.17u l=0.17u
X4744 B3_2_N B3_2_P cml_tlatch_46.xmux.xp.S1 VSS sg13_lv_nmos ad=56.9f pd=0.74u as=56.9f ps=0.74u w=0.17u l=0.17u
X4745 B0_2_N B0_2_P cml_tlatch_28.xmux.xp.S1 VSS sg13_lv_nmos ad=56.9f pd=0.74u as=56.9f ps=0.74u w=0.17u l=0.17u
X4746 cml_tlatch_30.OUTP cml_tlatch_30.OUTN cml_tlatch_30.xmux.xp.S1 VSS sg13_lv_nmos ad=56.9f pd=0.74u as=56.9f ps=0.74u w=0.17u l=0.17u
X4747 VDD cml_tlatch_83.OUTP VSS rppd l=5.17u w=1u
X4748 cml_tlatch_87.xmux.xp.S1 CKHA2_N cml_tlatch_87.xtail.S1 VSS sg13_lv_nmos ad=89.3f pd=0.85u as=89.3f ps=0.85u w=0.47u l=0.16u
X4749 cml_tlatch_52.OUTN A3_2_P cml_tlatch_52.xmux.xn.S1 VSS sg13_lv_nmos ad=63.19999f pd=0.74u as=63.19999f ps=0.74u w=0.26u l=0.38u
X4750 cml_tlatch_70.xmux.xn.S1 cml_tlatch_70.INP MOT29_N VSS sg13_lv_nmos ad=63.19999f pd=0.74u as=0.1082p ps=1.34u w=0.26u l=0.38u
X4751 cml_tlatch_45.xmux.xp.S1 cml_tlatch_45.OUTP cml_tlatch_45.OUTN VSS sg13_lv_nmos ad=56.9f pd=0.74u as=56.9f ps=0.74u w=0.17u l=0.17u
X4752 cml_tlatch_33.xmux.xp.S1 B1_2_P B1_2_N VSS sg13_lv_nmos ad=56.9f pd=0.74u as=56.9f ps=0.74u w=0.17u l=0.17u
X4753 cml_tlatch_6.INN cml_tlatch_6.INP cml_tlatch_94.xmux.xp.S1 VSS sg13_lv_nmos ad=56.9f pd=0.74u as=0.1019p ps=1.34u w=0.17u l=0.17u
X4754 VDD MOT18_P VSS rppd l=5.17u w=1u
X4755 cml_tlatch_7.xmux.xp.S1 MOT15_N MOT15_P VSS sg13_lv_nmos ad=56.9f pd=0.74u as=56.9f ps=0.74u w=0.17u l=0.17u
X4756 cml_tlatch_63.xmux.xp.S1 cml_tlatch_63.OUTP cml_tlatch_63.OUTN VSS sg13_lv_nmos ad=56.9f pd=0.74u as=56.9f ps=0.74u w=0.17u l=0.17u
X4757 cml_tlatch_54.xtail.S1 CKA3_P cml_tlatch_54.xmux.xn.S1 VSS sg13_lv_nmos ad=89.3f pd=0.85u as=89.3f ps=0.85u w=0.47u l=0.16u
X4758 cml_tlatch_86.xmux.xp.S1 CKHA3_N cml_tlatch_86.xtail.S1 VSS sg13_lv_nmos ad=89.3f pd=0.85u as=89.3f ps=0.85u w=0.47u l=0.16u
X4759 VSS POLN cml_tlatch_11.xtail.S1 VSS sg13_lv_nmos ad=1.5637p pd=8.61u as=1.5637p ps=8.61u w=8.23u l=0.13u
X4760 cml_tlatch_22.OUTN cml_tlatch_22.OUTP cml_tlatch_22.xmux.xp.S1 VSS sg13_lv_nmos ad=56.9f pd=0.74u as=56.9f ps=0.74u w=0.17u l=0.17u
X4761 cml_tlatch_15.xmux.xp.S1 CKB1_N cml_tlatch_15.xtail.S1 VSS sg13_lv_nmos ad=89.3f pd=0.85u as=89.3f ps=0.85u w=0.47u l=0.16u
X4762 cml_tlatch_79.xmux.xn.S1 stub_bi_49.BOTN stub_bi_63.BOTP VSS sg13_lv_nmos ad=63.19999f pd=0.74u as=63.19999f ps=0.74u w=0.26u l=0.38u
X4763 cml_tlatch_9.xmux.xp.S1 cml_tlatch_9.OUTP cml_tlatch_9.OUTN VSS sg13_lv_nmos ad=56.9f pd=0.74u as=56.9f ps=0.74u w=0.17u l=0.17u
X4764 cml_tlatch_72.xmux.xp.S1 CKA2_N cml_tlatch_72.xtail.S1 VSS sg13_lv_nmos ad=89.3f pd=0.85u as=89.3f ps=0.85u w=0.47u l=0.16u
X4765 cml_tlatch_47.xtail.S1 CKB3_P cml_tlatch_47.xmux.xn.S1 VSS sg13_lv_nmos ad=0.1598p pd=1.62u as=89.3f ps=0.85u w=0.47u l=0.16u
X4766 cml_tlatch_98.OUTP cml_tlatch_98.OUTN cml_tlatch_98.xmux.xp.S1 VSS sg13_lv_nmos ad=56.9f pd=0.74u as=56.9f ps=0.74u w=0.17u l=0.17u
X4767 cml_tlatch_35.OUTP cml_tlatch_35.OUTN cml_tlatch_35.xmux.xp.S1 VSS sg13_lv_nmos ad=56.9f pd=0.74u as=56.9f ps=0.74u w=0.17u l=0.17u
X4768 cml_tlatch_60.xmux.xn.S1 CKB3_N cml_tlatch_60.xtail.S1 VSS sg13_lv_nmos ad=89.3f pd=0.85u as=89.3f ps=0.85u w=0.47u l=0.16u
X4769 cml_tlatch_78.xmux.xp.S1 stub_bi_62.BOTP stub_bi_62.BOTN VSS sg13_lv_nmos ad=56.9f pd=0.74u as=56.9f ps=0.74u w=0.17u l=0.17u
X4770 MOT15_N MOT15_P cml_tlatch_7.xmux.xp.S1 VSS sg13_lv_nmos ad=56.9f pd=0.74u as=56.9f ps=0.74u w=0.17u l=0.17u
X4771 cml_tlatch_34.xmux.xp.S1 stub_bi_31.BOTN stub_bi_31.BOTP VSS sg13_lv_nmos ad=56.9f pd=0.74u as=56.9f ps=0.74u w=0.17u l=0.17u
X4772 cml_tlatch_57.INP cml_tlatch_57.INN cml_tlatch_66.xmux.xp.S1 VSS sg13_lv_nmos ad=56.9f pd=0.74u as=56.9f ps=0.74u w=0.17u l=0.17u
X4773 cml_tlatch_93.xmux.xp.S1 J1_P J1_N VSS sg13_lv_nmos ad=56.9f pd=0.74u as=56.9f ps=0.74u w=0.17u l=0.17u
X4774 cml_tlatch_85.xmux.xp.S1 cml_tlatch_58.INN cml_tlatch_58.INP VSS sg13_lv_nmos ad=56.9f pd=0.74u as=56.9f ps=0.74u w=0.17u l=0.17u
X4775 cml_tlatch_24.xmux.xp.S1 CKHA0_N cml_tlatch_24.xtail.S1 VSS sg13_lv_nmos ad=89.3f pd=0.85u as=89.3f ps=0.85u w=0.47u l=0.16u
X4776 cml_tlatch_6.INN cml_tlatch_6.INP cml_tlatch_94.xmux.xp.S1 VSS sg13_lv_nmos ad=56.9f pd=0.74u as=56.9f ps=0.74u w=0.17u l=0.17u
X4777 cml_tlatch_46.xmux.xp.S1 B3_2_N B3_2_P VSS sg13_lv_nmos ad=56.9f pd=0.74u as=56.9f ps=0.74u w=0.17u l=0.17u
X4778 MOT19_N MOT19_P cml_tlatch_74.xmux.xp.S1 VSS sg13_lv_nmos ad=56.9f pd=0.74u as=56.9f ps=0.74u w=0.17u l=0.17u
X4779 cml_tlatch_51.xmux.xp.S1 MOT22_P MOT22_N VSS sg13_lv_nmos ad=56.9f pd=0.74u as=56.9f ps=0.74u w=0.17u l=0.17u
X4780 cml_tlatch_7.xtail.S1 CKHB1_N cml_tlatch_7.xmux.xp.S1 VSS sg13_lv_nmos ad=89.3f pd=0.85u as=0.1598p ps=1.62u w=0.47u l=0.16u
X4781 cml_drvb_7.xrtail.R1 GB2_N CKHB2_P VSS sg13_lv_nmos ad=0.1463p pd=1.15u as=0.2618p ps=2.22u w=0.77u l=0.21u
X4782 cml_tlatch_85.xmux.xn.S1 CKA3_N cml_tlatch_85.xtail.S1 VSS sg13_lv_nmos ad=89.3f pd=0.85u as=89.3f ps=0.85u w=0.47u l=0.16u
X4783 cml_tlatch_86.xmux.xn.S1 A3_8_N MOT24_P VSS sg13_lv_nmos ad=0.1082p pd=1.34u as=63.19999f ps=0.74u w=0.26u l=0.38u
X4784 cml_tlatch_73.xmux.xn.S1 CKHB2_P cml_tlatch_73.xtail.S1 VSS sg13_lv_nmos ad=89.3f pd=0.85u as=89.3f ps=0.85u w=0.47u l=0.16u
X4785 cml_tlatch_23.xmux.xp.S1 cml_tlatch_39.INP cml_tlatch_39.INN VSS sg13_lv_nmos ad=56.9f pd=0.74u as=56.9f ps=0.74u w=0.17u l=0.17u
X4786 cml_tlatch_23.xmux.xp.S1 cml_tlatch_39.INN cml_tlatch_39.INP VSS sg13_lv_nmos ad=56.9f pd=0.74u as=56.9f ps=0.74u w=0.17u l=0.17u
X4787 cml_tlatch_0.xtail.S1 POLN VSS VSS sg13_lv_nmos ad=1.5637p pd=8.61u as=1.5637p ps=8.61u w=8.23u l=0.13u
X4788 cml_tlatch_5.INP cml_tlatch_5.INN cml_tlatch_14.xmux.xp.S1 VSS sg13_lv_nmos ad=56.9f pd=0.74u as=56.9f ps=0.74u w=0.17u l=0.17u
X4789 cml_tlatch_36.xmux.xp.S1 CKA1_N cml_tlatch_36.xtail.S1 VSS sg13_lv_nmos ad=89.3f pd=0.85u as=89.3f ps=0.85u w=0.47u l=0.16u
X4790 cml_tlatch_94.xmux.xp.S1 cml_tlatch_6.INN cml_tlatch_6.INP VSS sg13_lv_nmos ad=56.9f pd=0.74u as=56.9f ps=0.74u w=0.17u l=0.17u
X4791 MOT11_N MOT11_P cml_tlatch_5.xmux.xp.S1 VSS sg13_lv_nmos ad=56.9f pd=0.74u as=56.9f ps=0.74u w=0.17u l=0.17u
X4792 A3_8_N A3_8_P cml_tlatch_64.xmux.xp.S1 VSS sg13_lv_nmos ad=56.9f pd=0.74u as=56.9f ps=0.74u w=0.17u l=0.17u
X4793 B2_8_N stub_bi_62.BOTN cml_tlatch_77.xmux.xn.S1 VSS sg13_lv_nmos ad=63.19999f pd=0.74u as=63.19999f ps=0.74u w=0.26u l=0.38u
X4794 cml_tlatch_27.OUTN cml_tlatch_27.OUTP cml_tlatch_27.xmux.xp.S1 VSS sg13_lv_nmos ad=56.9f pd=0.74u as=56.9f ps=0.74u w=0.17u l=0.17u
X4795 cml_drv_1.xrtail.R1 ENA_N ENA1_P VSS sg13_lv_nmos ad=56.2f pd=0.74u as=56.2f ps=0.74u w=0.16u l=0.19u
X4796 cml_tlatch_65.OUTP cml_tlatch_65.OUTN cml_tlatch_65.xmux.xp.S1 VSS sg13_lv_nmos ad=56.9f pd=0.74u as=0.1019p ps=1.34u w=0.17u l=0.17u
X4797 cml_tlatch_3.OUTN cml_tlatch_3.OUTP cml_tlatch_3.xmux.xp.S1 VSS sg13_lv_nmos ad=56.9f pd=0.74u as=56.9f ps=0.74u w=0.17u l=0.17u
X4798 cml_tlatch_70.INN cml_tlatch_70.INP cml_tlatch_84.xmux.xp.S1 VSS sg13_lv_nmos ad=56.9f pd=0.74u as=56.9f ps=0.74u w=0.17u l=0.17u
X4799 cml_tlatch_14.xmux.xn.S1 stub_bi_19.BOTP cml_tlatch_5.INP VSS sg13_lv_nmos ad=0.1082p pd=1.34u as=63.19999f ps=0.74u w=0.26u l=0.38u
X4800 cml_tlatch_84.xmux.xn.S1 CKB3_N cml_tlatch_84.xtail.S1 VSS sg13_lv_nmos ad=89.3f pd=0.85u as=89.3f ps=0.85u w=0.47u l=0.16u
X4801 cml_tlatch_57.INN cml_tlatch_67.OUTP cml_tlatch_66.xmux.xn.S1 VSS sg13_lv_nmos ad=63.19999f pd=0.74u as=63.19999f ps=0.74u w=0.26u l=0.38u
X4802 cml_tlatch_4.xmux.xp.S1 MOT9_N MOT9_P VSS sg13_lv_nmos ad=56.9f pd=0.74u as=56.9f ps=0.74u w=0.17u l=0.17u
X4803 cml_tlatch_63.xmux.xp.S1 cml_tlatch_63.OUTP cml_tlatch_63.OUTN VSS sg13_lv_nmos ad=56.9f pd=0.74u as=56.9f ps=0.74u w=0.17u l=0.17u
X4804 cml_tlatch_83.INN cml_tlatch_83.INP cml_tlatch_72.xmux.xp.S1 VSS sg13_lv_nmos ad=56.9f pd=0.74u as=56.9f ps=0.74u w=0.17u l=0.17u
X4805 cml_tlatch_52.OUTP cml_tlatch_52.OUTN cml_tlatch_52.xmux.xp.S1 VSS sg13_lv_nmos ad=56.9f pd=0.74u as=56.9f ps=0.74u w=0.17u l=0.17u
X4806 cml_tlatch_89.xmux.xn.S1 cml_tlatch_89.INN cml_tlatch_89.OUTP VSS sg13_lv_nmos ad=63.19999f pd=0.74u as=63.19999f ps=0.74u w=0.26u l=0.38u
X4807 MOT20_N MOT20_P cml_tlatch_50.xmux.xp.S1 VSS sg13_lv_nmos ad=56.9f pd=0.74u as=56.9f ps=0.74u w=0.17u l=0.17u
X4808 cml_tlatch_58.xmux.xp.S1 MOT28_P MOT28_N VSS sg13_lv_nmos ad=56.9f pd=0.74u as=56.9f ps=0.74u w=0.17u l=0.17u
X4809 cml_tlatch_31.xtail.S1 CKA0_N cml_tlatch_31.xmux.xn.S1 VSS sg13_lv_nmos ad=89.3f pd=0.85u as=89.3f ps=0.85u w=0.47u l=0.16u
X4810 cml_tlatch_70.xtail.S1 CKHB3_P cml_tlatch_70.xmux.xn.S1 VSS sg13_lv_nmos ad=89.3f pd=0.85u as=89.3f ps=0.85u w=0.47u l=0.16u
X4811 cml_tlatch_16.OUTP cml_tlatch_16.OUTN cml_tlatch_16.xmux.xp.S1 VSS sg13_lv_nmos ad=56.9f pd=0.74u as=56.9f ps=0.74u w=0.17u l=0.17u
X4812 cml_tlatch_89.xmux.xn.S1 cml_tlatch_89.INN cml_tlatch_89.OUTP VSS sg13_lv_nmos ad=63.19999f pd=0.74u as=63.19999f ps=0.74u w=0.26u l=0.38u
X4813 cml_tlatch_55.xmux.xp.S1 cml_tlatch_89.INP cml_tlatch_89.INN VSS sg13_lv_nmos ad=0.1019p pd=1.34u as=56.9f ps=0.74u w=0.17u l=0.17u
X4814 cml_tlatch_78.xtail.S1 CKB2_N cml_tlatch_78.xmux.xp.S1 VSS sg13_lv_nmos ad=89.3f pd=0.85u as=0.1598p ps=1.62u w=0.47u l=0.16u
X4815 cml_tlatch_18.xmux.xp.S1 MOT3_N MOT3_P VSS sg13_lv_nmos ad=56.9f pd=0.74u as=56.9f ps=0.74u w=0.17u l=0.17u
X4816 B3_8_N B3_8_P cml_tlatch_60.xmux.xp.S1 VSS sg13_lv_nmos ad=56.9f pd=0.74u as=0.1019p ps=1.34u w=0.17u l=0.17u
X4817 cml_tlatch_44.xmux.xn.S1 stub_bi_32.BOTP B2_2_P VSS sg13_lv_nmos ad=0.1082p pd=1.34u as=63.19999f ps=0.74u w=0.26u l=0.38u
X4818 VSS hs_to_clk_8.sg13_lv_nmos_2HGZLP_0.G VSS VSS sg13_lv_nmos ad=2.071p pd=11.28u as=0 ps=0 w=10.9u l=1.38u
X4819 CLK_W_N CLK_W_P cml_tlatch_91.xmux.xp.S1 VSS sg13_lv_nmos ad=56.9f pd=0.74u as=56.9f ps=0.74u w=0.17u l=0.17u
X4820 cml_tlatch_46.xmux.xn.S1 CKB3_N cml_tlatch_46.xtail.S1 VSS sg13_lv_nmos ad=89.3f pd=0.85u as=89.3f ps=0.85u w=0.47u l=0.16u
X4821 cml_tlatch_48.xmux.xp.S1 stub_bi_32.BOTP stub_bi_32.BOTN VSS sg13_lv_nmos ad=56.9f pd=0.74u as=56.9f ps=0.74u w=0.17u l=0.17u
X4822 CKHB1_N GB1_P cml_drvb_0.xrtail.R1 VSS sg13_lv_nmos ad=0.2618p pd=2.22u as=0.1463p ps=1.15u w=0.77u l=0.21u
X4823 CKHA3_P VDD VSS rppd l=13.09u w=1u
X4824 cml_tlatch_29.xmux.xp.S1 cml_tlatch_29.OUTN cml_tlatch_29.OUTP VSS sg13_lv_nmos ad=56.9f pd=0.74u as=56.9f ps=0.74u w=0.17u l=0.17u
X4825 ENB1_P ENB_N cml_drv_0.xrtail.R1 VSS sg13_lv_nmos ad=56.2f pd=0.74u as=56.2f ps=0.74u w=0.16u l=0.19u
X4826 cml_tlatch_6.xtail.S1 POLN VSS VSS sg13_lv_nmos ad=1.5637p pd=8.61u as=1.5637p ps=8.61u w=8.23u l=0.13u
X4827 cml_tlatch_83.INP cml_tlatch_89.OUTN cml_tlatch_72.xmux.xn.S1 VSS sg13_lv_nmos ad=63.19999f pd=0.74u as=63.19999f ps=0.74u w=0.26u l=0.38u
X4828 cml_tlatch_56.INN cml_tlatch_56.INP cml_tlatch_42.xmux.xp.S1 VSS sg13_lv_nmos ad=56.9f pd=0.74u as=56.9f ps=0.74u w=0.17u l=0.17u
X4829 cml_tlatch_11.OUTP cml_tlatch_11.OUTN cml_tlatch_11.xmux.xp.S1 VSS sg13_lv_nmos ad=56.9f pd=0.74u as=56.9f ps=0.74u w=0.17u l=0.17u
X4830 VDD cml_tlatch_67.OUTN VSS rppd l=5.17u w=1u
X4831 cml_tlatch_90.xmux.xp.S1 J4_N J4_P VSS sg13_lv_nmos ad=56.9f pd=0.74u as=56.9f ps=0.74u w=0.17u l=0.17u
X4832 cml_tlatch_44.xmux.xp.S1 B2_2_P B2_2_N VSS sg13_lv_nmos ad=56.9f pd=0.74u as=56.9f ps=0.74u w=0.17u l=0.17u
X4833 cml_tlatch_98.xmux.xp.S1 CKB0_P cml_tlatch_98.xtail.S1 VSS sg13_lv_nmos ad=89.3f pd=0.85u as=89.3f ps=0.85u w=0.47u l=0.16u
X4834 cml_tlatch_31.xmux.xp.S1 A0_2_N A0_2_P VSS sg13_lv_nmos ad=56.9f pd=0.74u as=56.9f ps=0.74u w=0.17u l=0.17u
X4835 VDD GA0_P VSS rppd l=7.42u w=1u
X4836 cml_tlatch_64.xmux.xp.S1 CKA3_P cml_tlatch_64.xtail.S1 VSS sg13_lv_nmos ad=89.3f pd=0.85u as=89.3f ps=0.85u w=0.47u l=0.16u
X4837 VSS POLN cml_tlatch_87.xtail.S1 VSS sg13_lv_nmos ad=2.7982p pd=17.14u as=1.5637p ps=8.61u w=8.23u l=0.13u
X4838 cml_tlatch_11.OUTN cml_tlatch_16.OUTP cml_tlatch_11.xmux.xn.S1 VSS sg13_lv_nmos ad=63.19999f pd=0.74u as=63.19999f ps=0.74u w=0.26u l=0.38u
X4839 cml_tlatch_30.xtail.S1 CKA0_N cml_tlatch_30.xmux.xp.S1 VSS sg13_lv_nmos ad=89.3f pd=0.85u as=89.3f ps=0.85u w=0.47u l=0.16u
X4840 cml_tlatch_17.xmux.xp.S1 MOT1_P MOT1_N VSS sg13_lv_nmos ad=56.9f pd=0.74u as=56.9f ps=0.74u w=0.17u l=0.17u
X4841 MOT6_N A0_2_P cml_tlatch_26.xmux.xn.S1 VSS sg13_lv_nmos ad=63.19999f pd=0.74u as=63.19999f ps=0.74u w=0.26u l=0.38u
X4842 cml_tlatch_45.OUTP cml_tlatch_45.OUTN cml_tlatch_45.xmux.xp.S1 VSS sg13_lv_nmos ad=56.9f pd=0.74u as=0.1019p ps=1.34u w=0.17u l=0.17u
X4843 B0_8_P B0_8_N cml_tlatch_10.xmux.xp.S1 VSS sg13_lv_nmos ad=56.9f pd=0.74u as=56.9f ps=0.74u w=0.17u l=0.17u
X4844 VSS hs_to_clk_8.sg13_lv_nmos_2HGZLP_0.G VSS VSS sg13_lv_nmos ad=2.071p pd=11.28u as=0 ps=0 w=10.9u l=1.38u
X4845 cml_tlatch_61.xtail.S1 CKB3_N cml_tlatch_61.xmux.xp.S1 VSS sg13_lv_nmos ad=89.3f pd=0.85u as=89.3f ps=0.85u w=0.47u l=0.16u
X4846 cml_tlatch_22.xmux.xp.S1 CKA1_N cml_tlatch_22.xtail.S1 VSS sg13_lv_nmos ad=0.1598p pd=1.62u as=89.3f ps=0.85u w=0.47u l=0.16u
X4847 cml_tlatch_61.OUTN cml_tlatch_61.OUTP cml_tlatch_61.xmux.xp.S1 VSS sg13_lv_nmos ad=56.9f pd=0.74u as=56.9f ps=0.74u w=0.17u l=0.17u
X4848 cml_tlatch_10.xmux.xp.S1 CKB0_P cml_tlatch_10.xtail.S1 VSS sg13_lv_nmos ad=89.3f pd=0.85u as=89.3f ps=0.85u w=0.47u l=0.16u
X4849 cml_tlatch_54.OUTP cml_tlatch_54.OUTN cml_tlatch_54.xmux.xp.S1 VSS sg13_lv_nmos ad=56.9f pd=0.74u as=0.1019p ps=1.34u w=0.17u l=0.17u
X4850 cml_tlatch_64.xtail.S1 POLN VSS VSS sg13_lv_nmos ad=1.5637p pd=8.61u as=2.7982p ps=17.14u w=8.23u l=0.13u
X4851 cml_tlatch_91.xmux.xp.S1 CLK_W_N CLK_W_P VSS sg13_lv_nmos ad=56.9f pd=0.74u as=56.9f ps=0.74u w=0.17u l=0.17u
X4852 cml_tlatch_57.INN cml_tlatch_57.INP cml_tlatch_66.xmux.xp.S1 VSS sg13_lv_nmos ad=56.9f pd=0.74u as=56.9f ps=0.74u w=0.17u l=0.17u
X4853 cml_tlatch_38.xtail.S1 CKA1_N cml_tlatch_38.xmux.xp.S1 VSS sg13_lv_nmos ad=89.3f pd=0.85u as=89.3f ps=0.85u w=0.47u l=0.16u
X4854 cml_tlatch_62.xmux.xp.S1 cml_tlatch_69.INN cml_tlatch_69.INP VSS sg13_lv_nmos ad=56.9f pd=0.74u as=56.9f ps=0.74u w=0.17u l=0.17u
X4855 A2_2_P A2_2_N cml_tlatch_56.xmux.xp.S1 VSS sg13_lv_nmos ad=56.9f pd=0.74u as=56.9f ps=0.74u w=0.17u l=0.17u
X4856 cml_tlatch_40.xtail.S1 CKHA1_P cml_tlatch_40.xmux.xn.S1 VSS sg13_lv_nmos ad=89.3f pd=0.85u as=0.1598p ps=1.62u w=0.47u l=0.16u
X4857 cml_tlatch_90.xmux.xp.S1 J4_N J4_P VSS sg13_lv_nmos ad=0.1019p pd=1.34u as=56.9f ps=0.74u w=0.17u l=0.17u
X4858 cml_tlatch_45.xmux.xn.S1 CKB3_P cml_tlatch_45.xtail.S1 VSS sg13_lv_nmos ad=89.3f pd=0.85u as=89.3f ps=0.85u w=0.47u l=0.16u
X4859 cml_tlatch_60.xmux.xp.S1 CKB3_P cml_tlatch_60.xtail.S1 VSS sg13_lv_nmos ad=89.3f pd=0.85u as=89.3f ps=0.85u w=0.47u l=0.16u
X4860 stub_bi_49.BOTP stub_bi_49.BOTN cml_tlatch_80.xmux.xp.S1 VSS sg13_lv_nmos ad=56.9f pd=0.74u as=0.1019p ps=1.34u w=0.17u l=0.17u
X4861 MOT13_N cml_tlatch_6.INP cml_tlatch_6.xmux.xn.S1 VSS sg13_lv_nmos ad=63.19999f pd=0.74u as=63.19999f ps=0.74u w=0.26u l=0.38u
X4862 J1_P J1_N cml_tlatch_93.xmux.xp.S1 VSS sg13_lv_nmos ad=56.9f pd=0.74u as=56.9f ps=0.74u w=0.17u l=0.17u
X4863 cml_tlatch_91.xmux.xn.S1 CKJ_P cml_tlatch_91.xtail.S1 VSS sg13_lv_nmos ad=89.3f pd=0.85u as=89.3f ps=0.85u w=0.47u l=0.16u
X4864 MOT18_P cml_tlatch_83.OUTN cml_tlatch_49.xmux.xn.S1 VSS sg13_lv_nmos ad=63.19999f pd=0.74u as=63.19999f ps=0.74u w=0.26u l=0.38u
X4865 A0_2_N A0_2_P cml_tlatch_31.xmux.xp.S1 VSS sg13_lv_nmos ad=56.9f pd=0.74u as=0.1019p ps=1.34u w=0.17u l=0.17u
X4866 cml_tlatch_83.xmux.xp.S1 CKA2_P cml_tlatch_83.xtail.S1 VSS sg13_lv_nmos ad=89.3f pd=0.85u as=89.3f ps=0.85u w=0.47u l=0.16u
X4867 cml_tlatch_73.xmux.xp.S1 MOT17_P MOT17_N VSS sg13_lv_nmos ad=56.9f pd=0.74u as=56.9f ps=0.74u w=0.17u l=0.17u
X4868 cml_tlatch_5.INN cml_tlatch_5.INP cml_tlatch_14.xmux.xp.S1 VSS sg13_lv_nmos ad=56.9f pd=0.74u as=56.9f ps=0.74u w=0.17u l=0.17u
X4869 cml_tlatch_5.INP cml_tlatch_5.INN cml_tlatch_14.xmux.xp.S1 VSS sg13_lv_nmos ad=56.9f pd=0.74u as=56.9f ps=0.74u w=0.17u l=0.17u
X4870 cml_tlatch_59.xtail.S1 CKHA3_N cml_tlatch_59.xmux.xp.S1 VSS sg13_lv_nmos ad=89.3f pd=0.85u as=0.1598p ps=1.62u w=0.47u l=0.16u
X4871 VDD cml_tlatch_89.INN VSS rppd l=5.17u w=1u
X4872 cml_tlatch_29.xtail.S1 CKB0_N cml_tlatch_29.xmux.xp.S1 VSS sg13_lv_nmos ad=89.3f pd=0.85u as=89.3f ps=0.85u w=0.47u l=0.16u
X4873 cml_tlatch_31.xmux.xp.S1 CKA0_P cml_tlatch_31.xtail.S1 VSS sg13_lv_nmos ad=89.3f pd=0.85u as=89.3f ps=0.85u w=0.47u l=0.16u
X4874 MOT13_N cml_tlatch_6.INP cml_tlatch_6.xmux.xn.S1 VSS sg13_lv_nmos ad=63.19999f pd=0.74u as=63.19999f ps=0.74u w=0.26u l=0.38u
X4875 VDD cml_tlatch_22.OUTP VSS rppd l=5.17u w=1u
X4876 VSS hs_to_clk_1.sg13_lv_nmos_2HGZLP_0.G VSS VSS sg13_lv_nmos ad=2.071p pd=11.28u as=0 ps=0 w=10.9u l=1.38u
X4877 MOT11_N MOT11_P cml_tlatch_5.xmux.xp.S1 VSS sg13_lv_nmos ad=56.9f pd=0.74u as=56.9f ps=0.74u w=0.17u l=0.17u
X4878 cml_gate2_9.xrtail.R1 NM1_P cml_gate2_9.sg13_lv_nmos_FTPY57_0.D0 VSS sg13_lv_nmos ad=0.1007p pd=0.91u as=0.1007p ps=0.91u w=0.53u l=0.13u
X4879 B3_2_N cml_tlatch_47.OUTP cml_tlatch_46.xmux.xn.S1 VSS sg13_lv_nmos ad=63.19999f pd=0.74u as=63.19999f ps=0.74u w=0.26u l=0.38u
X4880 MOT5_P MOT5_N cml_tlatch_19.xmux.xp.S1 VSS sg13_lv_nmos ad=56.9f pd=0.74u as=56.9f ps=0.74u w=0.17u l=0.17u
X4881 cml_tlatch_13.xmux.xp.S1 stub_bi_17.BOTN stub_bi_17.BOTP VSS sg13_lv_nmos ad=0.1019p pd=1.34u as=56.9f ps=0.74u w=0.17u l=0.17u
X4882 cml_tlatch_63.OUTP cml_tlatch_63.OUTN cml_tlatch_63.xmux.xp.S1 VSS sg13_lv_nmos ad=56.9f pd=0.74u as=56.9f ps=0.74u w=0.17u l=0.17u
X4883 cml_tlatch_72.xmux.xp.S1 cml_tlatch_83.INN cml_tlatch_83.INP VSS sg13_lv_nmos ad=56.9f pd=0.74u as=56.9f ps=0.74u w=0.17u l=0.17u
X4884 MOT19_P MOT19_N cml_tlatch_74.xmux.xp.S1 VSS sg13_lv_nmos ad=56.9f pd=0.74u as=0.1019p ps=1.34u w=0.17u l=0.17u
X4885 cml_tlatch_89.xmux.xp.S1 cml_tlatch_89.OUTP cml_tlatch_89.OUTN VSS sg13_lv_nmos ad=56.9f pd=0.74u as=56.9f ps=0.74u w=0.17u l=0.17u
X4886 cml_tlatch_52.xtail.S1 CKA3_N cml_tlatch_52.xmux.xp.S1 VSS sg13_lv_nmos ad=89.3f pd=0.85u as=89.3f ps=0.85u w=0.47u l=0.16u
X4887 cml_gate2_4.sg13_lv_nmos_FTPY57_0.D0 ENA1_N GA2_P VSS sg13_lv_nmos ad=0.1007p pd=0.91u as=0.1007p ps=0.91u w=0.53u l=0.13u
X4888 cml_tlatch_79.xmux.xp.S1 CKB2_P cml_tlatch_79.xtail.S1 VSS sg13_lv_nmos ad=89.3f pd=0.85u as=89.3f ps=0.85u w=0.47u l=0.16u
X4889 cml_tlatch_95.xtail.S1 CKA1_P cml_tlatch_95.xmux.xp.S1 VSS sg13_lv_nmos ad=89.3f pd=0.85u as=89.3f ps=0.85u w=0.47u l=0.16u
X4890 ENA0_N ENA_P cml_drv_3.xrtail.R1 VSS sg13_lv_nmos ad=56.2f pd=0.74u as=56.2f ps=0.74u w=0.16u l=0.19u
X4891 cml_tlatch_66.xmux.xp.S1 CKA3_P cml_tlatch_66.xtail.S1 VSS sg13_lv_nmos ad=89.3f pd=0.85u as=89.3f ps=0.85u w=0.47u l=0.16u
X4892 stub_bi_17.BOTN stub_bi_17.BOTP cml_tlatch_13.xmux.xp.S1 VSS sg13_lv_nmos ad=56.9f pd=0.74u as=56.9f ps=0.74u w=0.17u l=0.17u
X4893 cml_tlatch_54.xmux.xn.S1 D3_N cml_tlatch_54.OUTP VSS sg13_lv_nmos ad=63.19999f pd=0.74u as=63.19999f ps=0.74u w=0.26u l=0.38u
X4894 cml_tlatch_8.xtail.S1 CKA0_N cml_tlatch_8.xmux.xn.S1 VSS sg13_lv_nmos ad=89.3f pd=0.85u as=89.3f ps=0.85u w=0.47u l=0.16u
X4895 CLK_W_N CLK_W_P cml_tlatch_91.xmux.xp.S1 VSS sg13_lv_nmos ad=56.9f pd=0.74u as=56.9f ps=0.74u w=0.17u l=0.17u
X4896 A0_8_P cml_tlatch_3.OUTN cml_tlatch_2.xmux.xn.S1 VSS sg13_lv_nmos ad=63.19999f pd=0.74u as=63.19999f ps=0.74u w=0.26u l=0.38u
X4897 cml_tlatch_58.xmux.xp.S1 MOT28_P MOT28_N VSS sg13_lv_nmos ad=56.9f pd=0.74u as=56.9f ps=0.74u w=0.17u l=0.17u
X4898 cml_tlatch_24.xtail.S1 CKHA0_N cml_tlatch_24.xmux.xp.S1 VSS sg13_lv_nmos ad=89.3f pd=0.85u as=89.3f ps=0.85u w=0.47u l=0.16u
X4899 cml_tlatch_24.xmux.xp.S1 MOT2_N MOT2_P VSS sg13_lv_nmos ad=56.9f pd=0.74u as=56.9f ps=0.74u w=0.17u l=0.17u
X4900 ENB0_N ENB_P cml_drv_2.xrtail.R1 VSS sg13_lv_nmos ad=56.2f pd=0.74u as=56.2f ps=0.74u w=0.16u l=0.19u
X4901 cml_gate2_5.sg13_lv_nmos_FTPY57_0.D0 CKB3_P cml_gate2_5.xrtail.R1 VSS sg13_lv_nmos ad=0.1007p pd=0.91u as=0.1007p ps=0.91u w=0.53u l=0.13u
X4902 MOT12_N MOT12_P cml_tlatch_40.xmux.xp.S1 VSS sg13_lv_nmos ad=56.9f pd=0.74u as=56.9f ps=0.74u w=0.17u l=0.17u
X4903 A3_2_N A3_2_P cml_tlatch_53.xmux.xp.S1 VSS sg13_lv_nmos ad=56.9f pd=0.74u as=56.9f ps=0.74u w=0.17u l=0.17u
X4904 J2_N J2_P cml_tlatch_92.xmux.xp.S1 VSS sg13_lv_nmos ad=56.9f pd=0.74u as=56.9f ps=0.74u w=0.17u l=0.17u
X4905 cml_tlatch_65.OUTN cml_tlatch_57.INP cml_tlatch_65.xmux.xn.S1 VSS sg13_lv_nmos ad=63.19999f pd=0.74u as=0.1082p ps=1.34u w=0.26u l=0.38u
X4906 cml_tlatch_16.OUTN cml_tlatch_16.OUTP cml_tlatch_16.xmux.xp.S1 VSS sg13_lv_nmos ad=56.9f pd=0.74u as=56.9f ps=0.74u w=0.17u l=0.17u
X4907 cml_tlatch_51.xmux.xn.S1 A2_2_N MOT22_P VSS sg13_lv_nmos ad=63.19999f pd=0.74u as=63.19999f ps=0.74u w=0.26u l=0.38u
X4908 cml_tlatch_81.xmux.xp.S1 A2_8_P A2_8_N VSS sg13_lv_nmos ad=56.9f pd=0.74u as=56.9f ps=0.74u w=0.17u l=0.17u
X4909 cml_tlatch_69.xmux.xn.S1 cml_tlatch_69.INN MOT27_P VSS sg13_lv_nmos ad=63.19999f pd=0.74u as=63.19999f ps=0.74u w=0.26u l=0.38u
X4910 GB1_P CKA1_N cml_gate2_0.xrtail.R1 VSS sg13_lv_nmos ad=0.1007p pd=0.91u as=0.1007p ps=0.91u w=0.53u l=0.13u
X4911 cml_tlatch_86.xmux.xp.S1 CKHA3_N cml_tlatch_86.xtail.S1 VSS sg13_lv_nmos ad=89.3f pd=0.85u as=89.3f ps=0.85u w=0.47u l=0.16u
X4912 B2_2_P B2_2_N cml_tlatch_44.xmux.xp.S1 VSS sg13_lv_nmos ad=56.9f pd=0.74u as=56.9f ps=0.74u w=0.17u l=0.17u
X4913 cml_tlatch_1.xmux.xp.S1 cml_tlatch_1.OUTP cml_tlatch_1.OUTN VSS sg13_lv_nmos ad=0.1019p pd=1.34u as=56.9f ps=0.74u w=0.17u l=0.17u
X4914 MOT16_N A2_8_P cml_tlatch_87.xmux.xn.S1 VSS sg13_lv_nmos ad=63.19999f pd=0.74u as=63.19999f ps=0.74u w=0.26u l=0.38u
X4915 cml_tlatch_56.INN cml_tlatch_56.INP cml_tlatch_42.xmux.xp.S1 VSS sg13_lv_nmos ad=56.9f pd=0.74u as=56.9f ps=0.74u w=0.17u l=0.17u
X4916 cml_tlatch_7.xtail.S1 CKHB1_P cml_tlatch_7.xmux.xn.S1 VSS sg13_lv_nmos ad=89.3f pd=0.85u as=89.3f ps=0.85u w=0.47u l=0.16u
X4917 MOT19_P MOT19_N cml_tlatch_74.xmux.xp.S1 VSS sg13_lv_nmos ad=56.9f pd=0.74u as=56.9f ps=0.74u w=0.17u l=0.17u
X4918 cml_tlatch_48.xmux.xp.S1 stub_bi_32.BOTN stub_bi_32.BOTP VSS sg13_lv_nmos ad=56.9f pd=0.74u as=56.9f ps=0.74u w=0.17u l=0.17u
X4919 cml_tlatch_12.xtail.S1 CKB1_P cml_tlatch_12.xmux.xp.S1 VSS sg13_lv_nmos ad=89.3f pd=0.85u as=89.3f ps=0.85u w=0.47u l=0.16u
X4920 cml_tlatch_56.xtail.S1 CKA2_P cml_tlatch_56.xmux.xp.S1 VSS sg13_lv_nmos ad=89.3f pd=0.85u as=89.3f ps=0.85u w=0.47u l=0.16u
X4921 MOT1_P B0_8_N cml_tlatch_17.xmux.xn.S1 VSS sg13_lv_nmos ad=63.19999f pd=0.74u as=0.1082p ps=1.34u w=0.26u l=0.38u
X4922 cml_tlatch_49.xtail.S1 CKHA2_N cml_tlatch_49.xmux.xp.S1 VSS sg13_lv_nmos ad=89.3f pd=0.85u as=89.3f ps=0.85u w=0.47u l=0.16u
X4923 cml_tlatch_17.xmux.xn.S1 B0_8_P MOT1_N VSS sg13_lv_nmos ad=63.19999f pd=0.74u as=63.19999f ps=0.74u w=0.26u l=0.38u
X4924 cml_tlatch_55.xmux.xp.S1 cml_tlatch_89.INN cml_tlatch_89.INP VSS sg13_lv_nmos ad=56.9f pd=0.74u as=56.9f ps=0.74u w=0.17u l=0.17u
X4925 VSS POLN cml_tlatch_96.xtail.S1 VSS sg13_lv_nmos ad=1.5637p pd=8.61u as=1.5637p ps=8.61u w=8.23u l=0.13u
X4926 VDD MOT7_N VSS rppd l=5.17u w=1u
X4927 MOT13_N MOT13_P cml_tlatch_6.xmux.xp.S1 VSS sg13_lv_nmos ad=56.9f pd=0.74u as=56.9f ps=0.74u w=0.17u l=0.17u
X4928 cml_tlatch_75.xmux.xp.S1 MOT21_N MOT21_P VSS sg13_lv_nmos ad=56.9f pd=0.74u as=56.9f ps=0.74u w=0.17u l=0.17u
X4929 MOT29_P MOT29_N cml_tlatch_70.xmux.xp.S1 VSS sg13_lv_nmos ad=56.9f pd=0.74u as=56.9f ps=0.74u w=0.17u l=0.17u
X4930 cml_tlatch_83.xmux.xp.S1 cml_tlatch_83.OUTN cml_tlatch_83.OUTP VSS sg13_lv_nmos ad=56.9f pd=0.74u as=56.9f ps=0.74u w=0.17u l=0.17u
X4931 A1_8_N cml_tlatch_22.OUTP cml_tlatch_21.xmux.xn.S1 VSS sg13_lv_nmos ad=0.1082p pd=1.34u as=63.19999f ps=0.74u w=0.26u l=0.38u
X4932 cml_tlatch_60.xmux.xp.S1 B3_8_N B3_8_P VSS sg13_lv_nmos ad=56.9f pd=0.74u as=56.9f ps=0.74u w=0.17u l=0.17u
X4933 cml_tlatch_89.OUTP cml_tlatch_89.OUTN cml_tlatch_89.xmux.xp.S1 VSS sg13_lv_nmos ad=56.9f pd=0.74u as=56.9f ps=0.74u w=0.17u l=0.17u
X4934 cml_tlatch_91.xmux.xp.S1 CLK_W_N CLK_W_P VSS sg13_lv_nmos ad=56.9f pd=0.74u as=56.9f ps=0.74u w=0.17u l=0.17u
X4935 cml_tlatch_44.xtail.S1 CKB2_P cml_tlatch_44.xmux.xp.S1 VSS sg13_lv_nmos ad=89.3f pd=0.85u as=89.3f ps=0.85u w=0.47u l=0.16u
X4936 cml_tlatch_95.xtail.S1 CKA1_P cml_tlatch_95.xmux.xp.S1 VSS sg13_lv_nmos ad=89.3f pd=0.85u as=89.3f ps=0.85u w=0.47u l=0.16u
X4937 cml_tlatch_6.xmux.xp.S1 MOT13_N MOT13_P VSS sg13_lv_nmos ad=56.9f pd=0.74u as=56.9f ps=0.74u w=0.17u l=0.17u
X4938 cml_tlatch_95.INN cml_tlatch_95.INP cml_tlatch_36.xmux.xp.S1 VSS sg13_lv_nmos ad=56.9f pd=0.74u as=56.9f ps=0.74u w=0.17u l=0.17u
X4939 cml_tlatch_53.xtail.S1 CKA3_P cml_tlatch_53.xmux.xp.S1 VSS sg13_lv_nmos ad=89.3f pd=0.85u as=89.3f ps=0.85u w=0.47u l=0.16u
X4940 hs_to_clk_8.sg13_lv_nmos_2HGZLP_0.G CKJ_P VSS rppd l=4.25u w=1u
X4941 cml_tlatch_76.xmux.xp.S1 MOT23_P MOT23_N VSS sg13_lv_nmos ad=56.9f pd=0.74u as=56.9f ps=0.74u w=0.17u l=0.17u
X4942 cml_tlatch_80.xmux.xp.S1 CKB2_N cml_tlatch_80.xtail.S1 VSS sg13_lv_nmos ad=89.3f pd=0.85u as=89.3f ps=0.85u w=0.47u l=0.16u
X4943 cml_tlatch_21.xmux.xn.S1 CKA1_N cml_tlatch_21.xtail.S1 VSS sg13_lv_nmos ad=89.3f pd=0.85u as=0.1598p ps=1.62u w=0.47u l=0.16u
X4944 cml_tlatch_32.xmux.xp.S1 stub_bi_29.BOTN stub_bi_29.BOTP VSS sg13_lv_nmos ad=56.9f pd=0.74u as=56.9f ps=0.74u w=0.17u l=0.17u
X4945 stub_bi_31.BOTN stub_bi_31.BOTP cml_tlatch_34.xmux.xp.S1 VSS sg13_lv_nmos ad=56.9f pd=0.74u as=56.9f ps=0.74u w=0.17u l=0.17u
X4946 cml_tlatch_4.xmux.xn.S1 B1_8_N MOT9_P VSS sg13_lv_nmos ad=0.1082p pd=1.34u as=63.19999f ps=0.74u w=0.26u l=0.38u
X4947 cml_tlatch_40.xtail.S1 CKHA1_N cml_tlatch_40.xmux.xp.S1 VSS sg13_lv_nmos ad=89.3f pd=0.85u as=89.3f ps=0.85u w=0.47u l=0.16u
X4948 cml_tlatch_9.OUTP cml_tlatch_9.OUTN cml_tlatch_9.xmux.xp.S1 VSS sg13_lv_nmos ad=56.9f pd=0.74u as=56.9f ps=0.74u w=0.17u l=0.17u
X4949 MOT18_P MOT18_N cml_tlatch_49.xmux.xp.S1 VSS sg13_lv_nmos ad=56.9f pd=0.74u as=0.1019p ps=1.34u w=0.17u l=0.17u
X4950 cml_tlatch_9.xtail.S1 CKA0_N cml_tlatch_9.xmux.xp.S1 VSS sg13_lv_nmos ad=89.3f pd=0.85u as=89.3f ps=0.85u w=0.47u l=0.16u
X4951 cml_tlatch_18.xtail.S1 CKHB0_P cml_tlatch_18.xmux.xn.S1 VSS sg13_lv_nmos ad=89.3f pd=0.85u as=89.3f ps=0.85u w=0.47u l=0.16u
X4952 cml_tlatch_41.xmux.xp.S1 MOT14_N MOT14_P VSS sg13_lv_nmos ad=56.9f pd=0.74u as=56.9f ps=0.74u w=0.17u l=0.17u
X4953 MOT25_N MOT25_P cml_tlatch_68.xmux.xp.S1 VSS sg13_lv_nmos ad=56.9f pd=0.74u as=56.9f ps=0.74u w=0.17u l=0.17u
X4954 cml_tlatch_95.xmux.xn.S1 cml_tlatch_95.INP cml_tlatch_40.INN VSS sg13_lv_nmos ad=63.19999f pd=0.74u as=63.19999f ps=0.74u w=0.26u l=0.38u
X4955 MOT29_N MOT29_P cml_tlatch_70.xmux.xp.S1 VSS sg13_lv_nmos ad=56.9f pd=0.74u as=56.9f ps=0.74u w=0.17u l=0.17u
X4956 cml_tlatch_99.OUTN cml_tlatch_99.OUTP cml_tlatch_99.xmux.xp.S1 VSS sg13_lv_nmos ad=56.9f pd=0.74u as=56.9f ps=0.74u w=0.17u l=0.17u
X4957 cml_tlatch_82.xmux.xp.S1 cml_tlatch_82.OUTN cml_tlatch_82.OUTP VSS sg13_lv_nmos ad=56.9f pd=0.74u as=56.9f ps=0.74u w=0.17u l=0.17u
X4958 cml_tlatch_9.OUTP cml_tlatch_99.OUTN cml_tlatch_9.xmux.xn.S1 VSS sg13_lv_nmos ad=63.19999f pd=0.74u as=63.19999f ps=0.74u w=0.26u l=0.38u
X4959 cml_tlatch_7.xmux.xp.S1 MOT15_P MOT15_N VSS sg13_lv_nmos ad=56.9f pd=0.74u as=56.9f ps=0.74u w=0.17u l=0.17u
X4960 cml_gate2_8.xrtail.R1 NS1_N ENB_P VSS sg13_lv_nmos ad=0.1007p pd=0.91u as=0.1007p ps=0.91u w=0.53u l=0.13u
X4961 cml_tlatch_76.xtail.S1 CKHB2_P cml_tlatch_76.xmux.xn.S1 VSS sg13_lv_nmos ad=89.3f pd=0.85u as=89.3f ps=0.85u w=0.47u l=0.16u
X4962 cml_tlatch_72.xmux.xp.S1 cml_tlatch_83.INN cml_tlatch_83.INP VSS sg13_lv_nmos ad=56.9f pd=0.74u as=56.9f ps=0.74u w=0.17u l=0.17u
X4963 hs_to_clk_4.sg13_lv_nmos_2HGZLP_0.G CKA2_P VSS rppd l=4.25u w=1u
X4964 cml_tlatch_93.xmux.xn.S1 J4_P J1_P VSS sg13_lv_nmos ad=63.19999f pd=0.74u as=63.19999f ps=0.74u w=0.26u l=0.38u
X4965 cml_drvb_8.xrtail.R1 J4_P NS1_P VSS sg13_lv_nmos ad=0.1463p pd=1.15u as=0.2618p ps=2.22u w=0.77u l=0.21u
X4966 stub_bi_55.BOTP stub_bi_55.BOTN cml_tlatch_88.xmux.xp.S1 VSS sg13_lv_nmos ad=56.9f pd=0.74u as=56.9f ps=0.74u w=0.17u l=0.17u
X4967 cml_tlatch_78.xtail.S1 CKB2_P cml_tlatch_78.xmux.xn.S1 VSS sg13_lv_nmos ad=89.3f pd=0.85u as=89.3f ps=0.85u w=0.47u l=0.16u
X4968 cml_tlatch_39.xtail.S1 CKHA1_N cml_tlatch_39.xmux.xp.S1 VSS sg13_lv_nmos ad=89.3f pd=0.85u as=89.3f ps=0.85u w=0.47u l=0.16u
X4969 cml_tlatch_30.xmux.xn.S1 A0_2_N cml_tlatch_30.OUTP VSS sg13_lv_nmos ad=63.19999f pd=0.74u as=63.19999f ps=0.74u w=0.26u l=0.38u
X4970 VSS hs_to_clk_6.sg13_lv_nmos_2HGZLP_0.G VSS VSS sg13_lv_nmos ad=2.071p pd=11.28u as=0 ps=0 w=10.9u l=1.38u
X4971 cml_tlatch_59.xmux.xp.S1 MOT30_N MOT30_P VSS sg13_lv_nmos ad=56.9f pd=0.74u as=56.9f ps=0.74u w=0.17u l=0.17u
X4972 cml_tlatch_45.xtail.S1 CKB3_P cml_tlatch_45.xmux.xn.S1 VSS sg13_lv_nmos ad=89.3f pd=0.85u as=89.3f ps=0.85u w=0.47u l=0.16u
X4973 cml_tlatch_23.xtail.S1 CKA1_N cml_tlatch_23.xmux.xn.S1 VSS sg13_lv_nmos ad=89.3f pd=0.85u as=89.3f ps=0.85u w=0.47u l=0.16u
X4974 cml_tlatch_91.xtail.S1 CKJ_P cml_tlatch_91.xmux.xn.S1 VSS sg13_lv_nmos ad=89.3f pd=0.85u as=89.3f ps=0.85u w=0.47u l=0.16u
X4975 cml_gate2_1.sg13_lv_nmos_FTPY57_0.D0 ENB1_N GB0_P VSS sg13_lv_nmos ad=0.1802p pd=1.74u as=0.1007p ps=0.91u w=0.53u l=0.13u
X4976 A3_2_N A3_2_P cml_tlatch_53.xmux.xp.S1 VSS sg13_lv_nmos ad=56.9f pd=0.74u as=56.9f ps=0.74u w=0.17u l=0.17u
X4977 cml_tlatch_16.OUTN cml_tlatch_16.OUTP cml_tlatch_16.xmux.xp.S1 VSS sg13_lv_nmos ad=56.9f pd=0.74u as=56.9f ps=0.74u w=0.17u l=0.17u
X4978 cml_tlatch_46.xmux.xp.S1 B3_2_P B3_2_N VSS sg13_lv_nmos ad=56.9f pd=0.74u as=56.9f ps=0.74u w=0.17u l=0.17u
X4979 cml_tlatch_70.INP cml_tlatch_45.OUTN cml_tlatch_84.xmux.xn.S1 VSS sg13_lv_nmos ad=63.19999f pd=0.74u as=63.19999f ps=0.74u w=0.26u l=0.38u
X4980 cml_tlatch_28.xmux.xp.S1 B0_2_P B0_2_N VSS sg13_lv_nmos ad=56.9f pd=0.74u as=56.9f ps=0.74u w=0.17u l=0.17u
X4981 cml_tlatch_30.xmux.xp.S1 cml_tlatch_30.OUTN cml_tlatch_30.OUTP VSS sg13_lv_nmos ad=56.9f pd=0.74u as=56.9f ps=0.74u w=0.17u l=0.17u
X4982 cml_tlatch_26.xmux.xp.S1 MOT6_P MOT6_N VSS sg13_lv_nmos ad=56.9f pd=0.74u as=56.9f ps=0.74u w=0.17u l=0.17u
X4983 MOT18_P MOT18_N cml_tlatch_49.xmux.xp.S1 VSS sg13_lv_nmos ad=56.9f pd=0.74u as=56.9f ps=0.74u w=0.17u l=0.17u
X4984 cml_tlatch_30.OUTN cml_tlatch_30.OUTP cml_tlatch_30.xmux.xp.S1 VSS sg13_lv_nmos ad=56.9f pd=0.74u as=56.9f ps=0.74u w=0.17u l=0.17u
X4985 A0_8_N cml_tlatch_3.OUTP cml_tlatch_2.xmux.xn.S1 VSS sg13_lv_nmos ad=63.19999f pd=0.74u as=0.1082p ps=1.34u w=0.26u l=0.38u
X4986 VDD MOT1_N VSS rppd l=5.17u w=1u
X4987 GA1_P ENA0_N cml_gate2_3.sg13_lv_nmos_FTPY57_0.D0 VSS sg13_lv_nmos ad=0.1007p pd=0.91u as=0.1007p ps=0.91u w=0.53u l=0.13u
X4988 cml_tlatch_86.xmux.xp.S1 MOT24_N MOT24_P VSS sg13_lv_nmos ad=56.9f pd=0.74u as=56.9f ps=0.74u w=0.17u l=0.17u
X4989 VSS hs_to_clk_3.sg13_lv_nmos_2HGZLP_0.G VSS VSS sg13_lv_nmos ad=2.071p pd=11.28u as=0 ps=0 w=10.9u l=1.38u
X4990 cml_tlatch_2.xtail.S1 CKA0_N cml_tlatch_2.xmux.xn.S1 VSS sg13_lv_nmos ad=89.3f pd=0.85u as=89.3f ps=0.85u w=0.47u l=0.16u
X4991 VSS POLN cml_tlatch_79.xtail.S1 VSS sg13_lv_nmos ad=1.5637p pd=8.61u as=1.5637p ps=8.61u w=8.23u l=0.13u
X4992 cml_tlatch_37.xmux.xn.S1 CKA1_N cml_tlatch_37.xtail.S1 VSS sg13_lv_nmos ad=89.3f pd=0.85u as=0.1598p ps=1.62u w=0.47u l=0.16u
X4993 B1_2_N B1_2_P cml_tlatch_33.xmux.xp.S1 VSS sg13_lv_nmos ad=56.9f pd=0.74u as=56.9f ps=0.74u w=0.17u l=0.17u
X4994 MOT6_P A0_2_N cml_tlatch_26.xmux.xn.S1 VSS sg13_lv_nmos ad=0.1082p pd=1.34u as=63.19999f ps=0.74u w=0.26u l=0.38u
X4995 GA3_P CKB3_N cml_gate2_5.xrtail.R1 VSS sg13_lv_nmos ad=0.1007p pd=0.91u as=0.1007p ps=0.91u w=0.53u l=0.13u
X4996 A1_8_N A1_8_P cml_tlatch_21.xmux.xp.S1 VSS sg13_lv_nmos ad=56.9f pd=0.74u as=56.9f ps=0.74u w=0.17u l=0.17u
X4997 cml_tlatch_81.xtail.S1 CKA2_N cml_tlatch_81.xmux.xn.S1 VSS sg13_lv_nmos ad=89.3f pd=0.85u as=89.3f ps=0.85u w=0.47u l=0.16u
X4998 cml_tlatch_40.xmux.xn.S1 cml_tlatch_40.INN MOT12_P VSS sg13_lv_nmos ad=63.19999f pd=0.74u as=63.19999f ps=0.74u w=0.26u l=0.38u
X4999 cml_tlatch_6.xtail.S1 CKHB1_P cml_tlatch_6.xmux.xn.S1 VSS sg13_lv_nmos ad=0.1598p pd=1.62u as=89.3f ps=0.85u w=0.47u l=0.16u
X5000 cml_tlatch_68.xtail.S1 CKHB3_P cml_tlatch_68.xmux.xn.S1 VSS sg13_lv_nmos ad=89.3f pd=0.85u as=89.3f ps=0.85u w=0.47u l=0.16u
X5001 cml_tlatch_67.xmux.xp.S1 cml_tlatch_67.OUTP cml_tlatch_67.OUTN VSS sg13_lv_nmos ad=56.9f pd=0.74u as=56.9f ps=0.74u w=0.17u l=0.17u
X5002 cml_tlatch_42.xmux.xp.S1 cml_tlatch_56.INN cml_tlatch_56.INP VSS sg13_lv_nmos ad=56.9f pd=0.74u as=56.9f ps=0.74u w=0.17u l=0.17u
X5003 GA2_N ENA1_P cml_gate2_4.sg13_lv_nmos_FTPY57_0.D0 VSS sg13_lv_nmos ad=0.1007p pd=0.91u as=0.1802p ps=1.74u w=0.53u l=0.13u
X5004 VSS hs_to_clk_1.sg13_lv_nmos_2HGZLP_0.G VSS VSS sg13_lv_nmos ad=2.071p pd=11.28u as=0 ps=0 w=10.9u l=1.38u
X5005 ENB1_N ENB_P cml_drv_0.xrtail.R1 VSS sg13_lv_nmos ad=56.2f pd=0.74u as=56.2f ps=0.74u w=0.16u l=0.19u
X5006 MOT31_P B3_2_N cml_tlatch_71.xmux.xn.S1 VSS sg13_lv_nmos ad=63.19999f pd=0.74u as=63.19999f ps=0.74u w=0.26u l=0.38u
X5007 cml_tlatch_83.xmux.xp.S1 cml_tlatch_83.OUTP cml_tlatch_83.OUTN VSS sg13_lv_nmos ad=56.9f pd=0.74u as=56.9f ps=0.74u w=0.17u l=0.17u
X5008 cml_tlatch_33.xmux.xn.S1 stub_bi_31.BOTN B1_2_N VSS sg13_lv_nmos ad=63.19999f pd=0.74u as=63.19999f ps=0.74u w=0.26u l=0.38u
X5009 stub_bi_63.BOTN stub_bi_63.BOTP cml_tlatch_79.xmux.xp.S1 VSS sg13_lv_nmos ad=56.9f pd=0.74u as=56.9f ps=0.74u w=0.17u l=0.17u
X5010 cml_gate2_7.sg13_lv_nmos_FTPY57_0.D0 ENB0_P GB2_N VSS sg13_lv_nmos ad=0.1007p pd=0.91u as=0.1007p ps=0.91u w=0.53u l=0.13u
X5011 cml_tlatch_22.xtail.S1 CKA1_N cml_tlatch_22.xmux.xp.S1 VSS sg13_lv_nmos ad=89.3f pd=0.85u as=89.3f ps=0.85u w=0.47u l=0.16u
X5012 cml_tlatch_95.INP cml_tlatch_95.INN cml_tlatch_36.xmux.xp.S1 VSS sg13_lv_nmos ad=56.9f pd=0.74u as=56.9f ps=0.74u w=0.17u l=0.17u
X5013 cml_tlatch_15.xmux.xp.S1 stub_bi_19.BOTN stub_bi_19.BOTP VSS sg13_lv_nmos ad=56.9f pd=0.74u as=56.9f ps=0.74u w=0.17u l=0.17u
X5014 cml_tlatch_37.xmux.xn.S1 cml_tlatch_38.OUTN A1_2_P VSS sg13_lv_nmos ad=63.19999f pd=0.74u as=63.19999f ps=0.74u w=0.26u l=0.38u
X5015 cml_tlatch_32.xmux.xp.S1 stub_bi_29.BOTN stub_bi_29.BOTP VSS sg13_lv_nmos ad=56.9f pd=0.74u as=56.9f ps=0.74u w=0.17u l=0.17u
X5016 MOT31_N MOT31_P cml_tlatch_71.xmux.xp.S1 VSS sg13_lv_nmos ad=56.9f pd=0.74u as=56.9f ps=0.74u w=0.17u l=0.17u
X5017 cml_tlatch_90.xmux.xn.S1 CLK_W_P J4_P VSS sg13_lv_nmos ad=63.19999f pd=0.74u as=63.19999f ps=0.74u w=0.26u l=0.38u
X5018 cml_tlatch_54.OUTN D3_P cml_tlatch_54.xmux.xn.S1 VSS sg13_lv_nmos ad=63.19999f pd=0.74u as=0.1082p ps=1.34u w=0.26u l=0.38u
X5019 cml_tlatch_87.xmux.xn.S1 CKHA2_P cml_tlatch_87.xtail.S1 VSS sg13_lv_nmos ad=89.3f pd=0.85u as=0.1598p ps=1.62u w=0.47u l=0.16u
X5020 cml_tlatch_98.xmux.xp.S1 cml_tlatch_98.OUTN cml_tlatch_98.OUTP VSS sg13_lv_nmos ad=56.9f pd=0.74u as=56.9f ps=0.74u w=0.17u l=0.17u
X5021 cml_gate2_6.xrtail.R1 CKA3_N GB3_P VSS sg13_lv_nmos ad=0.1007p pd=0.91u as=0.1007p ps=0.91u w=0.53u l=0.13u
X5022 cml_tlatch_27.xmux.xp.S1 CKB0_N cml_tlatch_27.xtail.S1 VSS sg13_lv_nmos ad=89.3f pd=0.85u as=89.3f ps=0.85u w=0.47u l=0.16u
X5023 cml_tlatch_35.xmux.xp.S1 cml_tlatch_35.OUTN cml_tlatch_35.OUTP VSS sg13_lv_nmos ad=56.9f pd=0.74u as=56.9f ps=0.74u w=0.17u l=0.17u
X5024 cml_tlatch_67.xmux.xn.S1 cml_tlatch_58.INP cml_tlatch_67.OUTN VSS sg13_lv_nmos ad=63.19999f pd=0.74u as=63.19999f ps=0.74u w=0.26u l=0.38u
X5025 VSS POLN cml_tlatch_99.xtail.S1 VSS sg13_lv_nmos ad=1.5637p pd=8.61u as=1.5637p ps=8.61u w=8.23u l=0.13u
X5026 cml_tlatch_41.xmux.xp.S1 MOT14_N MOT14_P VSS sg13_lv_nmos ad=0.1019p pd=1.34u as=56.9f ps=0.74u w=0.17u l=0.17u
X5027 cml_tlatch_23.xtail.S1 CKA1_N cml_tlatch_23.xmux.xn.S1 VSS sg13_lv_nmos ad=89.3f pd=0.85u as=89.3f ps=0.85u w=0.47u l=0.16u
X5028 stub_bi_19.BOTN VDD VSS rppd l=5.17u w=1u
X5029 cml_tlatch_85.xmux.xp.S1 CKA3_P cml_tlatch_85.xtail.S1 VSS sg13_lv_nmos ad=0.1598p pd=1.62u as=89.3f ps=0.85u w=0.47u l=0.16u
X5030 cml_tlatch_18.xtail.S1 CKHB0_N cml_tlatch_18.xmux.xp.S1 VSS sg13_lv_nmos ad=89.3f pd=0.85u as=89.3f ps=0.85u w=0.47u l=0.16u
X5031 cml_tlatch_96.xmux.xp.S1 MOT8_P MOT8_N VSS sg13_lv_nmos ad=56.9f pd=0.74u as=56.9f ps=0.74u w=0.17u l=0.17u
X5032 cml_tlatch_82.xmux.xp.S1 cml_tlatch_82.OUTN cml_tlatch_82.OUTP VSS sg13_lv_nmos ad=56.9f pd=0.74u as=56.9f ps=0.74u w=0.17u l=0.17u
X5033 stub_bi_62.BOTN stub_bi_62.BOTP cml_tlatch_78.xmux.xp.S1 VSS sg13_lv_nmos ad=56.9f pd=0.74u as=56.9f ps=0.74u w=0.17u l=0.17u
X5034 cml_tlatch_29.xtail.S1 CKB0_N cml_tlatch_29.xmux.xp.S1 VSS sg13_lv_nmos ad=89.3f pd=0.85u as=89.3f ps=0.85u w=0.47u l=0.16u
X5035 cml_tlatch_7.xmux.xp.S1 MOT15_P MOT15_N VSS sg13_lv_nmos ad=56.9f pd=0.74u as=56.9f ps=0.74u w=0.17u l=0.17u
X5036 cml_tlatch_1.xtail.S1 CKB0_P cml_tlatch_1.xmux.xn.S1 VSS sg13_lv_nmos ad=89.3f pd=0.85u as=89.3f ps=0.85u w=0.47u l=0.16u
X5037 cml_tlatch_66.xmux.xp.S1 cml_tlatch_57.INN cml_tlatch_57.INP VSS sg13_lv_nmos ad=56.9f pd=0.74u as=56.9f ps=0.74u w=0.17u l=0.17u
X5038 cml_tlatch_74.xmux.xp.S1 MOT19_P MOT19_N VSS sg13_lv_nmos ad=56.9f pd=0.74u as=56.9f ps=0.74u w=0.17u l=0.17u
X5039 MOT22_N MOT22_P cml_tlatch_51.xmux.xp.S1 VSS sg13_lv_nmos ad=56.9f pd=0.74u as=56.9f ps=0.74u w=0.17u l=0.17u
X5040 cml_tlatch_49.xmux.xp.S1 CKHA2_N cml_tlatch_49.xtail.S1 VSS sg13_lv_nmos ad=89.3f pd=0.85u as=89.3f ps=0.85u w=0.47u l=0.16u
X5041 cml_tlatch_48.xmux.xn.S1 D2_N stub_bi_32.BOTN VSS sg13_lv_nmos ad=0.1082p pd=1.34u as=63.19999f ps=0.74u w=0.26u l=0.38u
X5042 cml_tlatch_47.xmux.xn.S1 CKB3_P cml_tlatch_47.xtail.S1 VSS sg13_lv_nmos ad=89.3f pd=0.85u as=89.3f ps=0.85u w=0.47u l=0.16u
X5043 cml_tlatch_86.xmux.xn.S1 CKHA3_P cml_tlatch_86.xtail.S1 VSS sg13_lv_nmos ad=89.3f pd=0.85u as=89.3f ps=0.85u w=0.47u l=0.16u
X5044 cml_tlatch_52.xtail.S1 CKA3_N cml_tlatch_52.xmux.xp.S1 VSS sg13_lv_nmos ad=89.3f pd=0.85u as=89.3f ps=0.85u w=0.47u l=0.16u
X5045 VDD MOT20_P VSS rppd l=5.17u w=1u
X5046 cml_tlatch_5.xmux.xp.S1 MOT11_P MOT11_N VSS sg13_lv_nmos ad=56.9f pd=0.74u as=56.9f ps=0.74u w=0.17u l=0.17u
X5047 cml_tlatch_22.OUTP cml_tlatch_39.INN cml_tlatch_22.xmux.xn.S1 VSS sg13_lv_nmos ad=63.19999f pd=0.74u as=0.1082p ps=1.34u w=0.26u l=0.38u
X5048 cml_tlatch_64.xmux.xp.S1 A3_8_P A3_8_N VSS sg13_lv_nmos ad=56.9f pd=0.74u as=56.9f ps=0.74u w=0.17u l=0.17u
X5049 cml_tlatch_27.xmux.xp.S1 cml_tlatch_27.OUTP cml_tlatch_27.OUTN VSS sg13_lv_nmos ad=56.9f pd=0.74u as=56.9f ps=0.74u w=0.17u l=0.17u
X5050 cml_tlatch_4.xtail.S1 CKHB1_N cml_tlatch_4.xmux.xp.S1 VSS sg13_lv_nmos ad=89.3f pd=0.85u as=89.3f ps=0.85u w=0.47u l=0.16u
X5051 cml_tlatch_56.xtail.S1 CKA2_N cml_tlatch_56.xmux.xn.S1 VSS sg13_lv_nmos ad=89.3f pd=0.85u as=89.3f ps=0.85u w=0.47u l=0.16u
X5052 cml_tlatch_80.xtail.S1 CKB2_N cml_tlatch_80.xmux.xp.S1 VSS sg13_lv_nmos ad=89.3f pd=0.85u as=89.3f ps=0.85u w=0.47u l=0.16u
X5053 cml_tlatch_57.xmux.xp.S1 CKHA3_N cml_tlatch_57.xtail.S1 VSS sg13_lv_nmos ad=89.3f pd=0.85u as=89.3f ps=0.85u w=0.47u l=0.16u
X5054 stub_bi_19.BOTN cml_tlatch_6.INN cml_tlatch_15.xmux.xn.S1 VSS sg13_lv_nmos ad=63.19999f pd=0.74u as=63.19999f ps=0.74u w=0.26u l=0.38u
X5055 A2_2_N cml_tlatch_56.INP cml_tlatch_56.xmux.xn.S1 VSS sg13_lv_nmos ad=63.19999f pd=0.74u as=63.19999f ps=0.74u w=0.26u l=0.38u
X5056 stub_bi_62.BOTP stub_bi_63.BOTN cml_tlatch_78.xmux.xn.S1 VSS sg13_lv_nmos ad=63.19999f pd=0.74u as=63.19999f ps=0.74u w=0.26u l=0.38u
X5057 cml_tlatch_84.xmux.xp.S1 cml_tlatch_70.INP cml_tlatch_70.INN VSS sg13_lv_nmos ad=56.9f pd=0.74u as=56.9f ps=0.74u w=0.17u l=0.17u
X5058 cml_tlatch_54.OUTN cml_tlatch_54.OUTP cml_tlatch_54.xmux.xp.S1 VSS sg13_lv_nmos ad=56.9f pd=0.74u as=56.9f ps=0.74u w=0.17u l=0.17u
X5059 cml_gate2_1.xrtail.R1 VSS VSS rppd l=4.86u w=1u
X5060 MOT3_N cml_tlatch_16.OUTP cml_tlatch_18.xmux.xn.S1 VSS sg13_lv_nmos ad=63.19999f pd=0.74u as=63.19999f ps=0.74u w=0.26u l=0.38u
X5061 cml_tlatch_45.xtail.S1 CKB3_N cml_tlatch_45.xmux.xp.S1 VSS sg13_lv_nmos ad=0.1598p pd=1.62u as=89.3f ps=0.85u w=0.47u l=0.16u
X5062 cml_tlatch_95.xmux.xp.S1 cml_tlatch_40.INN cml_tlatch_40.INP VSS sg13_lv_nmos ad=56.9f pd=0.74u as=56.9f ps=0.74u w=0.17u l=0.17u
X5063 cml_tlatch_33.xmux.xp.S1 B1_2_N B1_2_P VSS sg13_lv_nmos ad=56.9f pd=0.74u as=56.9f ps=0.74u w=0.17u l=0.17u
X5064 cml_tlatch_14.xtail.S1 POLN VSS VSS sg13_lv_nmos ad=1.5637p pd=8.61u as=1.5637p ps=8.61u w=8.23u l=0.13u
X5065 cml_tlatch_28.xmux.xp.S1 B0_2_P B0_2_N VSS sg13_lv_nmos ad=56.9f pd=0.74u as=56.9f ps=0.74u w=0.17u l=0.17u
X5066 cml_tlatch_26.xmux.xp.S1 MOT6_P MOT6_N VSS sg13_lv_nmos ad=56.9f pd=0.74u as=56.9f ps=0.74u w=0.17u l=0.17u
X5067 cml_tlatch_52.xmux.xp.S1 cml_tlatch_52.OUTN cml_tlatch_52.OUTP VSS sg13_lv_nmos ad=56.9f pd=0.74u as=56.9f ps=0.74u w=0.17u l=0.17u
X5068 cml_tlatch_52.OUTP A3_2_N cml_tlatch_52.xmux.xn.S1 VSS sg13_lv_nmos ad=63.19999f pd=0.74u as=63.19999f ps=0.74u w=0.26u l=0.38u
X5069 cml_tlatch_66.xmux.xp.S1 cml_tlatch_57.INN cml_tlatch_57.INP VSS sg13_lv_nmos ad=56.9f pd=0.74u as=56.9f ps=0.74u w=0.17u l=0.17u
X5070 cml_tlatch_16.xmux.xp.S1 cml_tlatch_16.OUTN cml_tlatch_16.OUTP VSS sg13_lv_nmos ad=56.9f pd=0.74u as=56.9f ps=0.74u w=0.17u l=0.17u
X5071 cml_gate2_2.sg13_lv_nmos_FTPY57_0.D0 ENA0_P GA0_N VSS sg13_lv_nmos ad=0.1007p pd=0.91u as=0.1007p ps=0.91u w=0.53u l=0.13u
X5072 CKHA3_P GA3_N cml_drvb_5.xrtail.R1 VSS sg13_lv_nmos ad=0.2618p pd=2.22u as=0.1463p ps=1.15u w=0.77u l=0.21u
X5073 cml_tlatch_75.xmux.xn.S1 CKHB2_P cml_tlatch_75.xtail.S1 VSS sg13_lv_nmos ad=89.3f pd=0.85u as=89.3f ps=0.85u w=0.47u l=0.16u
X5074 cml_tlatch_15.xmux.xn.S1 cml_tlatch_6.INP stub_bi_19.BOTP VSS sg13_lv_nmos ad=63.19999f pd=0.74u as=0.1082p ps=1.34u w=0.26u l=0.38u
X5075 CKB3_N hs_to_clk_5.sg13_lv_nmos_2HGZLP_0.G VSS rppd l=4.25u w=1u
X5076 cml_tlatch_89.INN cml_tlatch_89.INP cml_tlatch_55.xmux.xp.S1 VSS sg13_lv_nmos ad=56.9f pd=0.74u as=56.9f ps=0.74u w=0.17u l=0.17u
X5077 cml_tlatch_17.xmux.xn.S1 CKHB0_P cml_tlatch_17.xtail.S1 VSS sg13_lv_nmos ad=89.3f pd=0.85u as=89.3f ps=0.85u w=0.47u l=0.16u
X5078 cml_tlatch_63.OUTN cml_tlatch_63.OUTP cml_tlatch_63.xmux.xp.S1 VSS sg13_lv_nmos ad=56.9f pd=0.74u as=56.9f ps=0.74u w=0.17u l=0.17u
X5079 cml_tlatch_52.xmux.xn.S1 A3_2_P cml_tlatch_52.OUTN VSS sg13_lv_nmos ad=63.19999f pd=0.74u as=63.19999f ps=0.74u w=0.26u l=0.38u
X5080 B2_8_P B2_8_N cml_tlatch_77.xmux.xp.S1 VSS sg13_lv_nmos ad=56.9f pd=0.74u as=56.9f ps=0.74u w=0.17u l=0.17u
X5081 cml_tlatch_42.xmux.xp.S1 cml_tlatch_56.INN cml_tlatch_56.INP VSS sg13_lv_nmos ad=56.9f pd=0.74u as=56.9f ps=0.74u w=0.17u l=0.17u
X5082 stub_bi_32.BOTN stub_bi_32.BOTP cml_tlatch_48.xmux.xp.S1 VSS sg13_lv_nmos ad=56.9f pd=0.74u as=56.9f ps=0.74u w=0.17u l=0.17u
X5083 cml_tlatch_90.xmux.xp.S1 J4_P J4_N VSS sg13_lv_nmos ad=56.9f pd=0.74u as=56.9f ps=0.74u w=0.17u l=0.17u
X5084 cml_tlatch_70.INN cml_tlatch_70.INP cml_tlatch_84.xmux.xp.S1 VSS sg13_lv_nmos ad=56.9f pd=0.74u as=56.9f ps=0.74u w=0.17u l=0.17u
X5085 cml_tlatch_1.OUTN cml_tlatch_1.OUTP cml_tlatch_1.xmux.xp.S1 VSS sg13_lv_nmos ad=56.9f pd=0.74u as=56.9f ps=0.74u w=0.17u l=0.17u
X5086 cml_tlatch_74.xmux.xn.S1 CKHB2_P cml_tlatch_74.xtail.S1 VSS sg13_lv_nmos ad=89.3f pd=0.85u as=89.3f ps=0.85u w=0.47u l=0.16u
X5087 cml_tlatch_15.xmux.xp.S1 stub_bi_19.BOTN stub_bi_19.BOTP VSS sg13_lv_nmos ad=56.9f pd=0.74u as=56.9f ps=0.74u w=0.17u l=0.17u
X5088 cml_tlatch_47.OUTN cml_tlatch_47.OUTP cml_tlatch_47.xmux.xp.S1 VSS sg13_lv_nmos ad=56.9f pd=0.74u as=0.1019p ps=1.34u w=0.17u l=0.17u
X5089 cml_tlatch_96.xmux.xp.S1 CKHA1_N cml_tlatch_96.xtail.S1 VSS sg13_lv_nmos ad=89.3f pd=0.85u as=89.3f ps=0.85u w=0.47u l=0.16u
X5090 MOT4_N MOT4_P cml_tlatch_25.xmux.xp.S1 VSS sg13_lv_nmos ad=56.9f pd=0.74u as=56.9f ps=0.74u w=0.17u l=0.17u
X5091 A0_2_P A0_2_N cml_tlatch_31.xmux.xp.S1 VSS sg13_lv_nmos ad=56.9f pd=0.74u as=56.9f ps=0.74u w=0.17u l=0.17u
X5092 cml_tlatch_67.xmux.xp.S1 cml_tlatch_67.OUTN cml_tlatch_67.OUTP VSS sg13_lv_nmos ad=0.1019p pd=1.34u as=56.9f ps=0.74u w=0.17u l=0.17u
X5093 MOT1_N MOT1_P cml_tlatch_17.xmux.xp.S1 VSS sg13_lv_nmos ad=56.9f pd=0.74u as=56.9f ps=0.74u w=0.17u l=0.17u
X5094 cml_tlatch_16.xtail.S1 CKB0_P cml_tlatch_16.xmux.xp.S1 VSS sg13_lv_nmos ad=89.3f pd=0.85u as=89.3f ps=0.85u w=0.47u l=0.16u
X5095 cml_tlatch_98.OUTN cml_tlatch_98.OUTP cml_tlatch_98.xmux.xp.S1 VSS sg13_lv_nmos ad=56.9f pd=0.74u as=56.9f ps=0.74u w=0.17u l=0.17u
X5096 cml_tlatch_16.xtail.S1 CKB0_N cml_tlatch_16.xmux.xn.S1 VSS sg13_lv_nmos ad=0.1598p pd=1.62u as=89.3f ps=0.85u w=0.47u l=0.16u
X5097 cml_tlatch_54.xmux.xp.S1 CKA3_N cml_tlatch_54.xtail.S1 VSS sg13_lv_nmos ad=89.3f pd=0.85u as=89.3f ps=0.85u w=0.47u l=0.16u
X5098 VSS POLN cml_tlatch_20.xtail.S1 VSS sg13_lv_nmos ad=1.5637p pd=8.61u as=1.5637p ps=8.61u w=8.23u l=0.13u
X5099 cml_tlatch_35.OUTN cml_tlatch_35.OUTP cml_tlatch_35.xmux.xp.S1 VSS sg13_lv_nmos ad=56.9f pd=0.74u as=56.9f ps=0.74u w=0.17u l=0.17u
X5100 B1_8_N B1_8_P cml_tlatch_12.xmux.xp.S1 VSS sg13_lv_nmos ad=56.9f pd=0.74u as=56.9f ps=0.74u w=0.17u l=0.17u
X5101 B1_8_N VDD VSS rppd l=5.17u w=1u
X5102 cml_tlatch_6.xmux.xn.S1 CKHB1_P cml_tlatch_6.xtail.S1 VSS sg13_lv_nmos ad=89.3f pd=0.85u as=89.3f ps=0.85u w=0.47u l=0.16u
X5103 cml_tlatch_94.xmux.xp.S1 cml_tlatch_6.INP cml_tlatch_6.INN VSS sg13_lv_nmos ad=56.9f pd=0.74u as=56.9f ps=0.74u w=0.17u l=0.17u
X5104 VSS POLN cml_tlatch_61.xtail.S1 VSS sg13_lv_nmos ad=1.5637p pd=8.61u as=1.5637p ps=8.61u w=8.23u l=0.13u
X5105 B3_2_P B3_2_N cml_tlatch_46.xmux.xp.S1 VSS sg13_lv_nmos ad=56.9f pd=0.74u as=56.9f ps=0.74u w=0.17u l=0.17u
X5106 cml_tlatch_87.xmux.xn.S1 A2_8_P MOT16_N VSS sg13_lv_nmos ad=63.19999f pd=0.74u as=63.19999f ps=0.74u w=0.26u l=0.38u
X5107 MOT27_N MOT27_P cml_tlatch_69.xmux.xp.S1 VSS sg13_lv_nmos ad=56.9f pd=0.74u as=56.9f ps=0.74u w=0.17u l=0.17u
X5108 cml_tlatch_66.xmux.xn.S1 CKA3_N cml_tlatch_66.xtail.S1 VSS sg13_lv_nmos ad=0.1598p pd=1.62u as=89.3f ps=0.85u w=0.47u l=0.16u
X5109 cml_tlatch_54.xtail.S1 POLN VSS VSS sg13_lv_nmos ad=1.5637p pd=8.61u as=2.7982p ps=17.14u w=8.23u l=0.13u
X5110 cml_gate2_5.xrtail.R1 CKB3_P cml_gate2_5.sg13_lv_nmos_FTPY57_0.D0 VSS sg13_lv_nmos ad=0.1007p pd=0.91u as=0.1007p ps=0.91u w=0.53u l=0.13u
X5111 GB1_N ENB1_P cml_gate2_0.sg13_lv_nmos_FTPY57_0.D0 VSS sg13_lv_nmos ad=0.1007p pd=0.91u as=0.1007p ps=0.91u w=0.53u l=0.13u
X5112 cml_tlatch_94.xmux.xn.S1 stub_bi_29.BOTP cml_tlatch_6.INP VSS sg13_lv_nmos ad=63.19999f pd=0.74u as=63.19999f ps=0.74u w=0.26u l=0.38u
X5113 cml_tlatch_39.INN cml_tlatch_39.INP cml_tlatch_23.xmux.xp.S1 VSS sg13_lv_nmos ad=56.9f pd=0.74u as=56.9f ps=0.74u w=0.17u l=0.17u
X5114 cml_tlatch_14.xmux.xp.S1 cml_tlatch_5.INN cml_tlatch_5.INP VSS sg13_lv_nmos ad=56.9f pd=0.74u as=56.9f ps=0.74u w=0.17u l=0.17u
X5115 VSS hs_to_clk_7.sg13_lv_nmos_2HGZLP_0.G VSS VSS sg13_lv_nmos ad=2.071p pd=11.28u as=0 ps=0 w=10.9u l=1.38u
X5116 cml_gate2_6.sg13_lv_nmos_FTPY57_0.D0 CKA3_P cml_gate2_6.xrtail.R1 VSS sg13_lv_nmos ad=0.1007p pd=0.91u as=0.1007p ps=0.91u w=0.53u l=0.13u
X5117 cml_tlatch_5.xmux.xp.S1 MOT11_P MOT11_N VSS sg13_lv_nmos ad=56.9f pd=0.74u as=56.9f ps=0.74u w=0.17u l=0.17u
X5118 cml_tlatch_47.xmux.xp.S1 CKB3_N cml_tlatch_47.xtail.S1 VSS sg13_lv_nmos ad=89.3f pd=0.85u as=89.3f ps=0.85u w=0.47u l=0.16u
X5119 stub_bi_29.BOTN stub_bi_29.BOTP cml_tlatch_32.xmux.xp.S1 VSS sg13_lv_nmos ad=56.9f pd=0.74u as=56.9f ps=0.74u w=0.17u l=0.17u
X5120 cml_gate2_5.sg13_lv_nmos_FTPY57_0.D0 ENA1_P GA3_N VSS sg13_lv_nmos ad=0.1007p pd=0.91u as=0.1007p ps=0.91u w=0.53u l=0.13u
X5121 cml_tlatch_19.xmux.xp.S1 MOT5_N MOT5_P VSS sg13_lv_nmos ad=56.9f pd=0.74u as=56.9f ps=0.74u w=0.17u l=0.17u
X5122 cml_tlatch_11.xmux.xp.S1 cml_tlatch_11.OUTN cml_tlatch_11.OUTP VSS sg13_lv_nmos ad=56.9f pd=0.74u as=56.9f ps=0.74u w=0.17u l=0.17u
X5123 stub_bi_17.BOTP stub_bi_17.BOTN cml_tlatch_13.xmux.xp.S1 VSS sg13_lv_nmos ad=56.9f pd=0.74u as=56.9f ps=0.74u w=0.17u l=0.17u
X5124 cml_tlatch_63.xmux.xp.S1 cml_tlatch_63.OUTN cml_tlatch_63.OUTP VSS sg13_lv_nmos ad=56.9f pd=0.74u as=56.9f ps=0.74u w=0.17u l=0.17u
X5125 cml_tlatch_56.xmux.xp.S1 A2_2_P A2_2_N VSS sg13_lv_nmos ad=56.9f pd=0.74u as=56.9f ps=0.74u w=0.17u l=0.17u
X5126 cml_tlatch_89.OUTN cml_tlatch_89.OUTP cml_tlatch_89.xmux.xp.S1 VSS sg13_lv_nmos ad=56.9f pd=0.74u as=0.1019p ps=1.34u w=0.17u l=0.17u
X5127 cml_gate2_0.sg13_lv_nmos_FTPY57_0.D0 ENB1_N GB1_P VSS sg13_lv_nmos ad=0.1007p pd=0.91u as=0.1007p ps=0.91u w=0.53u l=0.13u
X5128 cml_tlatch_7.xtail.S1 POLN VSS VSS sg13_lv_nmos ad=1.5637p pd=8.61u as=1.5637p ps=8.61u w=8.23u l=0.13u
X5129 hs_to_clk_5.sg13_lv_nmos_2HGZLP_0.G VDD VSS rppd l=0.68u w=1u
X5130 MOT24_P A3_8_N cml_tlatch_86.xmux.xn.S1 VSS sg13_lv_nmos ad=63.19999f pd=0.74u as=63.19999f ps=0.74u w=0.26u l=0.38u
X5131 cml_tlatch_36.xtail.S1 CKA1_P cml_tlatch_36.xmux.xn.S1 VSS sg13_lv_nmos ad=89.3f pd=0.85u as=89.3f ps=0.85u w=0.47u l=0.16u
X5132 cml_tlatch_77.xmux.xn.S1 stub_bi_62.BOTN B2_8_N VSS sg13_lv_nmos ad=63.19999f pd=0.74u as=63.19999f ps=0.74u w=0.26u l=0.38u
X5133 cml_tlatch_99.xmux.xn.S1 CKA0_N cml_tlatch_99.xtail.S1 VSS sg13_lv_nmos ad=0.1598p pd=1.62u as=89.3f ps=0.85u w=0.47u l=0.16u
X5134 VSS POLN cml_tlatch_39.xtail.S1 VSS sg13_lv_nmos ad=2.7982p pd=17.14u as=1.5637p ps=8.61u w=8.23u l=0.13u
X5135 cml_tlatch_91.xmux.xp.S1 CLK_W_P CLK_W_N VSS sg13_lv_nmos ad=56.9f pd=0.74u as=56.9f ps=0.74u w=0.17u l=0.17u
X5136 cml_tlatch_50.xmux.xp.S1 MOT20_P MOT20_N VSS sg13_lv_nmos ad=56.9f pd=0.74u as=56.9f ps=0.74u w=0.17u l=0.17u
X5137 stub_bi_63.BOTN VDD VSS rppd l=5.17u w=1u
X5138 cml_tlatch_31.xmux.xn.S1 cml_tlatch_35.OUTN A0_2_P VSS sg13_lv_nmos ad=63.19999f pd=0.74u as=63.19999f ps=0.74u w=0.26u l=0.38u
X5139 MOT28_N MOT28_P cml_tlatch_58.xmux.xp.S1 VSS sg13_lv_nmos ad=56.9f pd=0.74u as=56.9f ps=0.74u w=0.17u l=0.17u
X5140 cml_gate2_4.xrtail.R1 CKB2_N GA2_P VSS sg13_lv_nmos ad=0.1802p pd=1.74u as=0.1007p ps=0.91u w=0.53u l=0.13u
X5141 cml_tlatch_61.OUTN cml_tlatch_61.OUTP cml_tlatch_61.xmux.xp.S1 VSS sg13_lv_nmos ad=56.9f pd=0.74u as=56.9f ps=0.74u w=0.17u l=0.17u
X5142 cml_tlatch_5.INP stub_bi_19.BOTP cml_tlatch_14.xmux.xn.S1 VSS sg13_lv_nmos ad=63.19999f pd=0.74u as=63.19999f ps=0.74u w=0.26u l=0.38u
X5143 cml_tlatch_26.xmux.xn.S1 CKHA0_P cml_tlatch_26.xtail.S1 VSS sg13_lv_nmos ad=89.3f pd=0.85u as=89.3f ps=0.85u w=0.47u l=0.16u
X5144 GA1_N VDD VSS rppd l=7.42u w=1u
X5145 cml_tlatch_32.xtail.S1 CKB1_P cml_tlatch_32.xmux.xn.S1 VSS sg13_lv_nmos ad=89.3f pd=0.85u as=89.3f ps=0.85u w=0.47u l=0.16u
X5146 ENA0_P ENA_N cml_drv_3.xrtail.R1 VSS sg13_lv_nmos ad=56.2f pd=0.74u as=56.2f ps=0.74u w=0.16u l=0.19u
X5147 cml_tlatch_40.xmux.xp.S1 MOT12_P MOT12_N VSS sg13_lv_nmos ad=56.9f pd=0.74u as=56.9f ps=0.74u w=0.17u l=0.17u
X5148 cml_tlatch_92.xmux.xp.S1 J2_P J2_N VSS sg13_lv_nmos ad=56.9f pd=0.74u as=56.9f ps=0.74u w=0.17u l=0.17u
X5149 cml_tlatch_43.xmux.xp.S1 stub_bi_42.BOTN stub_bi_42.BOTP VSS sg13_lv_nmos ad=0.1019p pd=1.34u as=56.9f ps=0.74u w=0.17u l=0.17u
X5150 cml_tlatch_68.xmux.xn.S1 B3_8_N MOT25_P VSS sg13_lv_nmos ad=63.19999f pd=0.74u as=0.1082p ps=1.34u w=0.26u l=0.38u
X5151 cml_tlatch_92.xmux.xn.S1 CKJ_N cml_tlatch_92.xtail.S1 VSS sg13_lv_nmos ad=89.3f pd=0.85u as=89.3f ps=0.85u w=0.47u l=0.16u
X5152 cml_tlatch_91.xmux.xp.S1 CLK_W_P CLK_W_N VSS sg13_lv_nmos ad=0.1019p pd=1.34u as=56.9f ps=0.74u w=0.17u l=0.17u
X5153 VSS POLN cml_tlatch_53.xtail.S1 VSS sg13_lv_nmos ad=2.7982p pd=17.14u as=1.5637p ps=8.61u w=8.23u l=0.13u
X5154 MOT25_N B3_8_P cml_tlatch_68.xmux.xn.S1 VSS sg13_lv_nmos ad=63.19999f pd=0.74u as=63.19999f ps=0.74u w=0.26u l=0.38u
X5155 cml_tlatch_44.xmux.xp.S1 B2_2_N B2_2_P VSS sg13_lv_nmos ad=56.9f pd=0.74u as=56.9f ps=0.74u w=0.17u l=0.17u
X5156 cml_tlatch_89.OUTP cml_tlatch_89.INN cml_tlatch_89.xmux.xn.S1 VSS sg13_lv_nmos ad=63.19999f pd=0.74u as=63.19999f ps=0.74u w=0.26u l=0.38u
X5157 cml_tlatch_1.OUTN cml_tlatch_1.OUTP cml_tlatch_1.xmux.xp.S1 VSS sg13_lv_nmos ad=56.9f pd=0.74u as=56.9f ps=0.74u w=0.17u l=0.17u
X5158 cml_tlatch_71.xmux.xn.S1 CKHB3_P cml_tlatch_71.xtail.S1 VSS sg13_lv_nmos ad=89.3f pd=0.85u as=89.3f ps=0.85u w=0.47u l=0.16u
X5159 VDD MOT22_N VSS rppd l=5.17u w=1u
X5160 cml_tlatch_80.xmux.xn.S1 CKB2_P cml_tlatch_80.xtail.S1 VSS sg13_lv_nmos ad=89.3f pd=0.85u as=89.3f ps=0.85u w=0.47u l=0.16u
X5161 cml_tlatch_65.xmux.xp.S1 cml_tlatch_65.OUTN cml_tlatch_65.OUTP VSS sg13_lv_nmos ad=56.9f pd=0.74u as=56.9f ps=0.74u w=0.17u l=0.17u
X5162 cml_tlatch_42.xmux.xp.S1 cml_tlatch_56.INP cml_tlatch_56.INN VSS sg13_lv_nmos ad=56.9f pd=0.74u as=56.9f ps=0.74u w=0.17u l=0.17u
X5163 cml_tlatch_3.xtail.S1 CKA0_P cml_tlatch_3.xmux.xn.S1 VSS sg13_lv_nmos ad=89.3f pd=0.85u as=89.3f ps=0.85u w=0.47u l=0.16u
X5164 stub_bi_32.BOTP D2_P cml_tlatch_48.xmux.xn.S1 VSS sg13_lv_nmos ad=63.19999f pd=0.74u as=63.19999f ps=0.74u w=0.26u l=0.38u
X5165 ENB_P NS1_N cml_gate2_8.xrtail.R1 VSS sg13_lv_nmos ad=0.1007p pd=0.91u as=0.1802p ps=1.74u w=0.53u l=0.13u
X5166 cml_tlatch_67.xmux.xn.S1 CKA3_P cml_tlatch_67.xtail.S1 VSS sg13_lv_nmos ad=89.3f pd=0.85u as=89.3f ps=0.85u w=0.47u l=0.16u
X5167 cml_tlatch_44.xtail.S1 POLN VSS VSS sg13_lv_nmos ad=1.5637p pd=8.61u as=2.7982p ps=17.14u w=8.23u l=0.13u
X5168 cml_tlatch_89.OUTN cml_tlatch_89.OUTP cml_tlatch_89.xmux.xp.S1 VSS sg13_lv_nmos ad=56.9f pd=0.74u as=56.9f ps=0.74u w=0.17u l=0.17u
X5169 VSS POLN cml_tlatch_11.xtail.S1 VSS sg13_lv_nmos ad=2.7982p pd=17.14u as=1.5637p ps=8.61u w=8.23u l=0.13u
X5170 B2_2_P stub_bi_32.BOTP cml_tlatch_44.xmux.xn.S1 VSS sg13_lv_nmos ad=63.19999f pd=0.74u as=63.19999f ps=0.74u w=0.26u l=0.38u
X5171 MOT21_P MOT21_N cml_tlatch_75.xmux.xp.S1 VSS sg13_lv_nmos ad=56.9f pd=0.74u as=0.1019p ps=1.34u w=0.17u l=0.17u
X5172 cml_tlatch_6.xmux.xp.S1 MOT13_P MOT13_N VSS sg13_lv_nmos ad=56.9f pd=0.74u as=56.9f ps=0.74u w=0.17u l=0.17u
X5173 cml_tlatch_61.xmux.xp.S1 cml_tlatch_61.OUTP cml_tlatch_61.OUTN VSS sg13_lv_nmos ad=56.9f pd=0.74u as=56.9f ps=0.74u w=0.17u l=0.17u
X5174 cml_tlatch_78.xtail.S1 POLN VSS VSS sg13_lv_nmos ad=1.5637p pd=8.61u as=1.5637p ps=8.61u w=8.23u l=0.13u
X5175 cml_tlatch_34.xtail.S1 CKB1_N cml_tlatch_34.xmux.xp.S1 VSS sg13_lv_nmos ad=89.3f pd=0.85u as=89.3f ps=0.85u w=0.47u l=0.16u
X5176 ENB_P J2_N cml_gate2_8.sg13_lv_nmos_FTPY57_0.D0 VSS sg13_lv_nmos ad=0.1007p pd=0.91u as=0.1007p ps=0.91u w=0.53u l=0.13u
X5177 cml_tlatch_62.xmux.xp.S1 cml_tlatch_69.INP cml_tlatch_69.INN VSS sg13_lv_nmos ad=56.9f pd=0.74u as=56.9f ps=0.74u w=0.17u l=0.17u
X5178 A1_2_N A1_2_P cml_tlatch_37.xmux.xp.S1 VSS sg13_lv_nmos ad=56.9f pd=0.74u as=56.9f ps=0.74u w=0.17u l=0.17u
X5179 VSS hs_to_clk_8.sg13_lv_nmos_2HGZLP_0.G VSS VSS sg13_lv_nmos ad=3.706p pd=22.48u as=0 ps=0 w=10.9u l=1.38u
X5180 cml_tlatch_83.OUTP cml_tlatch_83.OUTN cml_tlatch_83.xmux.xp.S1 VSS sg13_lv_nmos ad=56.9f pd=0.74u as=56.9f ps=0.74u w=0.17u l=0.17u
X5181 cml_tlatch_89.xmux.xp.S1 cml_tlatch_89.OUTN cml_tlatch_89.OUTP VSS sg13_lv_nmos ad=56.9f pd=0.74u as=56.9f ps=0.74u w=0.17u l=0.17u
X5182 cml_tlatch_85.xmux.xp.S1 CKA3_P cml_tlatch_85.xtail.S1 VSS sg13_lv_nmos ad=89.3f pd=0.85u as=89.3f ps=0.85u w=0.47u l=0.16u
X5183 cml_tlatch_18.xtail.S1 CKHB0_N cml_tlatch_18.xmux.xp.S1 VSS sg13_lv_nmos ad=89.3f pd=0.85u as=89.3f ps=0.85u w=0.47u l=0.16u
X5184 CLK_W_P CLK_W_N cml_tlatch_91.xmux.xp.S1 VSS sg13_lv_nmos ad=56.9f pd=0.74u as=56.9f ps=0.74u w=0.17u l=0.17u
X5185 GB0_P ENB1_N cml_gate2_1.sg13_lv_nmos_FTPY57_0.D0 VSS sg13_lv_nmos ad=0.1007p pd=0.91u as=0.1007p ps=0.91u w=0.53u l=0.13u
X5186 cml_tlatch_26.xmux.xn.S1 A0_2_P MOT6_N VSS sg13_lv_nmos ad=63.19999f pd=0.74u as=63.19999f ps=0.74u w=0.26u l=0.38u
X5187 cml_tlatch_55.xmux.xn.S1 CKA2_P cml_tlatch_55.xtail.S1 VSS sg13_lv_nmos ad=89.3f pd=0.85u as=89.3f ps=0.85u w=0.47u l=0.16u
X5188 MOT14_P MOT14_N cml_tlatch_41.xmux.xp.S1 VSS sg13_lv_nmos ad=56.9f pd=0.74u as=56.9f ps=0.74u w=0.17u l=0.17u
X5189 cml_tlatch_4.xtail.S1 POLN VSS VSS sg13_lv_nmos ad=1.5637p pd=8.61u as=1.5637p ps=8.61u w=8.23u l=0.13u
X5190 cml_tlatch_70.xmux.xp.S1 MOT29_P MOT29_N VSS sg13_lv_nmos ad=56.9f pd=0.74u as=56.9f ps=0.74u w=0.17u l=0.17u
X5191 cml_tlatch_44.xmux.xp.S1 B2_2_N B2_2_P VSS sg13_lv_nmos ad=56.9f pd=0.74u as=56.9f ps=0.74u w=0.17u l=0.17u
X5192 cml_tlatch_38.xmux.xn.S1 CKA1_P cml_tlatch_38.xtail.S1 VSS sg13_lv_nmos ad=89.3f pd=0.85u as=0.1598p ps=1.62u w=0.47u l=0.16u
X5193 cml_tlatch_49.xmux.xn.S1 cml_tlatch_83.OUTN MOT18_P VSS sg13_lv_nmos ad=63.19999f pd=0.74u as=63.19999f ps=0.74u w=0.26u l=0.38u
X5194 cml_tlatch_62.xmux.xp.S1 CKB3_P cml_tlatch_62.xtail.S1 VSS sg13_lv_nmos ad=89.3f pd=0.85u as=89.3f ps=0.85u w=0.47u l=0.16u
X5195 cml_tlatch_57.xmux.xp.S1 CKHA3_N cml_tlatch_57.xtail.S1 VSS sg13_lv_nmos ad=89.3f pd=0.85u as=89.3f ps=0.85u w=0.47u l=0.16u
X5196 MOT18_N cml_tlatch_83.OUTP cml_tlatch_49.xmux.xn.S1 VSS sg13_lv_nmos ad=63.19999f pd=0.74u as=63.19999f ps=0.74u w=0.26u l=0.38u
X5197 cml_tlatch_99.xmux.xp.S1 cml_tlatch_99.OUTN cml_tlatch_99.OUTP VSS sg13_lv_nmos ad=56.9f pd=0.74u as=56.9f ps=0.74u w=0.17u l=0.17u
X5198 cml_tlatch_6.xmux.xn.S1 cml_tlatch_6.INP MOT13_N VSS sg13_lv_nmos ad=63.19999f pd=0.74u as=63.19999f ps=0.74u w=0.26u l=0.38u
X5199 cml_tlatch_97.xmux.xp.S1 MOT0_N MOT0_P VSS sg13_lv_nmos ad=56.9f pd=0.74u as=56.9f ps=0.74u w=0.17u l=0.17u
X5200 cml_tlatch_46.xmux.xn.S1 cml_tlatch_47.OUTP B3_2_N VSS sg13_lv_nmos ad=63.19999f pd=0.74u as=0.1082p ps=1.34u w=0.26u l=0.38u
X5201 MOT21_P MOT21_N cml_tlatch_75.xmux.xp.S1 VSS sg13_lv_nmos ad=56.9f pd=0.74u as=56.9f ps=0.74u w=0.17u l=0.17u
X5202 MOT3_P cml_tlatch_16.OUTN cml_tlatch_18.xmux.xn.S1 VSS sg13_lv_nmos ad=63.19999f pd=0.74u as=0.1082p ps=1.34u w=0.26u l=0.38u
X5203 cml_tlatch_20.xmux.xp.S1 MOT7_P MOT7_N VSS sg13_lv_nmos ad=56.9f pd=0.74u as=56.9f ps=0.74u w=0.17u l=0.17u
X5204 cml_tlatch_73.xtail.S1 CKHB2_P cml_tlatch_73.xmux.xn.S1 VSS sg13_lv_nmos ad=89.3f pd=0.85u as=89.3f ps=0.85u w=0.47u l=0.16u
X5205 cml_tlatch_54.xmux.xp.S1 cml_tlatch_54.OUTN cml_tlatch_54.OUTP VSS sg13_lv_nmos ad=56.9f pd=0.74u as=56.9f ps=0.74u w=0.17u l=0.17u
X5206 cml_tlatch_69.xmux.xp.S1 MOT27_N MOT27_P VSS sg13_lv_nmos ad=56.9f pd=0.74u as=56.9f ps=0.74u w=0.17u l=0.17u
X5207 MOT30_P MOT30_N cml_tlatch_59.xmux.xp.S1 VSS sg13_lv_nmos ad=56.9f pd=0.74u as=56.9f ps=0.74u w=0.17u l=0.17u
X5208 cml_tlatch_38.xmux.xn.S1 D1_N cml_tlatch_38.OUTP VSS sg13_lv_nmos ad=63.19999f pd=0.74u as=63.19999f ps=0.74u w=0.26u l=0.38u
X5209 cml_tlatch_94.xmux.xp.S1 CKB1_P cml_tlatch_94.xtail.S1 VSS sg13_lv_nmos ad=89.3f pd=0.85u as=89.3f ps=0.85u w=0.47u l=0.16u
X5210 cml_tlatch_67.OUTN cml_tlatch_58.INP cml_tlatch_67.xmux.xn.S1 VSS sg13_lv_nmos ad=0.1082p pd=1.34u as=63.19999f ps=0.74u w=0.26u l=0.38u
X5211 cml_tlatch_37.xtail.S1 CKA1_P cml_tlatch_37.xmux.xp.S1 VSS sg13_lv_nmos ad=89.3f pd=0.85u as=89.3f ps=0.85u w=0.47u l=0.16u
X5212 B0_8_P VDD VSS rppd l=5.17u w=1u
X5213 cml_tlatch_80.xmux.xp.S1 stub_bi_49.BOTN stub_bi_49.BOTP VSS sg13_lv_nmos ad=56.9f pd=0.74u as=56.9f ps=0.74u w=0.17u l=0.17u
X5214 cml_gate2_3.sg13_lv_nmos_FTPY57_0.D0 ENA0_P GA1_N VSS sg13_lv_nmos ad=0.1007p pd=0.91u as=0.1007p ps=0.91u w=0.53u l=0.13u
X5215 B0_8_N B0_8_P cml_tlatch_10.xmux.xp.S1 VSS sg13_lv_nmos ad=56.9f pd=0.74u as=56.9f ps=0.74u w=0.17u l=0.17u
X5216 cml_tlatch_92.xmux.xp.S1 J2_P J2_N VSS sg13_lv_nmos ad=56.9f pd=0.74u as=56.9f ps=0.74u w=0.17u l=0.17u
X5217 cml_tlatch_53.xmux.xp.S1 A3_2_P A3_2_N VSS sg13_lv_nmos ad=56.9f pd=0.74u as=56.9f ps=0.74u w=0.17u l=0.17u
X5218 cml_tlatch_16.xmux.xp.S1 cml_tlatch_16.OUTP cml_tlatch_16.OUTN VSS sg13_lv_nmos ad=56.9f pd=0.74u as=56.9f ps=0.74u w=0.17u l=0.17u
X5219 MOT17_N MOT17_P cml_tlatch_73.xmux.xp.S1 VSS sg13_lv_nmos ad=56.9f pd=0.74u as=56.9f ps=0.74u w=0.17u l=0.17u
X5220 MOT6_N MOT6_P cml_tlatch_26.xmux.xp.S1 VSS sg13_lv_nmos ad=56.9f pd=0.74u as=0.1019p ps=1.34u w=0.17u l=0.17u
X5221 cml_tlatch_68.xmux.xp.S1 MOT25_P MOT25_N VSS sg13_lv_nmos ad=56.9f pd=0.74u as=56.9f ps=0.74u w=0.17u l=0.17u
X5222 cml_tlatch_30.xmux.xp.S1 cml_tlatch_30.OUTP cml_tlatch_30.OUTN VSS sg13_lv_nmos ad=56.9f pd=0.74u as=56.9f ps=0.74u w=0.17u l=0.17u
X5223 cml_tlatch_87.xmux.xp.S1 MOT16_N MOT16_P VSS sg13_lv_nmos ad=56.9f pd=0.74u as=56.9f ps=0.74u w=0.17u l=0.17u
X5224 cml_tlatch_22.OUTN cml_tlatch_39.INP cml_tlatch_22.xmux.xn.S1 VSS sg13_lv_nmos ad=63.19999f pd=0.74u as=63.19999f ps=0.74u w=0.26u l=0.38u
X5225 VSS POLN cml_tlatch_33.xtail.S1 VSS sg13_lv_nmos ad=1.5637p pd=8.61u as=1.5637p ps=8.61u w=8.23u l=0.13u
X5226 B3_8_P cml_tlatch_61.OUTN cml_tlatch_60.xmux.xn.S1 VSS sg13_lv_nmos ad=63.19999f pd=0.74u as=63.19999f ps=0.74u w=0.26u l=0.38u
X5227 cml_tlatch_5.xmux.xn.S1 cml_tlatch_5.INN MOT11_P VSS sg13_lv_nmos ad=0.1082p pd=1.34u as=63.19999f ps=0.74u w=0.26u l=0.38u
X5228 cml_tlatch_33.xmux.xp.S1 B1_2_P B1_2_N VSS sg13_lv_nmos ad=56.9f pd=0.74u as=56.9f ps=0.74u w=0.17u l=0.17u
X5229 B0_2_P B0_2_N cml_tlatch_28.xmux.xp.S1 VSS sg13_lv_nmos ad=56.9f pd=0.74u as=56.9f ps=0.74u w=0.17u l=0.17u
X5230 MOT26_N VDD VSS rppd l=5.17u w=1u
X5231 cml_tlatch_21.xmux.xp.S1 A1_8_P A1_8_N VSS sg13_lv_nmos ad=56.9f pd=0.74u as=56.9f ps=0.74u w=0.17u l=0.17u
X5232 CLK_W_N J2_N cml_tlatch_91.xmux.xn.S1 VSS sg13_lv_nmos ad=63.19999f pd=0.74u as=0.1082p ps=1.34u w=0.26u l=0.38u
X5233 B2_8_N B2_8_P cml_tlatch_77.xmux.xp.S1 VSS sg13_lv_nmos ad=56.9f pd=0.74u as=56.9f ps=0.74u w=0.17u l=0.17u
X5234 cml_tlatch_91.xmux.xn.S1 J2_P CLK_W_P VSS sg13_lv_nmos ad=63.19999f pd=0.74u as=63.19999f ps=0.74u w=0.26u l=0.38u
X5235 cml_tlatch_67.OUTN cml_tlatch_67.OUTP cml_tlatch_67.xmux.xp.S1 VSS sg13_lv_nmos ad=56.9f pd=0.74u as=0.1019p ps=1.34u w=0.17u l=0.17u
X5236 cml_tlatch_90.xmux.xn.S1 CKJ_N cml_tlatch_90.xtail.S1 VSS sg13_lv_nmos ad=89.3f pd=0.85u as=89.3f ps=0.85u w=0.47u l=0.16u
X5237 VSS POLN cml_tlatch_83.xtail.S1 VSS sg13_lv_nmos ad=2.7982p pd=17.14u as=1.5637p ps=8.61u w=8.23u l=0.13u
X5238 cml_tlatch_6.xmux.xp.S1 MOT13_P MOT13_N VSS sg13_lv_nmos ad=0.1019p pd=1.34u as=56.9f ps=0.74u w=0.17u l=0.17u
X5239 cml_tlatch_38.OUTN cml_tlatch_38.OUTP cml_tlatch_38.xmux.xp.S1 VSS sg13_lv_nmos ad=56.9f pd=0.74u as=56.9f ps=0.74u w=0.17u l=0.17u
X5240 cml_tlatch_42.xtail.S1 CKA2_P cml_tlatch_42.xmux.xn.S1 VSS sg13_lv_nmos ad=89.3f pd=0.85u as=89.3f ps=0.85u w=0.47u l=0.16u
X5241 cml_tlatch_83.OUTP cml_tlatch_83.OUTN cml_tlatch_83.xmux.xp.S1 VSS sg13_lv_nmos ad=56.9f pd=0.74u as=56.9f ps=0.74u w=0.17u l=0.17u
X5242 cml_tlatch_83.OUTN cml_tlatch_83.OUTP cml_tlatch_83.xmux.xp.S1 VSS sg13_lv_nmos ad=56.9f pd=0.74u as=56.9f ps=0.74u w=0.17u l=0.17u
X5243 cml_tlatch_16.xtail.S1 CKB0_P cml_tlatch_16.xmux.xp.S1 VSS sg13_lv_nmos ad=89.3f pd=0.85u as=89.3f ps=0.85u w=0.47u l=0.16u
X5244 cml_tlatch_24.xtail.S1 POLN VSS VSS sg13_lv_nmos ad=1.5637p pd=8.61u as=1.5637p ps=8.61u w=8.23u l=0.13u
X5245 cml_tlatch_79.xmux.xp.S1 stub_bi_63.BOTP stub_bi_63.BOTN VSS sg13_lv_nmos ad=56.9f pd=0.74u as=56.9f ps=0.74u w=0.17u l=0.17u
X5246 cml_tlatch_65.xmux.xp.S1 CKA3_N cml_tlatch_65.xtail.S1 VSS sg13_lv_nmos ad=89.3f pd=0.85u as=89.3f ps=0.85u w=0.47u l=0.16u
X5247 stub_bi_42.BOTN stub_bi_42.BOTP cml_tlatch_43.xmux.xp.S1 VSS sg13_lv_nmos ad=56.9f pd=0.74u as=56.9f ps=0.74u w=0.17u l=0.17u
X5248 cml_tlatch_36.xmux.xp.S1 cml_tlatch_95.INN cml_tlatch_95.INP VSS sg13_lv_nmos ad=56.9f pd=0.74u as=56.9f ps=0.74u w=0.17u l=0.17u
X5249 CKB3_P CK_N hs_to_clk_5.D2 VSS sg13_lv_nmos ad=0.228p pd=1.58u as=0.228p ps=1.58u w=1.2u l=0.2u
X5250 cml_tlatch_82.xmux.xp.S1 cml_tlatch_82.OUTP cml_tlatch_82.OUTN VSS sg13_lv_nmos ad=0.1019p pd=1.34u as=56.9f ps=0.74u w=0.17u l=0.17u
X5251 cml_gate2_4.sg13_lv_nmos_FTPY57_0.D0 CKB2_P cml_gate2_4.xrtail.R1 VSS sg13_lv_nmos ad=0.1007p pd=0.91u as=0.1007p ps=0.91u w=0.53u l=0.13u
X5252 cml_tlatch_6.xmux.xn.S1 CKHB1_P cml_tlatch_6.xtail.S1 VSS sg13_lv_nmos ad=89.3f pd=0.85u as=89.3f ps=0.85u w=0.47u l=0.16u
X5253 cml_tlatch_92.xtail.S1 CKJ_N cml_tlatch_92.xmux.xn.S1 VSS sg13_lv_nmos ad=89.3f pd=0.85u as=89.3f ps=0.85u w=0.47u l=0.16u
X5254 cml_tlatch_0.xmux.xp.S1 CKA1_N cml_tlatch_0.xtail.S1 VSS sg13_lv_nmos ad=89.3f pd=0.85u as=89.3f ps=0.85u w=0.47u l=0.16u
X5255 cml_tlatch_66.xmux.xn.S1 CKA3_N cml_tlatch_66.xtail.S1 VSS sg13_lv_nmos ad=89.3f pd=0.85u as=89.3f ps=0.85u w=0.47u l=0.16u
X5256 cml_gate2_7.xrtail.R1 CKA2_P cml_gate2_7.sg13_lv_nmos_FTPY57_0.D0 VSS sg13_lv_nmos ad=0.1802p pd=1.74u as=0.1007p ps=0.91u w=0.53u l=0.13u
X5257 cml_tlatch_35.OUTP cml_tlatch_35.OUTN cml_tlatch_35.xmux.xp.S1 VSS sg13_lv_nmos ad=56.9f pd=0.74u as=56.9f ps=0.74u w=0.17u l=0.17u
X5258 MOT14_P MOT14_N cml_tlatch_41.xmux.xp.S1 VSS sg13_lv_nmos ad=56.9f pd=0.74u as=56.9f ps=0.74u w=0.17u l=0.17u
X5259 cml_tlatch_61.xmux.xp.S1 CKB3_N cml_tlatch_61.xtail.S1 VSS sg13_lv_nmos ad=89.3f pd=0.85u as=89.3f ps=0.85u w=0.47u l=0.16u
X5260 cml_tlatch_82.OUTP cml_tlatch_82.OUTN cml_tlatch_82.xmux.xp.S1 VSS sg13_lv_nmos ad=56.9f pd=0.74u as=56.9f ps=0.74u w=0.17u l=0.17u
X5261 stub_bi_42.BOTP VDD VSS rppd l=5.17u w=1u
X5262 cml_tlatch_78.xmux.xp.S1 stub_bi_62.BOTP stub_bi_62.BOTN VSS sg13_lv_nmos ad=56.9f pd=0.74u as=56.9f ps=0.74u w=0.17u l=0.17u
X5263 cml_tlatch_27.xmux.xn.S1 CKB0_P cml_tlatch_27.xtail.S1 VSS sg13_lv_nmos ad=89.3f pd=0.85u as=89.3f ps=0.85u w=0.47u l=0.16u
X5264 MOT15_N MOT15_P cml_tlatch_7.xmux.xp.S1 VSS sg13_lv_nmos ad=56.9f pd=0.74u as=56.9f ps=0.74u w=0.17u l=0.17u
X5265 cml_tlatch_95.xmux.xp.S1 cml_tlatch_40.INP cml_tlatch_40.INN VSS sg13_lv_nmos ad=56.9f pd=0.74u as=56.9f ps=0.74u w=0.17u l=0.17u
X5266 cml_tlatch_77.xmux.xn.S1 CKB2_N cml_tlatch_77.xtail.S1 VSS sg13_lv_nmos ad=89.3f pd=0.85u as=89.3f ps=0.85u w=0.47u l=0.16u
X5267 MOT9_P B1_8_N cml_tlatch_4.xmux.xn.S1 VSS sg13_lv_nmos ad=63.19999f pd=0.74u as=63.19999f ps=0.74u w=0.26u l=0.38u
X5268 cml_tlatch_57.xmux.xp.S1 MOT26_N MOT26_P VSS sg13_lv_nmos ad=56.9f pd=0.74u as=56.9f ps=0.74u w=0.17u l=0.17u
X5269 VDD MOT3_N VSS rppd l=5.17u w=1u
X5270 MOT9_P B1_8_N cml_tlatch_4.xmux.xn.S1 VSS sg13_lv_nmos ad=63.19999f pd=0.74u as=63.19999f ps=0.74u w=0.26u l=0.38u
X5271 cml_tlatch_40.INN cml_tlatch_95.INP cml_tlatch_95.xmux.xn.S1 VSS sg13_lv_nmos ad=63.19999f pd=0.74u as=63.19999f ps=0.74u w=0.26u l=0.38u
X5272 cml_tlatch_95.xtail.S1 POLN VSS VSS sg13_lv_nmos ad=1.5637p pd=8.61u as=2.7982p ps=17.14u w=8.23u l=0.13u
X5273 MOT2_P cml_tlatch_8.OUTN cml_tlatch_24.xmux.xn.S1 VSS sg13_lv_nmos ad=0.1082p pd=1.34u as=63.19999f ps=0.74u w=0.26u l=0.38u
X5274 MOT12_P MOT12_N cml_tlatch_40.xmux.xp.S1 VSS sg13_lv_nmos ad=56.9f pd=0.74u as=56.9f ps=0.74u w=0.17u l=0.17u
X5275 cml_tlatch_18.xmux.xp.S1 CKHB0_N cml_tlatch_18.xtail.S1 VSS sg13_lv_nmos ad=89.3f pd=0.85u as=0.1598p ps=1.62u w=0.47u l=0.16u
X5276 cml_tlatch_9.xmux.xn.S1 cml_tlatch_99.OUTN cml_tlatch_9.OUTP VSS sg13_lv_nmos ad=63.19999f pd=0.74u as=63.19999f ps=0.74u w=0.26u l=0.38u
X5277 cml_tlatch_69.xtail.S1 CKHB3_P cml_tlatch_69.xmux.xn.S1 VSS sg13_lv_nmos ad=89.3f pd=0.85u as=89.3f ps=0.85u w=0.47u l=0.16u
X5278 cml_tlatch_31.xtail.S1 CKA0_P cml_tlatch_31.xmux.xp.S1 VSS sg13_lv_nmos ad=89.3f pd=0.85u as=89.3f ps=0.85u w=0.47u l=0.16u
X5279 A3_2_P A3_2_N cml_tlatch_53.xmux.xp.S1 VSS sg13_lv_nmos ad=56.9f pd=0.74u as=56.9f ps=0.74u w=0.17u l=0.17u
X5280 cml_tlatch_11.xmux.xp.S1 CKB0_N cml_tlatch_11.xtail.S1 VSS sg13_lv_nmos ad=89.3f pd=0.85u as=89.3f ps=0.85u w=0.47u l=0.16u
X5281 cml_tlatch_54.xmux.xp.S1 cml_tlatch_54.OUTP cml_tlatch_54.OUTN VSS sg13_lv_nmos ad=56.9f pd=0.74u as=56.9f ps=0.74u w=0.17u l=0.17u
X5282 cml_tlatch_21.xmux.xp.S1 A1_8_P A1_8_N VSS sg13_lv_nmos ad=56.9f pd=0.74u as=56.9f ps=0.74u w=0.17u l=0.17u
X5283 cml_drv_2.xrtail.R1 ENB_P ENB0_N VSS sg13_lv_nmos ad=56.2f pd=0.74u as=56.2f ps=0.74u w=0.16u l=0.19u
X5284 stub_bi_63.BOTP stub_bi_63.BOTN cml_tlatch_79.xmux.xp.S1 VSS sg13_lv_nmos ad=56.9f pd=0.74u as=56.9f ps=0.74u w=0.17u l=0.17u
X5285 cml_tlatch_37.xmux.xp.S1 A1_2_N A1_2_P VSS sg13_lv_nmos ad=56.9f pd=0.74u as=56.9f ps=0.74u w=0.17u l=0.17u
X5286 A1_2_P cml_tlatch_38.OUTN cml_tlatch_37.xmux.xn.S1 VSS sg13_lv_nmos ad=0.1082p pd=1.34u as=63.19999f ps=0.74u w=0.26u l=0.38u
X5287 cml_tlatch_18.xmux.xp.S1 MOT3_P MOT3_N VSS sg13_lv_nmos ad=56.9f pd=0.74u as=56.9f ps=0.74u w=0.17u l=0.17u
X5288 B1_2_P B1_2_N cml_tlatch_33.xmux.xp.S1 VSS sg13_lv_nmos ad=56.9f pd=0.74u as=56.9f ps=0.74u w=0.17u l=0.17u
X5289 cml_tlatch_14.xmux.xn.S1 CKB1_N cml_tlatch_14.xtail.S1 VSS sg13_lv_nmos ad=89.3f pd=0.85u as=89.3f ps=0.85u w=0.47u l=0.16u
X5290 cml_tlatch_88.xmux.xn.S1 CKB2_N cml_tlatch_88.xtail.S1 VSS sg13_lv_nmos ad=89.3f pd=0.85u as=89.3f ps=0.85u w=0.47u l=0.16u
X5291 cml_tlatch_26.xmux.xn.S1 CKHA0_P cml_tlatch_26.xtail.S1 VSS sg13_lv_nmos ad=89.3f pd=0.85u as=89.3f ps=0.85u w=0.47u l=0.16u
X5292 MOT6_N MOT6_P cml_tlatch_26.xmux.xp.S1 VSS sg13_lv_nmos ad=56.9f pd=0.74u as=56.9f ps=0.74u w=0.17u l=0.17u
X5293 cml_tlatch_85.xmux.xn.S1 CKA3_N cml_tlatch_85.xtail.S1 VSS sg13_lv_nmos ad=89.3f pd=0.85u as=89.3f ps=0.85u w=0.47u l=0.16u
X5294 MOT24_P MOT24_N cml_tlatch_86.xmux.xp.S1 VSS sg13_lv_nmos ad=56.9f pd=0.74u as=56.9f ps=0.74u w=0.17u l=0.17u
X5295 MOT28_P MOT28_N cml_tlatch_58.xmux.xp.S1 VSS sg13_lv_nmos ad=56.9f pd=0.74u as=56.9f ps=0.74u w=0.17u l=0.17u
X5296 cml_tlatch_83.OUTN cml_tlatch_83.INP cml_tlatch_83.xmux.xn.S1 VSS sg13_lv_nmos ad=63.19999f pd=0.74u as=63.19999f ps=0.74u w=0.26u l=0.38u
X5297 cml_tlatch_49.xmux.xn.S1 CKHA2_P cml_tlatch_49.xtail.S1 VSS sg13_lv_nmos ad=89.3f pd=0.85u as=0.1598p ps=1.62u w=0.47u l=0.16u
X5298 cml_tlatch_16.OUTP cml_tlatch_16.OUTN cml_tlatch_16.xmux.xp.S1 VSS sg13_lv_nmos ad=56.9f pd=0.74u as=56.9f ps=0.74u w=0.17u l=0.17u
X5299 cml_gate2_9.xrtail.R1 NM1_N ENA_P VSS sg13_lv_nmos ad=0.1007p pd=0.91u as=0.1007p ps=0.91u w=0.53u l=0.13u
X5300 VSS hs_to_clk_3.sg13_lv_nmos_2HGZLP_0.G VSS VSS sg13_lv_nmos ad=2.071p pd=11.28u as=0 ps=0 w=10.9u l=1.38u
X5301 cml_tlatch_80.xmux.xn.S1 CKB2_P cml_tlatch_80.xtail.S1 VSS sg13_lv_nmos ad=89.3f pd=0.85u as=89.3f ps=0.85u w=0.47u l=0.16u
X5302 cml_tlatch_2.xmux.xp.S1 A0_8_N A0_8_P VSS sg13_lv_nmos ad=56.9f pd=0.74u as=56.9f ps=0.74u w=0.17u l=0.17u
X5303 cml_tlatch_39.xmux.xp.S1 MOT10_P MOT10_N VSS sg13_lv_nmos ad=56.9f pd=0.74u as=56.9f ps=0.74u w=0.17u l=0.17u
X5304 cml_tlatch_36.xmux.xp.S1 cml_tlatch_95.INN cml_tlatch_95.INP VSS sg13_lv_nmos ad=56.9f pd=0.74u as=56.9f ps=0.74u w=0.17u l=0.17u
X5305 cml_tlatch_21.xmux.xp.S1 A1_8_P A1_8_N VSS sg13_lv_nmos ad=56.9f pd=0.74u as=56.9f ps=0.74u w=0.17u l=0.17u
X5306 cml_tlatch_84.xmux.xn.S1 cml_tlatch_45.OUTN cml_tlatch_70.INP VSS sg13_lv_nmos ad=63.19999f pd=0.74u as=0.1082p ps=1.34u w=0.26u l=0.38u
X5307 cml_tlatch_74.xmux.xp.S1 CKHB2_N cml_tlatch_74.xtail.S1 VSS sg13_lv_nmos ad=89.3f pd=0.85u as=89.3f ps=0.85u w=0.47u l=0.16u
X5308 cml_tlatch_19.xtail.S1 CKHB0_N cml_tlatch_19.xmux.xp.S1 VSS sg13_lv_nmos ad=89.3f pd=0.85u as=89.3f ps=0.85u w=0.47u l=0.16u
X5309 cml_gate2_9.sg13_lv_nmos_FTPY57_0.D0 J1_P ENA_N VSS sg13_lv_nmos ad=0.1007p pd=0.91u as=0.1007p ps=0.91u w=0.53u l=0.13u
X5310 cml_tlatch_45.xmux.xp.S1 CKB3_N cml_tlatch_45.xtail.S1 VSS sg13_lv_nmos ad=89.3f pd=0.85u as=89.3f ps=0.85u w=0.47u l=0.16u
X5311 cml_tlatch_96.xtail.S1 CKHA1_P cml_tlatch_96.xmux.xn.S1 VSS sg13_lv_nmos ad=89.3f pd=0.85u as=89.3f ps=0.85u w=0.47u l=0.16u
X5312 cml_tlatch_70.INN cml_tlatch_45.OUTP cml_tlatch_84.xmux.xn.S1 VSS sg13_lv_nmos ad=63.19999f pd=0.74u as=63.19999f ps=0.74u w=0.26u l=0.38u
X5313 cml_tlatch_45.OUTN cml_tlatch_45.OUTP cml_tlatch_45.xmux.xp.S1 VSS sg13_lv_nmos ad=56.9f pd=0.74u as=56.9f ps=0.74u w=0.17u l=0.17u
X5314 cml_tlatch_55.xmux.xp.S1 cml_tlatch_89.INP cml_tlatch_89.INN VSS sg13_lv_nmos ad=56.9f pd=0.74u as=56.9f ps=0.74u w=0.17u l=0.17u
X5315 cml_tlatch_56.INP cml_tlatch_56.INN cml_tlatch_42.xmux.xp.S1 VSS sg13_lv_nmos ad=56.9f pd=0.74u as=56.9f ps=0.74u w=0.17u l=0.17u
X5316 cml_tlatch_77.xmux.xp.S1 B2_8_N B2_8_P VSS sg13_lv_nmos ad=56.9f pd=0.74u as=56.9f ps=0.74u w=0.17u l=0.17u
X5317 cml_tlatch_48.xmux.xp.S1 stub_bi_32.BOTP stub_bi_32.BOTN VSS sg13_lv_nmos ad=56.9f pd=0.74u as=56.9f ps=0.74u w=0.17u l=0.17u
X5318 cml_gate2_2.xrtail.R1 CKB0_P cml_gate2_2.sg13_lv_nmos_FTPY57_0.D0 VSS sg13_lv_nmos ad=0.1007p pd=0.91u as=0.1007p ps=0.91u w=0.53u l=0.13u
X5319 cml_tlatch_13.xtail.S1 CKB1_N cml_tlatch_13.xmux.xp.S1 VSS sg13_lv_nmos ad=89.3f pd=0.85u as=89.3f ps=0.85u w=0.47u l=0.16u
X5320 J4_N J4_P cml_tlatch_90.xmux.xp.S1 VSS sg13_lv_nmos ad=56.9f pd=0.74u as=56.9f ps=0.74u w=0.17u l=0.17u
X5321 cml_tlatch_57.xmux.xn.S1 CKHA3_P cml_tlatch_57.xtail.S1 VSS sg13_lv_nmos ad=89.3f pd=0.85u as=89.3f ps=0.85u w=0.47u l=0.16u
X5322 cml_tlatch_44.xmux.xn.S1 CKB2_N cml_tlatch_44.xtail.S1 VSS sg13_lv_nmos ad=89.3f pd=0.85u as=89.3f ps=0.85u w=0.47u l=0.16u
X5323 cml_tlatch_26.xmux.xn.S1 A0_2_N MOT6_P VSS sg13_lv_nmos ad=63.19999f pd=0.74u as=63.19999f ps=0.74u w=0.26u l=0.38u
X5324 MOT15_P MOT15_N cml_tlatch_7.xmux.xp.S1 VSS sg13_lv_nmos ad=56.9f pd=0.74u as=56.9f ps=0.74u w=0.17u l=0.17u
X5325 hs_to_clk_4.D2 CK_N CKA2_N VSS sg13_lv_nmos ad=0.228p pd=1.58u as=0.228p ps=1.58u w=1.2u l=0.2u
X5326 cml_tlatch_36.xmux.xp.S1 cml_tlatch_95.INN cml_tlatch_95.INP VSS sg13_lv_nmos ad=56.9f pd=0.74u as=56.9f ps=0.74u w=0.17u l=0.17u
X5327 stub_bi_19.BOTP stub_bi_19.BOTN cml_tlatch_15.xmux.xp.S1 VSS sg13_lv_nmos ad=56.9f pd=0.74u as=56.9f ps=0.74u w=0.17u l=0.17u
X5328 cml_tlatch_3.OUTP cml_tlatch_8.OUTN cml_tlatch_3.xmux.xn.S1 VSS sg13_lv_nmos ad=63.19999f pd=0.74u as=63.19999f ps=0.74u w=0.26u l=0.38u
X5329 cml_tlatch_26.xmux.xn.S1 A0_2_N MOT6_P VSS sg13_lv_nmos ad=63.19999f pd=0.74u as=63.19999f ps=0.74u w=0.26u l=0.38u
X5330 cml_tlatch_25.xmux.xp.S1 MOT4_P MOT4_N VSS sg13_lv_nmos ad=56.9f pd=0.74u as=56.9f ps=0.74u w=0.17u l=0.17u
X5331 cml_drvb_1.xrtail.R1 GB0_N CKHB0_P VSS sg13_lv_nmos ad=0.1463p pd=1.15u as=0.2618p ps=2.22u w=0.77u l=0.21u
X5332 cml_tlatch_7.xmux.xn.S1 CKHB1_P cml_tlatch_7.xtail.S1 VSS sg13_lv_nmos ad=89.3f pd=0.85u as=89.3f ps=0.85u w=0.47u l=0.16u
X5333 cml_tlatch_12.xmux.xp.S1 CKB1_P cml_tlatch_12.xtail.S1 VSS sg13_lv_nmos ad=89.3f pd=0.85u as=89.3f ps=0.85u w=0.47u l=0.16u
X5334 cml_tlatch_58.INN cml_tlatch_58.INP cml_tlatch_85.xmux.xp.S1 VSS sg13_lv_nmos ad=56.9f pd=0.74u as=56.9f ps=0.74u w=0.17u l=0.17u
X5335 cml_tlatch_98.xmux.xp.S1 cml_tlatch_98.OUTP cml_tlatch_98.OUTN VSS sg13_lv_nmos ad=56.9f pd=0.74u as=56.9f ps=0.74u w=0.17u l=0.17u
X5336 cml_tlatch_81.xmux.xp.S1 CKA2_P cml_tlatch_81.xtail.S1 VSS sg13_lv_nmos ad=89.3f pd=0.85u as=89.3f ps=0.85u w=0.47u l=0.16u
X5337 cml_tlatch_67.xmux.xn.S1 cml_tlatch_58.INN cml_tlatch_67.OUTP VSS sg13_lv_nmos ad=63.19999f pd=0.74u as=63.19999f ps=0.74u w=0.26u l=0.38u
X5338 cml_tlatch_38.OUTN D1_P cml_tlatch_38.xmux.xn.S1 VSS sg13_lv_nmos ad=63.19999f pd=0.74u as=63.19999f ps=0.74u w=0.26u l=0.38u
X5339 cml_tlatch_92.xtail.S1 CKJ_P cml_tlatch_92.xmux.xp.S1 VSS sg13_lv_nmos ad=89.3f pd=0.85u as=89.3f ps=0.85u w=0.47u l=0.16u
X5340 MOT31_P MOT31_N cml_tlatch_71.xmux.xp.S1 VSS sg13_lv_nmos ad=56.9f pd=0.74u as=56.9f ps=0.74u w=0.17u l=0.17u
X5341 cml_tlatch_84.xmux.xp.S1 CKB3_P cml_tlatch_84.xtail.S1 VSS sg13_lv_nmos ad=89.3f pd=0.85u as=89.3f ps=0.85u w=0.47u l=0.16u
X5342 cml_tlatch_6.INN cml_tlatch_6.INP cml_tlatch_94.xmux.xp.S1 VSS sg13_lv_nmos ad=56.9f pd=0.74u as=56.9f ps=0.74u w=0.17u l=0.17u
X5343 cml_tlatch_90.xtail.S1 CKJ_N cml_tlatch_90.xmux.xn.S1 VSS sg13_lv_nmos ad=89.3f pd=0.85u as=89.3f ps=0.85u w=0.47u l=0.16u
X5344 cml_tlatch_89.OUTN cml_tlatch_89.INP cml_tlatch_89.xmux.xn.S1 VSS sg13_lv_nmos ad=0.1082p pd=1.34u as=63.19999f ps=0.74u w=0.26u l=0.38u
X5345 cml_tlatch_22.xmux.xp.S1 cml_tlatch_22.OUTN cml_tlatch_22.OUTP VSS sg13_lv_nmos ad=56.9f pd=0.74u as=56.9f ps=0.74u w=0.17u l=0.17u
X5346 VSS hs_to_clk_7.sg13_lv_nmos_2HGZLP_0.G VSS VSS sg13_lv_nmos ad=2.071p pd=11.28u as=0 ps=0 w=10.9u l=1.38u
X5347 stub_bi_31.BOTP stub_bi_31.BOTN cml_tlatch_34.xmux.xp.S1 VSS sg13_lv_nmos ad=56.9f pd=0.74u as=56.9f ps=0.74u w=0.17u l=0.17u
X5348 stub_bi_31.BOTP VDD VSS rppd l=5.17u w=1u
X5349 cml_tlatch_82.xmux.xn.S1 CKA2_P cml_tlatch_82.xtail.S1 VSS sg13_lv_nmos ad=89.3f pd=0.85u as=89.3f ps=0.85u w=0.47u l=0.16u
X5350 cml_tlatch_16.xmux.xn.S1 CKB0_N cml_tlatch_16.xtail.S1 VSS sg13_lv_nmos ad=89.3f pd=0.85u as=89.3f ps=0.85u w=0.47u l=0.16u
X5351 MOT11_N MOT11_P cml_tlatch_5.xmux.xp.S1 VSS sg13_lv_nmos ad=56.9f pd=0.74u as=56.9f ps=0.74u w=0.17u l=0.17u
X5352 cml_tlatch_23.xmux.xp.S1 CKA1_P cml_tlatch_23.xtail.S1 VSS sg13_lv_nmos ad=89.3f pd=0.85u as=89.3f ps=0.85u w=0.47u l=0.16u
X5353 cml_tlatch_9.xmux.xp.S1 CKA0_N cml_tlatch_9.xtail.S1 VSS sg13_lv_nmos ad=89.3f pd=0.85u as=89.3f ps=0.85u w=0.47u l=0.16u
X5354 cml_tlatch_18.xmux.xn.S1 CKHB0_P cml_tlatch_18.xtail.S1 VSS sg13_lv_nmos ad=89.3f pd=0.85u as=89.3f ps=0.85u w=0.47u l=0.16u
X5355 GA1_P VDD VSS rppd l=7.42u w=1u
X5356 cml_tlatch_22.OUTN cml_tlatch_22.OUTP cml_tlatch_22.xmux.xp.S1 VSS sg13_lv_nmos ad=56.9f pd=0.74u as=56.9f ps=0.74u w=0.17u l=0.17u
X5357 cml_tlatch_46.xmux.xp.S1 B3_2_N B3_2_P VSS sg13_lv_nmos ad=56.9f pd=0.74u as=56.9f ps=0.74u w=0.17u l=0.17u
X5358 cml_tlatch_8.xmux.xn.S1 cml_tlatch_9.OUTN cml_tlatch_8.OUTP VSS sg13_lv_nmos ad=63.19999f pd=0.74u as=63.19999f ps=0.74u w=0.26u l=0.38u
X5359 cml_tlatch_13.xmux.xp.S1 stub_bi_17.BOTN stub_bi_17.BOTP VSS sg13_lv_nmos ad=56.9f pd=0.74u as=56.9f ps=0.74u w=0.17u l=0.17u
X5360 A2_2_N A2_2_P cml_tlatch_56.xmux.xp.S1 VSS sg13_lv_nmos ad=56.9f pd=0.74u as=56.9f ps=0.74u w=0.17u l=0.17u
X5361 cml_tlatch_90.xmux.xp.S1 J4_P J4_N VSS sg13_lv_nmos ad=56.9f pd=0.74u as=56.9f ps=0.74u w=0.17u l=0.17u
X5362 stub_bi_32.BOTN D2_N cml_tlatch_48.xmux.xn.S1 VSS sg13_lv_nmos ad=63.19999f pd=0.74u as=63.19999f ps=0.74u w=0.26u l=0.38u
X5363 cml_tlatch_35.OUTN D0_P cml_tlatch_35.xmux.xn.S1 VSS sg13_lv_nmos ad=63.19999f pd=0.74u as=0.1082p ps=1.34u w=0.26u l=0.38u
X5364 cml_tlatch_78.xmux.xn.S1 CKB2_P cml_tlatch_78.xtail.S1 VSS sg13_lv_nmos ad=89.3f pd=0.85u as=89.3f ps=0.85u w=0.47u l=0.16u
X5365 B1_2_P B1_2_N cml_tlatch_33.xmux.xp.S1 VSS sg13_lv_nmos ad=56.9f pd=0.74u as=56.9f ps=0.74u w=0.17u l=0.17u
X5366 cml_tlatch_39.xmux.xp.S1 CKHA1_N cml_tlatch_39.xtail.S1 VSS sg13_lv_nmos ad=89.3f pd=0.85u as=89.3f ps=0.85u w=0.47u l=0.16u
X5367 VDD cml_tlatch_95.INP VSS rppd l=5.17u w=1u
X5368 cml_tlatch_14.xmux.xp.S1 CKB1_P cml_tlatch_14.xtail.S1 VSS sg13_lv_nmos ad=89.3f pd=0.85u as=89.3f ps=0.85u w=0.47u l=0.16u
X5369 cml_tlatch_65.xmux.xn.S1 CKA3_P cml_tlatch_65.xtail.S1 VSS sg13_lv_nmos ad=89.3f pd=0.85u as=89.3f ps=0.85u w=0.47u l=0.16u
X5370 MOT20_N MOT20_P cml_tlatch_50.xmux.xp.S1 VSS sg13_lv_nmos ad=56.9f pd=0.74u as=0.1019p ps=1.34u w=0.17u l=0.17u
X5371 cml_tlatch_57.INP cml_tlatch_57.INN cml_tlatch_66.xmux.xp.S1 VSS sg13_lv_nmos ad=56.9f pd=0.74u as=56.9f ps=0.74u w=0.17u l=0.17u
X5372 cml_tlatch_16.OUTP cml_tlatch_16.OUTN cml_tlatch_16.xmux.xp.S1 VSS sg13_lv_nmos ad=56.9f pd=0.74u as=56.9f ps=0.74u w=0.17u l=0.17u
X5373 MOT9_P MOT9_N cml_tlatch_4.xmux.xp.S1 VSS sg13_lv_nmos ad=56.9f pd=0.74u as=56.9f ps=0.74u w=0.17u l=0.17u
X5374 VDD MOT5_P VSS rppd l=5.17u w=1u
X5375 cml_tlatch_15.xmux.xn.S1 cml_tlatch_6.INN stub_bi_19.BOTN VSS sg13_lv_nmos ad=63.19999f pd=0.74u as=0.1082p ps=1.34u w=0.26u l=0.38u
X5376 cml_tlatch_72.xmux.xp.S1 cml_tlatch_83.INP cml_tlatch_83.INN VSS sg13_lv_nmos ad=56.9f pd=0.74u as=56.9f ps=0.74u w=0.17u l=0.17u
X5377 MOT15_P B1_2_N cml_tlatch_7.xmux.xn.S1 VSS sg13_lv_nmos ad=63.19999f pd=0.74u as=63.19999f ps=0.74u w=0.26u l=0.38u
X5378 cml_tlatch_52.xmux.xn.S1 A3_2_N cml_tlatch_52.OUTP VSS sg13_lv_nmos ad=63.19999f pd=0.74u as=63.19999f ps=0.74u w=0.26u l=0.38u
X5379 cml_tlatch_55.xmux.xp.S1 cml_tlatch_89.INP cml_tlatch_89.INN VSS sg13_lv_nmos ad=56.9f pd=0.74u as=56.9f ps=0.74u w=0.17u l=0.17u
X5380 cml_tlatch_99.xtail.S1 CKA0_N cml_tlatch_99.xmux.xn.S1 VSS sg13_lv_nmos ad=89.3f pd=0.85u as=89.3f ps=0.85u w=0.47u l=0.16u
X5381 cml_tlatch_15.xmux.xp.S1 stub_bi_19.BOTP stub_bi_19.BOTN VSS sg13_lv_nmos ad=56.9f pd=0.74u as=56.9f ps=0.74u w=0.17u l=0.17u
X5382 A1_8_P A1_8_N cml_tlatch_21.xmux.xp.S1 VSS sg13_lv_nmos ad=56.9f pd=0.74u as=0.1019p ps=1.34u w=0.17u l=0.17u
X5383 cml_tlatch_49.xmux.xn.S1 cml_tlatch_83.OUTP MOT18_N VSS sg13_lv_nmos ad=63.19999f pd=0.74u as=63.19999f ps=0.74u w=0.26u l=0.38u
X5384 J4_N J4_P cml_tlatch_90.xmux.xp.S1 VSS sg13_lv_nmos ad=56.9f pd=0.74u as=56.9f ps=0.74u w=0.17u l=0.17u
X5385 CKB1_N hs_to_clk_2.sg13_lv_nmos_2HGZLP_0.G VSS rppd l=4.25u w=1u
X5386 cml_tlatch_1.xmux.xp.S1 cml_tlatch_1.OUTP cml_tlatch_1.OUTN VSS sg13_lv_nmos ad=56.9f pd=0.74u as=56.9f ps=0.74u w=0.17u l=0.17u
X5387 GA3_P CKB3_N cml_gate2_5.xrtail.R1 VSS sg13_lv_nmos ad=0.1007p pd=0.91u as=0.1007p ps=0.91u w=0.53u l=0.13u
X5388 cml_drv_0.xrtail.R1 ENB_P ENB1_N VSS sg13_lv_nmos ad=56.2f pd=0.74u as=56.2f ps=0.74u w=0.16u l=0.19u
X5389 cml_tlatch_21.xmux.xn.S1 CKA1_N cml_tlatch_21.xtail.S1 VSS sg13_lv_nmos ad=89.3f pd=0.85u as=89.3f ps=0.85u w=0.47u l=0.16u
X5390 cml_tlatch_65.OUTP cml_tlatch_65.OUTN cml_tlatch_65.xmux.xp.S1 VSS sg13_lv_nmos ad=56.9f pd=0.74u as=56.9f ps=0.74u w=0.17u l=0.17u
X5391 cml_tlatch_3.OUTN cml_tlatch_3.OUTP cml_tlatch_3.xmux.xp.S1 VSS sg13_lv_nmos ad=56.9f pd=0.74u as=56.9f ps=0.74u w=0.17u l=0.17u
X5392 MOT25_P MOT25_N cml_tlatch_68.xmux.xp.S1 VSS sg13_lv_nmos ad=56.9f pd=0.74u as=56.9f ps=0.74u w=0.17u l=0.17u
X5393 cml_tlatch_2.xmux.xn.S1 CKA0_N cml_tlatch_2.xtail.S1 VSS sg13_lv_nmos ad=0.1598p pd=1.62u as=89.3f ps=0.85u w=0.47u l=0.16u
X5394 cml_tlatch_38.xmux.xp.S1 cml_tlatch_38.OUTN cml_tlatch_38.OUTP VSS sg13_lv_nmos ad=56.9f pd=0.74u as=56.9f ps=0.74u w=0.17u l=0.17u
X5395 cml_tlatch_8.xmux.xp.S1 cml_tlatch_8.OUTP cml_tlatch_8.OUTN VSS sg13_lv_nmos ad=56.9f pd=0.74u as=56.9f ps=0.74u w=0.17u l=0.17u
X5396 cml_tlatch_29.OUTP cml_tlatch_29.OUTN cml_tlatch_29.xmux.xp.S1 VSS sg13_lv_nmos ad=56.9f pd=0.74u as=56.9f ps=0.74u w=0.17u l=0.17u
X5397 A2_8_P cml_tlatch_82.OUTN cml_tlatch_81.xmux.xn.S1 VSS sg13_lv_nmos ad=63.19999f pd=0.74u as=63.19999f ps=0.74u w=0.26u l=0.38u
X5398 cml_tlatch_81.xmux.xn.S1 CKA2_N cml_tlatch_81.xtail.S1 VSS sg13_lv_nmos ad=0.1598p pd=1.62u as=89.3f ps=0.85u w=0.47u l=0.16u
X5399 cml_tlatch_52.OUTN A3_2_P cml_tlatch_52.xmux.xn.S1 VSS sg13_lv_nmos ad=63.19999f pd=0.74u as=0.1082p ps=1.34u w=0.26u l=0.38u
X5400 cml_tlatch_98.xmux.xp.S1 cml_tlatch_98.OUTP cml_tlatch_98.OUTN VSS sg13_lv_nmos ad=56.9f pd=0.74u as=56.9f ps=0.74u w=0.17u l=0.17u
X5401 MOT13_N MOT13_P cml_tlatch_6.xmux.xp.S1 VSS sg13_lv_nmos ad=56.9f pd=0.74u as=56.9f ps=0.74u w=0.17u l=0.17u
X5402 VSS hs_to_clk_8.sg13_lv_nmos_2HGZLP_0.G VSS VSS sg13_lv_nmos ad=2.071p pd=11.28u as=0 ps=0 w=10.9u l=1.38u
X5403 cml_tlatch_56.xtail.S1 POLN VSS VSS sg13_lv_nmos ad=1.5637p pd=8.61u as=1.5637p ps=8.61u w=8.23u l=0.13u
X5404 cml_tlatch_69.INP cml_tlatch_69.INN cml_tlatch_62.xmux.xp.S1 VSS sg13_lv_nmos ad=56.9f pd=0.74u as=0.1019p ps=1.34u w=0.17u l=0.17u
X5405 MOT20_N MOT20_P cml_tlatch_50.xmux.xp.S1 VSS sg13_lv_nmos ad=56.9f pd=0.74u as=56.9f ps=0.74u w=0.17u l=0.17u
X5406 MOT21_N stub_bi_55.BOTN cml_tlatch_75.xmux.xn.S1 VSS sg13_lv_nmos ad=63.19999f pd=0.74u as=0.1082p ps=1.34u w=0.26u l=0.38u
X5407 hs_to_clk_6.D2 CK_P CKB2_N VSS sg13_lv_nmos ad=0.408p pd=3.08u as=0.228p ps=1.58u w=1.2u l=0.2u
X5408 VDD hs_to_clk_4.sg13_lv_nmos_2HGZLP_0.G VSS rppd l=0.68u w=1u
X5409 cml_tlatch_80.xtail.S1 CKB2_P cml_tlatch_80.xmux.xn.S1 VSS sg13_lv_nmos ad=89.3f pd=0.85u as=0.1598p ps=1.62u w=0.47u l=0.16u
X5410 cml_tlatch_10.xmux.xp.S1 B0_8_N B0_8_P VSS sg13_lv_nmos ad=56.9f pd=0.74u as=56.9f ps=0.74u w=0.17u l=0.17u
X5411 VSS POLN cml_tlatch_8.xtail.S1 VSS sg13_lv_nmos ad=1.5637p pd=8.61u as=1.5637p ps=8.61u w=8.23u l=0.13u
X5412 VSS POLN cml_tlatch_40.xtail.S1 VSS sg13_lv_nmos ad=2.7982p pd=17.14u as=1.5637p ps=8.61u w=8.23u l=0.13u
X5413 cml_tlatch_74.xtail.S1 CKHB2_N cml_tlatch_74.xmux.xp.S1 VSS sg13_lv_nmos ad=89.3f pd=0.85u as=89.3f ps=0.85u w=0.47u l=0.16u
X5414 cml_tlatch_33.xtail.S1 CKB1_P cml_tlatch_33.xmux.xp.S1 VSS sg13_lv_nmos ad=0.1598p pd=1.62u as=89.3f ps=0.85u w=0.47u l=0.16u
X5415 VSS POLN cml_tlatch_99.xtail.S1 VSS sg13_lv_nmos ad=2.7982p pd=17.14u as=1.5637p ps=8.61u w=8.23u l=0.13u
X5416 cml_tlatch_18.xmux.xp.S1 MOT3_N MOT3_P VSS sg13_lv_nmos ad=56.9f pd=0.74u as=56.9f ps=0.74u w=0.17u l=0.17u
X5417 cml_tlatch_62.xmux.xn.S1 CKB3_N cml_tlatch_62.xtail.S1 VSS sg13_lv_nmos ad=89.3f pd=0.85u as=89.3f ps=0.85u w=0.47u l=0.16u
X5418 MOT30_P VDD VSS rppd l=5.17u w=1u
X5419 cml_tlatch_56.xmux.xp.S1 A2_2_N A2_2_P VSS sg13_lv_nmos ad=56.9f pd=0.74u as=56.9f ps=0.74u w=0.17u l=0.17u
X5420 cml_tlatch_4.xmux.xn.S1 CKHB1_P cml_tlatch_4.xtail.S1 VSS sg13_lv_nmos ad=89.3f pd=0.85u as=89.3f ps=0.85u w=0.47u l=0.16u
X5421 cml_tlatch_84.xmux.xp.S1 cml_tlatch_70.INN cml_tlatch_70.INP VSS sg13_lv_nmos ad=56.9f pd=0.74u as=56.9f ps=0.74u w=0.17u l=0.17u
X5422 MOT29_N MOT29_P cml_tlatch_70.xmux.xp.S1 VSS sg13_lv_nmos ad=56.9f pd=0.74u as=56.9f ps=0.74u w=0.17u l=0.17u
X5423 GB2_P ENB0_N cml_gate2_7.sg13_lv_nmos_FTPY57_0.D0 VSS sg13_lv_nmos ad=0.1007p pd=0.91u as=0.1007p ps=0.91u w=0.53u l=0.13u
X5424 cml_tlatch_59.xmux.xp.S1 MOT30_P MOT30_N VSS sg13_lv_nmos ad=0.1019p pd=1.34u as=56.9f ps=0.74u w=0.17u l=0.17u
X5425 cml_tlatch_51.xtail.S1 CKHA2_P cml_tlatch_51.xmux.xn.S1 VSS sg13_lv_nmos ad=89.3f pd=0.85u as=89.3f ps=0.85u w=0.47u l=0.16u
X5426 cml_tlatch_69.xtail.S1 CKHB3_N cml_tlatch_69.xmux.xp.S1 VSS sg13_lv_nmos ad=89.3f pd=0.85u as=89.3f ps=0.85u w=0.47u l=0.16u
X5427 cml_tlatch_93.xmux.xp.S1 J1_N J1_P VSS sg13_lv_nmos ad=56.9f pd=0.74u as=56.9f ps=0.74u w=0.17u l=0.17u
X5428 cml_tlatch_63.xtail.S1 CKB3_P cml_tlatch_63.xmux.xn.S1 VSS sg13_lv_nmos ad=89.3f pd=0.85u as=89.3f ps=0.85u w=0.47u l=0.16u
X5429 cml_tlatch_69.xmux.xn.S1 cml_tlatch_69.INN MOT27_P VSS sg13_lv_nmos ad=63.19999f pd=0.74u as=0.1082p ps=1.34u w=0.26u l=0.38u
X5430 cml_tlatch_31.xmux.xp.S1 A0_2_P A0_2_N VSS sg13_lv_nmos ad=56.9f pd=0.74u as=56.9f ps=0.74u w=0.17u l=0.17u
X5431 cml_tlatch_13.xmux.xp.S1 stub_bi_17.BOTN stub_bi_17.BOTP VSS sg13_lv_nmos ad=56.9f pd=0.74u as=56.9f ps=0.74u w=0.17u l=0.17u
X5432 cml_tlatch_93.xmux.xn.S1 CKJ_P cml_tlatch_93.xtail.S1 VSS sg13_lv_nmos ad=89.3f pd=0.85u as=89.3f ps=0.85u w=0.47u l=0.16u
X5433 cml_tlatch_11.OUTP cml_tlatch_11.OUTN cml_tlatch_11.xmux.xp.S1 VSS sg13_lv_nmos ad=56.9f pd=0.74u as=56.9f ps=0.74u w=0.17u l=0.17u
X5434 cml_tlatch_0.xmux.xn.S1 CKA1_P cml_tlatch_0.xtail.S1 VSS sg13_lv_nmos ad=0.1598p pd=1.62u as=89.3f ps=0.85u w=0.47u l=0.16u
X5435 MOT16_N A2_8_P cml_tlatch_87.xmux.xn.S1 VSS sg13_lv_nmos ad=63.19999f pd=0.74u as=63.19999f ps=0.74u w=0.26u l=0.38u
X5436 cml_tlatch_14.xmux.xp.S1 cml_tlatch_5.INP cml_tlatch_5.INN VSS sg13_lv_nmos ad=56.9f pd=0.74u as=56.9f ps=0.74u w=0.17u l=0.17u
X5437 cml_tlatch_28.xmux.xn.S1 CKB0_N cml_tlatch_28.xtail.S1 VSS sg13_lv_nmos ad=89.3f pd=0.85u as=89.3f ps=0.85u w=0.47u l=0.16u
X5438 cml_tlatch_99.xmux.xp.S1 CKA0_P cml_tlatch_99.xtail.S1 VSS sg13_lv_nmos ad=89.3f pd=0.85u as=89.3f ps=0.85u w=0.47u l=0.16u
X5439 cml_tlatch_72.xmux.xp.S1 CKA2_N cml_tlatch_72.xtail.S1 VSS sg13_lv_nmos ad=89.3f pd=0.85u as=0.1598p ps=1.62u w=0.47u l=0.16u
X5440 MOT0_P MOT0_N cml_tlatch_97.xmux.xp.S1 VSS sg13_lv_nmos ad=56.9f pd=0.74u as=56.9f ps=0.74u w=0.17u l=0.17u
X5441 cml_tlatch_86.xtail.S1 CKHA3_P cml_tlatch_86.xmux.xn.S1 VSS sg13_lv_nmos ad=0.1598p pd=1.62u as=89.3f ps=0.85u w=0.47u l=0.16u
X5442 cml_tlatch_74.xmux.xp.S1 MOT19_N MOT19_P VSS sg13_lv_nmos ad=56.9f pd=0.74u as=56.9f ps=0.74u w=0.17u l=0.17u
X5443 cml_tlatch_2.xmux.xp.S1 CKA0_P cml_tlatch_2.xtail.S1 VSS sg13_lv_nmos ad=89.3f pd=0.85u as=89.3f ps=0.85u w=0.47u l=0.16u
X5444 MOT7_N MOT7_P cml_tlatch_20.xmux.xp.S1 VSS sg13_lv_nmos ad=56.9f pd=0.74u as=56.9f ps=0.74u w=0.17u l=0.17u
X5445 cml_tlatch_37.xmux.xn.S1 CKA1_N cml_tlatch_37.xtail.S1 VSS sg13_lv_nmos ad=89.3f pd=0.85u as=89.3f ps=0.85u w=0.47u l=0.16u
X5446 A3_8_P A3_8_N cml_tlatch_64.xmux.xp.S1 VSS sg13_lv_nmos ad=56.9f pd=0.74u as=56.9f ps=0.74u w=0.17u l=0.17u
X5447 cml_tlatch_54.OUTP cml_tlatch_54.OUTN cml_tlatch_54.xmux.xp.S1 VSS sg13_lv_nmos ad=56.9f pd=0.74u as=56.9f ps=0.74u w=0.17u l=0.17u
X5448 cml_tlatch_88.xmux.xn.S1 CKB2_N cml_tlatch_88.xtail.S1 VSS sg13_lv_nmos ad=89.3f pd=0.85u as=89.3f ps=0.85u w=0.47u l=0.16u
X5449 cml_tlatch_84.xtail.S1 CKB3_P cml_tlatch_84.xmux.xp.S1 VSS sg13_lv_nmos ad=89.3f pd=0.85u as=89.3f ps=0.85u w=0.47u l=0.16u
X5450 VDD cml_tlatch_39.INN VSS rppd l=5.17u w=1u
X5451 hs_to_clk_2.sg13_lv_nmos_2HGZLP_0.G VDD VSS rppd l=0.68u w=1u
X5452 cml_tlatch_62.xmux.xn.S1 cml_tlatch_63.OUTP cml_tlatch_69.INN VSS sg13_lv_nmos ad=0.1082p pd=1.34u as=63.19999f ps=0.74u w=0.26u l=0.38u
X5453 cml_tlatch_43.xtail.S1 CKB2_P cml_tlatch_43.xmux.xn.S1 VSS sg13_lv_nmos ad=89.3f pd=0.85u as=89.3f ps=0.85u w=0.47u l=0.16u
X5454 cml_tlatch_72.xmux.xp.S1 cml_tlatch_83.INP cml_tlatch_83.INN VSS sg13_lv_nmos ad=56.9f pd=0.74u as=56.9f ps=0.74u w=0.17u l=0.17u
X5455 cml_tlatch_56.xmux.xn.S1 CKA2_N cml_tlatch_56.xtail.S1 VSS sg13_lv_nmos ad=0.1598p pd=1.62u as=89.3f ps=0.85u w=0.47u l=0.16u
X5456 stub_bi_49.BOTP stub_bi_49.BOTN cml_tlatch_80.xmux.xp.S1 VSS sg13_lv_nmos ad=56.9f pd=0.74u as=56.9f ps=0.74u w=0.17u l=0.17u
X5457 cml_tlatch_62.xmux.xn.S1 cml_tlatch_63.OUTP cml_tlatch_69.INN VSS sg13_lv_nmos ad=63.19999f pd=0.74u as=63.19999f ps=0.74u w=0.26u l=0.38u
X5458 cml_tlatch_19.xtail.S1 CKHB0_N cml_tlatch_19.xmux.xp.S1 VSS sg13_lv_nmos ad=89.3f pd=0.85u as=89.3f ps=0.85u w=0.47u l=0.16u
X5459 J2_N J2_P cml_tlatch_92.xmux.xp.S1 VSS sg13_lv_nmos ad=56.9f pd=0.74u as=56.9f ps=0.74u w=0.17u l=0.17u
X5460 cml_gate2_8.sg13_lv_nmos_FTPY57_0.D0 J2_P ENB_N VSS sg13_lv_nmos ad=0.1007p pd=0.91u as=0.1007p ps=0.91u w=0.53u l=0.13u
X5461 cml_tlatch_73.xmux.xp.S1 MOT17_P MOT17_N VSS sg13_lv_nmos ad=56.9f pd=0.74u as=56.9f ps=0.74u w=0.17u l=0.17u
X5462 cml_tlatch_96.xtail.S1 CKHA1_P cml_tlatch_96.xmux.xn.S1 VSS sg13_lv_nmos ad=89.3f pd=0.85u as=89.3f ps=0.85u w=0.47u l=0.16u
X5463 cml_tlatch_23.xmux.xn.S1 interco_bi_19.INP cml_tlatch_39.INN VSS sg13_lv_nmos ad=63.19999f pd=0.74u as=63.19999f ps=0.74u w=0.26u l=0.38u
X5464 cml_tlatch_35.xtail.S1 CKA0_N cml_tlatch_35.xmux.xp.S1 VSS sg13_lv_nmos ad=89.3f pd=0.85u as=89.3f ps=0.85u w=0.47u l=0.16u
X5465 cml_tlatch_30.OUTN cml_tlatch_30.OUTP cml_tlatch_30.xmux.xp.S1 VSS sg13_lv_nmos ad=56.9f pd=0.74u as=56.9f ps=0.74u w=0.17u l=0.17u
X5466 VSS POLN cml_tlatch_70.xtail.S1 VSS sg13_lv_nmos ad=1.5637p pd=8.61u as=1.5637p ps=8.61u w=8.23u l=0.13u
X5467 cml_tlatch_36.xmux.xp.S1 CKA1_N cml_tlatch_36.xtail.S1 VSS sg13_lv_nmos ad=89.3f pd=0.85u as=0.1598p ps=1.62u w=0.47u l=0.16u
X5468 VDD MOT1_P VSS rppd l=5.17u w=1u
X5469 cml_tlatch_28.xmux.xp.S1 B0_2_N B0_2_P VSS sg13_lv_nmos ad=56.9f pd=0.74u as=56.9f ps=0.74u w=0.17u l=0.17u
X5470 cml_tlatch_5.xtail.S1 POLN VSS VSS sg13_lv_nmos ad=1.5637p pd=8.61u as=1.5637p ps=8.61u w=8.23u l=0.13u
X5471 A2_8_N A2_8_P cml_tlatch_81.xmux.xp.S1 VSS sg13_lv_nmos ad=56.9f pd=0.74u as=56.9f ps=0.74u w=0.17u l=0.17u
X5472 cml_tlatch_77.xmux.xp.S1 B2_8_P B2_8_N VSS sg13_lv_nmos ad=56.9f pd=0.74u as=56.9f ps=0.74u w=0.17u l=0.17u
X5473 cml_tlatch_3.xmux.xn.S1 cml_tlatch_8.OUTP cml_tlatch_3.OUTN VSS sg13_lv_nmos ad=63.19999f pd=0.74u as=63.19999f ps=0.74u w=0.26u l=0.38u
X5474 cml_tlatch_89.xmux.xp.S1 cml_tlatch_89.OUTP cml_tlatch_89.OUTN VSS sg13_lv_nmos ad=56.9f pd=0.74u as=56.9f ps=0.74u w=0.17u l=0.17u
X5475 cml_tlatch_99.OUTP cml_tlatch_99.OUTN cml_tlatch_99.xmux.xp.S1 VSS sg13_lv_nmos ad=56.9f pd=0.74u as=56.9f ps=0.74u w=0.17u l=0.17u
X5476 cml_tlatch_68.xmux.xn.S1 B3_8_P MOT25_N VSS sg13_lv_nmos ad=63.19999f pd=0.74u as=63.19999f ps=0.74u w=0.26u l=0.38u
X5477 VSS POLN hs_to_clk_6.D2 VSS sg13_lv_nmos ad=1.9p pd=10.38u as=3.4p ps=20.68u w=10u l=0.13u
X5478 MOT13_N MOT13_P cml_tlatch_6.xmux.xp.S1 VSS sg13_lv_nmos ad=56.9f pd=0.74u as=56.9f ps=0.74u w=0.17u l=0.17u
X5479 stub_bi_32.BOTP stub_bi_32.BOTN cml_tlatch_48.xmux.xp.S1 VSS sg13_lv_nmos ad=56.9f pd=0.74u as=56.9f ps=0.74u w=0.17u l=0.17u
X5480 cml_tlatch_26.xtail.S1 CKHA0_N cml_tlatch_26.xmux.xp.S1 VSS sg13_lv_nmos ad=89.3f pd=0.85u as=89.3f ps=0.85u w=0.47u l=0.16u
X5481 cml_tlatch_38.xmux.xp.S1 cml_tlatch_38.OUTP cml_tlatch_38.OUTN VSS sg13_lv_nmos ad=56.9f pd=0.74u as=56.9f ps=0.74u w=0.17u l=0.17u
X5482 cml_tlatch_69.INN cml_tlatch_69.INP cml_tlatch_62.xmux.xp.S1 VSS sg13_lv_nmos ad=56.9f pd=0.74u as=56.9f ps=0.74u w=0.17u l=0.17u
X5483 MOT20_N cml_tlatch_89.OUTP cml_tlatch_50.xmux.xn.S1 VSS sg13_lv_nmos ad=63.19999f pd=0.74u as=63.19999f ps=0.74u w=0.26u l=0.38u
X5484 cml_tlatch_37.xmux.xp.S1 A1_2_P A1_2_N VSS sg13_lv_nmos ad=56.9f pd=0.74u as=56.9f ps=0.74u w=0.17u l=0.17u
X5485 cml_tlatch_83.xmux.xp.S1 cml_tlatch_83.OUTN cml_tlatch_83.OUTP VSS sg13_lv_nmos ad=56.9f pd=0.74u as=56.9f ps=0.74u w=0.17u l=0.17u
X5486 cml_tlatch_28.xtail.S1 CKB0_P cml_tlatch_28.xmux.xp.S1 VSS sg13_lv_nmos ad=0.1598p pd=1.62u as=89.3f ps=0.85u w=0.47u l=0.16u
X5487 MOT5_P cml_tlatch_98.OUTN cml_tlatch_19.xmux.xn.S1 VSS sg13_lv_nmos ad=63.19999f pd=0.74u as=63.19999f ps=0.74u w=0.26u l=0.38u
X5488 cml_tlatch_24.xmux.xp.S1 MOT2_N MOT2_P VSS sg13_lv_nmos ad=56.9f pd=0.74u as=56.9f ps=0.74u w=0.17u l=0.17u
X5489 cml_tlatch_92.xtail.S1 CKJ_P cml_tlatch_92.xmux.xp.S1 VSS sg13_lv_nmos ad=89.3f pd=0.85u as=89.3f ps=0.85u w=0.47u l=0.16u
X5490 cml_tlatch_89.INP cml_tlatch_89.INN cml_tlatch_55.xmux.xp.S1 VSS sg13_lv_nmos ad=56.9f pd=0.74u as=56.9f ps=0.74u w=0.17u l=0.17u
X5491 cml_tlatch_43.xmux.xp.S1 stub_bi_42.BOTP stub_bi_42.BOTN VSS sg13_lv_nmos ad=56.9f pd=0.74u as=56.9f ps=0.74u w=0.17u l=0.17u
X5492 cml_tlatch_70.xtail.S1 CKHB3_P cml_tlatch_70.xmux.xn.S1 VSS sg13_lv_nmos ad=89.3f pd=0.85u as=0.1598p ps=1.62u w=0.47u l=0.16u
X5493 cml_tlatch_74.xtail.S1 CKHB2_P cml_tlatch_74.xmux.xn.S1 VSS sg13_lv_nmos ad=89.3f pd=0.85u as=89.3f ps=0.85u w=0.47u l=0.16u
X5494 cml_tlatch_70.xmux.xp.S1 MOT29_N MOT29_P VSS sg13_lv_nmos ad=56.9f pd=0.74u as=56.9f ps=0.74u w=0.17u l=0.17u
X5495 GA2_P ENA1_N cml_gate2_4.sg13_lv_nmos_FTPY57_0.D0 VSS sg13_lv_nmos ad=0.1007p pd=0.91u as=0.1802p ps=1.74u w=0.53u l=0.13u
X5496 cml_tlatch_44.xmux.xn.S1 stub_bi_32.BOTP B2_2_P VSS sg13_lv_nmos ad=63.19999f pd=0.74u as=63.19999f ps=0.74u w=0.26u l=0.38u
X5497 cml_tlatch_82.OUTN cml_tlatch_82.OUTP cml_tlatch_82.xmux.xp.S1 VSS sg13_lv_nmos ad=56.9f pd=0.74u as=56.9f ps=0.74u w=0.17u l=0.17u
X5498 cml_tlatch_38.OUTP D1_N cml_tlatch_38.xmux.xn.S1 VSS sg13_lv_nmos ad=0.1082p pd=1.34u as=63.19999f ps=0.74u w=0.26u l=0.38u
X5499 cml_tlatch_67.xtail.S1 CKA3_N cml_tlatch_67.xmux.xp.S1 VSS sg13_lv_nmos ad=89.3f pd=0.85u as=89.3f ps=0.85u w=0.47u l=0.16u
X5500 cml_tlatch_10.xmux.xp.S1 B0_8_P B0_8_N VSS sg13_lv_nmos ad=56.9f pd=0.74u as=56.9f ps=0.74u w=0.17u l=0.17u
X5501 A1_8_N cml_tlatch_22.OUTP cml_tlatch_21.xmux.xn.S1 VSS sg13_lv_nmos ad=63.19999f pd=0.74u as=0.1082p ps=1.34u w=0.26u l=0.38u
X5502 cml_tlatch_77.xmux.xp.S1 CKB2_P cml_tlatch_77.xtail.S1 VSS sg13_lv_nmos ad=89.3f pd=0.85u as=89.3f ps=0.85u w=0.47u l=0.16u
X5503 cml_tlatch_41.xmux.xn.S1 CKHA1_P cml_tlatch_41.xtail.S1 VSS sg13_lv_nmos ad=89.3f pd=0.85u as=89.3f ps=0.85u w=0.47u l=0.16u
X5504 cml_tlatch_84.xmux.xn.S1 cml_tlatch_45.OUTP cml_tlatch_70.INN VSS sg13_lv_nmos ad=63.19999f pd=0.74u as=63.19999f ps=0.74u w=0.26u l=0.38u
X5505 B2_2_P B2_2_N cml_tlatch_44.xmux.xp.S1 VSS sg13_lv_nmos ad=56.9f pd=0.74u as=56.9f ps=0.74u w=0.17u l=0.17u
X5506 cml_tlatch_61.OUTP cml_tlatch_61.OUTN cml_tlatch_61.xmux.xp.S1 VSS sg13_lv_nmos ad=56.9f pd=0.74u as=56.9f ps=0.74u w=0.17u l=0.17u
X5507 MOT8_P A1_8_N cml_tlatch_96.xmux.xn.S1 VSS sg13_lv_nmos ad=63.19999f pd=0.74u as=63.19999f ps=0.74u w=0.26u l=0.38u
X5508 cml_tlatch_22.xmux.xn.S1 cml_tlatch_39.INP cml_tlatch_22.OUTN VSS sg13_lv_nmos ad=63.19999f pd=0.74u as=63.19999f ps=0.74u w=0.26u l=0.38u
X5509 cml_tlatch_49.xmux.xp.S1 MOT18_N MOT18_P VSS sg13_lv_nmos ad=56.9f pd=0.74u as=56.9f ps=0.74u w=0.17u l=0.17u
X5510 cml_gate2_6.sg13_lv_nmos_FTPY57_0.D0 CKA3_P cml_gate2_6.xrtail.R1 VSS sg13_lv_nmos ad=0.1007p pd=0.91u as=0.1007p ps=0.91u w=0.53u l=0.13u
X5511 cml_drv_2.xrtail.R1 ENB_P ENB0_N VSS sg13_lv_nmos ad=56.2f pd=0.74u as=56.2f ps=0.74u w=0.16u l=0.19u
X5512 cml_tlatch_76.xmux.xp.S1 CKHB2_N cml_tlatch_76.xtail.S1 VSS sg13_lv_nmos ad=89.3f pd=0.85u as=0.1598p ps=1.62u w=0.47u l=0.16u
X5513 cml_tlatch_48.xmux.xn.S1 CKB2_P cml_tlatch_48.xtail.S1 VSS sg13_lv_nmos ad=89.3f pd=0.85u as=89.3f ps=0.85u w=0.47u l=0.16u
X5514 MOT28_N VDD VSS rppd l=5.17u w=1u
X5515 J2_P J1_N cml_tlatch_92.xmux.xn.S1 VSS sg13_lv_nmos ad=63.19999f pd=0.74u as=0.1082p ps=1.34u w=0.26u l=0.38u
X5516 cml_tlatch_52.xmux.xp.S1 cml_tlatch_52.OUTP cml_tlatch_52.OUTN VSS sg13_lv_nmos ad=0.1019p pd=1.34u as=56.9f ps=0.74u w=0.17u l=0.17u
X5517 cml_tlatch_40.xmux.xp.S1 MOT12_N MOT12_P VSS sg13_lv_nmos ad=56.9f pd=0.74u as=56.9f ps=0.74u w=0.17u l=0.17u
X5518 cml_tlatch_55.xtail.S1 CKA2_N cml_tlatch_55.xmux.xp.S1 VSS sg13_lv_nmos ad=89.3f pd=0.85u as=89.3f ps=0.85u w=0.47u l=0.16u
X5519 MOT27_P MOT27_N cml_tlatch_69.xmux.xp.S1 VSS sg13_lv_nmos ad=56.9f pd=0.74u as=56.9f ps=0.74u w=0.17u l=0.17u
X5520 cml_tlatch_14.xmux.xp.S1 CKB1_P cml_tlatch_14.xtail.S1 VSS sg13_lv_nmos ad=89.3f pd=0.85u as=89.3f ps=0.85u w=0.47u l=0.16u
X5521 cml_tlatch_92.xmux.xn.S1 J1_P J2_N VSS sg13_lv_nmos ad=63.19999f pd=0.74u as=63.19999f ps=0.74u w=0.26u l=0.38u
X5522 cml_tlatch_67.OUTP cml_tlatch_58.INN cml_tlatch_67.xmux.xn.S1 VSS sg13_lv_nmos ad=0.1082p pd=1.34u as=63.19999f ps=0.74u w=0.26u l=0.38u
X5523 cml_tlatch_53.xmux.xp.S1 A3_2_N A3_2_P VSS sg13_lv_nmos ad=56.9f pd=0.74u as=56.9f ps=0.74u w=0.17u l=0.17u
X5524 cml_tlatch_71.xmux.xn.S1 B3_2_P MOT31_N VSS sg13_lv_nmos ad=0.1082p pd=1.34u as=63.19999f ps=0.74u w=0.26u l=0.38u
X5525 cml_tlatch_35.xmux.xn.S1 CKA0_P cml_tlatch_35.xtail.S1 VSS sg13_lv_nmos ad=89.3f pd=0.85u as=89.3f ps=0.85u w=0.47u l=0.16u
X5526 cml_tlatch_1.xtail.S1 CKB0_N cml_tlatch_1.xmux.xp.S1 VSS sg13_lv_nmos ad=89.3f pd=0.85u as=89.3f ps=0.85u w=0.47u l=0.16u
X5527 cml_tlatch_76.xmux.xp.S1 MOT23_P MOT23_N VSS sg13_lv_nmos ad=56.9f pd=0.74u as=56.9f ps=0.74u w=0.17u l=0.17u
X5528 cml_tlatch_62.xtail.S1 CKB3_N cml_tlatch_62.xmux.xn.S1 VSS sg13_lv_nmos ad=89.3f pd=0.85u as=89.3f ps=0.85u w=0.47u l=0.16u
X5529 cml_tlatch_71.xmux.xp.S1 CKHB3_N cml_tlatch_71.xtail.S1 VSS sg13_lv_nmos ad=89.3f pd=0.85u as=89.3f ps=0.85u w=0.47u l=0.16u
X5530 cml_tlatch_79.xmux.xp.S1 stub_bi_63.BOTN stub_bi_63.BOTP VSS sg13_lv_nmos ad=56.9f pd=0.74u as=56.9f ps=0.74u w=0.17u l=0.17u
X5531 cml_tlatch_25.xtail.S1 CKHA0_N cml_tlatch_25.xmux.xp.S1 VSS sg13_lv_nmos ad=89.3f pd=0.85u as=89.3f ps=0.85u w=0.47u l=0.16u
X5532 cml_tlatch_76.xmux.xn.S1 B2_2_N MOT23_P VSS sg13_lv_nmos ad=63.19999f pd=0.74u as=63.19999f ps=0.74u w=0.26u l=0.38u
X5533 cml_tlatch_9.OUTP cml_tlatch_9.OUTN cml_tlatch_9.xmux.xp.S1 VSS sg13_lv_nmos ad=56.9f pd=0.74u as=56.9f ps=0.74u w=0.17u l=0.17u
X5534 MOT3_N MOT3_P cml_tlatch_18.xmux.xp.S1 VSS sg13_lv_nmos ad=56.9f pd=0.74u as=56.9f ps=0.74u w=0.17u l=0.17u
X5535 cml_tlatch_51.xmux.xn.S1 CKHA2_P cml_tlatch_51.xtail.S1 VSS sg13_lv_nmos ad=89.3f pd=0.85u as=89.3f ps=0.85u w=0.47u l=0.16u
X5536 cml_tlatch_26.xmux.xp.S1 MOT6_P MOT6_N VSS sg13_lv_nmos ad=56.9f pd=0.74u as=56.9f ps=0.74u w=0.17u l=0.17u
X5537 cml_tlatch_41.xmux.xn.S1 A1_2_P MOT14_N VSS sg13_lv_nmos ad=63.19999f pd=0.74u as=63.19999f ps=0.74u w=0.26u l=0.38u
X5538 cml_tlatch_38.xmux.xp.S1 cml_tlatch_38.OUTP cml_tlatch_38.OUTN VSS sg13_lv_nmos ad=56.9f pd=0.74u as=56.9f ps=0.74u w=0.17u l=0.17u
X5539 cml_tlatch_93.xtail.S1 CKJ_P cml_tlatch_93.xmux.xn.S1 VSS sg13_lv_nmos ad=89.3f pd=0.85u as=89.3f ps=0.85u w=0.47u l=0.16u
X5540 cml_tlatch_58.xmux.xp.S1 MOT28_N MOT28_P VSS sg13_lv_nmos ad=56.9f pd=0.74u as=56.9f ps=0.74u w=0.17u l=0.17u
X5541 VSS hs_to_clk_3.sg13_lv_nmos_2HGZLP_0.G VSS VSS sg13_lv_nmos ad=2.071p pd=11.28u as=0 ps=0 w=10.9u l=1.38u
X5542 cml_tlatch_67.xmux.xn.S1 cml_tlatch_58.INP cml_tlatch_67.OUTN VSS sg13_lv_nmos ad=63.19999f pd=0.74u as=63.19999f ps=0.74u w=0.26u l=0.38u
X5543 hs_to_clk_2.D2 POLN VSS VSS sg13_lv_nmos ad=1.9p pd=10.38u as=1.9p ps=10.38u w=10u l=0.13u
X5544 cml_tlatch_53.xmux.xn.S1 cml_tlatch_54.OUTP A3_2_N VSS sg13_lv_nmos ad=63.19999f pd=0.74u as=63.19999f ps=0.74u w=0.26u l=0.38u
X5545 stub_bi_42.BOTP B2_2_P cml_tlatch_43.xmux.xn.S1 VSS sg13_lv_nmos ad=63.19999f pd=0.74u as=63.19999f ps=0.74u w=0.26u l=0.38u
X5546 cml_tlatch_28.xmux.xp.S1 B0_2_N B0_2_P VSS sg13_lv_nmos ad=56.9f pd=0.74u as=56.9f ps=0.74u w=0.17u l=0.17u
X5547 cml_tlatch_30.OUTP cml_tlatch_30.OUTN cml_tlatch_30.xmux.xp.S1 VSS sg13_lv_nmos ad=56.9f pd=0.74u as=56.9f ps=0.74u w=0.17u l=0.17u
X5548 MOT30_P A3_2_N cml_tlatch_59.xmux.xn.S1 VSS sg13_lv_nmos ad=63.19999f pd=0.74u as=63.19999f ps=0.74u w=0.26u l=0.38u
X5549 cml_tlatch_77.xmux.xp.S1 B2_8_P B2_8_N VSS sg13_lv_nmos ad=56.9f pd=0.74u as=56.9f ps=0.74u w=0.17u l=0.17u
X5550 A0_8_P A0_8_N cml_tlatch_2.xmux.xp.S1 VSS sg13_lv_nmos ad=56.9f pd=0.74u as=56.9f ps=0.74u w=0.17u l=0.17u
X5551 cml_tlatch_86.xtail.S1 POLN VSS VSS sg13_lv_nmos ad=1.5637p pd=8.61u as=2.7982p ps=17.14u w=8.23u l=0.13u
X5552 cml_tlatch_51.xtail.S1 POLN VSS VSS sg13_lv_nmos ad=1.5637p pd=8.61u as=2.7982p ps=17.14u w=8.23u l=0.13u
X5553 cml_tlatch_45.xmux.xp.S1 cml_tlatch_45.OUTP cml_tlatch_45.OUTN VSS sg13_lv_nmos ad=56.9f pd=0.74u as=56.9f ps=0.74u w=0.17u l=0.17u
X5554 cml_tlatch_59.xmux.xn.S1 CKHA3_P cml_tlatch_59.xtail.S1 VSS sg13_lv_nmos ad=89.3f pd=0.85u as=89.3f ps=0.85u w=0.47u l=0.16u
X5555 A0_2_N cml_tlatch_35.OUTP cml_tlatch_31.xmux.xn.S1 VSS sg13_lv_nmos ad=63.19999f pd=0.74u as=63.19999f ps=0.74u w=0.26u l=0.38u
X5556 cml_tlatch_47.OUTP cml_tlatch_47.OUTN cml_tlatch_47.xmux.xp.S1 VSS sg13_lv_nmos ad=56.9f pd=0.74u as=56.9f ps=0.74u w=0.17u l=0.17u
X5557 cml_tlatch_88.xtail.S1 CKB2_N cml_tlatch_88.xmux.xn.S1 VSS sg13_lv_nmos ad=89.3f pd=0.85u as=0.1598p ps=1.62u w=0.47u l=0.16u
X5558 B2_8_P B2_8_N cml_tlatch_77.xmux.xp.S1 VSS sg13_lv_nmos ad=56.9f pd=0.74u as=56.9f ps=0.74u w=0.17u l=0.17u
X5559 MOT11_P cml_tlatch_5.INN cml_tlatch_5.xmux.xn.S1 VSS sg13_lv_nmos ad=63.19999f pd=0.74u as=63.19999f ps=0.74u w=0.26u l=0.38u
X5560 cml_gate2_2.sg13_lv_nmos_FTPY57_0.D0 ENA0_N GA0_P VSS sg13_lv_nmos ad=0.1007p pd=0.91u as=0.1007p ps=0.91u w=0.53u l=0.13u
X5561 cml_tlatch_38.xmux.xp.S1 cml_tlatch_38.OUTP cml_tlatch_38.OUTN VSS sg13_lv_nmos ad=56.9f pd=0.74u as=56.9f ps=0.74u w=0.17u l=0.17u
X5562 cml_tlatch_7.xmux.xp.S1 MOT15_N MOT15_P VSS sg13_lv_nmos ad=56.9f pd=0.74u as=56.9f ps=0.74u w=0.17u l=0.17u
X5563 cml_tlatch_53.xmux.xp.S1 A3_2_N A3_2_P VSS sg13_lv_nmos ad=56.9f pd=0.74u as=56.9f ps=0.74u w=0.17u l=0.17u
X5564 MOT11_P cml_tlatch_5.INN cml_tlatch_5.xmux.xn.S1 VSS sg13_lv_nmos ad=63.19999f pd=0.74u as=63.19999f ps=0.74u w=0.26u l=0.38u
X5565 cml_tlatch_43.xmux.xp.S1 stub_bi_42.BOTP stub_bi_42.BOTN VSS sg13_lv_nmos ad=56.9f pd=0.74u as=56.9f ps=0.74u w=0.17u l=0.17u
X5566 cml_tlatch_19.xmux.xp.S1 CKHB0_N cml_tlatch_19.xtail.S1 VSS sg13_lv_nmos ad=89.3f pd=0.85u as=0.1598p ps=1.62u w=0.47u l=0.16u
X5567 cml_tlatch_78.xmux.xp.S1 stub_bi_62.BOTN stub_bi_62.BOTP VSS sg13_lv_nmos ad=0.1019p pd=1.34u as=56.9f ps=0.74u w=0.17u l=0.17u
X5568 cml_tlatch_3.xmux.xn.S1 CKA0_P cml_tlatch_3.xtail.S1 VSS sg13_lv_nmos ad=89.3f pd=0.85u as=89.3f ps=0.85u w=0.47u l=0.16u
X5569 cml_tlatch_33.xtail.S1 CKB1_P cml_tlatch_33.xmux.xp.S1 VSS sg13_lv_nmos ad=89.3f pd=0.85u as=89.3f ps=0.85u w=0.47u l=0.16u
X5570 cml_tlatch_79.xmux.xp.S1 stub_bi_63.BOTN stub_bi_63.BOTP VSS sg13_lv_nmos ad=56.9f pd=0.74u as=56.9f ps=0.74u w=0.17u l=0.17u
X5571 cml_tlatch_39.INP cml_tlatch_39.INN cml_tlatch_23.xmux.xp.S1 VSS sg13_lv_nmos ad=56.9f pd=0.74u as=56.9f ps=0.74u w=0.17u l=0.17u
X5572 stub_bi_55.BOTN stub_bi_55.BOTP cml_tlatch_88.xmux.xp.S1 VSS sg13_lv_nmos ad=56.9f pd=0.74u as=56.9f ps=0.74u w=0.17u l=0.17u
X5573 cml_tlatch_9.xmux.xp.S1 cml_tlatch_9.OUTP cml_tlatch_9.OUTN VSS sg13_lv_nmos ad=56.9f pd=0.74u as=56.9f ps=0.74u w=0.17u l=0.17u
X5574 VSS POLN cml_tlatch_63.xtail.S1 VSS sg13_lv_nmos ad=1.5637p pd=8.61u as=1.5637p ps=8.61u w=8.23u l=0.13u
X5575 cml_tlatch_84.xtail.S1 CKB3_N cml_tlatch_84.xmux.xn.S1 VSS sg13_lv_nmos ad=89.3f pd=0.85u as=89.3f ps=0.85u w=0.47u l=0.16u
X5576 MOT16_P MOT16_N cml_tlatch_87.xmux.xp.S1 VSS sg13_lv_nmos ad=56.9f pd=0.74u as=56.9f ps=0.74u w=0.17u l=0.17u
X5577 cml_tlatch_95.xmux.xn.S1 CKA1_N cml_tlatch_95.xtail.S1 VSS sg13_lv_nmos ad=0.1598p pd=1.62u as=89.3f ps=0.85u w=0.47u l=0.16u
X5578 cml_tlatch_86.xmux.xp.S1 MOT24_N MOT24_P VSS sg13_lv_nmos ad=56.9f pd=0.74u as=56.9f ps=0.74u w=0.17u l=0.17u
X5579 cml_tlatch_34.xmux.xp.S1 CKB1_N cml_tlatch_34.xtail.S1 VSS sg13_lv_nmos ad=89.3f pd=0.85u as=89.3f ps=0.85u w=0.47u l=0.16u
X5580 cml_tlatch_71.xmux.xp.S1 MOT31_P MOT31_N VSS sg13_lv_nmos ad=56.9f pd=0.74u as=56.9f ps=0.74u w=0.17u l=0.17u
X5581 cml_tlatch_71.xmux.xp.S1 MOT31_N MOT31_P VSS sg13_lv_nmos ad=56.9f pd=0.74u as=56.9f ps=0.74u w=0.17u l=0.17u
X5582 cml_tlatch_40.INN cml_tlatch_40.INP cml_tlatch_95.xmux.xp.S1 VSS sg13_lv_nmos ad=56.9f pd=0.74u as=56.9f ps=0.74u w=0.17u l=0.17u
X5583 ENA1_N ENA_P cml_drv_1.xrtail.R1 VSS sg13_lv_nmos ad=56.2f pd=0.74u as=56.2f ps=0.74u w=0.16u l=0.19u
X5584 cml_tlatch_42.xmux.xp.S1 CKA2_N cml_tlatch_42.xtail.S1 VSS sg13_lv_nmos ad=89.3f pd=0.85u as=89.3f ps=0.85u w=0.47u l=0.16u
X5585 cml_tlatch_69.xtail.S1 CKHB3_N cml_tlatch_69.xmux.xp.S1 VSS sg13_lv_nmos ad=89.3f pd=0.85u as=89.3f ps=0.85u w=0.47u l=0.16u
X5586 VDD J2_N VSS rppd l=5.17u w=1u
X5587 MOT26_P MOT26_N cml_tlatch_57.xmux.xp.S1 VSS sg13_lv_nmos ad=56.9f pd=0.74u as=56.9f ps=0.74u w=0.17u l=0.17u
X5588 cml_tlatch_8.OUTN cml_tlatch_9.OUTP cml_tlatch_8.xmux.xn.S1 VSS sg13_lv_nmos ad=63.19999f pd=0.74u as=0.1082p ps=1.34u w=0.26u l=0.38u
X5589 MOT8_N MOT8_P cml_tlatch_96.xmux.xp.S1 VSS sg13_lv_nmos ad=56.9f pd=0.74u as=56.9f ps=0.74u w=0.17u l=0.17u
X5590 cml_tlatch_67.xmux.xp.S1 cml_tlatch_67.OUTP cml_tlatch_67.OUTN VSS sg13_lv_nmos ad=56.9f pd=0.74u as=56.9f ps=0.74u w=0.17u l=0.17u
X5591 cml_tlatch_50.xmux.xn.S1 CKHA2_P cml_tlatch_50.xtail.S1 VSS sg13_lv_nmos ad=89.3f pd=0.85u as=0.1598p ps=1.62u w=0.47u l=0.16u
X5592 cml_tlatch_0.xtail.S1 CKA1_P cml_tlatch_0.xmux.xn.S1 VSS sg13_lv_nmos ad=89.3f pd=0.85u as=89.3f ps=0.85u w=0.47u l=0.16u
X5593 cml_tlatch_93.xmux.xp.S1 J1_P J1_N VSS sg13_lv_nmos ad=56.9f pd=0.74u as=56.9f ps=0.74u w=0.17u l=0.17u
X5594 cml_tlatch_40.xmux.xp.S1 MOT12_N MOT12_P VSS sg13_lv_nmos ad=0.1019p pd=1.34u as=56.9f ps=0.74u w=0.17u l=0.17u
X5595 cml_tlatch_92.xmux.xp.S1 CKJ_P cml_tlatch_92.xtail.S1 VSS sg13_lv_nmos ad=89.3f pd=0.85u as=0.1598p ps=1.62u w=0.47u l=0.16u
X5596 cml_tlatch_75.xmux.xp.S1 CKHB2_N cml_tlatch_75.xtail.S1 VSS sg13_lv_nmos ad=89.3f pd=0.85u as=89.3f ps=0.85u w=0.47u l=0.16u
X5597 cml_tlatch_39.xtail.S1 CKHA1_P cml_tlatch_39.xmux.xn.S1 VSS sg13_lv_nmos ad=89.3f pd=0.85u as=89.3f ps=0.85u w=0.47u l=0.16u
X5598 cml_gate2_5.xrtail.R1 CKB3_N GA3_P VSS sg13_lv_nmos ad=0.1007p pd=0.91u as=0.1007p ps=0.91u w=0.53u l=0.13u
X5599 cml_tlatch_4.xmux.xn.S1 B1_8_N MOT9_P VSS sg13_lv_nmos ad=63.19999f pd=0.74u as=63.19999f ps=0.74u w=0.26u l=0.38u
X5600 cml_tlatch_10.xmux.xn.S1 cml_tlatch_11.OUTP B0_8_N VSS sg13_lv_nmos ad=0.1082p pd=1.34u as=63.19999f ps=0.74u w=0.26u l=0.38u
X5601 cml_tlatch_9.OUTN cml_tlatch_99.OUTP cml_tlatch_9.xmux.xn.S1 VSS sg13_lv_nmos ad=63.19999f pd=0.74u as=63.19999f ps=0.74u w=0.26u l=0.38u
X5602 cml_tlatch_95.xtail.S1 CKA1_P cml_tlatch_95.xmux.xp.S1 VSS sg13_lv_nmos ad=89.3f pd=0.85u as=89.3f ps=0.85u w=0.47u l=0.16u
X5603 cml_tlatch_56.xmux.xp.S1 A2_2_P A2_2_N VSS sg13_lv_nmos ad=56.9f pd=0.74u as=56.9f ps=0.74u w=0.17u l=0.17u
X5604 cml_tlatch_58.xmux.xn.S1 CKHA3_P cml_tlatch_58.xtail.S1 VSS sg13_lv_nmos ad=89.3f pd=0.85u as=89.3f ps=0.85u w=0.47u l=0.16u
X5605 A3_8_N A3_8_P cml_tlatch_64.xmux.xp.S1 VSS sg13_lv_nmos ad=56.9f pd=0.74u as=56.9f ps=0.74u w=0.17u l=0.17u
X5606 cml_tlatch_53.xtail.S1 CKA3_P cml_tlatch_53.xmux.xp.S1 VSS sg13_lv_nmos ad=89.3f pd=0.85u as=89.3f ps=0.85u w=0.47u l=0.16u
X5607 cml_tlatch_77.xtail.S1 CKB2_P cml_tlatch_77.xmux.xp.S1 VSS sg13_lv_nmos ad=89.3f pd=0.85u as=89.3f ps=0.85u w=0.47u l=0.16u
X5608 cml_tlatch_27.OUTN cml_tlatch_27.OUTP cml_tlatch_27.xmux.xp.S1 VSS sg13_lv_nmos ad=56.9f pd=0.74u as=56.9f ps=0.74u w=0.17u l=0.17u
X5609 cml_tlatch_24.xmux.xn.S1 cml_tlatch_8.OUTN MOT2_P VSS sg13_lv_nmos ad=63.19999f pd=0.74u as=63.19999f ps=0.74u w=0.26u l=0.38u
X5610 MOT24_N MOT24_P cml_tlatch_86.xmux.xp.S1 VSS sg13_lv_nmos ad=56.9f pd=0.74u as=56.9f ps=0.74u w=0.17u l=0.17u
X5611 B1_8_P stub_bi_17.BOTP cml_tlatch_12.xmux.xn.S1 VSS sg13_lv_nmos ad=63.19999f pd=0.74u as=63.19999f ps=0.74u w=0.26u l=0.38u
X5612 cml_tlatch_62.xtail.S1 CKB3_P cml_tlatch_62.xmux.xp.S1 VSS sg13_lv_nmos ad=89.3f pd=0.85u as=89.3f ps=0.85u w=0.47u l=0.16u
X5613 cml_tlatch_33.xmux.xp.S1 B1_2_N B1_2_P VSS sg13_lv_nmos ad=56.9f pd=0.74u as=56.9f ps=0.74u w=0.17u l=0.17u
X5614 cml_gate2_5.sg13_lv_nmos_FTPY57_0.D0 ENA1_N GA3_P VSS sg13_lv_nmos ad=0.1007p pd=0.91u as=0.1007p ps=0.91u w=0.53u l=0.13u
X5615 cml_tlatch_30.xmux.xp.S1 CKA0_N cml_tlatch_30.xtail.S1 VSS sg13_lv_nmos ad=89.3f pd=0.85u as=89.3f ps=0.85u w=0.47u l=0.16u
X5616 cml_tlatch_24.xmux.xn.S1 cml_tlatch_8.OUTN MOT2_P VSS sg13_lv_nmos ad=63.19999f pd=0.74u as=63.19999f ps=0.74u w=0.26u l=0.38u
X5617 GB2_N ENB0_P cml_gate2_7.sg13_lv_nmos_FTPY57_0.D0 VSS sg13_lv_nmos ad=0.1007p pd=0.91u as=0.1802p ps=1.74u w=0.53u l=0.13u
X5618 cml_tlatch_3.OUTP cml_tlatch_3.OUTN cml_tlatch_3.xmux.xp.S1 VSS sg13_lv_nmos ad=56.9f pd=0.74u as=56.9f ps=0.74u w=0.17u l=0.17u
X5619 cml_drv_0.xrtail.R1 ENB_P ENB1_N VSS sg13_lv_nmos ad=56.2f pd=0.74u as=56.2f ps=0.74u w=0.16u l=0.19u
X5620 cml_tlatch_9.xtail.S1 CKA0_P cml_tlatch_9.xmux.xn.S1 VSS sg13_lv_nmos ad=89.3f pd=0.85u as=89.3f ps=0.85u w=0.47u l=0.16u
X5621 cml_tlatch_4.xmux.xp.S1 MOT9_N MOT9_P VSS sg13_lv_nmos ad=56.9f pd=0.74u as=56.9f ps=0.74u w=0.17u l=0.17u
X5622 cml_tlatch_38.xmux.xn.S1 D1_P cml_tlatch_38.OUTN VSS sg13_lv_nmos ad=63.19999f pd=0.74u as=63.19999f ps=0.74u w=0.26u l=0.38u
X5623 cml_tlatch_66.xmux.xp.S1 cml_tlatch_57.INN cml_tlatch_57.INP VSS sg13_lv_nmos ad=56.9f pd=0.74u as=56.9f ps=0.74u w=0.17u l=0.17u
X5624 cml_tlatch_57.INP cml_tlatch_67.OUTN cml_tlatch_66.xmux.xn.S1 VSS sg13_lv_nmos ad=63.19999f pd=0.74u as=63.19999f ps=0.74u w=0.26u l=0.38u
X5625 cml_tlatch_51.xmux.xp.S1 CKHA2_N cml_tlatch_51.xtail.S1 VSS sg13_lv_nmos ad=0.1598p pd=1.62u as=89.3f ps=0.85u w=0.47u l=0.16u
X5626 cml_tlatch_74.xmux.xp.S1 MOT19_P MOT19_N VSS sg13_lv_nmos ad=56.9f pd=0.74u as=56.9f ps=0.74u w=0.17u l=0.17u
X5627 B0_2_N B0_2_P cml_tlatch_28.xmux.xp.S1 VSS sg13_lv_nmos ad=56.9f pd=0.74u as=56.9f ps=0.74u w=0.17u l=0.17u
X5628 cml_tlatch_94.xtail.S1 CKB1_P cml_tlatch_94.xmux.xp.S1 VSS sg13_lv_nmos ad=89.3f pd=0.85u as=89.3f ps=0.85u w=0.47u l=0.16u
X5629 cml_tlatch_52.OUTP cml_tlatch_52.OUTN cml_tlatch_52.xmux.xp.S1 VSS sg13_lv_nmos ad=56.9f pd=0.74u as=56.9f ps=0.74u w=0.17u l=0.17u
X5630 A0_8_P A0_8_N cml_tlatch_2.xmux.xp.S1 VSS sg13_lv_nmos ad=56.9f pd=0.74u as=56.9f ps=0.74u w=0.17u l=0.17u
X5631 cml_tlatch_93.xtail.S1 CKJ_N cml_tlatch_93.xmux.xp.S1 VSS sg13_lv_nmos ad=89.3f pd=0.85u as=89.3f ps=0.85u w=0.47u l=0.16u
X5632 cml_tlatch_61.OUTP cml_tlatch_69.INN cml_tlatch_61.xmux.xn.S1 VSS sg13_lv_nmos ad=63.19999f pd=0.74u as=63.19999f ps=0.74u w=0.26u l=0.38u
X5633 stub_bi_19.BOTN stub_bi_19.BOTP cml_tlatch_15.xmux.xp.S1 VSS sg13_lv_nmos ad=56.9f pd=0.74u as=0.1019p ps=1.34u w=0.17u l=0.17u
X5634 VSS POLN cml_tlatch_33.xtail.S1 VSS sg13_lv_nmos ad=2.7982p pd=17.14u as=1.5637p ps=8.61u w=8.23u l=0.13u
X5635 cml_tlatch_14.xtail.S1 CKB1_P cml_tlatch_14.xmux.xp.S1 VSS sg13_lv_nmos ad=89.3f pd=0.85u as=0.1598p ps=1.62u w=0.47u l=0.16u
X5636 cml_tlatch_83.xmux.xn.S1 cml_tlatch_83.INP cml_tlatch_83.OUTN VSS sg13_lv_nmos ad=63.19999f pd=0.74u as=63.19999f ps=0.74u w=0.26u l=0.38u
X5637 VSS POLN hs_to_clk_8.D2 VSS sg13_lv_nmos ad=1.9p pd=10.38u as=3.4p ps=20.68u w=10u l=0.13u
X5638 cml_tlatch_7.xmux.xp.S1 MOT15_N MOT15_P VSS sg13_lv_nmos ad=0.1019p pd=1.34u as=56.9f ps=0.74u w=0.17u l=0.17u
X5639 cml_tlatch_17.xtail.S1 CKHB0_N cml_tlatch_17.xmux.xp.S1 VSS sg13_lv_nmos ad=89.3f pd=0.85u as=89.3f ps=0.85u w=0.47u l=0.16u
X5640 cml_tlatch_3.xmux.xp.S1 cml_tlatch_3.OUTP cml_tlatch_3.OUTN VSS sg13_lv_nmos ad=56.9f pd=0.74u as=56.9f ps=0.74u w=0.17u l=0.17u
X5641 cml_gate2_3.xrtail.R1 CKB1_P cml_gate2_3.sg13_lv_nmos_FTPY57_0.D0 VSS sg13_lv_nmos ad=0.1007p pd=0.91u as=0.1007p ps=0.91u w=0.53u l=0.13u
X5642 cml_tlatch_65.xmux.xp.S1 cml_tlatch_65.OUTN cml_tlatch_65.OUTP VSS sg13_lv_nmos ad=56.9f pd=0.74u as=56.9f ps=0.74u w=0.17u l=0.17u
X5643 cml_tlatch_80.xtail.S1 POLN VSS VSS sg13_lv_nmos ad=1.5637p pd=8.61u as=1.5637p ps=8.61u w=8.23u l=0.13u
X5644 cml_tlatch_68.xmux.xp.S1 MOT25_N MOT25_P VSS sg13_lv_nmos ad=56.9f pd=0.74u as=56.9f ps=0.74u w=0.17u l=0.17u
X5645 cml_tlatch_84.xmux.xp.S1 cml_tlatch_70.INP cml_tlatch_70.INN VSS sg13_lv_nmos ad=56.9f pd=0.74u as=56.9f ps=0.74u w=0.17u l=0.17u
X5646 cml_tlatch_29.OUTN VDD VSS rppd l=5.17u w=1u
X5647 cml_tlatch_25.xmux.xp.S1 CKHA0_N cml_tlatch_25.xtail.S1 VSS sg13_lv_nmos ad=89.3f pd=0.85u as=89.3f ps=0.85u w=0.47u l=0.16u
X5648 cml_tlatch_29.xmux.xp.S1 cml_tlatch_29.OUTN cml_tlatch_29.OUTP VSS sg13_lv_nmos ad=56.9f pd=0.74u as=56.9f ps=0.74u w=0.17u l=0.17u
X5649 cml_tlatch_38.xmux.xn.S1 CKA1_P cml_tlatch_38.xtail.S1 VSS sg13_lv_nmos ad=89.3f pd=0.85u as=89.3f ps=0.85u w=0.47u l=0.16u
X5650 cml_tlatch_98.OUTN cml_tlatch_98.OUTP cml_tlatch_98.xmux.xp.S1 VSS sg13_lv_nmos ad=56.9f pd=0.74u as=56.9f ps=0.74u w=0.17u l=0.17u
X5651 cml_tlatch_85.xmux.xn.S1 cml_tlatch_52.OUTN cml_tlatch_58.INP VSS sg13_lv_nmos ad=63.19999f pd=0.74u as=63.19999f ps=0.74u w=0.26u l=0.38u
X5652 MOT6_P A0_2_N cml_tlatch_26.xmux.xn.S1 VSS sg13_lv_nmos ad=63.19999f pd=0.74u as=63.19999f ps=0.74u w=0.26u l=0.38u
X5653 cml_tlatch_42.xmux.xn.S1 CKA2_P cml_tlatch_42.xtail.S1 VSS sg13_lv_nmos ad=0.1598p pd=1.62u as=89.3f ps=0.85u w=0.47u l=0.16u
X5654 cml_tlatch_17.xmux.xp.S1 MOT1_P MOT1_N VSS sg13_lv_nmos ad=56.9f pd=0.74u as=56.9f ps=0.74u w=0.17u l=0.17u
X5655 cml_tlatch_29.xmux.xn.S1 D0_N cml_tlatch_29.OUTP VSS sg13_lv_nmos ad=63.19999f pd=0.74u as=0.1082p ps=1.34u w=0.26u l=0.38u
X5656 cml_tlatch_89.xmux.xp.S1 CKA2_P cml_tlatch_89.xtail.S1 VSS sg13_lv_nmos ad=89.3f pd=0.85u as=89.3f ps=0.85u w=0.47u l=0.16u
X5657 cml_tlatch_2.xtail.S1 CKA0_N cml_tlatch_2.xmux.xn.S1 VSS sg13_lv_nmos ad=89.3f pd=0.85u as=89.3f ps=0.85u w=0.47u l=0.16u
X5658 cml_tlatch_87.xmux.xn.S1 A2_8_N MOT16_P VSS sg13_lv_nmos ad=63.19999f pd=0.74u as=63.19999f ps=0.74u w=0.26u l=0.38u
X5659 cml_tlatch_63.xtail.S1 CKB3_N cml_tlatch_63.xmux.xp.S1 VSS sg13_lv_nmos ad=89.3f pd=0.85u as=89.3f ps=0.85u w=0.47u l=0.16u
X5660 cml_tlatch_22.OUTP cml_tlatch_22.OUTN cml_tlatch_22.xmux.xp.S1 VSS sg13_lv_nmos ad=56.9f pd=0.74u as=56.9f ps=0.74u w=0.17u l=0.17u
X5661 cml_tlatch_81.xtail.S1 CKA2_N cml_tlatch_81.xmux.xn.S1 VSS sg13_lv_nmos ad=89.3f pd=0.85u as=89.3f ps=0.85u w=0.47u l=0.16u
X5662 MOT3_P MOT3_N cml_tlatch_18.xmux.xp.S1 VSS sg13_lv_nmos ad=56.9f pd=0.74u as=56.9f ps=0.74u w=0.17u l=0.17u
X5663 stub_bi_19.BOTN stub_bi_19.BOTP cml_tlatch_15.xmux.xp.S1 VSS sg13_lv_nmos ad=56.9f pd=0.74u as=56.9f ps=0.74u w=0.17u l=0.17u
X5664 CKJ_N CK_N hs_to_clk_8.D2 VSS sg13_lv_nmos ad=0.408p pd=3.08u as=0.228p ps=1.58u w=1.2u l=0.2u
X5665 cml_tlatch_60.xmux.xp.S1 B3_8_P B3_8_N VSS sg13_lv_nmos ad=56.9f pd=0.74u as=56.9f ps=0.74u w=0.17u l=0.17u
X5666 cml_tlatch_57.INN cml_tlatch_57.INP cml_tlatch_66.xmux.xp.S1 VSS sg13_lv_nmos ad=56.9f pd=0.74u as=56.9f ps=0.74u w=0.17u l=0.17u
X5667 cml_tlatch_68.xtail.S1 CKHB3_P cml_tlatch_68.xmux.xn.S1 VSS sg13_lv_nmos ad=89.3f pd=0.85u as=89.3f ps=0.85u w=0.47u l=0.16u
X5668 VSS hs_to_clk_7.sg13_lv_nmos_2HGZLP_0.G VSS VSS sg13_lv_nmos ad=2.071p pd=11.28u as=0 ps=0 w=10.9u l=1.38u
X5669 A2_2_P A2_2_N cml_tlatch_56.xmux.xp.S1 VSS sg13_lv_nmos ad=56.9f pd=0.74u as=56.9f ps=0.74u w=0.17u l=0.17u
X5670 cml_tlatch_69.xmux.xp.S1 MOT27_P MOT27_N VSS sg13_lv_nmos ad=56.9f pd=0.74u as=56.9f ps=0.74u w=0.17u l=0.17u
X5671 cml_tlatch_51.xmux.xp.S1 MOT22_P MOT22_N VSS sg13_lv_nmos ad=56.9f pd=0.74u as=56.9f ps=0.74u w=0.17u l=0.17u
X5672 MOT30_N MOT30_P cml_tlatch_59.xmux.xp.S1 VSS sg13_lv_nmos ad=56.9f pd=0.74u as=56.9f ps=0.74u w=0.17u l=0.17u
X5673 cml_tlatch_89.xmux.xn.S1 cml_tlatch_89.INP cml_tlatch_89.OUTN VSS sg13_lv_nmos ad=63.19999f pd=0.74u as=63.19999f ps=0.74u w=0.26u l=0.38u
X5674 cml_tlatch_11.xmux.xp.S1 cml_tlatch_11.OUTN cml_tlatch_11.OUTP VSS sg13_lv_nmos ad=56.9f pd=0.74u as=56.9f ps=0.74u w=0.17u l=0.17u
X5675 cml_tlatch_35.xmux.xn.S1 CKA0_P cml_tlatch_35.xtail.S1 VSS sg13_lv_nmos ad=89.3f pd=0.85u as=89.3f ps=0.85u w=0.47u l=0.16u
X5676 cml_tlatch_23.xmux.xp.S1 cml_tlatch_39.INP cml_tlatch_39.INN VSS sg13_lv_nmos ad=56.9f pd=0.74u as=56.9f ps=0.74u w=0.17u l=0.17u
X5677 cml_tlatch_50.xmux.xn.S1 cml_tlatch_89.OUTP MOT20_N VSS sg13_lv_nmos ad=63.19999f pd=0.74u as=63.19999f ps=0.74u w=0.26u l=0.38u
X5678 cml_gate2_1.sg13_lv_nmos_FTPY57_0.D0 ENB1_P GB0_N VSS sg13_lv_nmos ad=0.1007p pd=0.91u as=0.1007p ps=0.91u w=0.53u l=0.13u
X5679 cml_tlatch_5.INN cml_tlatch_5.INP cml_tlatch_14.xmux.xp.S1 VSS sg13_lv_nmos ad=56.9f pd=0.74u as=56.9f ps=0.74u w=0.17u l=0.17u
X5680 cml_tlatch_33.xmux.xp.S1 CKB1_P cml_tlatch_33.xtail.S1 VSS sg13_lv_nmos ad=89.3f pd=0.85u as=89.3f ps=0.85u w=0.47u l=0.16u
X5681 cml_tlatch_5.INP cml_tlatch_5.INN cml_tlatch_14.xmux.xp.S1 VSS sg13_lv_nmos ad=56.9f pd=0.74u as=56.9f ps=0.74u w=0.17u l=0.17u
X5682 cml_tlatch_77.xtail.S1 CKB2_N cml_tlatch_77.xmux.xn.S1 VSS sg13_lv_nmos ad=89.3f pd=0.85u as=89.3f ps=0.85u w=0.47u l=0.16u
X5683 cml_tlatch_1.xtail.S1 CKB0_N cml_tlatch_1.xmux.xp.S1 VSS sg13_lv_nmos ad=89.3f pd=0.85u as=89.3f ps=0.85u w=0.47u l=0.16u
X5684 cml_tlatch_8.OUTN cml_tlatch_8.OUTP cml_tlatch_8.xmux.xp.S1 VSS sg13_lv_nmos ad=56.9f pd=0.74u as=56.9f ps=0.74u w=0.17u l=0.17u
X5685 cml_tlatch_89.xmux.xn.S1 cml_tlatch_89.INP cml_tlatch_89.OUTN VSS sg13_lv_nmos ad=63.19999f pd=0.74u as=63.19999f ps=0.74u w=0.26u l=0.38u
X5686 cml_tlatch_61.xmux.xn.S1 CKB3_P cml_tlatch_61.xtail.S1 VSS sg13_lv_nmos ad=89.3f pd=0.85u as=89.3f ps=0.85u w=0.47u l=0.16u
X5687 cml_tlatch_60.xmux.xp.S1 B3_8_P B3_8_N VSS sg13_lv_nmos ad=0.1019p pd=1.34u as=56.9f ps=0.74u w=0.17u l=0.17u
X5688 cml_tlatch_45.xmux.xp.S1 cml_tlatch_45.OUTN cml_tlatch_45.OUTP VSS sg13_lv_nmos ad=56.9f pd=0.74u as=56.9f ps=0.74u w=0.17u l=0.17u
X5689 GB2_P CKA2_N cml_gate2_7.xrtail.R1 VSS sg13_lv_nmos ad=0.1007p pd=0.91u as=0.1007p ps=0.91u w=0.53u l=0.13u
X5690 cml_tlatch_8.xtail.S1 CKA0_P cml_tlatch_8.xmux.xp.S1 VSS sg13_lv_nmos ad=89.3f pd=0.85u as=89.3f ps=0.85u w=0.47u l=0.16u
X5691 cml_tlatch_63.OUTP cml_tlatch_63.OUTN cml_tlatch_63.xmux.xp.S1 VSS sg13_lv_nmos ad=56.9f pd=0.74u as=56.9f ps=0.74u w=0.17u l=0.17u
X5692 cml_tlatch_64.xmux.xp.S1 A3_8_N A3_8_P VSS sg13_lv_nmos ad=56.9f pd=0.74u as=56.9f ps=0.74u w=0.17u l=0.17u
X5693 cml_tlatch_44.xmux.xn.S1 stub_bi_32.BOTN B2_2_N VSS sg13_lv_nmos ad=0.1082p pd=1.34u as=63.19999f ps=0.74u w=0.26u l=0.38u
X5694 cml_tlatch_8.OUTP cml_tlatch_9.OUTN cml_tlatch_8.xmux.xn.S1 VSS sg13_lv_nmos ad=63.19999f pd=0.74u as=63.19999f ps=0.74u w=0.26u l=0.38u
X5695 cml_tlatch_54.xmux.xp.S1 cml_tlatch_54.OUTN cml_tlatch_54.OUTP VSS sg13_lv_nmos ad=56.9f pd=0.74u as=56.9f ps=0.74u w=0.17u l=0.17u
X5696 cml_tlatch_23.xtail.S1 CKA1_N cml_tlatch_23.xmux.xn.S1 VSS sg13_lv_nmos ad=89.3f pd=0.85u as=89.3f ps=0.85u w=0.47u l=0.16u
X5697 cml_tlatch_35.OUTN cml_tlatch_35.OUTP cml_tlatch_35.xmux.xp.S1 VSS sg13_lv_nmos ad=56.9f pd=0.74u as=56.9f ps=0.74u w=0.17u l=0.17u
X5698 B1_8_N B1_8_P cml_tlatch_12.xmux.xp.S1 VSS sg13_lv_nmos ad=56.9f pd=0.74u as=56.9f ps=0.74u w=0.17u l=0.17u
X5699 cml_tlatch_48.xmux.xn.S1 D2_N stub_bi_32.BOTN VSS sg13_lv_nmos ad=63.19999f pd=0.74u as=63.19999f ps=0.74u w=0.26u l=0.38u
X5700 cml_tlatch_4.xmux.xp.S1 MOT9_N MOT9_P VSS sg13_lv_nmos ad=0.1019p pd=1.34u as=56.9f ps=0.74u w=0.17u l=0.17u
X5701 cml_tlatch_83.INN cml_tlatch_83.INP cml_tlatch_72.xmux.xp.S1 VSS sg13_lv_nmos ad=56.9f pd=0.74u as=56.9f ps=0.74u w=0.17u l=0.17u
X5702 cml_tlatch_80.xmux.xp.S1 stub_bi_49.BOTN stub_bi_49.BOTP VSS sg13_lv_nmos ad=56.9f pd=0.74u as=56.9f ps=0.74u w=0.17u l=0.17u
X5703 cml_tlatch_45.xmux.xp.S1 cml_tlatch_45.OUTN cml_tlatch_45.OUTP VSS sg13_lv_nmos ad=0.1019p pd=1.34u as=56.9f ps=0.74u w=0.17u l=0.17u
X5704 cml_tlatch_21.xtail.S1 POLN VSS VSS sg13_lv_nmos ad=1.5637p pd=8.61u as=2.7982p ps=17.14u w=8.23u l=0.13u
X5705 cml_tlatch_86.xmux.xn.S1 CKHA3_P cml_tlatch_86.xtail.S1 VSS sg13_lv_nmos ad=89.3f pd=0.85u as=89.3f ps=0.85u w=0.47u l=0.16u
X5706 cml_tlatch_58.xmux.xp.S1 MOT28_P MOT28_N VSS sg13_lv_nmos ad=56.9f pd=0.74u as=56.9f ps=0.74u w=0.17u l=0.17u
X5707 cml_tlatch_75.xtail.S1 CKHB2_N cml_tlatch_75.xmux.xp.S1 VSS sg13_lv_nmos ad=89.3f pd=0.85u as=89.3f ps=0.85u w=0.47u l=0.16u
X5708 MOT17_N MOT17_P cml_tlatch_73.xmux.xp.S1 VSS sg13_lv_nmos ad=56.9f pd=0.74u as=56.9f ps=0.74u w=0.17u l=0.17u
X5709 cml_tlatch_14.xtail.S1 CKB1_N cml_tlatch_14.xmux.xn.S1 VSS sg13_lv_nmos ad=89.3f pd=0.85u as=89.3f ps=0.85u w=0.47u l=0.16u
X5710 stub_bi_29.BOTN stub_bi_29.BOTP cml_tlatch_32.xmux.xp.S1 VSS sg13_lv_nmos ad=56.9f pd=0.74u as=56.9f ps=0.74u w=0.17u l=0.17u
X5711 cml_gate2_3.sg13_lv_nmos_FTPY57_0.D0 ENA0_N GA1_P VSS sg13_lv_nmos ad=0.1007p pd=0.91u as=0.1007p ps=0.91u w=0.53u l=0.13u
X5712 cml_tlatch_19.xmux.xp.S1 MOT5_N MOT5_P VSS sg13_lv_nmos ad=56.9f pd=0.74u as=56.9f ps=0.74u w=0.17u l=0.17u
X5713 cml_gate2_9.sg13_lv_nmos_FTPY57_0.D0 J1_P ENA_N VSS sg13_lv_nmos ad=0.1007p pd=0.91u as=0.1007p ps=0.91u w=0.53u l=0.13u
X5714 cml_tlatch_11.OUTN cml_tlatch_11.OUTP cml_tlatch_11.xmux.xp.S1 VSS sg13_lv_nmos ad=56.9f pd=0.74u as=0.1019p ps=1.34u w=0.17u l=0.17u
X5715 cml_tlatch_5.xmux.xn.S1 CKHB1_P cml_tlatch_5.xtail.S1 VSS sg13_lv_nmos ad=89.3f pd=0.85u as=89.3f ps=0.85u w=0.47u l=0.16u
X5716 cml_tlatch_38.OUTP cml_tlatch_38.OUTN cml_tlatch_38.xmux.xp.S1 VSS sg13_lv_nmos ad=56.9f pd=0.74u as=56.9f ps=0.74u w=0.17u l=0.17u
X5717 cml_tlatch_56.xtail.S1 CKA2_N cml_tlatch_56.xmux.xn.S1 VSS sg13_lv_nmos ad=89.3f pd=0.85u as=89.3f ps=0.85u w=0.47u l=0.16u
X5718 cml_tlatch_89.OUTN cml_tlatch_89.OUTP cml_tlatch_89.xmux.xp.S1 VSS sg13_lv_nmos ad=56.9f pd=0.74u as=56.9f ps=0.74u w=0.17u l=0.17u
X5719 cml_tlatch_52.OUTP A3_2_N cml_tlatch_52.xmux.xn.S1 VSS sg13_lv_nmos ad=63.19999f pd=0.74u as=0.1082p ps=1.34u w=0.26u l=0.38u
X5720 cml_tlatch_70.xtail.S1 CKHB3_N cml_tlatch_70.xmux.xp.S1 VSS sg13_lv_nmos ad=89.3f pd=0.85u as=89.3f ps=0.85u w=0.47u l=0.16u
X5721 cml_tlatch_29.xmux.xp.S1 cml_tlatch_29.OUTN cml_tlatch_29.OUTP VSS sg13_lv_nmos ad=56.9f pd=0.74u as=56.9f ps=0.74u w=0.17u l=0.17u
X5722 cml_gate2_2.xrtail.R1 CKB0_P cml_gate2_2.sg13_lv_nmos_FTPY57_0.D0 VSS sg13_lv_nmos ad=0.1802p pd=1.74u as=0.1007p ps=0.91u w=0.53u l=0.13u
X5723 cml_gate2_6.xrtail.R1 CKA3_P cml_gate2_6.sg13_lv_nmos_FTPY57_0.D0 VSS sg13_lv_nmos ad=0.1007p pd=0.91u as=0.1007p ps=0.91u w=0.53u l=0.13u
X5724 cml_tlatch_56.INN cml_tlatch_56.INP cml_tlatch_42.xmux.xp.S1 VSS sg13_lv_nmos ad=56.9f pd=0.74u as=56.9f ps=0.74u w=0.17u l=0.17u
X5725 MOT18_N cml_tlatch_83.OUTP cml_tlatch_49.xmux.xn.S1 VSS sg13_lv_nmos ad=63.19999f pd=0.74u as=63.19999f ps=0.74u w=0.26u l=0.38u
X5726 cml_tlatch_95.INN A1_2_P cml_tlatch_36.xmux.xn.S1 VSS sg13_lv_nmos ad=63.19999f pd=0.74u as=63.19999f ps=0.74u w=0.26u l=0.38u
X5727 cml_tlatch_48.xmux.xp.S1 stub_bi_32.BOTN stub_bi_32.BOTP VSS sg13_lv_nmos ad=56.9f pd=0.74u as=56.9f ps=0.74u w=0.17u l=0.17u
X5728 cml_tlatch_13.xmux.xp.S1 CKB1_N cml_tlatch_13.xtail.S1 VSS sg13_lv_nmos ad=89.3f pd=0.85u as=89.3f ps=0.85u w=0.47u l=0.16u
X5729 cml_tlatch_17.xmux.xp.S1 MOT1_P MOT1_N VSS sg13_lv_nmos ad=56.9f pd=0.74u as=56.9f ps=0.74u w=0.17u l=0.17u
X5730 cml_tlatch_57.xtail.S1 CKHA3_P cml_tlatch_57.xmux.xn.S1 VSS sg13_lv_nmos ad=0.1598p pd=1.62u as=89.3f ps=0.85u w=0.47u l=0.16u
X5731 cml_tlatch_44.xtail.S1 CKB2_N cml_tlatch_44.xmux.xn.S1 VSS sg13_lv_nmos ad=89.3f pd=0.85u as=89.3f ps=0.85u w=0.47u l=0.16u
X5732 MOT2_P MOT2_N cml_tlatch_24.xmux.xp.S1 VSS sg13_lv_nmos ad=56.9f pd=0.74u as=56.9f ps=0.74u w=0.17u l=0.17u
X5733 B3_2_N VDD VSS rppd l=5.17u w=1u
X5734 cml_gate2_6.sg13_lv_nmos_FTPY57_0.D0 ENB0_P GB3_N VSS sg13_lv_nmos ad=0.1007p pd=0.91u as=0.1007p ps=0.91u w=0.53u l=0.13u
X5735 cml_tlatch_95.xtail.S1 CKA1_N cml_tlatch_95.xmux.xn.S1 VSS sg13_lv_nmos ad=89.3f pd=0.85u as=89.3f ps=0.85u w=0.47u l=0.16u
X5736 cml_tlatch_82.xmux.xp.S1 CKA2_N cml_tlatch_82.xtail.S1 VSS sg13_lv_nmos ad=89.3f pd=0.85u as=89.3f ps=0.85u w=0.47u l=0.16u
X5737 cml_tlatch_75.xmux.xp.S1 MOT21_N MOT21_P VSS sg13_lv_nmos ad=56.9f pd=0.74u as=56.9f ps=0.74u w=0.17u l=0.17u
X5738 cml_tlatch_61.OUTN cml_tlatch_61.OUTP cml_tlatch_61.xmux.xp.S1 VSS sg13_lv_nmos ad=56.9f pd=0.74u as=56.9f ps=0.74u w=0.17u l=0.17u
X5739 GB1_P ENB1_N cml_gate2_0.sg13_lv_nmos_FTPY57_0.D0 VSS sg13_lv_nmos ad=0.1007p pd=0.91u as=0.1802p ps=1.74u w=0.53u l=0.13u
X5740 cml_tlatch_82.xmux.xp.S1 cml_tlatch_82.OUTP cml_tlatch_82.OUTN VSS sg13_lv_nmos ad=56.9f pd=0.74u as=56.9f ps=0.74u w=0.17u l=0.17u
X5741 cml_tlatch_11.xtail.S1 CKB0_P cml_tlatch_11.xmux.xn.S1 VSS sg13_lv_nmos ad=89.3f pd=0.85u as=89.3f ps=0.85u w=0.47u l=0.16u
X5742 cml_tlatch_91.xmux.xp.S1 CLK_W_N CLK_W_P VSS sg13_lv_nmos ad=56.9f pd=0.74u as=56.9f ps=0.74u w=0.17u l=0.17u
X5743 cml_tlatch_17.xmux.xp.S1 CKHB0_N cml_tlatch_17.xtail.S1 VSS sg13_lv_nmos ad=89.3f pd=0.85u as=89.3f ps=0.85u w=0.47u l=0.16u
X5744 cml_tlatch_62.xmux.xp.S1 cml_tlatch_69.INP cml_tlatch_69.INN VSS sg13_lv_nmos ad=56.9f pd=0.74u as=56.9f ps=0.74u w=0.17u l=0.17u
X5745 A2_2_P A2_2_N cml_tlatch_56.xmux.xp.S1 VSS sg13_lv_nmos ad=56.9f pd=0.74u as=56.9f ps=0.74u w=0.17u l=0.17u
X5746 cml_tlatch_83.xmux.xn.S1 CKA2_N cml_tlatch_83.xtail.S1 VSS sg13_lv_nmos ad=89.3f pd=0.85u as=89.3f ps=0.85u w=0.47u l=0.16u
X5747 cml_tlatch_44.xmux.xp.S1 B2_2_N B2_2_P VSS sg13_lv_nmos ad=56.9f pd=0.74u as=56.9f ps=0.74u w=0.17u l=0.17u
X5748 GA2_P CKB2_N cml_gate2_4.xrtail.R1 VSS sg13_lv_nmos ad=0.1007p pd=0.91u as=0.1007p ps=0.91u w=0.53u l=0.13u
X5749 cml_tlatch_28.xmux.xp.S1 CKB0_P cml_tlatch_28.xtail.S1 VSS sg13_lv_nmos ad=89.3f pd=0.85u as=89.3f ps=0.85u w=0.47u l=0.16u
X5750 J1_P J1_N cml_tlatch_93.xmux.xp.S1 VSS sg13_lv_nmos ad=56.9f pd=0.74u as=56.9f ps=0.74u w=0.17u l=0.17u
X5751 cml_tlatch_11.OUTN cml_tlatch_11.OUTP cml_tlatch_11.xmux.xp.S1 VSS sg13_lv_nmos ad=56.9f pd=0.74u as=56.9f ps=0.74u w=0.17u l=0.17u
X5752 cml_tlatch_39.xtail.S1 CKHA1_P cml_tlatch_39.xmux.xn.S1 VSS sg13_lv_nmos ad=89.3f pd=0.85u as=89.3f ps=0.85u w=0.47u l=0.16u
X5753 VSS POLN cml_tlatch_71.xtail.S1 VSS sg13_lv_nmos ad=1.5637p pd=8.61u as=1.5637p ps=8.61u w=8.23u l=0.13u
X5754 cml_tlatch_48.xmux.xp.S1 CKB2_N cml_tlatch_48.xtail.S1 VSS sg13_lv_nmos ad=89.3f pd=0.85u as=89.3f ps=0.85u w=0.47u l=0.16u
X5755 cml_tlatch_5.INN cml_tlatch_5.INP cml_tlatch_14.xmux.xp.S1 VSS sg13_lv_nmos ad=56.9f pd=0.74u as=56.9f ps=0.74u w=0.17u l=0.17u
X5756 VDD MOT3_P VSS rppd l=5.17u w=1u
X5757 VSS POLN hs_to_clk_4.D2 VSS sg13_lv_nmos ad=1.9p pd=10.38u as=3.4p ps=20.68u w=10u l=0.13u
X5758 cml_tlatch_72.xmux.xp.S1 cml_tlatch_83.INN cml_tlatch_83.INP VSS sg13_lv_nmos ad=56.9f pd=0.74u as=56.9f ps=0.74u w=0.17u l=0.17u
X5759 MOT12_P MOT12_N cml_tlatch_40.xmux.xp.S1 VSS sg13_lv_nmos ad=56.9f pd=0.74u as=56.9f ps=0.74u w=0.17u l=0.17u
X5760 cml_tlatch_91.xmux.xp.S1 CKJ_N cml_tlatch_91.xtail.S1 VSS sg13_lv_nmos ad=0.1598p pd=1.62u as=89.3f ps=0.85u w=0.47u l=0.16u
X5761 cml_tlatch_87.xmux.xn.S1 A2_8_P MOT16_N VSS sg13_lv_nmos ad=63.19999f pd=0.74u as=63.19999f ps=0.74u w=0.26u l=0.38u
X5762 stub_bi_55.BOTP stub_bi_55.BOTN cml_tlatch_88.xmux.xp.S1 VSS sg13_lv_nmos ad=56.9f pd=0.74u as=56.9f ps=0.74u w=0.17u l=0.17u
X5763 cml_tlatch_16.xtail.S1 CKB0_N cml_tlatch_16.xmux.xn.S1 VSS sg13_lv_nmos ad=89.3f pd=0.85u as=89.3f ps=0.85u w=0.47u l=0.16u
X5764 VSS cml_drvb_6.xrtail.R1 VSS rppd l=2.72u w=1u
X5765 MOT22_P MOT22_N cml_tlatch_51.xmux.xp.S1 VSS sg13_lv_nmos ad=56.9f pd=0.74u as=56.9f ps=0.74u w=0.17u l=0.17u
X5766 cml_tlatch_20.xmux.xn.S1 CKHB0_P cml_tlatch_20.xtail.S1 VSS sg13_lv_nmos ad=0.1598p pd=1.62u as=89.3f ps=0.85u w=0.47u l=0.16u
X5767 cml_tlatch_63.xmux.xp.S1 CKB3_N cml_tlatch_63.xtail.S1 VSS sg13_lv_nmos ad=89.3f pd=0.85u as=89.3f ps=0.85u w=0.47u l=0.16u
X5768 MOT23_N MOT23_P cml_tlatch_76.xmux.xp.S1 VSS sg13_lv_nmos ad=56.9f pd=0.74u as=56.9f ps=0.74u w=0.17u l=0.17u
X5769 MOT1_N B0_8_P cml_tlatch_17.xmux.xn.S1 VSS sg13_lv_nmos ad=63.19999f pd=0.74u as=0.1082p ps=1.34u w=0.26u l=0.38u
X5770 cml_tlatch_93.xtail.S1 CKJ_N cml_tlatch_93.xmux.xp.S1 VSS sg13_lv_nmos ad=89.3f pd=0.85u as=89.3f ps=0.85u w=0.47u l=0.16u
X5771 cml_tlatch_9.xmux.xp.S1 cml_tlatch_9.OUTN cml_tlatch_9.OUTP VSS sg13_lv_nmos ad=56.9f pd=0.74u as=56.9f ps=0.74u w=0.17u l=0.17u
X5772 cml_gate2_8.sg13_lv_nmos_FTPY57_0.D0 J2_N ENB_P VSS sg13_lv_nmos ad=0.1007p pd=0.91u as=0.1007p ps=0.91u w=0.53u l=0.13u
X5773 cml_tlatch_50.xtail.S1 CKHA2_N cml_tlatch_50.xmux.xp.S1 VSS sg13_lv_nmos ad=89.3f pd=0.85u as=89.3f ps=0.85u w=0.47u l=0.16u
X5774 cml_tlatch_0.xmux.xp.S1 interco_bi_19.INP interco_bi_19.INN VSS sg13_lv_nmos ad=56.9f pd=0.74u as=56.9f ps=0.74u w=0.17u l=0.17u
X5775 cml_tlatch_97.xtail.S1 CKHA0_N cml_tlatch_97.xmux.xp.S1 VSS sg13_lv_nmos ad=89.3f pd=0.85u as=89.3f ps=0.85u w=0.47u l=0.16u
X5776 MOT28_P MOT28_N cml_tlatch_58.xmux.xp.S1 VSS sg13_lv_nmos ad=56.9f pd=0.74u as=56.9f ps=0.74u w=0.17u l=0.17u
X5777 cml_tlatch_69.INN cml_tlatch_63.OUTP cml_tlatch_62.xmux.xn.S1 VSS sg13_lv_nmos ad=63.19999f pd=0.74u as=63.19999f ps=0.74u w=0.26u l=0.38u
X5778 B0_2_P B0_2_N cml_tlatch_28.xmux.xp.S1 VSS sg13_lv_nmos ad=56.9f pd=0.74u as=56.9f ps=0.74u w=0.17u l=0.17u
X5779 B2_8_N B2_8_P cml_tlatch_77.xmux.xp.S1 VSS sg13_lv_nmos ad=56.9f pd=0.74u as=56.9f ps=0.74u w=0.17u l=0.17u
X5780 cml_tlatch_99.xmux.xp.S1 cml_tlatch_99.OUTN cml_tlatch_99.OUTP VSS sg13_lv_nmos ad=56.9f pd=0.74u as=56.9f ps=0.74u w=0.17u l=0.17u
X5781 cml_tlatch_88.xmux.xn.S1 stub_bi_42.BOTP stub_bi_55.BOTN VSS sg13_lv_nmos ad=0.1082p pd=1.34u as=63.19999f ps=0.74u w=0.26u l=0.38u
X5782 cml_tlatch_43.xmux.xp.S1 CKB2_N cml_tlatch_43.xtail.S1 VSS sg13_lv_nmos ad=89.3f pd=0.85u as=89.3f ps=0.85u w=0.47u l=0.16u
X5783 VDD hs_to_clk_0.sg13_lv_nmos_2HGZLP_0.G VSS rppd l=0.68u w=1u
X5784 cml_tlatch_4.xmux.xn.S1 B1_8_P MOT9_N VSS sg13_lv_nmos ad=0.1082p pd=1.34u as=63.19999f ps=0.74u w=0.26u l=0.38u
X5785 MOT19_P MOT19_N cml_tlatch_74.xmux.xp.S1 VSS sg13_lv_nmos ad=56.9f pd=0.74u as=56.9f ps=0.74u w=0.17u l=0.17u
X5786 cml_tlatch_48.xmux.xp.S1 stub_bi_32.BOTN stub_bi_32.BOTP VSS sg13_lv_nmos ad=56.9f pd=0.74u as=56.9f ps=0.74u w=0.17u l=0.17u
X5787 cml_tlatch_69.xmux.xp.S1 MOT27_N MOT27_P VSS sg13_lv_nmos ad=56.9f pd=0.74u as=56.9f ps=0.74u w=0.17u l=0.17u
X5788 MOT20_P cml_tlatch_89.OUTN cml_tlatch_50.xmux.xn.S1 VSS sg13_lv_nmos ad=63.19999f pd=0.74u as=63.19999f ps=0.74u w=0.26u l=0.38u
X5789 MOT15_P MOT15_N cml_tlatch_7.xmux.xp.S1 VSS sg13_lv_nmos ad=56.9f pd=0.74u as=56.9f ps=0.74u w=0.17u l=0.17u
X5790 cml_tlatch_82.OUTP cml_tlatch_83.OUTN cml_tlatch_82.xmux.xn.S1 VSS sg13_lv_nmos ad=63.19999f pd=0.74u as=63.19999f ps=0.74u w=0.26u l=0.38u
X5791 stub_bi_42.BOTN stub_bi_42.BOTP cml_tlatch_43.xmux.xp.S1 VSS sg13_lv_nmos ad=56.9f pd=0.74u as=56.9f ps=0.74u w=0.17u l=0.17u
X5792 J1_P J4_P cml_tlatch_93.xmux.xn.S1 VSS sg13_lv_nmos ad=63.19999f pd=0.74u as=0.1082p ps=1.34u w=0.26u l=0.38u
X5793 MOT29_P MOT29_N cml_tlatch_70.xmux.xp.S1 VSS sg13_lv_nmos ad=56.9f pd=0.74u as=56.9f ps=0.74u w=0.17u l=0.17u
X5794 cml_tlatch_82.xmux.xp.S1 cml_tlatch_82.OUTP cml_tlatch_82.OUTN VSS sg13_lv_nmos ad=56.9f pd=0.74u as=56.9f ps=0.74u w=0.17u l=0.17u
X5795 cml_tlatch_83.xmux.xp.S1 cml_tlatch_83.OUTP cml_tlatch_83.OUTN VSS sg13_lv_nmos ad=56.9f pd=0.74u as=56.9f ps=0.74u w=0.17u l=0.17u
X5796 cml_gate2_2.xrtail.R1 CKB0_N GA0_P VSS sg13_lv_nmos ad=0.1007p pd=0.91u as=0.1007p ps=0.91u w=0.53u l=0.13u
X5797 cml_tlatch_93.xmux.xn.S1 J4_N J1_N VSS sg13_lv_nmos ad=63.19999f pd=0.74u as=63.19999f ps=0.74u w=0.26u l=0.38u
X5798 B0_8_N B0_8_P cml_tlatch_10.xmux.xp.S1 VSS sg13_lv_nmos ad=56.9f pd=0.74u as=56.9f ps=0.74u w=0.17u l=0.17u
X5799 VSS POLN cml_tlatch_2.xtail.S1 VSS sg13_lv_nmos ad=1.5637p pd=8.61u as=1.5637p ps=8.61u w=8.23u l=0.13u
X5800 cml_tlatch_23.xmux.xp.S1 cml_tlatch_39.INN cml_tlatch_39.INP VSS sg13_lv_nmos ad=56.9f pd=0.74u as=56.9f ps=0.74u w=0.17u l=0.17u
X5801 VSS POLN cml_tlatch_68.xtail.S1 VSS sg13_lv_nmos ad=1.5637p pd=8.61u as=1.5637p ps=8.61u w=8.23u l=0.13u
X5802 stub_bi_63.BOTN stub_bi_63.BOTP cml_tlatch_79.xmux.xp.S1 VSS sg13_lv_nmos ad=56.9f pd=0.74u as=56.9f ps=0.74u w=0.17u l=0.17u
X5803 cml_tlatch_7.xtail.S1 CKHB1_N cml_tlatch_7.xmux.xp.S1 VSS sg13_lv_nmos ad=89.3f pd=0.85u as=89.3f ps=0.85u w=0.47u l=0.16u
X5804 cml_tlatch_88.xmux.xp.S1 stub_bi_55.BOTP stub_bi_55.BOTN VSS sg13_lv_nmos ad=56.9f pd=0.74u as=56.9f ps=0.74u w=0.17u l=0.17u
X5805 cml_tlatch_30.OUTP A0_2_N cml_tlatch_30.xmux.xn.S1 VSS sg13_lv_nmos ad=63.19999f pd=0.74u as=0.1082p ps=1.34u w=0.26u l=0.38u
X5806 cml_tlatch_87.xmux.xp.S1 MOT16_N MOT16_P VSS sg13_lv_nmos ad=56.9f pd=0.74u as=56.9f ps=0.74u w=0.17u l=0.17u
X5807 MOT17_P B2_8_N cml_tlatch_73.xmux.xn.S1 VSS sg13_lv_nmos ad=63.19999f pd=0.74u as=0.1082p ps=1.34u w=0.26u l=0.38u
X5808 VSS POLN cml_tlatch_8.xtail.S1 VSS sg13_lv_nmos ad=2.7982p pd=17.14u as=1.5637p ps=8.61u w=8.23u l=0.13u
X5809 cml_tlatch_21.xmux.xp.S1 CKA1_P cml_tlatch_21.xtail.S1 VSS sg13_lv_nmos ad=89.3f pd=0.85u as=89.3f ps=0.85u w=0.47u l=0.16u
X5810 cml_tlatch_32.xmux.xp.S1 stub_bi_29.BOTN stub_bi_29.BOTP VSS sg13_lv_nmos ad=56.9f pd=0.74u as=56.9f ps=0.74u w=0.17u l=0.17u
X5811 MOT31_N MOT31_P cml_tlatch_71.xmux.xp.S1 VSS sg13_lv_nmos ad=56.9f pd=0.74u as=56.9f ps=0.74u w=0.17u l=0.17u
X5812 MOT31_P MOT31_N cml_tlatch_71.xmux.xp.S1 VSS sg13_lv_nmos ad=56.9f pd=0.74u as=56.9f ps=0.74u w=0.17u l=0.17u
X5813 cml_tlatch_19.xmux.xn.S1 cml_tlatch_98.OUTN MOT5_P VSS sg13_lv_nmos ad=63.19999f pd=0.74u as=63.19999f ps=0.74u w=0.26u l=0.38u
X5814 hs_to_clk_3.D2 POLN VSS VSS sg13_lv_nmos ad=1.9p pd=10.38u as=1.9p ps=10.38u w=10u l=0.13u
X5815 cml_tlatch_41.xmux.xp.S1 MOT14_N MOT14_P VSS sg13_lv_nmos ad=56.9f pd=0.74u as=56.9f ps=0.74u w=0.17u l=0.17u
X5816 cml_tlatch_96.xmux.xp.S1 MOT8_P MOT8_N VSS sg13_lv_nmos ad=56.9f pd=0.74u as=56.9f ps=0.74u w=0.17u l=0.17u
X5817 cml_tlatch_80.xmux.xn.S1 stub_bi_55.BOTN stub_bi_49.BOTP VSS sg13_lv_nmos ad=63.19999f pd=0.74u as=63.19999f ps=0.74u w=0.26u l=0.38u
X5818 cml_gate2_0.sg13_lv_nmos_FTPY57_0.D0 ENB1_P GB1_N VSS sg13_lv_nmos ad=0.1007p pd=0.91u as=0.1007p ps=0.91u w=0.53u l=0.13u
X5819 cml_tlatch_67.OUTN cml_tlatch_67.OUTP cml_tlatch_67.xmux.xp.S1 VSS sg13_lv_nmos ad=56.9f pd=0.74u as=56.9f ps=0.74u w=0.17u l=0.17u
X5820 cml_tlatch_67.xmux.xn.S1 CKA3_P cml_tlatch_67.xtail.S1 VSS sg13_lv_nmos ad=89.3f pd=0.85u as=89.3f ps=0.85u w=0.47u l=0.16u
X5821 cml_tlatch_1.OUTP cml_tlatch_98.OUTN cml_tlatch_1.xmux.xn.S1 VSS sg13_lv_nmos ad=63.19999f pd=0.74u as=63.19999f ps=0.74u w=0.26u l=0.38u
X5822 stub_bi_62.BOTN stub_bi_62.BOTP cml_tlatch_78.xmux.xp.S1 VSS sg13_lv_nmos ad=56.9f pd=0.74u as=56.9f ps=0.74u w=0.17u l=0.17u
X5823 cml_tlatch_7.xmux.xp.S1 MOT15_P MOT15_N VSS sg13_lv_nmos ad=56.9f pd=0.74u as=56.9f ps=0.74u w=0.17u l=0.17u
X5824 MOT12_P MOT12_N cml_tlatch_40.xmux.xp.S1 VSS sg13_lv_nmos ad=56.9f pd=0.74u as=56.9f ps=0.74u w=0.17u l=0.17u
X5825 cml_tlatch_70.INN cml_tlatch_45.OUTP cml_tlatch_84.xmux.xn.S1 VSS sg13_lv_nmos ad=63.19999f pd=0.74u as=63.19999f ps=0.74u w=0.26u l=0.38u
X5826 MOT26_P cml_tlatch_57.INN cml_tlatch_57.xmux.xn.S1 VSS sg13_lv_nmos ad=63.19999f pd=0.74u as=63.19999f ps=0.74u w=0.26u l=0.38u
X5827 stub_bi_49.BOTN stub_bi_49.BOTP cml_tlatch_80.xmux.xp.S1 VSS sg13_lv_nmos ad=56.9f pd=0.74u as=56.9f ps=0.74u w=0.17u l=0.17u
X5828 cml_tlatch_22.OUTN cml_tlatch_39.INP cml_tlatch_22.xmux.xn.S1 VSS sg13_lv_nmos ad=63.19999f pd=0.74u as=63.19999f ps=0.74u w=0.26u l=0.38u
X5829 cml_tlatch_22.xmux.xn.S1 CKA1_P cml_tlatch_22.xtail.S1 VSS sg13_lv_nmos ad=89.3f pd=0.85u as=89.3f ps=0.85u w=0.47u l=0.16u
X5830 cml_tlatch_41.xtail.S1 CKHA1_N cml_tlatch_41.xmux.xp.S1 VSS sg13_lv_nmos ad=89.3f pd=0.85u as=89.3f ps=0.85u w=0.47u l=0.16u
X5831 cml_tlatch_63.xmux.xn.S1 CKB3_P cml_tlatch_63.xtail.S1 VSS sg13_lv_nmos ad=89.3f pd=0.85u as=89.3f ps=0.85u w=0.47u l=0.16u
X5832 cml_tlatch_64.xmux.xp.S1 A3_8_P A3_8_N VSS sg13_lv_nmos ad=56.9f pd=0.74u as=56.9f ps=0.74u w=0.17u l=0.17u
X5833 MOT0_N A0_8_P cml_tlatch_97.xmux.xn.S1 VSS sg13_lv_nmos ad=0.1082p pd=1.34u as=63.19999f ps=0.74u w=0.26u l=0.38u
X5834 cml_tlatch_86.xmux.xp.S1 MOT24_P MOT24_N VSS sg13_lv_nmos ad=56.9f pd=0.74u as=56.9f ps=0.74u w=0.17u l=0.17u
X5835 cml_tlatch_27.xmux.xp.S1 cml_tlatch_27.OUTP cml_tlatch_27.OUTN VSS sg13_lv_nmos ad=56.9f pd=0.74u as=56.9f ps=0.74u w=0.17u l=0.17u
X5836 cml_tlatch_99.xtail.S1 CKA0_P cml_tlatch_99.xmux.xp.S1 VSS sg13_lv_nmos ad=89.3f pd=0.85u as=89.3f ps=0.85u w=0.47u l=0.16u
X5837 cml_tlatch_55.xmux.xn.S1 CKA2_P cml_tlatch_55.xtail.S1 VSS sg13_lv_nmos ad=89.3f pd=0.85u as=89.3f ps=0.85u w=0.47u l=0.16u
X5838 cml_tlatch_9.OUTN cml_tlatch_9.OUTP cml_tlatch_9.xmux.xp.S1 VSS sg13_lv_nmos ad=56.9f pd=0.74u as=56.9f ps=0.74u w=0.17u l=0.17u
X5839 cml_tlatch_13.xmux.xn.S1 CKB1_P cml_tlatch_13.xtail.S1 VSS sg13_lv_nmos ad=89.3f pd=0.85u as=89.3f ps=0.85u w=0.47u l=0.16u
X5840 cml_tlatch_1.OUTP cml_tlatch_1.OUTN cml_tlatch_1.xmux.xp.S1 VSS sg13_lv_nmos ad=56.9f pd=0.74u as=0.1019p ps=1.34u w=0.17u l=0.17u
X5841 cml_tlatch_54.OUTN cml_tlatch_54.OUTP cml_tlatch_54.xmux.xp.S1 VSS sg13_lv_nmos ad=56.9f pd=0.74u as=56.9f ps=0.74u w=0.17u l=0.17u
X5842 cml_tlatch_3.xmux.xp.S1 cml_tlatch_3.OUTN cml_tlatch_3.OUTP VSS sg13_lv_nmos ad=56.9f pd=0.74u as=56.9f ps=0.74u w=0.17u l=0.17u
X5843 cml_tlatch_30.xmux.xn.S1 CKA0_P cml_tlatch_30.xtail.S1 VSS sg13_lv_nmos ad=89.3f pd=0.85u as=89.3f ps=0.85u w=0.47u l=0.16u
X5844 A1_8_N A1_8_P cml_tlatch_21.xmux.xp.S1 VSS sg13_lv_nmos ad=56.9f pd=0.74u as=56.9f ps=0.74u w=0.17u l=0.17u
X5845 MOT31_N B3_2_P cml_tlatch_71.xmux.xn.S1 VSS sg13_lv_nmos ad=63.19999f pd=0.74u as=63.19999f ps=0.74u w=0.26u l=0.38u
X5846 cml_tlatch_48.xtail.S1 CKB2_N cml_tlatch_48.xmux.xp.S1 VSS sg13_lv_nmos ad=89.3f pd=0.85u as=89.3f ps=0.85u w=0.47u l=0.16u
X5847 cml_tlatch_99.OUTN cml_tlatch_30.OUTP cml_tlatch_99.xmux.xn.S1 VSS sg13_lv_nmos ad=0.1082p pd=1.34u as=63.19999f ps=0.74u w=0.26u l=0.38u
X5848 cml_tlatch_2.xtail.S1 CKA0_P cml_tlatch_2.xmux.xp.S1 VSS sg13_lv_nmos ad=89.3f pd=0.85u as=89.3f ps=0.85u w=0.47u l=0.16u
X5849 cml_tlatch_67.xmux.xn.S1 cml_tlatch_58.INN cml_tlatch_67.OUTP VSS sg13_lv_nmos ad=63.19999f pd=0.74u as=63.19999f ps=0.74u w=0.26u l=0.38u
X5850 stub_bi_42.BOTN B2_2_N cml_tlatch_43.xmux.xn.S1 VSS sg13_lv_nmos ad=63.19999f pd=0.74u as=63.19999f ps=0.74u w=0.26u l=0.38u
X5851 MOT9_P MOT9_N cml_tlatch_4.xmux.xp.S1 VSS sg13_lv_nmos ad=56.9f pd=0.74u as=56.9f ps=0.74u w=0.17u l=0.17u
X5852 A1_2_P cml_tlatch_38.OUTN cml_tlatch_37.xmux.xn.S1 VSS sg13_lv_nmos ad=63.19999f pd=0.74u as=0.1082p ps=1.34u w=0.26u l=0.38u
X5853 cml_tlatch_46.xmux.xp.S1 B3_2_P B3_2_N VSS sg13_lv_nmos ad=56.9f pd=0.74u as=56.9f ps=0.74u w=0.17u l=0.17u
X5854 MOT19_N MOT19_P cml_tlatch_74.xmux.xp.S1 VSS sg13_lv_nmos ad=56.9f pd=0.74u as=56.9f ps=0.74u w=0.17u l=0.17u
X5855 cml_tlatch_28.xmux.xp.S1 B0_2_P B0_2_N VSS sg13_lv_nmos ad=56.9f pd=0.74u as=56.9f ps=0.74u w=0.17u l=0.17u
X5856 MOT18_P MOT18_N cml_tlatch_49.xmux.xp.S1 VSS sg13_lv_nmos ad=56.9f pd=0.74u as=56.9f ps=0.74u w=0.17u l=0.17u
X5857 MOT23_P B2_2_N cml_tlatch_76.xmux.xn.S1 VSS sg13_lv_nmos ad=63.19999f pd=0.74u as=63.19999f ps=0.74u w=0.26u l=0.38u
X5858 cml_tlatch_16.OUTN VDD VSS rppd l=5.17u w=1u
X5859 VSS hs_to_clk_3.sg13_lv_nmos_2HGZLP_0.G VSS VSS sg13_lv_nmos ad=2.071p pd=11.28u as=0 ps=0 w=10.9u l=1.38u
X5860 cml_tlatch_52.xmux.xp.S1 cml_tlatch_52.OUTN cml_tlatch_52.OUTP VSS sg13_lv_nmos ad=56.9f pd=0.74u as=56.9f ps=0.74u w=0.17u l=0.17u
X5861 cml_tlatch_57.xmux.xp.S1 MOT26_N MOT26_P VSS sg13_lv_nmos ad=56.9f pd=0.74u as=56.9f ps=0.74u w=0.17u l=0.17u
X5862 cml_tlatch_99.OUTN cml_tlatch_30.OUTP cml_tlatch_99.xmux.xn.S1 VSS sg13_lv_nmos ad=63.19999f pd=0.74u as=63.19999f ps=0.74u w=0.26u l=0.38u
X5863 cml_tlatch_37.xmux.xn.S1 cml_tlatch_38.OUTP A1_2_N VSS sg13_lv_nmos ad=63.19999f pd=0.74u as=63.19999f ps=0.74u w=0.26u l=0.38u
X5864 J4_P CLK_W_P cml_tlatch_90.xmux.xn.S1 VSS sg13_lv_nmos ad=63.19999f pd=0.74u as=0.1082p ps=1.34u w=0.26u l=0.38u
X5865 VSS POLN cml_tlatch_70.xtail.S1 VSS sg13_lv_nmos ad=2.7982p pd=17.14u as=1.5637p ps=8.61u w=8.23u l=0.13u
X5866 cml_gate2_7.sg13_lv_nmos_FTPY57_0.D0 CKA2_P cml_gate2_7.xrtail.R1 VSS sg13_lv_nmos ad=0.1007p pd=0.91u as=0.1007p ps=0.91u w=0.53u l=0.13u
X5867 cml_tlatch_43.xmux.xn.S1 CKB2_P cml_tlatch_43.xtail.S1 VSS sg13_lv_nmos ad=89.3f pd=0.85u as=89.3f ps=0.85u w=0.47u l=0.16u
X5868 cml_tlatch_23.xmux.xp.S1 cml_tlatch_39.INN cml_tlatch_39.INP VSS sg13_lv_nmos ad=56.9f pd=0.74u as=56.9f ps=0.74u w=0.17u l=0.17u
X5869 cml_tlatch_52.xmux.xn.S1 CKA3_P cml_tlatch_52.xtail.S1 VSS sg13_lv_nmos ad=89.3f pd=0.85u as=89.3f ps=0.85u w=0.47u l=0.16u
X5870 cml_tlatch_70.xtail.S1 CKHB3_N cml_tlatch_70.xmux.xp.S1 VSS sg13_lv_nmos ad=89.3f pd=0.85u as=89.3f ps=0.85u w=0.47u l=0.16u
X5871 cml_tlatch_90.xmux.xn.S1 CLK_W_N J4_N VSS sg13_lv_nmos ad=63.19999f pd=0.74u as=63.19999f ps=0.74u w=0.26u l=0.38u
X5872 cml_tlatch_67.OUTN cml_tlatch_58.INP cml_tlatch_67.xmux.xn.S1 VSS sg13_lv_nmos ad=63.19999f pd=0.74u as=63.19999f ps=0.74u w=0.26u l=0.38u
X5873 cml_tlatch_69.xmux.xn.S1 cml_tlatch_69.INP MOT27_N VSS sg13_lv_nmos ad=0.1082p pd=1.34u as=63.19999f ps=0.74u w=0.26u l=0.38u
X5874 MOT10_N MOT10_P cml_tlatch_39.xmux.xp.S1 VSS sg13_lv_nmos ad=56.9f pd=0.74u as=56.9f ps=0.74u w=0.17u l=0.17u
X5875 cml_tlatch_95.INP cml_tlatch_95.INN cml_tlatch_36.xmux.xp.S1 VSS sg13_lv_nmos ad=56.9f pd=0.74u as=56.9f ps=0.74u w=0.17u l=0.17u
X5876 A1_8_N A1_8_P cml_tlatch_21.xmux.xp.S1 VSS sg13_lv_nmos ad=56.9f pd=0.74u as=56.9f ps=0.74u w=0.17u l=0.17u
X5877 MOT15_P MOT15_N cml_tlatch_7.xmux.xp.S1 VSS sg13_lv_nmos ad=56.9f pd=0.74u as=56.9f ps=0.74u w=0.17u l=0.17u
X5878 cml_tlatch_61.OUTN cml_tlatch_69.INP cml_tlatch_61.xmux.xn.S1 VSS sg13_lv_nmos ad=63.19999f pd=0.74u as=63.19999f ps=0.74u w=0.26u l=0.38u
X5879 cml_tlatch_59.xmux.xn.S1 A3_2_N MOT30_P VSS sg13_lv_nmos ad=63.19999f pd=0.74u as=63.19999f ps=0.74u w=0.26u l=0.38u
X5880 cml_tlatch_35.xmux.xp.S1 CKA0_N cml_tlatch_35.xtail.S1 VSS sg13_lv_nmos ad=89.3f pd=0.85u as=89.3f ps=0.85u w=0.47u l=0.16u
X5881 A3_2_P A3_2_N cml_tlatch_53.xmux.xp.S1 VSS sg13_lv_nmos ad=56.9f pd=0.74u as=56.9f ps=0.74u w=0.17u l=0.17u
X5882 cml_tlatch_73.xtail.S1 CKHB2_N cml_tlatch_73.xmux.xp.S1 VSS sg13_lv_nmos ad=89.3f pd=0.85u as=89.3f ps=0.85u w=0.47u l=0.16u
X5883 cml_tlatch_3.xmux.xp.S1 CKA0_N cml_tlatch_3.xtail.S1 VSS sg13_lv_nmos ad=89.3f pd=0.85u as=89.3f ps=0.85u w=0.47u l=0.16u
X5884 cml_tlatch_51.xtail.S1 CKHA2_N cml_tlatch_51.xmux.xp.S1 VSS sg13_lv_nmos ad=89.3f pd=0.85u as=89.3f ps=0.85u w=0.47u l=0.16u
X5885 cml_tlatch_3.OUTN cml_tlatch_3.OUTP cml_tlatch_3.xmux.xp.S1 VSS sg13_lv_nmos ad=56.9f pd=0.74u as=0.1019p ps=1.34u w=0.17u l=0.17u
X5886 MOT31_N MOT31_P cml_tlatch_71.xmux.xp.S1 VSS sg13_lv_nmos ad=56.9f pd=0.74u as=0.1019p ps=1.34u w=0.17u l=0.17u
X5887 cml_tlatch_93.xmux.xp.S1 CKJ_N cml_tlatch_93.xtail.S1 VSS sg13_lv_nmos ad=89.3f pd=0.85u as=0.1598p ps=1.62u w=0.47u l=0.16u
X5888 cml_tlatch_59.xmux.xn.S1 A3_2_N MOT30_P VSS sg13_lv_nmos ad=63.19999f pd=0.74u as=63.19999f ps=0.74u w=0.26u l=0.38u
X5889 MOT25_P MOT25_N cml_tlatch_68.xmux.xp.S1 VSS sg13_lv_nmos ad=56.9f pd=0.74u as=56.9f ps=0.74u w=0.17u l=0.17u
X5890 stub_bi_32.BOTN stub_bi_32.BOTP cml_tlatch_48.xmux.xp.S1 VSS sg13_lv_nmos ad=56.9f pd=0.74u as=56.9f ps=0.74u w=0.17u l=0.17u
X5891 cml_tlatch_40.xtail.S1 CKHA1_P cml_tlatch_40.xmux.xn.S1 VSS sg13_lv_nmos ad=89.3f pd=0.85u as=89.3f ps=0.85u w=0.47u l=0.16u
X5892 stub_bi_63.BOTP stub_bi_63.BOTN cml_tlatch_79.xmux.xp.S1 VSS sg13_lv_nmos ad=56.9f pd=0.74u as=56.9f ps=0.74u w=0.17u l=0.17u
X5893 cml_tlatch_23.xmux.xp.S1 cml_tlatch_39.INN cml_tlatch_39.INP VSS sg13_lv_nmos ad=56.9f pd=0.74u as=56.9f ps=0.74u w=0.17u l=0.17u
X5894 cml_tlatch_40.INP cml_tlatch_40.INN cml_tlatch_95.xmux.xp.S1 VSS sg13_lv_nmos ad=56.9f pd=0.74u as=0.1019p ps=1.34u w=0.17u l=0.17u
X5895 cml_gate2_7.xrtail.R1 CKA2_N GB2_P VSS sg13_lv_nmos ad=0.1007p pd=0.91u as=0.1007p ps=0.91u w=0.53u l=0.13u
X5896 cml_tlatch_5.xmux.xn.S1 cml_tlatch_5.INN MOT11_P VSS sg13_lv_nmos ad=63.19999f pd=0.74u as=63.19999f ps=0.74u w=0.26u l=0.38u
X5897 cml_tlatch_1.OUTP cml_tlatch_1.OUTN cml_tlatch_1.xmux.xp.S1 VSS sg13_lv_nmos ad=56.9f pd=0.74u as=56.9f ps=0.74u w=0.17u l=0.17u
X5898 cml_tlatch_95.INP cml_tlatch_95.INN cml_tlatch_36.xmux.xp.S1 VSS sg13_lv_nmos ad=56.9f pd=0.74u as=56.9f ps=0.74u w=0.17u l=0.17u
X5899 cml_tlatch_11.xtail.S1 CKB0_P cml_tlatch_11.xmux.xn.S1 VSS sg13_lv_nmos ad=89.3f pd=0.85u as=89.3f ps=0.85u w=0.47u l=0.16u
X5900 cml_tlatch_83.xmux.xp.S1 CKA2_P cml_tlatch_83.xtail.S1 VSS sg13_lv_nmos ad=89.3f pd=0.85u as=89.3f ps=0.85u w=0.47u l=0.16u
X5901 MOT26_N MOT26_P cml_tlatch_57.xmux.xp.S1 VSS sg13_lv_nmos ad=56.9f pd=0.74u as=56.9f ps=0.74u w=0.17u l=0.17u
X5902 MOT1_N MOT1_P cml_tlatch_17.xmux.xp.S1 VSS sg13_lv_nmos ad=56.9f pd=0.74u as=0.1019p ps=1.34u w=0.17u l=0.17u
X5903 ENA0_P ENA_N cml_drv_3.xrtail.R1 VSS sg13_lv_nmos ad=56.2f pd=0.74u as=56.2f ps=0.74u w=0.16u l=0.19u
X5904 cml_tlatch_64.xmux.xn.S1 cml_tlatch_65.OUTN A3_8_P VSS sg13_lv_nmos ad=63.19999f pd=0.74u as=63.19999f ps=0.74u w=0.26u l=0.38u
X5905 cml_tlatch_78.xmux.xp.S1 CKB2_N cml_tlatch_78.xtail.S1 VSS sg13_lv_nmos ad=89.3f pd=0.85u as=89.3f ps=0.85u w=0.47u l=0.16u
X5906 cml_tlatch_15.xtail.S1 CKB1_P cml_tlatch_15.xmux.xn.S1 VSS sg13_lv_nmos ad=89.3f pd=0.85u as=89.3f ps=0.85u w=0.47u l=0.16u
X5907 cml_tlatch_96.xmux.xp.S1 MOT8_P MOT8_N VSS sg13_lv_nmos ad=0.1019p pd=1.34u as=56.9f ps=0.74u w=0.17u l=0.17u
X5908 stub_bi_62.BOTN stub_bi_62.BOTP cml_tlatch_78.xmux.xp.S1 VSS sg13_lv_nmos ad=56.9f pd=0.74u as=56.9f ps=0.74u w=0.17u l=0.17u
X5909 cml_tlatch_22.xmux.xp.S1 cml_tlatch_22.OUTN cml_tlatch_22.OUTP VSS sg13_lv_nmos ad=56.9f pd=0.74u as=56.9f ps=0.74u w=0.17u l=0.17u
X5910 cml_tlatch_66.xmux.xp.S1 cml_tlatch_57.INP cml_tlatch_57.INN VSS sg13_lv_nmos ad=56.9f pd=0.74u as=56.9f ps=0.74u w=0.17u l=0.17u
X5911 cml_tlatch_94.xmux.xp.S1 cml_tlatch_6.INP cml_tlatch_6.INN VSS sg13_lv_nmos ad=56.9f pd=0.74u as=56.9f ps=0.74u w=0.17u l=0.17u
X5912 cml_tlatch_82.OUTN cml_tlatch_83.OUTP cml_tlatch_82.xmux.xn.S1 VSS sg13_lv_nmos ad=0.1082p pd=1.34u as=63.19999f ps=0.74u w=0.26u l=0.38u
X5913 B3_2_P B3_2_N cml_tlatch_46.xmux.xp.S1 VSS sg13_lv_nmos ad=56.9f pd=0.74u as=0.1019p ps=1.34u w=0.17u l=0.17u
X5914 MOT27_N MOT27_P cml_tlatch_69.xmux.xp.S1 VSS sg13_lv_nmos ad=56.9f pd=0.74u as=56.9f ps=0.74u w=0.17u l=0.17u
X5915 MOT22_N MOT22_P cml_tlatch_51.xmux.xp.S1 VSS sg13_lv_nmos ad=56.9f pd=0.74u as=56.9f ps=0.74u w=0.17u l=0.17u
X5916 cml_tlatch_59.xmux.xp.S1 MOT30_P MOT30_N VSS sg13_lv_nmos ad=56.9f pd=0.74u as=56.9f ps=0.74u w=0.17u l=0.17u
X5917 cml_tlatch_41.xtail.S1 CKHA1_P cml_tlatch_41.xmux.xn.S1 VSS sg13_lv_nmos ad=89.3f pd=0.85u as=89.3f ps=0.85u w=0.47u l=0.16u
X5918 cml_tlatch_42.xtail.S1 CKA2_P cml_tlatch_42.xmux.xn.S1 VSS sg13_lv_nmos ad=89.3f pd=0.85u as=89.3f ps=0.85u w=0.47u l=0.16u
X5919 cml_tlatch_46.xtail.S1 CKB3_P cml_tlatch_46.xmux.xp.S1 VSS sg13_lv_nmos ad=89.3f pd=0.85u as=0.1598p ps=1.62u w=0.47u l=0.16u
X5920 cml_tlatch_47.xmux.xp.S1 cml_tlatch_47.OUTP cml_tlatch_47.OUTN VSS sg13_lv_nmos ad=56.9f pd=0.74u as=56.9f ps=0.74u w=0.17u l=0.17u
X5921 cml_tlatch_87.xmux.xp.S1 CKHA2_N cml_tlatch_87.xtail.S1 VSS sg13_lv_nmos ad=89.3f pd=0.85u as=89.3f ps=0.85u w=0.47u l=0.16u
X5922 cml_tlatch_25.xmux.xp.S1 MOT4_P MOT4_N VSS sg13_lv_nmos ad=56.9f pd=0.74u as=56.9f ps=0.74u w=0.17u l=0.17u
X5923 cml_tlatch_20.xmux.xn.S1 CKHB0_P cml_tlatch_20.xtail.S1 VSS sg13_lv_nmos ad=89.3f pd=0.85u as=89.3f ps=0.85u w=0.47u l=0.16u
X5924 cml_tlatch_5.xmux.xp.S1 MOT11_P MOT11_N VSS sg13_lv_nmos ad=56.9f pd=0.74u as=56.9f ps=0.74u w=0.17u l=0.17u
X5925 cml_tlatch_64.xmux.xp.S1 A3_8_P A3_8_N VSS sg13_lv_nmos ad=56.9f pd=0.74u as=56.9f ps=0.74u w=0.17u l=0.17u
X5926 cml_tlatch_27.xmux.xp.S1 cml_tlatch_27.OUTP cml_tlatch_27.OUTN VSS sg13_lv_nmos ad=56.9f pd=0.74u as=56.9f ps=0.74u w=0.17u l=0.17u
X5927 B3_8_N B3_8_P cml_tlatch_60.xmux.xp.S1 VSS sg13_lv_nmos ad=56.9f pd=0.74u as=56.9f ps=0.74u w=0.17u l=0.17u
X5928 cml_gate2_2.sg13_lv_nmos_FTPY57_0.D0 CKB0_P cml_gate2_2.xrtail.R1 VSS sg13_lv_nmos ad=0.1007p pd=0.91u as=0.1007p ps=0.91u w=0.53u l=0.13u
X5929 cml_tlatch_36.xmux.xp.S1 CKA1_N cml_tlatch_36.xtail.S1 VSS sg13_lv_nmos ad=89.3f pd=0.85u as=89.3f ps=0.85u w=0.47u l=0.16u
X5930 cml_tlatch_0.xmux.xp.S1 CKA1_N cml_tlatch_0.xtail.S1 VSS sg13_lv_nmos ad=89.3f pd=0.85u as=89.3f ps=0.85u w=0.47u l=0.16u
X5931 cml_tlatch_63.xmux.xp.S1 cml_tlatch_63.OUTN cml_tlatch_63.OUTP VSS sg13_lv_nmos ad=56.9f pd=0.74u as=56.9f ps=0.74u w=0.17u l=0.17u
X5932 A3_8_P A3_8_N cml_tlatch_64.xmux.xp.S1 VSS sg13_lv_nmos ad=56.9f pd=0.74u as=56.9f ps=0.74u w=0.17u l=0.17u
X5933 cml_tlatch_48.xtail.S1 CKB2_P cml_tlatch_48.xmux.xn.S1 VSS sg13_lv_nmos ad=89.3f pd=0.85u as=89.3f ps=0.85u w=0.47u l=0.16u
X5934 cml_gate2_1.xrtail.R1 CKA0_P cml_gate2_1.sg13_lv_nmos_FTPY57_0.D0 VSS sg13_lv_nmos ad=0.1007p pd=0.91u as=0.1007p ps=0.91u w=0.53u l=0.13u
X5935 cml_drv_2.xrtail.R1 ENB_N ENB0_P VSS sg13_lv_nmos ad=56.2f pd=0.74u as=56.2f ps=0.74u w=0.16u l=0.19u
X5936 cml_tlatch_52.xtail.S1 POLN VSS VSS sg13_lv_nmos ad=1.5637p pd=8.61u as=1.5637p ps=8.61u w=8.23u l=0.13u
X5937 cml_tlatch_47.xmux.xp.S1 cml_tlatch_47.OUTP cml_tlatch_47.OUTN VSS sg13_lv_nmos ad=0.1019p pd=1.34u as=56.9f ps=0.74u w=0.17u l=0.17u
X5938 cml_tlatch_55.xmux.xp.S1 CKA2_N cml_tlatch_55.xtail.S1 VSS sg13_lv_nmos ad=0.1598p pd=1.62u as=89.3f ps=0.85u w=0.47u l=0.16u
X5939 cml_tlatch_12.xmux.xp.S1 B1_8_P B1_8_N VSS sg13_lv_nmos ad=56.9f pd=0.74u as=56.9f ps=0.74u w=0.17u l=0.17u
X5940 cml_tlatch_88.xtail.S1 CKB2_P cml_tlatch_88.xmux.xp.S1 VSS sg13_lv_nmos ad=89.3f pd=0.85u as=89.3f ps=0.85u w=0.47u l=0.16u
X5941 cml_tlatch_35.xmux.xp.S1 cml_tlatch_35.OUTP cml_tlatch_35.OUTN VSS sg13_lv_nmos ad=56.9f pd=0.74u as=56.9f ps=0.74u w=0.17u l=0.17u
X5942 MOT9_P MOT9_N cml_tlatch_4.xmux.xp.S1 VSS sg13_lv_nmos ad=56.9f pd=0.74u as=56.9f ps=0.74u w=0.17u l=0.17u
X5943 cml_tlatch_63.OUTN cml_tlatch_63.OUTP cml_tlatch_63.xmux.xp.S1 VSS sg13_lv_nmos ad=56.9f pd=0.74u as=56.9f ps=0.74u w=0.17u l=0.17u
X5944 cml_tlatch_52.xmux.xp.S1 cml_tlatch_52.OUTN cml_tlatch_52.OUTP VSS sg13_lv_nmos ad=56.9f pd=0.74u as=56.9f ps=0.74u w=0.17u l=0.17u
X5945 cml_tlatch_45.OUTP cml_tlatch_45.OUTN cml_tlatch_45.xmux.xp.S1 VSS sg13_lv_nmos ad=56.9f pd=0.74u as=56.9f ps=0.74u w=0.17u l=0.17u
X5946 cml_tlatch_56.xtail.S1 CKA2_P cml_tlatch_56.xmux.xp.S1 VSS sg13_lv_nmos ad=89.3f pd=0.85u as=89.3f ps=0.85u w=0.47u l=0.16u
X5947 MOT2_P cml_tlatch_8.OUTN cml_tlatch_24.xmux.xn.S1 VSS sg13_lv_nmos ad=63.19999f pd=0.74u as=63.19999f ps=0.74u w=0.26u l=0.38u
X5948 cml_tlatch_50.xmux.xp.S1 MOT20_P MOT20_N VSS sg13_lv_nmos ad=56.9f pd=0.74u as=56.9f ps=0.74u w=0.17u l=0.17u
X5949 cml_tlatch_15.xmux.xp.S1 CKB1_N cml_tlatch_15.xtail.S1 VSS sg13_lv_nmos ad=89.3f pd=0.85u as=89.3f ps=0.85u w=0.47u l=0.16u
X5950 stub_bi_31.BOTP stub_bi_31.BOTN cml_tlatch_34.xmux.xp.S1 VSS sg13_lv_nmos ad=56.9f pd=0.74u as=56.9f ps=0.74u w=0.17u l=0.17u
X5951 cml_tlatch_65.xmux.xp.S1 cml_tlatch_65.OUTP cml_tlatch_65.OUTN VSS sg13_lv_nmos ad=0.1019p pd=1.34u as=56.9f ps=0.74u w=0.17u l=0.17u
X5952 cml_tlatch_12.xmux.xn.S1 stub_bi_17.BOTP B1_8_P VSS sg13_lv_nmos ad=63.19999f pd=0.74u as=0.1082p ps=1.34u w=0.26u l=0.38u
X5953 cml_tlatch_66.xmux.xp.S1 cml_tlatch_57.INP cml_tlatch_57.INN VSS sg13_lv_nmos ad=56.9f pd=0.74u as=56.9f ps=0.74u w=0.17u l=0.17u
X5954 cml_tlatch_58.INP cml_tlatch_58.INN cml_tlatch_85.xmux.xp.S1 VSS sg13_lv_nmos ad=56.9f pd=0.74u as=56.9f ps=0.74u w=0.17u l=0.17u
X5955 cml_tlatch_71.xtail.S1 CKHB3_N cml_tlatch_71.xmux.xp.S1 VSS sg13_lv_nmos ad=0.1598p pd=1.62u as=89.3f ps=0.85u w=0.47u l=0.16u
X5956 cml_tlatch_58.xtail.S1 CKHA3_N cml_tlatch_58.xmux.xp.S1 VSS sg13_lv_nmos ad=89.3f pd=0.85u as=89.3f ps=0.85u w=0.47u l=0.16u
X5957 cml_tlatch_38.OUTN D1_P cml_tlatch_38.xmux.xn.S1 VSS sg13_lv_nmos ad=63.19999f pd=0.74u as=63.19999f ps=0.74u w=0.26u l=0.38u
X5958 cml_tlatch_66.xmux.xn.S1 cml_tlatch_67.OUTN cml_tlatch_57.INP VSS sg13_lv_nmos ad=63.19999f pd=0.74u as=63.19999f ps=0.74u w=0.26u l=0.38u
X5959 cml_tlatch_38.xtail.S1 POLN VSS VSS sg13_lv_nmos ad=1.5637p pd=8.61u as=2.7982p ps=17.14u w=8.23u l=0.13u
X5960 cml_tlatch_32.xmux.xp.S1 stub_bi_29.BOTP stub_bi_29.BOTN VSS sg13_lv_nmos ad=56.9f pd=0.74u as=56.9f ps=0.74u w=0.17u l=0.17u
X5961 cml_tlatch_86.xtail.S1 POLN VSS VSS sg13_lv_nmos ad=1.5637p pd=8.61u as=1.5637p ps=8.61u w=8.23u l=0.13u
X5962 MOT5_P MOT5_N cml_tlatch_19.xmux.xp.S1 VSS sg13_lv_nmos ad=56.9f pd=0.74u as=56.9f ps=0.74u w=0.17u l=0.17u
X5963 cml_tlatch_69.xtail.S1 CKHB3_P cml_tlatch_69.xmux.xn.S1 VSS sg13_lv_nmos ad=89.3f pd=0.85u as=89.3f ps=0.85u w=0.47u l=0.16u
X5964 cml_tlatch_51.xtail.S1 POLN VSS VSS sg13_lv_nmos ad=1.5637p pd=8.61u as=1.5637p ps=8.61u w=8.23u l=0.13u
X5965 cml_tlatch_63.OUTP cml_tlatch_63.OUTN cml_tlatch_63.xmux.xp.S1 VSS sg13_lv_nmos ad=56.9f pd=0.74u as=56.9f ps=0.74u w=0.17u l=0.17u
X5966 cml_tlatch_21.xmux.xp.S1 A1_8_N A1_8_P VSS sg13_lv_nmos ad=56.9f pd=0.74u as=56.9f ps=0.74u w=0.17u l=0.17u
X5967 stub_bi_32.BOTN stub_bi_32.BOTP cml_tlatch_48.xmux.xp.S1 VSS sg13_lv_nmos ad=56.9f pd=0.74u as=56.9f ps=0.74u w=0.17u l=0.17u
X5968 cml_tlatch_38.xmux.xp.S1 cml_tlatch_38.OUTN cml_tlatch_38.OUTP VSS sg13_lv_nmos ad=56.9f pd=0.74u as=56.9f ps=0.74u w=0.17u l=0.17u
X5969 cml_tlatch_90.xmux.xp.S1 J4_P J4_N VSS sg13_lv_nmos ad=56.9f pd=0.74u as=56.9f ps=0.74u w=0.17u l=0.17u
X5970 cml_tlatch_70.INN cml_tlatch_70.INP cml_tlatch_84.xmux.xp.S1 VSS sg13_lv_nmos ad=56.9f pd=0.74u as=56.9f ps=0.74u w=0.17u l=0.17u
X5971 cml_tlatch_29.OUTP cml_tlatch_29.OUTN cml_tlatch_29.xmux.xp.S1 VSS sg13_lv_nmos ad=56.9f pd=0.74u as=56.9f ps=0.74u w=0.17u l=0.17u
X5972 cml_tlatch_83.OUTN cml_tlatch_83.INP cml_tlatch_83.xmux.xn.S1 VSS sg13_lv_nmos ad=63.19999f pd=0.74u as=0.1082p ps=1.34u w=0.26u l=0.38u
X5973 cml_tlatch_99.xmux.xn.S1 cml_tlatch_30.OUTN cml_tlatch_99.OUTP VSS sg13_lv_nmos ad=63.19999f pd=0.74u as=63.19999f ps=0.74u w=0.26u l=0.38u
X5974 cml_tlatch_7.xtail.S1 CKHB1_N cml_tlatch_7.xmux.xp.S1 VSS sg13_lv_nmos ad=89.3f pd=0.85u as=89.3f ps=0.85u w=0.47u l=0.16u
X5975 cml_tlatch_94.xmux.xn.S1 stub_bi_29.BOTN cml_tlatch_6.INN VSS sg13_lv_nmos ad=63.19999f pd=0.74u as=63.19999f ps=0.74u w=0.26u l=0.38u
X5976 cml_tlatch_1.OUTP cml_tlatch_98.OUTN cml_tlatch_1.xmux.xn.S1 VSS sg13_lv_nmos ad=63.19999f pd=0.74u as=63.19999f ps=0.74u w=0.26u l=0.38u
X5977 MOT27_N MOT27_P cml_tlatch_69.xmux.xp.S1 VSS sg13_lv_nmos ad=56.9f pd=0.74u as=0.1019p ps=1.34u w=0.17u l=0.17u
X5978 MOT1_N MOT1_P cml_tlatch_17.xmux.xp.S1 VSS sg13_lv_nmos ad=56.9f pd=0.74u as=56.9f ps=0.74u w=0.17u l=0.17u
X5979 cml_tlatch_95.xmux.xn.S1 cml_tlatch_95.INN cml_tlatch_40.INP VSS sg13_lv_nmos ad=63.19999f pd=0.74u as=63.19999f ps=0.74u w=0.26u l=0.38u
X5980 cml_tlatch_85.xmux.xn.S1 CKA3_N cml_tlatch_85.xtail.S1 VSS sg13_lv_nmos ad=89.3f pd=0.85u as=89.3f ps=0.85u w=0.47u l=0.16u
X5981 cml_tlatch_61.xmux.xp.S1 cml_tlatch_61.OUTP cml_tlatch_61.OUTN VSS sg13_lv_nmos ad=56.9f pd=0.74u as=56.9f ps=0.74u w=0.17u l=0.17u
X5982 cml_tlatch_15.xmux.xp.S1 stub_bi_19.BOTP stub_bi_19.BOTN VSS sg13_lv_nmos ad=56.9f pd=0.74u as=56.9f ps=0.74u w=0.17u l=0.17u
X5983 cml_tlatch_92.xtail.S1 POLN VSS VSS sg13_lv_nmos ad=1.5637p pd=8.61u as=2.7982p ps=17.14u w=8.23u l=0.13u
X5984 VSS hs_to_clk_8.sg13_lv_nmos_2HGZLP_0.G VSS VSS sg13_lv_nmos ad=2.071p pd=11.28u as=0 ps=0 w=10.9u l=1.38u
X5985 cml_tlatch_56.xmux.xp.S1 A2_2_N A2_2_P VSS sg13_lv_nmos ad=56.9f pd=0.74u as=56.9f ps=0.74u w=0.17u l=0.17u
X5986 cml_tlatch_47.OUTN D3_P cml_tlatch_47.xmux.xn.S1 VSS sg13_lv_nmos ad=63.19999f pd=0.74u as=63.19999f ps=0.74u w=0.26u l=0.38u
X5987 cml_tlatch_84.xmux.xn.S1 CKB3_N cml_tlatch_84.xtail.S1 VSS sg13_lv_nmos ad=89.3f pd=0.85u as=89.3f ps=0.85u w=0.47u l=0.16u
X5988 A0_2_P cml_tlatch_35.OUTN cml_tlatch_31.xmux.xn.S1 VSS sg13_lv_nmos ad=63.19999f pd=0.74u as=0.1082p ps=1.34u w=0.26u l=0.38u
X5989 cml_tlatch_29.xmux.xn.S1 D0_P cml_tlatch_29.OUTN VSS sg13_lv_nmos ad=0.1082p pd=1.34u as=63.19999f ps=0.74u w=0.26u l=0.38u
X5990 MOT16_P A2_8_N cml_tlatch_87.xmux.xn.S1 VSS sg13_lv_nmos ad=63.19999f pd=0.74u as=63.19999f ps=0.74u w=0.26u l=0.38u
X5991 cml_tlatch_57.xmux.xn.S1 CKHA3_P cml_tlatch_57.xtail.S1 VSS sg13_lv_nmos ad=89.3f pd=0.85u as=89.3f ps=0.85u w=0.47u l=0.16u
X5992 MOT21_N MOT21_P cml_tlatch_75.xmux.xp.S1 VSS sg13_lv_nmos ad=56.9f pd=0.74u as=56.9f ps=0.74u w=0.17u l=0.17u
X5993 cml_tlatch_50.xmux.xn.S1 cml_tlatch_89.OUTN MOT20_P VSS sg13_lv_nmos ad=63.19999f pd=0.74u as=63.19999f ps=0.74u w=0.26u l=0.38u
X5994 cml_tlatch_60.xtail.S1 CKB3_N cml_tlatch_60.xmux.xn.S1 VSS sg13_lv_nmos ad=89.3f pd=0.85u as=89.3f ps=0.85u w=0.47u l=0.16u
X5995 cml_tlatch_11.xmux.xp.S1 cml_tlatch_11.OUTP cml_tlatch_11.OUTN VSS sg13_lv_nmos ad=56.9f pd=0.74u as=56.9f ps=0.74u w=0.17u l=0.17u
X5996 cml_tlatch_14.xmux.xp.S1 cml_tlatch_5.INP cml_tlatch_5.INN VSS sg13_lv_nmos ad=56.9f pd=0.74u as=56.9f ps=0.74u w=0.17u l=0.17u
X5997 A0_8_N A0_8_P cml_tlatch_2.xmux.xp.S1 VSS sg13_lv_nmos ad=56.9f pd=0.74u as=56.9f ps=0.74u w=0.17u l=0.17u
X5998 cml_tlatch_8.xmux.xp.S1 cml_tlatch_8.OUTP cml_tlatch_8.OUTN VSS sg13_lv_nmos ad=56.9f pd=0.74u as=56.9f ps=0.74u w=0.17u l=0.17u
X5999 ENA1_P ENA_N cml_drv_1.xrtail.R1 VSS sg13_lv_nmos ad=56.2f pd=0.74u as=56.2f ps=0.74u w=0.16u l=0.19u
X6000 cml_tlatch_83.INP cml_tlatch_83.INN cml_tlatch_72.xmux.xp.S1 VSS sg13_lv_nmos ad=56.9f pd=0.74u as=0.1019p ps=1.34u w=0.17u l=0.17u
X6001 cml_tlatch_68.xmux.xn.S1 B3_8_P MOT25_N VSS sg13_lv_nmos ad=63.19999f pd=0.74u as=0.1082p ps=1.34u w=0.26u l=0.38u
X6002 cml_tlatch_98.xmux.xn.S1 CKB0_N cml_tlatch_98.xtail.S1 VSS sg13_lv_nmos ad=89.3f pd=0.85u as=89.3f ps=0.85u w=0.47u l=0.16u
X6003 cml_tlatch_81.xmux.xp.S1 CKA2_P cml_tlatch_81.xtail.S1 VSS sg13_lv_nmos ad=89.3f pd=0.85u as=0.1598p ps=1.62u w=0.47u l=0.16u
X6004 B2_2_N B2_2_P cml_tlatch_44.xmux.xp.S1 VSS sg13_lv_nmos ad=56.9f pd=0.74u as=56.9f ps=0.74u w=0.17u l=0.17u
X6005 cml_tlatch_13.xmux.xn.S1 CKB1_P cml_tlatch_13.xtail.S1 VSS sg13_lv_nmos ad=89.3f pd=0.85u as=89.3f ps=0.85u w=0.47u l=0.16u
X6006 cml_tlatch_78.xtail.S1 CKB2_N cml_tlatch_78.xmux.xp.S1 VSS sg13_lv_nmos ad=89.3f pd=0.85u as=89.3f ps=0.85u w=0.47u l=0.16u
X6007 cml_tlatch_88.xmux.xp.S1 stub_bi_55.BOTN stub_bi_55.BOTP VSS sg13_lv_nmos ad=56.9f pd=0.74u as=56.9f ps=0.74u w=0.17u l=0.17u
X6008 cml_tlatch_10.xmux.xp.S1 B0_8_N B0_8_P VSS sg13_lv_nmos ad=56.9f pd=0.74u as=56.9f ps=0.74u w=0.17u l=0.17u
X6009 cml_tlatch_36.xmux.xn.S1 A1_2_P cml_tlatch_95.INN VSS sg13_lv_nmos ad=63.19999f pd=0.74u as=63.19999f ps=0.74u w=0.26u l=0.38u
X6010 stub_bi_17.BOTN cml_tlatch_5.INN cml_tlatch_13.xmux.xn.S1 VSS sg13_lv_nmos ad=63.19999f pd=0.74u as=63.19999f ps=0.74u w=0.26u l=0.38u
X6011 cml_tlatch_32.xtail.S1 POLN VSS VSS sg13_lv_nmos ad=1.5637p pd=8.61u as=2.7982p ps=17.14u w=8.23u l=0.13u
X6012 cml_tlatch_89.OUTN cml_tlatch_89.INP cml_tlatch_89.xmux.xn.S1 VSS sg13_lv_nmos ad=63.19999f pd=0.74u as=63.19999f ps=0.74u w=0.26u l=0.38u
X6013 cml_tlatch_97.xmux.xp.S1 MOT0_N MOT0_P VSS sg13_lv_nmos ad=56.9f pd=0.74u as=56.9f ps=0.74u w=0.17u l=0.17u
X6014 MOT20_N cml_tlatch_89.OUTP cml_tlatch_50.xmux.xn.S1 VSS sg13_lv_nmos ad=63.19999f pd=0.74u as=63.19999f ps=0.74u w=0.26u l=0.38u
X6015 cml_tlatch_29.OUTN cml_tlatch_29.OUTP cml_tlatch_29.xmux.xp.S1 VSS sg13_lv_nmos ad=56.9f pd=0.74u as=0.1019p ps=1.34u w=0.17u l=0.17u
X6016 cml_gate2_2.xrtail.R1 VSS VSS rppd l=4.86u w=1u
X6017 cml_tlatch_58.xtail.S1 CKHA3_P cml_tlatch_58.xmux.xn.S1 VSS sg13_lv_nmos ad=0.1598p pd=1.62u as=89.3f ps=0.85u w=0.47u l=0.16u
X6018 MOT28_N MOT28_P cml_tlatch_58.xmux.xp.S1 VSS sg13_lv_nmos ad=56.9f pd=0.74u as=56.9f ps=0.74u w=0.17u l=0.17u
X6019 cml_tlatch_79.xtail.S1 CKB2_N cml_tlatch_79.xmux.xn.S1 VSS sg13_lv_nmos ad=89.3f pd=0.85u as=89.3f ps=0.85u w=0.47u l=0.16u
X6020 cml_tlatch_56.INN D2_P cml_tlatch_42.xmux.xn.S1 VSS sg13_lv_nmos ad=0.1082p pd=1.34u as=63.19999f ps=0.74u w=0.26u l=0.38u
X6021 cml_tlatch_9.OUTP cml_tlatch_9.OUTN cml_tlatch_9.xmux.xp.S1 VSS sg13_lv_nmos ad=56.9f pd=0.74u as=0.1019p ps=1.34u w=0.17u l=0.17u
X6022 B2_2_N stub_bi_32.BOTN cml_tlatch_44.xmux.xn.S1 VSS sg13_lv_nmos ad=63.19999f pd=0.74u as=63.19999f ps=0.74u w=0.26u l=0.38u
X6023 cml_tlatch_8.xmux.xn.S1 cml_tlatch_9.OUTN cml_tlatch_8.OUTP VSS sg13_lv_nmos ad=63.19999f pd=0.74u as=63.19999f ps=0.74u w=0.26u l=0.38u
X6024 cml_tlatch_30.xtail.S1 CKA0_N cml_tlatch_30.xmux.xp.S1 VSS sg13_lv_nmos ad=89.3f pd=0.85u as=89.3f ps=0.85u w=0.47u l=0.16u
X6025 cml_tlatch_20.xtail.S1 CKHB0_P cml_tlatch_20.xmux.xn.S1 VSS sg13_lv_nmos ad=89.3f pd=0.85u as=89.3f ps=0.85u w=0.47u l=0.16u
X6026 cml_tlatch_92.xmux.xp.S1 J2_P J2_N VSS sg13_lv_nmos ad=56.9f pd=0.74u as=56.9f ps=0.74u w=0.17u l=0.17u
X6027 cml_tlatch_41.xtail.S1 POLN VSS VSS sg13_lv_nmos ad=1.5637p pd=8.61u as=2.7982p ps=17.14u w=8.23u l=0.13u
X6028 cml_tlatch_10.xmux.xp.S1 CKB0_P cml_tlatch_10.xtail.S1 VSS sg13_lv_nmos ad=89.3f pd=0.85u as=89.3f ps=0.85u w=0.47u l=0.16u
X6029 cml_tlatch_31.xmux.xn.S1 CKA0_N cml_tlatch_31.xtail.S1 VSS sg13_lv_nmos ad=89.3f pd=0.85u as=89.3f ps=0.85u w=0.47u l=0.16u
X6030 cml_tlatch_99.OUTP cml_tlatch_99.OUTN cml_tlatch_99.xmux.xp.S1 VSS sg13_lv_nmos ad=56.9f pd=0.74u as=56.9f ps=0.74u w=0.17u l=0.17u
X6031 cml_drv_0.xrtail.R1 ENB_N ENB1_P VSS sg13_lv_nmos ad=56.2f pd=0.74u as=56.2f ps=0.74u w=0.16u l=0.19u
X6032 cml_tlatch_40.xtail.S1 CKHA1_P cml_tlatch_40.xmux.xn.S1 VSS sg13_lv_nmos ad=89.3f pd=0.85u as=89.3f ps=0.85u w=0.47u l=0.16u
X6033 cml_tlatch_83.INP cml_tlatch_83.INN cml_tlatch_72.xmux.xp.S1 VSS sg13_lv_nmos ad=56.9f pd=0.74u as=56.9f ps=0.74u w=0.17u l=0.17u
X6034 cml_tlatch_95.INP A1_2_N cml_tlatch_36.xmux.xn.S1 VSS sg13_lv_nmos ad=63.19999f pd=0.74u as=63.19999f ps=0.74u w=0.26u l=0.38u
X6035 cml_tlatch_61.OUTP cml_tlatch_61.OUTN cml_tlatch_61.xmux.xp.S1 VSS sg13_lv_nmos ad=56.9f pd=0.74u as=56.9f ps=0.74u w=0.17u l=0.17u
X6036 cml_tlatch_74.xmux.xp.S1 MOT19_N MOT19_P VSS sg13_lv_nmos ad=56.9f pd=0.74u as=56.9f ps=0.74u w=0.17u l=0.17u
X6037 stub_bi_32.BOTP stub_bi_32.BOTN cml_tlatch_48.xmux.xp.S1 VSS sg13_lv_nmos ad=56.9f pd=0.74u as=56.9f ps=0.74u w=0.17u l=0.17u
X6038 MOT7_N MOT7_P cml_tlatch_20.xmux.xp.S1 VSS sg13_lv_nmos ad=56.9f pd=0.74u as=56.9f ps=0.74u w=0.17u l=0.17u
X6039 cml_tlatch_94.xtail.S1 CKB1_N cml_tlatch_94.xmux.xn.S1 VSS sg13_lv_nmos ad=89.3f pd=0.85u as=89.3f ps=0.85u w=0.47u l=0.16u
X6040 cml_tlatch_46.xtail.S1 CKB3_N cml_tlatch_46.xmux.xn.S1 VSS sg13_lv_nmos ad=89.3f pd=0.85u as=89.3f ps=0.85u w=0.47u l=0.16u
X6041 cml_tlatch_88.xmux.xp.S1 stub_bi_55.BOTN stub_bi_55.BOTP VSS sg13_lv_nmos ad=56.9f pd=0.74u as=56.9f ps=0.74u w=0.17u l=0.17u
X6042 cml_tlatch_83.xmux.xp.S1 CKA2_P cml_tlatch_83.xtail.S1 VSS sg13_lv_nmos ad=89.3f pd=0.85u as=89.3f ps=0.85u w=0.47u l=0.16u
X6043 cml_tlatch_68.xtail.S1 CKHB3_N cml_tlatch_68.xmux.xp.S1 VSS sg13_lv_nmos ad=89.3f pd=0.85u as=89.3f ps=0.85u w=0.47u l=0.16u
X6044 cml_tlatch_29.xtail.S1 CKB0_N cml_tlatch_29.xmux.xp.S1 VSS sg13_lv_nmos ad=89.3f pd=0.85u as=89.3f ps=0.85u w=0.47u l=0.16u
X6045 cml_tlatch_29.OUTN cml_tlatch_29.OUTP cml_tlatch_29.xmux.xp.S1 VSS sg13_lv_nmos ad=56.9f pd=0.74u as=56.9f ps=0.74u w=0.17u l=0.17u
X6046 cml_tlatch_6.xmux.xp.S1 MOT13_P MOT13_N VSS sg13_lv_nmos ad=56.9f pd=0.74u as=56.9f ps=0.74u w=0.17u l=0.17u
X6047 cml_tlatch_13.xmux.xp.S1 stub_bi_17.BOTP stub_bi_17.BOTN VSS sg13_lv_nmos ad=56.9f pd=0.74u as=56.9f ps=0.74u w=0.17u l=0.17u
X6048 GA3_N ENA1_P cml_gate2_5.sg13_lv_nmos_FTPY57_0.D0 VSS sg13_lv_nmos ad=0.1007p pd=0.91u as=0.1007p ps=0.91u w=0.53u l=0.13u
X6049 cml_tlatch_5.xtail.S1 CKHB1_N cml_tlatch_5.xmux.xp.S1 VSS sg13_lv_nmos ad=89.3f pd=0.85u as=0.1598p ps=1.62u w=0.47u l=0.16u
X6050 cml_tlatch_49.xmux.xn.S1 cml_tlatch_83.OUTP MOT18_N VSS sg13_lv_nmos ad=63.19999f pd=0.74u as=63.19999f ps=0.74u w=0.26u l=0.38u
X6051 cml_tlatch_83.OUTN cml_tlatch_83.OUTP cml_tlatch_83.xmux.xp.S1 VSS sg13_lv_nmos ad=56.9f pd=0.74u as=56.9f ps=0.74u w=0.17u l=0.17u
X6052 cml_tlatch_83.OUTP cml_tlatch_83.OUTN cml_tlatch_83.xmux.xp.S1 VSS sg13_lv_nmos ad=56.9f pd=0.74u as=56.9f ps=0.74u w=0.17u l=0.17u
X6053 cml_tlatch_79.xmux.xp.S1 stub_bi_63.BOTP stub_bi_63.BOTN VSS sg13_lv_nmos ad=56.9f pd=0.74u as=56.9f ps=0.74u w=0.17u l=0.17u
X6054 cml_tlatch_10.xmux.xp.S1 B0_8_P B0_8_N VSS sg13_lv_nmos ad=56.9f pd=0.74u as=56.9f ps=0.74u w=0.17u l=0.17u
X6055 stub_bi_55.BOTN stub_bi_55.BOTP cml_tlatch_88.xmux.xp.S1 VSS sg13_lv_nmos ad=56.9f pd=0.74u as=56.9f ps=0.74u w=0.17u l=0.17u
X6056 cml_tlatch_98.xtail.S1 CKB0_P cml_tlatch_98.xmux.xp.S1 VSS sg13_lv_nmos ad=0.1598p pd=1.62u as=89.3f ps=0.85u w=0.47u l=0.16u
X6057 CLK_W_P CLK_W_N cml_tlatch_91.xmux.xp.S1 VSS sg13_lv_nmos ad=56.9f pd=0.74u as=56.9f ps=0.74u w=0.17u l=0.17u
X6058 cml_tlatch_76.xtail.S1 CKHB2_P cml_tlatch_76.xmux.xn.S1 VSS sg13_lv_nmos ad=89.3f pd=0.85u as=89.3f ps=0.85u w=0.47u l=0.16u
X6059 cml_tlatch_64.xtail.S1 CKA3_P cml_tlatch_64.xmux.xp.S1 VSS sg13_lv_nmos ad=89.3f pd=0.85u as=89.3f ps=0.85u w=0.47u l=0.16u
X6060 MOT16_P MOT16_N cml_tlatch_87.xmux.xp.S1 VSS sg13_lv_nmos ad=56.9f pd=0.74u as=56.9f ps=0.74u w=0.17u l=0.17u
X6061 ENA0_N ENA_P cml_drv_3.xrtail.R1 VSS sg13_lv_nmos ad=56.2f pd=0.74u as=56.2f ps=0.74u w=0.16u l=0.19u
X6062 cml_tlatch_38.OUTP D1_N cml_tlatch_38.xmux.xn.S1 VSS sg13_lv_nmos ad=63.19999f pd=0.74u as=0.1082p ps=1.34u w=0.26u l=0.38u
X6063 stub_bi_29.BOTP stub_bi_29.BOTN cml_tlatch_32.xmux.xp.S1 VSS sg13_lv_nmos ad=56.9f pd=0.74u as=0.1019p ps=1.34u w=0.17u l=0.17u
X6064 cml_tlatch_61.xmux.xn.S1 cml_tlatch_69.INP cml_tlatch_61.OUTN VSS sg13_lv_nmos ad=63.19999f pd=0.74u as=63.19999f ps=0.74u w=0.26u l=0.38u
X6065 A2_8_N A2_8_P cml_tlatch_81.xmux.xp.S1 VSS sg13_lv_nmos ad=56.9f pd=0.74u as=56.9f ps=0.74u w=0.17u l=0.17u
X6066 cml_tlatch_11.xmux.xp.S1 cml_tlatch_11.OUTP cml_tlatch_11.OUTN VSS sg13_lv_nmos ad=56.9f pd=0.74u as=56.9f ps=0.74u w=0.17u l=0.17u
X6067 cml_gate2_0.xrtail.R1 CKA1_N GB1_P VSS sg13_lv_nmos ad=0.1802p pd=1.74u as=0.1007p ps=0.91u w=0.53u l=0.13u
X6068 MOT8_N MOT8_P cml_tlatch_96.xmux.xp.S1 VSS sg13_lv_nmos ad=56.9f pd=0.74u as=56.9f ps=0.74u w=0.17u l=0.17u
X6069 MOT14_P MOT14_N cml_tlatch_41.xmux.xp.S1 VSS sg13_lv_nmos ad=56.9f pd=0.74u as=56.9f ps=0.74u w=0.17u l=0.17u
X6070 cml_tlatch_38.xmux.xp.S1 CKA1_N cml_tlatch_38.xtail.S1 VSS sg13_lv_nmos ad=89.3f pd=0.85u as=89.3f ps=0.85u w=0.47u l=0.16u
X6071 cml_tlatch_24.xtail.S1 CKHA0_N cml_tlatch_24.xmux.xp.S1 VSS sg13_lv_nmos ad=89.3f pd=0.85u as=89.3f ps=0.85u w=0.47u l=0.16u
X6072 A1_2_P A1_2_N cml_tlatch_37.xmux.xp.S1 VSS sg13_lv_nmos ad=56.9f pd=0.74u as=56.9f ps=0.74u w=0.17u l=0.17u
X6073 cml_tlatch_67.xmux.xp.S1 cml_tlatch_67.OUTP cml_tlatch_67.OUTN VSS sg13_lv_nmos ad=56.9f pd=0.74u as=56.9f ps=0.74u w=0.17u l=0.17u
X6074 cml_tlatch_30.xmux.xn.S1 A0_2_P cml_tlatch_30.OUTN VSS sg13_lv_nmos ad=63.19999f pd=0.74u as=63.19999f ps=0.74u w=0.26u l=0.38u
X6075 cml_tlatch_59.xmux.xp.S1 CKHA3_N cml_tlatch_59.xtail.S1 VSS sg13_lv_nmos ad=89.3f pd=0.85u as=89.3f ps=0.85u w=0.47u l=0.16u
X6076 cml_tlatch_89.INP cml_tlatch_89.INN cml_tlatch_55.xmux.xp.S1 VSS sg13_lv_nmos ad=56.9f pd=0.74u as=56.9f ps=0.74u w=0.17u l=0.17u
X6077 VSS POLN cml_tlatch_62.xtail.S1 VSS sg13_lv_nmos ad=2.7982p pd=17.14u as=1.5637p ps=8.61u w=8.23u l=0.13u
X6078 B3_8_N cml_tlatch_61.OUTP cml_tlatch_60.xmux.xn.S1 VSS sg13_lv_nmos ad=63.19999f pd=0.74u as=63.19999f ps=0.74u w=0.26u l=0.38u
X6079 cml_tlatch_97.xmux.xp.S1 MOT0_N MOT0_P VSS sg13_lv_nmos ad=56.9f pd=0.74u as=56.9f ps=0.74u w=0.17u l=0.17u
X6080 MOT21_P MOT21_N cml_tlatch_75.xmux.xp.S1 VSS sg13_lv_nmos ad=56.9f pd=0.74u as=56.9f ps=0.74u w=0.17u l=0.17u
X6081 cml_tlatch_70.xmux.xp.S1 MOT29_N MOT29_P VSS sg13_lv_nmos ad=56.9f pd=0.74u as=56.9f ps=0.74u w=0.17u l=0.17u
X6082 A3_8_P cml_tlatch_65.OUTN cml_tlatch_64.xmux.xn.S1 VSS sg13_lv_nmos ad=0.1082p pd=1.34u as=63.19999f ps=0.74u w=0.26u l=0.38u
X6083 CLK_W_P J2_P cml_tlatch_91.xmux.xn.S1 VSS sg13_lv_nmos ad=63.19999f pd=0.74u as=0.1082p ps=1.34u w=0.26u l=0.38u
X6084 cml_tlatch_47.OUTP cml_tlatch_47.OUTN cml_tlatch_47.xmux.xp.S1 VSS sg13_lv_nmos ad=56.9f pd=0.74u as=56.9f ps=0.74u w=0.17u l=0.17u
X6085 MOT24_N MOT24_P cml_tlatch_86.xmux.xp.S1 VSS sg13_lv_nmos ad=56.9f pd=0.74u as=56.9f ps=0.74u w=0.17u l=0.17u
X6086 cml_tlatch_7.xtail.S1 CKHB1_P cml_tlatch_7.xmux.xn.S1 VSS sg13_lv_nmos ad=89.3f pd=0.85u as=89.3f ps=0.85u w=0.47u l=0.16u
X6087 cml_tlatch_61.xtail.S1 CKB3_P cml_tlatch_61.xmux.xn.S1 VSS sg13_lv_nmos ad=89.3f pd=0.85u as=89.3f ps=0.85u w=0.47u l=0.16u
X6088 cml_tlatch_56.xtail.S1 CKA2_P cml_tlatch_56.xmux.xp.S1 VSS sg13_lv_nmos ad=89.3f pd=0.85u as=89.3f ps=0.85u w=0.47u l=0.16u
X6089 cml_tlatch_8.xmux.xp.S1 CKA0_P cml_tlatch_8.xtail.S1 VSS sg13_lv_nmos ad=89.3f pd=0.85u as=89.3f ps=0.85u w=0.47u l=0.16u
X6090 interco_bi_19.INN interco_bi_19.INP cml_tlatch_0.xmux.xp.S1 VSS sg13_lv_nmos ad=56.9f pd=0.74u as=56.9f ps=0.74u w=0.17u l=0.17u
X6091 stub_bi_29.BOTP stub_bi_29.BOTN cml_tlatch_32.xmux.xp.S1 VSS sg13_lv_nmos ad=56.9f pd=0.74u as=56.9f ps=0.74u w=0.17u l=0.17u
X6092 cml_tlatch_54.xmux.xp.S1 cml_tlatch_54.OUTP cml_tlatch_54.OUTN VSS sg13_lv_nmos ad=56.9f pd=0.74u as=56.9f ps=0.74u w=0.17u l=0.17u
X6093 VSS POLN cml_tlatch_69.xtail.S1 VSS sg13_lv_nmos ad=1.5637p pd=8.61u as=1.5637p ps=8.61u w=8.23u l=0.13u
X6094 cml_tlatch_3.OUTP cml_tlatch_3.OUTN cml_tlatch_3.xmux.xp.S1 VSS sg13_lv_nmos ad=56.9f pd=0.74u as=56.9f ps=0.74u w=0.17u l=0.17u
X6095 VSS hs_to_clk_3.sg13_lv_nmos_2HGZLP_0.G VSS VSS sg13_lv_nmos ad=2.071p pd=11.28u as=0 ps=0 w=10.9u l=1.38u
X6096 cml_tlatch_34.xmux.xp.S1 stub_bi_31.BOTP stub_bi_31.BOTN VSS sg13_lv_nmos ad=56.9f pd=0.74u as=56.9f ps=0.74u w=0.17u l=0.17u
X6097 GB0_P ENB1_N cml_gate2_1.sg13_lv_nmos_FTPY57_0.D0 VSS sg13_lv_nmos ad=0.1007p pd=0.91u as=0.1007p ps=0.91u w=0.53u l=0.13u
X6098 cml_tlatch_10.xmux.xn.S1 cml_tlatch_11.OUTN B0_8_P VSS sg13_lv_nmos ad=63.19999f pd=0.74u as=0.1082p ps=1.34u w=0.26u l=0.38u
X6099 cml_tlatch_49.xmux.xp.S1 MOT18_N MOT18_P VSS sg13_lv_nmos ad=56.9f pd=0.74u as=56.9f ps=0.74u w=0.17u l=0.17u
X6100 MOT19_P stub_bi_63.BOTP cml_tlatch_74.xmux.xn.S1 VSS sg13_lv_nmos ad=63.19999f pd=0.74u as=0.1082p ps=1.34u w=0.26u l=0.38u
X6101 B0_2_N B0_2_P cml_tlatch_28.xmux.xp.S1 VSS sg13_lv_nmos ad=56.9f pd=0.74u as=56.9f ps=0.74u w=0.17u l=0.17u
X6102 MOT6_N MOT6_P cml_tlatch_26.xmux.xp.S1 VSS sg13_lv_nmos ad=56.9f pd=0.74u as=56.9f ps=0.74u w=0.17u l=0.17u
X6103 cml_tlatch_5.INN stub_bi_19.BOTN cml_tlatch_14.xmux.xn.S1 VSS sg13_lv_nmos ad=63.19999f pd=0.74u as=63.19999f ps=0.74u w=0.26u l=0.38u
X6104 cml_tlatch_68.xmux.xp.S1 MOT25_P MOT25_N VSS sg13_lv_nmos ad=0.1019p pd=1.34u as=56.9f ps=0.74u w=0.17u l=0.17u
X6105 cml_tlatch_19.xtail.S1 CKHB0_P cml_tlatch_19.xmux.xn.S1 VSS sg13_lv_nmos ad=89.3f pd=0.85u as=89.3f ps=0.85u w=0.47u l=0.16u
X6106 cml_tlatch_99.xmux.xp.S1 cml_tlatch_99.OUTP cml_tlatch_99.OUTN VSS sg13_lv_nmos ad=56.9f pd=0.74u as=56.9f ps=0.74u w=0.17u l=0.17u
X6107 cml_tlatch_38.OUTN cml_tlatch_38.OUTP cml_tlatch_38.xmux.xp.S1 VSS sg13_lv_nmos ad=56.9f pd=0.74u as=56.9f ps=0.74u w=0.17u l=0.17u
X6108 cml_tlatch_44.xtail.S1 CKB2_P cml_tlatch_44.xmux.xp.S1 VSS sg13_lv_nmos ad=0.1598p pd=1.62u as=89.3f ps=0.85u w=0.47u l=0.16u
X6109 VSS POLN cml_tlatch_85.xtail.S1 VSS sg13_lv_nmos ad=2.7982p pd=17.14u as=1.5637p ps=8.61u w=8.23u l=0.13u
X6110 cml_tlatch_13.xtail.S1 CKB1_P cml_tlatch_13.xmux.xn.S1 VSS sg13_lv_nmos ad=89.3f pd=0.85u as=0.1598p ps=1.62u w=0.47u l=0.16u
X6111 cml_tlatch_62.xmux.xn.S1 cml_tlatch_63.OUTP cml_tlatch_69.INN VSS sg13_lv_nmos ad=63.19999f pd=0.74u as=63.19999f ps=0.74u w=0.26u l=0.38u
X6112 cml_tlatch_39.xmux.xp.S1 MOT10_P MOT10_N VSS sg13_lv_nmos ad=56.9f pd=0.74u as=56.9f ps=0.74u w=0.17u l=0.17u
X6113 cml_tlatch_21.xmux.xp.S1 A1_8_P A1_8_N VSS sg13_lv_nmos ad=56.9f pd=0.74u as=56.9f ps=0.74u w=0.17u l=0.17u
X6114 cml_gate2_5.sg13_lv_nmos_FTPY57_0.D0 ENA1_P GA3_N VSS sg13_lv_nmos ad=0.1007p pd=0.91u as=0.1007p ps=0.91u w=0.53u l=0.13u
X6115 cml_tlatch_59.xmux.xp.S1 MOT30_N MOT30_P VSS sg13_lv_nmos ad=56.9f pd=0.74u as=56.9f ps=0.74u w=0.17u l=0.17u
X6116 cml_tlatch_53.xmux.xp.S1 A3_2_N A3_2_P VSS sg13_lv_nmos ad=56.9f pd=0.74u as=56.9f ps=0.74u w=0.17u l=0.17u
X6117 cml_tlatch_45.OUTN cml_tlatch_45.OUTP cml_tlatch_45.xmux.xp.S1 VSS sg13_lv_nmos ad=56.9f pd=0.74u as=56.9f ps=0.74u w=0.17u l=0.17u
X6118 cml_tlatch_40.xtail.S1 CKHA1_N cml_tlatch_40.xmux.xp.S1 VSS sg13_lv_nmos ad=0.1598p pd=1.62u as=89.3f ps=0.85u w=0.47u l=0.16u
X6119 cml_tlatch_86.xtail.S1 CKHA3_N cml_tlatch_86.xmux.xp.S1 VSS sg13_lv_nmos ad=89.3f pd=0.85u as=89.3f ps=0.85u w=0.47u l=0.16u
X6120 cml_tlatch_9.xtail.S1 CKA0_N cml_tlatch_9.xmux.xp.S1 VSS sg13_lv_nmos ad=89.3f pd=0.85u as=89.3f ps=0.85u w=0.47u l=0.16u
X6121 cml_tlatch_88.xtail.S1 POLN VSS VSS sg13_lv_nmos ad=1.5637p pd=8.61u as=2.7982p ps=17.14u w=8.23u l=0.13u
X6122 cml_tlatch_38.OUTN cml_tlatch_38.OUTP cml_tlatch_38.xmux.xp.S1 VSS sg13_lv_nmos ad=56.9f pd=0.74u as=56.9f ps=0.74u w=0.17u l=0.17u
X6123 cml_tlatch_83.OUTN cml_tlatch_83.OUTP cml_tlatch_83.xmux.xp.S1 VSS sg13_lv_nmos ad=56.9f pd=0.74u as=56.9f ps=0.74u w=0.17u l=0.17u
X6124 MOT9_N B1_8_P cml_tlatch_4.xmux.xn.S1 VSS sg13_lv_nmos ad=63.19999f pd=0.74u as=63.19999f ps=0.74u w=0.26u l=0.38u
X6125 stub_bi_55.BOTN stub_bi_42.BOTP cml_tlatch_88.xmux.xn.S1 VSS sg13_lv_nmos ad=63.19999f pd=0.74u as=63.19999f ps=0.74u w=0.26u l=0.38u
X6126 cml_tlatch_79.xmux.xp.S1 stub_bi_63.BOTP stub_bi_63.BOTN VSS sg13_lv_nmos ad=56.9f pd=0.74u as=56.9f ps=0.74u w=0.17u l=0.17u
X6127 cml_tlatch_79.xmux.xp.S1 stub_bi_63.BOTN stub_bi_63.BOTP VSS sg13_lv_nmos ad=56.9f pd=0.74u as=56.9f ps=0.74u w=0.17u l=0.17u
X6128 MOT3_N MOT3_P cml_tlatch_18.xmux.xp.S1 VSS sg13_lv_nmos ad=56.9f pd=0.74u as=56.9f ps=0.74u w=0.17u l=0.17u
X6129 MOT9_N B1_8_P cml_tlatch_4.xmux.xn.S1 VSS sg13_lv_nmos ad=63.19999f pd=0.74u as=63.19999f ps=0.74u w=0.26u l=0.38u
X6130 cml_tlatch_36.xmux.xp.S1 cml_tlatch_95.INN cml_tlatch_95.INP VSS sg13_lv_nmos ad=56.9f pd=0.74u as=56.9f ps=0.74u w=0.17u l=0.17u
X6131 cml_tlatch_1.xmux.xp.S1 cml_tlatch_1.OUTN cml_tlatch_1.OUTP VSS sg13_lv_nmos ad=56.9f pd=0.74u as=56.9f ps=0.74u w=0.17u l=0.17u
X6132 cml_gate2_3.xrtail.R1 CKB1_N GA1_P VSS sg13_lv_nmos ad=0.1007p pd=0.91u as=0.1007p ps=0.91u w=0.53u l=0.13u
X6133 cml_tlatch_90.xmux.xp.S1 CKJ_P cml_tlatch_90.xtail.S1 VSS sg13_lv_nmos ad=89.3f pd=0.85u as=89.3f ps=0.85u w=0.47u l=0.16u
X6134 MOT2_N cml_tlatch_8.OUTP cml_tlatch_24.xmux.xn.S1 VSS sg13_lv_nmos ad=0.1082p pd=1.34u as=63.19999f ps=0.74u w=0.26u l=0.38u
X6135 cml_tlatch_57.xmux.xp.S1 MOT26_P MOT26_N VSS sg13_lv_nmos ad=56.9f pd=0.74u as=56.9f ps=0.74u w=0.17u l=0.17u
X6136 cml_tlatch_58.INN cml_tlatch_58.INP cml_tlatch_85.xmux.xp.S1 VSS sg13_lv_nmos ad=56.9f pd=0.74u as=56.9f ps=0.74u w=0.17u l=0.17u
X6137 cml_tlatch_30.OUTP cml_tlatch_30.OUTN cml_tlatch_30.xmux.xp.S1 VSS sg13_lv_nmos ad=56.9f pd=0.74u as=56.9f ps=0.74u w=0.17u l=0.17u
X6138 VSS hs_to_clk_1.sg13_lv_nmos_2HGZLP_0.G VSS VSS sg13_lv_nmos ad=3.706p pd=22.48u as=0 ps=0 w=10.9u l=1.38u
X6139 cml_gate2_9.sg13_lv_nmos_FTPY57_0.D0 J1_N ENA_P VSS sg13_lv_nmos ad=0.1007p pd=0.91u as=0.1007p ps=0.91u w=0.53u l=0.13u
X6140 GB3_P CKA3_N cml_gate2_6.xrtail.R1 VSS sg13_lv_nmos ad=0.1007p pd=0.91u as=0.1802p ps=1.74u w=0.53u l=0.13u
X6141 cml_tlatch_80.xmux.xn.S1 stub_bi_55.BOTP stub_bi_49.BOTN VSS sg13_lv_nmos ad=63.19999f pd=0.74u as=63.19999f ps=0.74u w=0.26u l=0.38u
X6142 MOT8_N MOT8_P cml_tlatch_96.xmux.xp.S1 VSS sg13_lv_nmos ad=56.9f pd=0.74u as=56.9f ps=0.74u w=0.17u l=0.17u
X6143 cml_tlatch_0.xmux.xp.S1 interco_bi_19.INN interco_bi_19.INP VSS sg13_lv_nmos ad=56.9f pd=0.74u as=56.9f ps=0.74u w=0.17u l=0.17u
X6144 cml_tlatch_78.xmux.xp.S1 stub_bi_62.BOTP stub_bi_62.BOTN VSS sg13_lv_nmos ad=56.9f pd=0.74u as=56.9f ps=0.74u w=0.17u l=0.17u
X6145 MOT15_N MOT15_P cml_tlatch_7.xmux.xp.S1 VSS sg13_lv_nmos ad=56.9f pd=0.74u as=56.9f ps=0.74u w=0.17u l=0.17u
X6146 cml_tlatch_21.xtail.S1 CKA1_N cml_tlatch_21.xmux.xn.S1 VSS sg13_lv_nmos ad=89.3f pd=0.85u as=89.3f ps=0.85u w=0.47u l=0.16u
X6147 cml_tlatch_95.xmux.xp.S1 cml_tlatch_40.INP cml_tlatch_40.INN VSS sg13_lv_nmos ad=56.9f pd=0.74u as=56.9f ps=0.74u w=0.17u l=0.17u
X6148 A1_2_N cml_tlatch_38.OUTP cml_tlatch_37.xmux.xn.S1 VSS sg13_lv_nmos ad=0.1082p pd=1.34u as=63.19999f ps=0.74u w=0.26u l=0.38u
X6149 cml_tlatch_6.INN cml_tlatch_6.INP cml_tlatch_94.xmux.xp.S1 VSS sg13_lv_nmos ad=56.9f pd=0.74u as=56.9f ps=0.74u w=0.17u l=0.17u
X6150 cml_tlatch_83.xmux.xn.S1 cml_tlatch_83.INP cml_tlatch_83.OUTN VSS sg13_lv_nmos ad=63.19999f pd=0.74u as=63.19999f ps=0.74u w=0.26u l=0.38u
X6151 VSS POLN cml_tlatch_71.xtail.S1 VSS sg13_lv_nmos ad=2.7982p pd=17.14u as=1.5637p ps=8.61u w=8.23u l=0.13u
X6152 GB3_P ENB0_N cml_gate2_6.sg13_lv_nmos_FTPY57_0.D0 VSS sg13_lv_nmos ad=0.1007p pd=0.91u as=0.1007p ps=0.91u w=0.53u l=0.13u
X6153 J2_P J2_N cml_tlatch_92.xmux.xp.S1 VSS sg13_lv_nmos ad=56.9f pd=0.74u as=56.9f ps=0.74u w=0.17u l=0.17u
X6154 cml_gate2_4.sg13_lv_nmos_FTPY57_0.D0 ENA1_P GA2_N VSS sg13_lv_nmos ad=0.1007p pd=0.91u as=0.1007p ps=0.91u w=0.53u l=0.13u
X6155 cml_tlatch_1.xmux.xn.S1 cml_tlatch_98.OUTN cml_tlatch_1.OUTP VSS sg13_lv_nmos ad=63.19999f pd=0.74u as=63.19999f ps=0.74u w=0.26u l=0.38u
X6156 cml_tlatch_28.xtail.S1 CKB0_P cml_tlatch_28.xmux.xp.S1 VSS sg13_lv_nmos ad=89.3f pd=0.85u as=89.3f ps=0.85u w=0.47u l=0.16u
X6157 MOT4_N MOT4_P cml_tlatch_25.xmux.xp.S1 VSS sg13_lv_nmos ad=56.9f pd=0.74u as=56.9f ps=0.74u w=0.17u l=0.17u
X6158 cml_tlatch_76.xmux.xn.S1 CKHB2_P cml_tlatch_76.xtail.S1 VSS sg13_lv_nmos ad=89.3f pd=0.85u as=89.3f ps=0.85u w=0.47u l=0.16u
X6159 A3_8_N A3_8_P cml_tlatch_64.xmux.xp.S1 VSS sg13_lv_nmos ad=56.9f pd=0.74u as=56.9f ps=0.74u w=0.17u l=0.17u
X6160 cml_tlatch_84.xmux.xn.S1 cml_tlatch_45.OUTP cml_tlatch_70.INN VSS sg13_lv_nmos ad=63.19999f pd=0.74u as=0.1082p ps=1.34u w=0.26u l=0.38u
X6161 cml_tlatch_67.xtail.S1 CKA3_N cml_tlatch_67.xmux.xp.S1 VSS sg13_lv_nmos ad=89.3f pd=0.85u as=89.3f ps=0.85u w=0.47u l=0.16u
X6162 cml_tlatch_57.xmux.xn.S1 cml_tlatch_57.INN MOT26_P VSS sg13_lv_nmos ad=63.19999f pd=0.74u as=63.19999f ps=0.74u w=0.26u l=0.38u
X6163 cml_tlatch_27.OUTN cml_tlatch_27.OUTP cml_tlatch_27.xmux.xp.S1 VSS sg13_lv_nmos ad=56.9f pd=0.74u as=56.9f ps=0.74u w=0.17u l=0.17u
X6164 cml_tlatch_12.xtail.S1 CKB1_N cml_tlatch_12.xmux.xn.S1 VSS sg13_lv_nmos ad=89.3f pd=0.85u as=89.3f ps=0.85u w=0.47u l=0.16u
X6165 cml_tlatch_65.xtail.S1 POLN VSS VSS sg13_lv_nmos ad=1.5637p pd=8.61u as=2.7982p ps=17.14u w=8.23u l=0.13u
X6166 cml_tlatch_9.xmux.xp.S1 cml_tlatch_9.OUTP cml_tlatch_9.OUTN VSS sg13_lv_nmos ad=56.9f pd=0.74u as=56.9f ps=0.74u w=0.17u l=0.17u
X6167 cml_tlatch_81.xtail.S1 CKA2_N cml_tlatch_81.xmux.xn.S1 VSS sg13_lv_nmos ad=89.3f pd=0.85u as=89.3f ps=0.85u w=0.47u l=0.16u
X6168 cml_tlatch_57.xmux.xn.S1 cml_tlatch_57.INN MOT26_P VSS sg13_lv_nmos ad=63.19999f pd=0.74u as=63.19999f ps=0.74u w=0.26u l=0.38u
X6169 cml_tlatch_54.xmux.xp.S1 cml_tlatch_54.OUTP cml_tlatch_54.OUTN VSS sg13_lv_nmos ad=56.9f pd=0.74u as=56.9f ps=0.74u w=0.17u l=0.17u
X6170 cml_tlatch_21.xmux.xp.S1 A1_8_P A1_8_N VSS sg13_lv_nmos ad=56.9f pd=0.74u as=56.9f ps=0.74u w=0.17u l=0.17u
X6171 cml_tlatch_47.OUTN cml_tlatch_47.OUTP cml_tlatch_47.xmux.xp.S1 VSS sg13_lv_nmos ad=56.9f pd=0.74u as=56.9f ps=0.74u w=0.17u l=0.17u
X6172 B1_8_N B1_8_P cml_tlatch_12.xmux.xp.S1 VSS sg13_lv_nmos ad=56.9f pd=0.74u as=56.9f ps=0.74u w=0.17u l=0.17u
X6173 cml_tlatch_35.OUTN cml_tlatch_35.OUTP cml_tlatch_35.xmux.xp.S1 VSS sg13_lv_nmos ad=56.9f pd=0.74u as=0.1019p ps=1.34u w=0.17u l=0.17u
X6174 cml_tlatch_47.xmux.xn.S1 D3_P cml_tlatch_47.OUTN VSS sg13_lv_nmos ad=63.19999f pd=0.74u as=63.19999f ps=0.74u w=0.26u l=0.38u
X6175 cml_tlatch_97.xmux.xn.S1 A0_8_P MOT0_N VSS sg13_lv_nmos ad=63.19999f pd=0.74u as=63.19999f ps=0.74u w=0.26u l=0.38u
X6176 B1_2_P B1_2_N cml_tlatch_33.xmux.xp.S1 VSS sg13_lv_nmos ad=56.9f pd=0.74u as=56.9f ps=0.74u w=0.17u l=0.17u
X6177 B0_2_N B0_2_P cml_tlatch_28.xmux.xp.S1 VSS sg13_lv_nmos ad=56.9f pd=0.74u as=56.9f ps=0.74u w=0.17u l=0.17u
X6178 cml_tlatch_71.xmux.xn.S1 CKHB3_P cml_tlatch_71.xtail.S1 VSS sg13_lv_nmos ad=89.3f pd=0.85u as=89.3f ps=0.85u w=0.47u l=0.16u
X6179 cml_tlatch_6.xmux.xn.S1 cml_tlatch_6.INN MOT13_P VSS sg13_lv_nmos ad=63.19999f pd=0.74u as=63.19999f ps=0.74u w=0.26u l=0.38u
X6180 cml_tlatch_45.xmux.xn.S1 CKB3_P cml_tlatch_45.xtail.S1 VSS sg13_lv_nmos ad=89.3f pd=0.85u as=89.3f ps=0.85u w=0.47u l=0.16u
X6181 cml_tlatch_52.OUTP cml_tlatch_52.OUTN cml_tlatch_52.xmux.xp.S1 VSS sg13_lv_nmos ad=56.9f pd=0.74u as=56.9f ps=0.74u w=0.17u l=0.17u
X6182 cml_tlatch_97.xmux.xn.S1 A0_8_P MOT0_N VSS sg13_lv_nmos ad=63.19999f pd=0.74u as=63.19999f ps=0.74u w=0.26u l=0.38u
X6183 cml_tlatch_34.xmux.xp.S1 stub_bi_31.BOTN stub_bi_31.BOTP VSS sg13_lv_nmos ad=56.9f pd=0.74u as=56.9f ps=0.74u w=0.17u l=0.17u
X6184 cml_tlatch_16.OUTP cml_tlatch_16.OUTN cml_tlatch_16.xmux.xp.S1 VSS sg13_lv_nmos ad=56.9f pd=0.74u as=56.9f ps=0.74u w=0.17u l=0.17u
X6185 cml_tlatch_93.xmux.xp.S1 J1_P J1_N VSS sg13_lv_nmos ad=56.9f pd=0.74u as=56.9f ps=0.74u w=0.17u l=0.17u
X6186 cml_tlatch_57.INP cml_tlatch_57.INN cml_tlatch_66.xmux.xp.S1 VSS sg13_lv_nmos ad=56.9f pd=0.74u as=56.9f ps=0.74u w=0.17u l=0.17u
X6187 cml_tlatch_67.OUTP cml_tlatch_58.INN cml_tlatch_67.xmux.xn.S1 VSS sg13_lv_nmos ad=63.19999f pd=0.74u as=63.19999f ps=0.74u w=0.26u l=0.38u
X6188 VSS POLN cml_tlatch_94.xtail.S1 VSS sg13_lv_nmos ad=1.5637p pd=8.61u as=1.5637p ps=8.61u w=8.23u l=0.13u
X6189 cml_tlatch_85.xmux.xp.S1 cml_tlatch_58.INN cml_tlatch_58.INP VSS sg13_lv_nmos ad=56.9f pd=0.74u as=56.9f ps=0.74u w=0.17u l=0.17u
X6190 cml_tlatch_2.xmux.xp.S1 A0_8_N A0_8_P VSS sg13_lv_nmos ad=56.9f pd=0.74u as=56.9f ps=0.74u w=0.17u l=0.17u
X6191 cml_tlatch_39.xmux.xp.S1 MOT10_P MOT10_N VSS sg13_lv_nmos ad=0.1019p pd=1.34u as=56.9f ps=0.74u w=0.17u l=0.17u
X6192 cml_tlatch_36.xmux.xp.S1 cml_tlatch_95.INN cml_tlatch_95.INP VSS sg13_lv_nmos ad=56.9f pd=0.74u as=56.9f ps=0.74u w=0.17u l=0.17u
X6193 cml_tlatch_50.xmux.xp.S1 CKHA2_N cml_tlatch_50.xtail.S1 VSS sg13_lv_nmos ad=89.3f pd=0.85u as=89.3f ps=0.85u w=0.47u l=0.16u
X6194 stub_bi_29.BOTN stub_bi_29.BOTP cml_tlatch_32.xmux.xp.S1 VSS sg13_lv_nmos ad=56.9f pd=0.74u as=56.9f ps=0.74u w=0.17u l=0.17u
X6195 cml_tlatch_76.xmux.xn.S1 B2_2_N MOT23_P VSS sg13_lv_nmos ad=63.19999f pd=0.74u as=63.19999f ps=0.74u w=0.26u l=0.38u
X6196 VSS POLN cml_tlatch_55.xtail.S1 VSS sg13_lv_nmos ad=1.5637p pd=8.61u as=1.5637p ps=8.61u w=8.23u l=0.13u
X6197 cml_tlatch_55.xtail.S1 CKA2_N cml_tlatch_55.xmux.xp.S1 VSS sg13_lv_nmos ad=89.3f pd=0.85u as=89.3f ps=0.85u w=0.47u l=0.16u
X6198 cml_tlatch_99.xmux.xn.S1 cml_tlatch_30.OUTP cml_tlatch_99.OUTN VSS sg13_lv_nmos ad=63.19999f pd=0.74u as=63.19999f ps=0.74u w=0.26u l=0.38u
X6199 CKA3_N CK_N hs_to_clk_7.D2 VSS sg13_lv_nmos ad=0.408p pd=3.08u as=0.228p ps=1.58u w=1.2u l=0.2u
X6200 cml_tlatch_55.xmux.xp.S1 cml_tlatch_89.INP cml_tlatch_89.INN VSS sg13_lv_nmos ad=56.9f pd=0.74u as=56.9f ps=0.74u w=0.17u l=0.17u
X6201 cml_tlatch_97.xmux.xp.S1 CKHA0_N cml_tlatch_97.xtail.S1 VSS sg13_lv_nmos ad=89.3f pd=0.85u as=89.3f ps=0.85u w=0.47u l=0.16u
X6202 A1_8_P A1_8_N cml_tlatch_21.xmux.xp.S1 VSS sg13_lv_nmos ad=56.9f pd=0.74u as=56.9f ps=0.74u w=0.17u l=0.17u
X6203 cml_tlatch_77.xmux.xp.S1 B2_8_N B2_8_P VSS sg13_lv_nmos ad=56.9f pd=0.74u as=56.9f ps=0.74u w=0.17u l=0.17u
X6204 cml_tlatch_48.xmux.xp.S1 stub_bi_32.BOTP stub_bi_32.BOTN VSS sg13_lv_nmos ad=56.9f pd=0.74u as=56.9f ps=0.74u w=0.17u l=0.17u
X6205 J4_N J4_P cml_tlatch_90.xmux.xp.S1 VSS sg13_lv_nmos ad=56.9f pd=0.74u as=56.9f ps=0.74u w=0.17u l=0.17u
X6206 cml_tlatch_29.xtail.S1 CKB0_N cml_tlatch_29.xmux.xp.S1 VSS sg13_lv_nmos ad=89.3f pd=0.85u as=89.3f ps=0.85u w=0.47u l=0.16u
X6207 cml_tlatch_37.xtail.S1 CKA1_N cml_tlatch_37.xmux.xn.S1 VSS sg13_lv_nmos ad=89.3f pd=0.85u as=89.3f ps=0.85u w=0.47u l=0.16u
X6208 cml_tlatch_41.xmux.xn.S1 A1_2_N MOT14_P VSS sg13_lv_nmos ad=63.19999f pd=0.74u as=63.19999f ps=0.74u w=0.26u l=0.38u
X6209 VSS hs_to_clk_3.sg13_lv_nmos_2HGZLP_0.G VSS VSS sg13_lv_nmos ad=3.706p pd=22.48u as=0 ps=0 w=10.9u l=1.38u
X6210 cml_tlatch_71.xmux.xp.S1 CKHB3_N cml_tlatch_71.xtail.S1 VSS sg13_lv_nmos ad=89.3f pd=0.85u as=89.3f ps=0.85u w=0.47u l=0.16u
X6211 cml_tlatch_65.OUTP cml_tlatch_65.OUTN cml_tlatch_65.xmux.xp.S1 VSS sg13_lv_nmos ad=56.9f pd=0.74u as=56.9f ps=0.74u w=0.17u l=0.17u
X6212 MOT27_N cml_tlatch_69.INP cml_tlatch_69.xmux.xn.S1 VSS sg13_lv_nmos ad=63.19999f pd=0.74u as=63.19999f ps=0.74u w=0.26u l=0.38u
X6213 cml_tlatch_49.xmux.xp.S1 CKHA2_N cml_tlatch_49.xtail.S1 VSS sg13_lv_nmos ad=89.3f pd=0.85u as=89.3f ps=0.85u w=0.47u l=0.16u
X6214 cml_tlatch_1.xmux.xp.S1 cml_tlatch_1.OUTN cml_tlatch_1.OUTP VSS sg13_lv_nmos ad=56.9f pd=0.74u as=56.9f ps=0.74u w=0.17u l=0.17u
X6215 cml_tlatch_43.xtail.S1 CKB2_N cml_tlatch_43.xmux.xp.S1 VSS sg13_lv_nmos ad=89.3f pd=0.85u as=89.3f ps=0.85u w=0.47u l=0.16u
X6216 cml_tlatch_16.xmux.xn.S1 cml_tlatch_1.OUTP cml_tlatch_16.OUTN VSS sg13_lv_nmos ad=0.1082p pd=1.34u as=63.19999f ps=0.74u w=0.26u l=0.38u
X6217 MOT30_P A3_2_N cml_tlatch_59.xmux.xn.S1 VSS sg13_lv_nmos ad=63.19999f pd=0.74u as=63.19999f ps=0.74u w=0.26u l=0.38u
X6218 ENA_P J1_N cml_gate2_9.sg13_lv_nmos_FTPY57_0.D0 VSS sg13_lv_nmos ad=0.1007p pd=0.91u as=0.1007p ps=0.91u w=0.53u l=0.13u
X6219 cml_tlatch_67.OUTP cml_tlatch_67.OUTN cml_tlatch_67.xmux.xp.S1 VSS sg13_lv_nmos ad=56.9f pd=0.74u as=56.9f ps=0.74u w=0.17u l=0.17u
X6220 cml_tlatch_17.xmux.xp.S1 MOT1_P MOT1_N VSS sg13_lv_nmos ad=56.9f pd=0.74u as=56.9f ps=0.74u w=0.17u l=0.17u
X6221 cml_gate2_2.xrtail.R1 CKB0_N GA0_P VSS sg13_lv_nmos ad=0.1802p pd=1.74u as=0.1007p ps=0.91u w=0.53u l=0.13u
X6222 VSS POLN cml_tlatch_68.xtail.S1 VSS sg13_lv_nmos ad=2.7982p pd=17.14u as=1.5637p ps=8.61u w=8.23u l=0.13u
X6223 cml_tlatch_98.xmux.xp.S1 cml_tlatch_98.OUTP cml_tlatch_98.OUTN VSS sg13_lv_nmos ad=56.9f pd=0.74u as=56.9f ps=0.74u w=0.17u l=0.17u
X6224 VSS POLN cml_tlatch_2.xtail.S1 VSS sg13_lv_nmos ad=2.7982p pd=17.14u as=1.5637p ps=8.61u w=8.23u l=0.13u
X6225 cml_tlatch_84.xmux.xp.S1 cml_tlatch_70.INP cml_tlatch_70.INN VSS sg13_lv_nmos ad=56.9f pd=0.74u as=56.9f ps=0.74u w=0.17u l=0.17u
X6226 cml_tlatch_33.xtail.S1 CKB1_N cml_tlatch_33.xmux.xn.S1 VSS sg13_lv_nmos ad=89.3f pd=0.85u as=89.3f ps=0.85u w=0.47u l=0.16u
X6227 cml_tlatch_22.xmux.xp.S1 CKA1_N cml_tlatch_22.xtail.S1 VSS sg13_lv_nmos ad=89.3f pd=0.85u as=89.3f ps=0.85u w=0.47u l=0.16u
X6228 cml_tlatch_4.xtail.S1 CKHB1_N cml_tlatch_4.xmux.xp.S1 VSS sg13_lv_nmos ad=0.1598p pd=1.62u as=89.3f ps=0.85u w=0.47u l=0.16u
X6229 cml_tlatch_56.xtail.S1 CKA2_N cml_tlatch_56.xmux.xn.S1 VSS sg13_lv_nmos ad=89.3f pd=0.85u as=89.3f ps=0.85u w=0.47u l=0.16u
X6230 stub_bi_19.BOTN stub_bi_19.BOTP cml_tlatch_15.xmux.xp.S1 VSS sg13_lv_nmos ad=56.9f pd=0.74u as=56.9f ps=0.74u w=0.17u l=0.17u
X6231 ENA1_P ENA_N cml_drv_1.xrtail.R1 VSS sg13_lv_nmos ad=56.2f pd=0.74u as=0.1012p ps=1.34u w=0.16u l=0.19u
X6232 cml_tlatch_6.INN cml_tlatch_6.INP cml_tlatch_94.xmux.xp.S1 VSS sg13_lv_nmos ad=56.9f pd=0.74u as=56.9f ps=0.74u w=0.17u l=0.17u
X6233 cml_tlatch_60.xtail.S1 CKB3_P cml_tlatch_60.xmux.xp.S1 VSS sg13_lv_nmos ad=89.3f pd=0.85u as=89.3f ps=0.85u w=0.47u l=0.16u
X6234 cml_tlatch_40.xmux.xp.S1 CKHA1_N cml_tlatch_40.xtail.S1 VSS sg13_lv_nmos ad=89.3f pd=0.85u as=89.3f ps=0.85u w=0.47u l=0.16u
X6235 hs_to_clk_3.D2 POLN VSS VSS sg13_lv_nmos ad=3.4p pd=20.68u as=1.9p ps=10.38u w=10u l=0.13u
X6236 cml_tlatch_27.xtail.S1 CKB0_N cml_tlatch_27.xmux.xp.S1 VSS sg13_lv_nmos ad=0.1598p pd=1.62u as=89.3f ps=0.85u w=0.47u l=0.16u
X6237 cml_tlatch_18.xmux.xp.S1 MOT3_N MOT3_P VSS sg13_lv_nmos ad=56.9f pd=0.74u as=56.9f ps=0.74u w=0.17u l=0.17u
X6238 cml_tlatch_2.xmux.xp.S1 A0_8_P A0_8_N VSS sg13_lv_nmos ad=56.9f pd=0.74u as=56.9f ps=0.74u w=0.17u l=0.17u
X6239 cml_tlatch_8.OUTN cml_tlatch_8.OUTP cml_tlatch_8.xmux.xp.S1 VSS sg13_lv_nmos ad=56.9f pd=0.74u as=56.9f ps=0.74u w=0.17u l=0.17u
X6240 MOT11_N MOT11_P cml_tlatch_5.xmux.xp.S1 VSS sg13_lv_nmos ad=56.9f pd=0.74u as=56.9f ps=0.74u w=0.17u l=0.17u
X6241 cml_tlatch_82.xmux.xn.S1 cml_tlatch_83.OUTP cml_tlatch_82.OUTN VSS sg13_lv_nmos ad=63.19999f pd=0.74u as=63.19999f ps=0.74u w=0.26u l=0.38u
X6242 cml_tlatch_75.xmux.xn.S1 CKHB2_P cml_tlatch_75.xtail.S1 VSS sg13_lv_nmos ad=0.1598p pd=1.62u as=89.3f ps=0.85u w=0.47u l=0.16u
X6243 MOT15_N B1_2_P cml_tlatch_7.xmux.xn.S1 VSS sg13_lv_nmos ad=63.19999f pd=0.74u as=63.19999f ps=0.74u w=0.26u l=0.38u
X6244 cml_tlatch_47.xtail.S1 CKB3_P cml_tlatch_47.xmux.xn.S1 VSS sg13_lv_nmos ad=89.3f pd=0.85u as=89.3f ps=0.85u w=0.47u l=0.16u
X6245 cml_tlatch_11.OUTP cml_tlatch_11.OUTN cml_tlatch_11.xmux.xp.S1 VSS sg13_lv_nmos ad=56.9f pd=0.74u as=56.9f ps=0.74u w=0.17u l=0.17u
X6246 cml_tlatch_13.xmux.xp.S1 stub_bi_17.BOTN stub_bi_17.BOTP VSS sg13_lv_nmos ad=56.9f pd=0.74u as=56.9f ps=0.74u w=0.17u l=0.17u
X6247 cml_tlatch_82.xmux.xn.S1 cml_tlatch_83.OUTP cml_tlatch_82.OUTN VSS sg13_lv_nmos ad=63.19999f pd=0.74u as=63.19999f ps=0.74u w=0.26u l=0.38u
X6248 cml_tlatch_62.xmux.xp.S1 cml_tlatch_69.INN cml_tlatch_69.INP VSS sg13_lv_nmos ad=56.9f pd=0.74u as=56.9f ps=0.74u w=0.17u l=0.17u
X6249 cml_tlatch_44.xmux.xp.S1 B2_2_P B2_2_N VSS sg13_lv_nmos ad=56.9f pd=0.74u as=56.9f ps=0.74u w=0.17u l=0.17u
X6250 cml_tlatch_31.xmux.xp.S1 A0_2_N A0_2_P VSS sg13_lv_nmos ad=56.9f pd=0.74u as=56.9f ps=0.74u w=0.17u l=0.17u
X6251 cml_tlatch_79.xtail.S1 CKB2_P cml_tlatch_79.xmux.xp.S1 VSS sg13_lv_nmos ad=89.3f pd=0.85u as=89.3f ps=0.85u w=0.47u l=0.16u
X6252 B0_8_P B0_8_N cml_tlatch_10.xmux.xp.S1 VSS sg13_lv_nmos ad=56.9f pd=0.74u as=56.9f ps=0.74u w=0.17u l=0.17u
X6253 MOT0_P MOT0_N cml_tlatch_97.xmux.xp.S1 VSS sg13_lv_nmos ad=56.9f pd=0.74u as=0.1019p ps=1.34u w=0.17u l=0.17u
X6254 cml_gate2_0.xrtail.R1 CKA1_P cml_gate2_0.sg13_lv_nmos_FTPY57_0.D0 VSS sg13_lv_nmos ad=0.1007p pd=0.91u as=0.1007p ps=0.91u w=0.53u l=0.13u
X6255 cml_tlatch_46.xtail.S1 POLN VSS VSS sg13_lv_nmos ad=1.5637p pd=8.61u as=1.5637p ps=8.61u w=8.23u l=0.13u
X6256 cml_tlatch_41.xmux.xp.S1 CKHA1_N cml_tlatch_41.xtail.S1 VSS sg13_lv_nmos ad=89.3f pd=0.85u as=89.3f ps=0.85u w=0.47u l=0.16u
X6257 cml_tlatch_42.xmux.xp.S1 CKA2_N cml_tlatch_42.xtail.S1 VSS sg13_lv_nmos ad=89.3f pd=0.85u as=0.1598p ps=1.62u w=0.47u l=0.16u
X6258 cml_tlatch_40.INP cml_tlatch_95.INN cml_tlatch_95.xmux.xn.S1 VSS sg13_lv_nmos ad=0.1082p pd=1.34u as=63.19999f ps=0.74u w=0.26u l=0.38u
X6259 cml_tlatch_54.OUTP cml_tlatch_54.OUTN cml_tlatch_54.xmux.xp.S1 VSS sg13_lv_nmos ad=56.9f pd=0.74u as=56.9f ps=0.74u w=0.17u l=0.17u
X6260 cml_tlatch_36.xtail.S1 POLN VSS VSS sg13_lv_nmos ad=1.5637p pd=8.61u as=1.5637p ps=8.61u w=8.23u l=0.13u
X6261 cml_tlatch_57.INN cml_tlatch_57.INP cml_tlatch_66.xmux.xp.S1 VSS sg13_lv_nmos ad=56.9f pd=0.74u as=56.9f ps=0.74u w=0.17u l=0.17u
X6262 A2_8_N cml_tlatch_82.OUTP cml_tlatch_81.xmux.xn.S1 VSS sg13_lv_nmos ad=63.19999f pd=0.74u as=63.19999f ps=0.74u w=0.26u l=0.38u
X6263 cml_tlatch_62.xmux.xp.S1 cml_tlatch_69.INN cml_tlatch_69.INP VSS sg13_lv_nmos ad=0.1019p pd=1.34u as=56.9f ps=0.74u w=0.17u l=0.17u
X6264 cml_gate2_5.sg13_lv_nmos_FTPY57_0.D0 CKB3_P cml_gate2_5.xrtail.R1 VSS sg13_lv_nmos ad=0.1007p pd=0.91u as=0.1007p ps=0.91u w=0.53u l=0.13u
X6265 stub_bi_49.BOTP stub_bi_49.BOTN cml_tlatch_80.xmux.xp.S1 VSS sg13_lv_nmos ad=56.9f pd=0.74u as=56.9f ps=0.74u w=0.17u l=0.17u
X6266 cml_tlatch_93.xtail.S1 POLN VSS VSS sg13_lv_nmos ad=1.5637p pd=8.61u as=2.7982p ps=17.14u w=8.23u l=0.13u
X6267 cml_tlatch_16.xtail.S1 CKB0_P cml_tlatch_16.xmux.xp.S1 VSS sg13_lv_nmos ad=89.3f pd=0.85u as=89.3f ps=0.85u w=0.47u l=0.16u
X6268 cml_tlatch_30.xtail.S1 CKA0_P cml_tlatch_30.xmux.xn.S1 VSS sg13_lv_nmos ad=89.3f pd=0.85u as=89.3f ps=0.85u w=0.47u l=0.16u
X6269 stub_bi_42.BOTP stub_bi_42.BOTN cml_tlatch_43.xmux.xp.S1 VSS sg13_lv_nmos ad=56.9f pd=0.74u as=56.9f ps=0.74u w=0.17u l=0.17u
X6270 cml_tlatch_5.INP cml_tlatch_5.INN cml_tlatch_14.xmux.xp.S1 VSS sg13_lv_nmos ad=56.9f pd=0.74u as=56.9f ps=0.74u w=0.17u l=0.17u
X6271 GB1_P CKA1_N cml_gate2_0.xrtail.R1 VSS sg13_lv_nmos ad=0.1007p pd=0.91u as=0.1007p ps=0.91u w=0.53u l=0.13u
X6272 cml_tlatch_58.xmux.xn.S1 CKHA3_P cml_tlatch_58.xtail.S1 VSS sg13_lv_nmos ad=89.3f pd=0.85u as=89.3f ps=0.85u w=0.47u l=0.16u
X6273 cml_tlatch_10.xmux.xn.S1 CKB0_N cml_tlatch_10.xtail.S1 VSS sg13_lv_nmos ad=89.3f pd=0.85u as=89.3f ps=0.85u w=0.47u l=0.16u
X6274 cml_tlatch_65.OUTP cml_tlatch_65.OUTN cml_tlatch_65.xmux.xp.S1 VSS sg13_lv_nmos ad=56.9f pd=0.74u as=56.9f ps=0.74u w=0.17u l=0.17u
X6275 cml_tlatch_17.xtail.S1 CKHB0_P cml_tlatch_17.xmux.xn.S1 VSS sg13_lv_nmos ad=89.3f pd=0.85u as=89.3f ps=0.85u w=0.47u l=0.16u
X6276 cml_tlatch_61.xmux.xp.S1 cml_tlatch_61.OUTN cml_tlatch_61.OUTP VSS sg13_lv_nmos ad=56.9f pd=0.74u as=56.9f ps=0.74u w=0.17u l=0.17u
X6277 MOT19_P MOT19_N cml_tlatch_74.xmux.xp.S1 VSS sg13_lv_nmos ad=56.9f pd=0.74u as=56.9f ps=0.74u w=0.17u l=0.17u
X6278 cml_tlatch_57.INP cml_tlatch_67.OUTN cml_tlatch_66.xmux.xn.S1 VSS sg13_lv_nmos ad=63.19999f pd=0.74u as=0.1082p ps=1.34u w=0.26u l=0.38u
X6279 cml_tlatch_89.xmux.xp.S1 cml_tlatch_89.OUTP cml_tlatch_89.OUTN VSS sg13_lv_nmos ad=56.9f pd=0.74u as=56.9f ps=0.74u w=0.17u l=0.17u
X6280 cml_tlatch_29.xmux.xp.S1 cml_tlatch_29.OUTP cml_tlatch_29.OUTN VSS sg13_lv_nmos ad=56.9f pd=0.74u as=56.9f ps=0.74u w=0.17u l=0.17u
X6281 cml_tlatch_73.xmux.xp.S1 CKHB2_N cml_tlatch_73.xtail.S1 VSS sg13_lv_nmos ad=89.3f pd=0.85u as=89.3f ps=0.85u w=0.47u l=0.16u
X6282 cml_tlatch_3.xtail.S1 CKA0_N cml_tlatch_3.xmux.xp.S1 VSS sg13_lv_nmos ad=89.3f pd=0.85u as=89.3f ps=0.85u w=0.47u l=0.16u
X6283 MOT13_N MOT13_P cml_tlatch_6.xmux.xp.S1 VSS sg13_lv_nmos ad=56.9f pd=0.74u as=56.9f ps=0.74u w=0.17u l=0.17u
X6284 stub_bi_17.BOTN stub_bi_17.BOTP cml_tlatch_13.xmux.xp.S1 VSS sg13_lv_nmos ad=56.9f pd=0.74u as=56.9f ps=0.74u w=0.17u l=0.17u
X6285 VDD cml_tlatch_65.OUTP VSS rppd l=5.17u w=1u
X6286 cml_gate2_7.xrtail.R1 CKA2_N GB2_P VSS sg13_lv_nmos ad=0.1007p pd=0.91u as=0.1007p ps=0.91u w=0.53u l=0.13u
X6287 cml_tlatch_69.INN cml_tlatch_69.INP cml_tlatch_62.xmux.xp.S1 VSS sg13_lv_nmos ad=56.9f pd=0.74u as=0.1019p ps=1.34u w=0.17u l=0.17u
X6288 cml_tlatch_99.OUTP cml_tlatch_30.OUTN cml_tlatch_99.xmux.xn.S1 VSS sg13_lv_nmos ad=63.19999f pd=0.74u as=63.19999f ps=0.74u w=0.26u l=0.38u
X6289 MOT20_N MOT20_P cml_tlatch_50.xmux.xp.S1 VSS sg13_lv_nmos ad=56.9f pd=0.74u as=56.9f ps=0.74u w=0.17u l=0.17u
X6290 cml_tlatch_29.xtail.S1 CKB0_P cml_tlatch_29.xmux.xn.S1 VSS sg13_lv_nmos ad=89.3f pd=0.85u as=89.3f ps=0.85u w=0.47u l=0.16u
X6291 cml_tlatch_65.xmux.xn.S1 cml_tlatch_57.INN cml_tlatch_65.OUTP VSS sg13_lv_nmos ad=63.19999f pd=0.74u as=63.19999f ps=0.74u w=0.26u l=0.38u
X6292 cml_tlatch_58.xmux.xp.S1 MOT28_P MOT28_N VSS sg13_lv_nmos ad=56.9f pd=0.74u as=56.9f ps=0.74u w=0.17u l=0.17u
X6293 VSS POLN cml_tlatch_3.xtail.S1 VSS sg13_lv_nmos ad=1.5637p pd=8.61u as=1.5637p ps=8.61u w=8.23u l=0.13u
X6294 cml_tlatch_24.xmux.xp.S1 MOT2_N MOT2_P VSS sg13_lv_nmos ad=56.9f pd=0.74u as=56.9f ps=0.74u w=0.17u l=0.17u
X6295 cml_tlatch_18.xmux.xp.S1 MOT3_N MOT3_P VSS sg13_lv_nmos ad=56.9f pd=0.74u as=56.9f ps=0.74u w=0.17u l=0.17u
X6296 MOT10_N VDD VSS rppd l=5.17u w=1u
X6297 cml_tlatch_81.xmux.xp.S1 A2_8_P A2_8_N VSS sg13_lv_nmos ad=56.9f pd=0.74u as=56.9f ps=0.74u w=0.17u l=0.17u
X6298 cml_tlatch_54.xtail.S1 CKA3_N cml_tlatch_54.xmux.xp.S1 VSS sg13_lv_nmos ad=89.3f pd=0.85u as=89.3f ps=0.85u w=0.47u l=0.16u
X6299 B2_2_P B2_2_N cml_tlatch_44.xmux.xp.S1 VSS sg13_lv_nmos ad=56.9f pd=0.74u as=56.9f ps=0.74u w=0.17u l=0.17u
X6300 cml_tlatch_37.xmux.xp.S1 A1_2_N A1_2_P VSS sg13_lv_nmos ad=56.9f pd=0.74u as=56.9f ps=0.74u w=0.17u l=0.17u
X6301 cml_tlatch_15.xmux.xn.S1 CKB1_P cml_tlatch_15.xtail.S1 VSS sg13_lv_nmos ad=89.3f pd=0.85u as=89.3f ps=0.85u w=0.47u l=0.16u
X6302 cml_tlatch_98.xmux.xp.S1 CKB0_P cml_tlatch_98.xtail.S1 VSS sg13_lv_nmos ad=89.3f pd=0.85u as=89.3f ps=0.85u w=0.47u l=0.16u
X6303 cml_tlatch_72.xmux.xn.S1 CKA2_P cml_tlatch_72.xtail.S1 VSS sg13_lv_nmos ad=89.3f pd=0.85u as=89.3f ps=0.85u w=0.47u l=0.16u
X6304 cml_tlatch_56.INN cml_tlatch_56.INP cml_tlatch_42.xmux.xp.S1 VSS sg13_lv_nmos ad=56.9f pd=0.74u as=56.9f ps=0.74u w=0.17u l=0.17u
X6305 cml_tlatch_97.xmux.xn.S1 CKHA0_P cml_tlatch_97.xtail.S1 VSS sg13_lv_nmos ad=89.3f pd=0.85u as=89.3f ps=0.85u w=0.47u l=0.16u
X6306 cml_gate2_8.xrtail.R1 NS1_N ENB_P VSS sg13_lv_nmos ad=0.1007p pd=0.91u as=0.1007p ps=0.91u w=0.53u l=0.13u
X6307 cml_tlatch_87.xmux.xn.S1 A2_8_N MOT16_P VSS sg13_lv_nmos ad=63.19999f pd=0.74u as=63.19999f ps=0.74u w=0.26u l=0.38u
X6308 cml_tlatch_12.xtail.S1 CKB1_N cml_tlatch_12.xmux.xn.S1 VSS sg13_lv_nmos ad=89.3f pd=0.85u as=89.3f ps=0.85u w=0.47u l=0.16u
X6309 VSS POLN cml_tlatch_44.xtail.S1 VSS sg13_lv_nmos ad=2.7982p pd=17.14u as=1.5637p ps=8.61u w=8.23u l=0.13u
X6310 A1_2_N A1_2_P cml_tlatch_37.xmux.xp.S1 VSS sg13_lv_nmos ad=56.9f pd=0.74u as=0.1019p ps=1.34u w=0.17u l=0.17u
X6311 cml_tlatch_36.xmux.xn.S1 A1_2_N cml_tlatch_95.INP VSS sg13_lv_nmos ad=63.19999f pd=0.74u as=63.19999f ps=0.74u w=0.26u l=0.38u
X6312 cml_tlatch_55.xmux.xp.S1 cml_tlatch_89.INN cml_tlatch_89.INP VSS sg13_lv_nmos ad=56.9f pd=0.74u as=56.9f ps=0.74u w=0.17u l=0.17u
X6313 cml_tlatch_92.xmux.xn.S1 CKJ_N cml_tlatch_92.xtail.S1 VSS sg13_lv_nmos ad=89.3f pd=0.85u as=89.3f ps=0.85u w=0.47u l=0.16u
X6314 MOT20_P cml_tlatch_89.OUTN cml_tlatch_50.xmux.xn.S1 VSS sg13_lv_nmos ad=63.19999f pd=0.74u as=63.19999f ps=0.74u w=0.26u l=0.38u
X6315 MOT0_P MOT0_N cml_tlatch_97.xmux.xp.S1 VSS sg13_lv_nmos ad=56.9f pd=0.74u as=56.9f ps=0.74u w=0.17u l=0.17u
X6316 cml_tlatch_4.xmux.xp.S1 CKHB1_N cml_tlatch_4.xtail.S1 VSS sg13_lv_nmos ad=89.3f pd=0.85u as=89.3f ps=0.85u w=0.47u l=0.16u
X6317 cml_tlatch_75.xmux.xp.S1 MOT21_N MOT21_P VSS sg13_lv_nmos ad=56.9f pd=0.74u as=56.9f ps=0.74u w=0.17u l=0.17u
X6318 cml_tlatch_3.OUTN cml_tlatch_8.OUTP cml_tlatch_3.xmux.xn.S1 VSS sg13_lv_nmos ad=63.19999f pd=0.74u as=0.1082p ps=1.34u w=0.26u l=0.38u
X6319 cml_tlatch_54.OUTP cml_tlatch_54.OUTN cml_tlatch_54.xmux.xp.S1 VSS sg13_lv_nmos ad=56.9f pd=0.74u as=56.9f ps=0.74u w=0.17u l=0.17u
X6320 cml_tlatch_87.xtail.S1 CKHA2_N cml_tlatch_87.xmux.xp.S1 VSS sg13_lv_nmos ad=89.3f pd=0.85u as=89.3f ps=0.85u w=0.47u l=0.16u
X6321 cml_tlatch_89.xmux.xp.S1 CKA2_P cml_tlatch_89.xtail.S1 VSS sg13_lv_nmos ad=89.3f pd=0.85u as=89.3f ps=0.85u w=0.47u l=0.16u
X6322 cml_tlatch_60.xmux.xp.S1 B3_8_N B3_8_P VSS sg13_lv_nmos ad=56.9f pd=0.74u as=56.9f ps=0.74u w=0.17u l=0.17u
X6323 cml_tlatch_71.xmux.xn.S1 CKHB3_P cml_tlatch_71.xtail.S1 VSS sg13_lv_nmos ad=89.3f pd=0.85u as=89.3f ps=0.85u w=0.47u l=0.16u
X6324 cml_tlatch_17.xtail.S1 POLN VSS VSS sg13_lv_nmos ad=1.5637p pd=8.61u as=1.5637p ps=8.61u w=8.23u l=0.13u
X6325 cml_tlatch_47.xmux.xp.S1 cml_tlatch_47.OUTN cml_tlatch_47.OUTP VSS sg13_lv_nmos ad=56.9f pd=0.74u as=56.9f ps=0.74u w=0.17u l=0.17u
X6326 cml_tlatch_60.xmux.xp.S1 CKB3_P cml_tlatch_60.xtail.S1 VSS sg13_lv_nmos ad=89.3f pd=0.85u as=89.3f ps=0.85u w=0.47u l=0.16u
X6327 cml_tlatch_3.xtail.S1 CKA0_P cml_tlatch_3.xmux.xn.S1 VSS sg13_lv_nmos ad=89.3f pd=0.85u as=89.3f ps=0.85u w=0.47u l=0.16u
X6328 cml_gate2_1.xrtail.R1 CKA0_P cml_gate2_1.sg13_lv_nmos_FTPY57_0.D0 VSS sg13_lv_nmos ad=0.1802p pd=1.74u as=0.1007p ps=0.91u w=0.53u l=0.13u
X6329 cml_tlatch_51.xmux.xp.S1 MOT22_N MOT22_P VSS sg13_lv_nmos ad=56.9f pd=0.74u as=56.9f ps=0.74u w=0.17u l=0.17u
X6330 cml_tlatch_6.xtail.S1 CKHB1_N cml_tlatch_6.xmux.xp.S1 VSS sg13_lv_nmos ad=89.3f pd=0.85u as=0.1598p ps=1.62u w=0.47u l=0.16u
X6331 cml_tlatch_36.xmux.xn.S1 CKA1_P cml_tlatch_36.xtail.S1 VSS sg13_lv_nmos ad=89.3f pd=0.85u as=89.3f ps=0.85u w=0.47u l=0.16u
X6332 cml_tlatch_95.INN A1_2_P cml_tlatch_36.xmux.xn.S1 VSS sg13_lv_nmos ad=63.19999f pd=0.74u as=63.19999f ps=0.74u w=0.26u l=0.38u
X6333 cml_tlatch_70.xmux.xp.S1 MOT29_P MOT29_N VSS sg13_lv_nmos ad=56.9f pd=0.74u as=56.9f ps=0.74u w=0.17u l=0.17u
X6334 cml_tlatch_50.xmux.xn.S1 cml_tlatch_89.OUTP MOT20_N VSS sg13_lv_nmos ad=63.19999f pd=0.74u as=63.19999f ps=0.74u w=0.26u l=0.38u
X6335 stub_bi_49.BOTP stub_bi_49.BOTN cml_tlatch_80.xmux.xp.S1 VSS sg13_lv_nmos ad=56.9f pd=0.74u as=56.9f ps=0.74u w=0.17u l=0.17u
X6336 cml_tlatch_0.xmux.xp.S1 interco_bi_19.INP interco_bi_19.INN VSS sg13_lv_nmos ad=56.9f pd=0.74u as=56.9f ps=0.74u w=0.17u l=0.17u
X6337 cml_tlatch_76.xmux.xp.S1 MOT23_P MOT23_N VSS sg13_lv_nmos ad=56.9f pd=0.74u as=56.9f ps=0.74u w=0.17u l=0.17u
X6338 stub_bi_31.BOTN stub_bi_31.BOTP cml_tlatch_34.xmux.xp.S1 VSS sg13_lv_nmos ad=56.9f pd=0.74u as=56.9f ps=0.74u w=0.17u l=0.17u
X6339 cml_tlatch_13.xmux.xn.S1 cml_tlatch_5.INN stub_bi_17.BOTN VSS sg13_lv_nmos ad=63.19999f pd=0.74u as=0.1082p ps=1.34u w=0.26u l=0.38u
X6340 J2_N J2_P cml_tlatch_92.xmux.xp.S1 VSS sg13_lv_nmos ad=56.9f pd=0.74u as=56.9f ps=0.74u w=0.17u l=0.17u
X6341 MOT20_P MOT20_N cml_tlatch_50.xmux.xp.S1 VSS sg13_lv_nmos ad=56.9f pd=0.74u as=56.9f ps=0.74u w=0.17u l=0.17u
X6342 MOT22_N A2_2_P cml_tlatch_51.xmux.xn.S1 VSS sg13_lv_nmos ad=63.19999f pd=0.74u as=63.19999f ps=0.74u w=0.26u l=0.38u
X6343 MOT18_P MOT18_N cml_tlatch_49.xmux.xp.S1 VSS sg13_lv_nmos ad=56.9f pd=0.74u as=56.9f ps=0.74u w=0.17u l=0.17u
X6344 cml_tlatch_73.xmux.xp.S1 MOT17_P MOT17_N VSS sg13_lv_nmos ad=56.9f pd=0.74u as=56.9f ps=0.74u w=0.17u l=0.17u
X6345 MOT5_N cml_tlatch_98.OUTP cml_tlatch_19.xmux.xn.S1 VSS sg13_lv_nmos ad=63.19999f pd=0.74u as=63.19999f ps=0.74u w=0.26u l=0.38u
X6346 MOT25_N MOT25_P cml_tlatch_68.xmux.xp.S1 VSS sg13_lv_nmos ad=56.9f pd=0.74u as=56.9f ps=0.74u w=0.17u l=0.17u
X6347 cml_tlatch_88.xmux.xp.S1 CKB2_P cml_tlatch_88.xtail.S1 VSS sg13_lv_nmos ad=89.3f pd=0.85u as=89.3f ps=0.85u w=0.47u l=0.16u
X6348 cml_tlatch_42.xmux.xn.S1 D2_P cml_tlatch_56.INN VSS sg13_lv_nmos ad=63.19999f pd=0.74u as=63.19999f ps=0.74u w=0.26u l=0.38u
X6349 cml_tlatch_99.OUTN cml_tlatch_99.OUTP cml_tlatch_99.xmux.xp.S1 VSS sg13_lv_nmos ad=56.9f pd=0.74u as=56.9f ps=0.74u w=0.17u l=0.17u
X6350 cml_tlatch_85.xmux.xp.S1 CKA3_P cml_tlatch_85.xtail.S1 VSS sg13_lv_nmos ad=89.3f pd=0.85u as=89.3f ps=0.85u w=0.47u l=0.16u
X6351 cml_tlatch_44.xmux.xn.S1 stub_bi_32.BOTN B2_2_N VSS sg13_lv_nmos ad=63.19999f pd=0.74u as=63.19999f ps=0.74u w=0.26u l=0.38u
X6352 cml_tlatch_32.xmux.xn.S1 CKB1_P cml_tlatch_32.xtail.S1 VSS sg13_lv_nmos ad=89.3f pd=0.85u as=89.3f ps=0.85u w=0.47u l=0.16u
X6353 cml_tlatch_42.xmux.xn.S1 D2_P cml_tlatch_56.INN VSS sg13_lv_nmos ad=63.19999f pd=0.74u as=63.19999f ps=0.74u w=0.26u l=0.38u
X6354 cml_tlatch_79.xmux.xp.S1 CKB2_P cml_tlatch_79.xtail.S1 VSS sg13_lv_nmos ad=89.3f pd=0.85u as=89.3f ps=0.85u w=0.47u l=0.16u
X6355 cml_tlatch_72.xmux.xp.S1 cml_tlatch_83.INN cml_tlatch_83.INP VSS sg13_lv_nmos ad=56.9f pd=0.74u as=56.9f ps=0.74u w=0.17u l=0.17u
X6356 cml_tlatch_28.xmux.xp.S1 B0_2_N B0_2_P VSS sg13_lv_nmos ad=56.9f pd=0.74u as=56.9f ps=0.74u w=0.17u l=0.17u
X6357 GB0_P CKA0_N cml_gate2_1.xrtail.R1 VSS sg13_lv_nmos ad=0.1007p pd=0.91u as=0.1007p ps=0.91u w=0.53u l=0.13u
X6358 hs_to_clk_4.D2 CK_P CKA2_P VSS sg13_lv_nmos ad=0.228p pd=1.58u as=0.228p ps=1.58u w=1.2u l=0.2u
X6359 cml_tlatch_77.xmux.xp.S1 B2_8_P B2_8_N VSS sg13_lv_nmos ad=56.9f pd=0.74u as=56.9f ps=0.74u w=0.17u l=0.17u
X6360 MOT10_N MOT10_P cml_tlatch_39.xmux.xp.S1 VSS sg13_lv_nmos ad=56.9f pd=0.74u as=56.9f ps=0.74u w=0.17u l=0.17u
X6361 cml_tlatch_66.xmux.xp.S1 CKA3_P cml_tlatch_66.xtail.S1 VSS sg13_lv_nmos ad=89.3f pd=0.85u as=0.1598p ps=1.62u w=0.47u l=0.16u
X6362 stub_bi_55.BOTP stub_bi_55.BOTN cml_tlatch_88.xmux.xp.S1 VSS sg13_lv_nmos ad=56.9f pd=0.74u as=56.9f ps=0.74u w=0.17u l=0.17u
X6363 cml_tlatch_8.xtail.S1 CKA0_N cml_tlatch_8.xmux.xn.S1 VSS sg13_lv_nmos ad=89.3f pd=0.85u as=89.3f ps=0.85u w=0.47u l=0.16u
X6364 cml_tlatch_45.xmux.xp.S1 cml_tlatch_45.OUTP cml_tlatch_45.OUTN VSS sg13_lv_nmos ad=56.9f pd=0.74u as=56.9f ps=0.74u w=0.17u l=0.17u
X6365 cml_tlatch_29.xmux.xp.S1 cml_tlatch_29.OUTP cml_tlatch_29.OUTN VSS sg13_lv_nmos ad=56.9f pd=0.74u as=56.9f ps=0.74u w=0.17u l=0.17u
X6366 cml_tlatch_83.INN cml_tlatch_89.OUTP cml_tlatch_72.xmux.xn.S1 VSS sg13_lv_nmos ad=63.19999f pd=0.74u as=63.19999f ps=0.74u w=0.26u l=0.38u
X6367 cml_tlatch_38.xmux.xp.S1 cml_tlatch_38.OUTP cml_tlatch_38.OUTN VSS sg13_lv_nmos ad=56.9f pd=0.74u as=56.9f ps=0.74u w=0.17u l=0.17u
X6368 cml_tlatch_83.xmux.xp.S1 cml_tlatch_83.OUTP cml_tlatch_83.OUTN VSS sg13_lv_nmos ad=56.9f pd=0.74u as=56.9f ps=0.74u w=0.17u l=0.17u
X6369 cml_tlatch_33.xtail.S1 CKB1_N cml_tlatch_33.xmux.xn.S1 VSS sg13_lv_nmos ad=89.3f pd=0.85u as=89.3f ps=0.85u w=0.47u l=0.16u
X6370 cml_gate2_4.xrtail.R1 VSS VSS rppd l=4.86u w=1u
X6371 stub_bi_63.BOTN stub_bi_63.BOTP cml_tlatch_79.xmux.xp.S1 VSS sg13_lv_nmos ad=56.9f pd=0.74u as=56.9f ps=0.74u w=0.17u l=0.17u
X6372 cml_tlatch_37.xmux.xp.S1 A1_2_N A1_2_P VSS sg13_lv_nmos ad=56.9f pd=0.74u as=56.9f ps=0.74u w=0.17u l=0.17u
X6373 cml_tlatch_24.xmux.xp.S1 MOT2_N MOT2_P VSS sg13_lv_nmos ad=56.9f pd=0.74u as=56.9f ps=0.74u w=0.17u l=0.17u
X6374 cml_tlatch_89.xtail.S1 POLN VSS VSS sg13_lv_nmos ad=1.5637p pd=8.61u as=1.5637p ps=8.61u w=8.23u l=0.13u
X6375 cml_tlatch_43.xmux.xp.S1 stub_bi_42.BOTP stub_bi_42.BOTN VSS sg13_lv_nmos ad=56.9f pd=0.74u as=56.9f ps=0.74u w=0.17u l=0.17u
X6376 GA1_N ENA0_P cml_gate2_3.sg13_lv_nmos_FTPY57_0.D0 VSS sg13_lv_nmos ad=0.1007p pd=0.91u as=0.1007p ps=0.91u w=0.53u l=0.13u
X6377 cml_tlatch_45.OUTN B3_2_P cml_tlatch_45.xmux.xn.S1 VSS sg13_lv_nmos ad=63.19999f pd=0.74u as=63.19999f ps=0.74u w=0.26u l=0.38u
X6378 J2_N J1_P cml_tlatch_92.xmux.xn.S1 VSS sg13_lv_nmos ad=63.19999f pd=0.74u as=0.1082p ps=1.34u w=0.26u l=0.38u
X6379 cml_tlatch_82.xmux.xn.S1 CKA2_P cml_tlatch_82.xtail.S1 VSS sg13_lv_nmos ad=89.3f pd=0.85u as=89.3f ps=0.85u w=0.47u l=0.16u
X6380 MOT26_N MOT26_P cml_tlatch_57.xmux.xp.S1 VSS sg13_lv_nmos ad=56.9f pd=0.74u as=56.9f ps=0.74u w=0.17u l=0.17u
X6381 cml_tlatch_40.xmux.xp.S1 CKHA1_N cml_tlatch_40.xtail.S1 VSS sg13_lv_nmos ad=89.3f pd=0.85u as=89.3f ps=0.85u w=0.47u l=0.16u
X6382 A3_2_N A3_2_P cml_tlatch_53.xmux.xp.S1 VSS sg13_lv_nmos ad=56.9f pd=0.74u as=56.9f ps=0.74u w=0.17u l=0.17u
X6383 cml_tlatch_85.xmux.xp.S1 cml_tlatch_58.INP cml_tlatch_58.INN VSS sg13_lv_nmos ad=56.9f pd=0.74u as=56.9f ps=0.74u w=0.17u l=0.17u
X6384 cml_tlatch_30.xmux.xp.S1 cml_tlatch_30.OUTN cml_tlatch_30.OUTP VSS sg13_lv_nmos ad=56.9f pd=0.74u as=56.9f ps=0.74u w=0.17u l=0.17u
X6385 MOT23_P MOT23_N cml_tlatch_76.xmux.xp.S1 VSS sg13_lv_nmos ad=56.9f pd=0.74u as=56.9f ps=0.74u w=0.17u l=0.17u
X6386 cml_tlatch_92.xtail.S1 POLN VSS VSS sg13_lv_nmos ad=1.5637p pd=8.61u as=1.5637p ps=8.61u w=8.23u l=0.13u
X6387 cml_tlatch_37.xmux.xp.S1 A1_2_N A1_2_P VSS sg13_lv_nmos ad=56.9f pd=0.74u as=56.9f ps=0.74u w=0.17u l=0.17u
X6388 cml_tlatch_45.OUTN cml_tlatch_45.OUTP cml_tlatch_45.xmux.xp.S1 VSS sg13_lv_nmos ad=56.9f pd=0.74u as=56.9f ps=0.74u w=0.17u l=0.17u
X6389 cml_tlatch_64.xmux.xn.S1 CKA3_N cml_tlatch_64.xtail.S1 VSS sg13_lv_nmos ad=89.3f pd=0.85u as=89.3f ps=0.85u w=0.47u l=0.16u
X6390 cml_tlatch_1.xmux.xn.S1 CKB0_P cml_tlatch_1.xtail.S1 VSS sg13_lv_nmos ad=89.3f pd=0.85u as=89.3f ps=0.85u w=0.47u l=0.16u
X6391 NS1_N VDD VSS rppd l=13.09u w=1u
X6392 cml_tlatch_76.xmux.xn.S1 B2_2_P MOT23_N VSS sg13_lv_nmos ad=63.19999f pd=0.74u as=63.19999f ps=0.74u w=0.26u l=0.38u
X6393 cml_tlatch_38.xtail.S1 CKA1_P cml_tlatch_38.xmux.xn.S1 VSS sg13_lv_nmos ad=89.3f pd=0.85u as=89.3f ps=0.85u w=0.47u l=0.16u
X6394 cml_tlatch_61.OUTN cml_tlatch_69.INP cml_tlatch_61.xmux.xn.S1 VSS sg13_lv_nmos ad=63.19999f pd=0.74u as=63.19999f ps=0.74u w=0.26u l=0.38u
X6395 cml_tlatch_30.OUTN A0_2_P cml_tlatch_30.xmux.xn.S1 VSS sg13_lv_nmos ad=63.19999f pd=0.74u as=63.19999f ps=0.74u w=0.26u l=0.38u
X6396 cml_tlatch_40.xmux.xp.S1 MOT12_N MOT12_P VSS sg13_lv_nmos ad=56.9f pd=0.74u as=56.9f ps=0.74u w=0.17u l=0.17u
X6397 cml_tlatch_82.xmux.xp.S1 CKA2_N cml_tlatch_82.xtail.S1 VSS sg13_lv_nmos ad=89.3f pd=0.85u as=0.1598p ps=1.62u w=0.47u l=0.16u
X6398 cml_gate2_8.xrtail.R1 NS1_P cml_gate2_8.sg13_lv_nmos_FTPY57_0.D0 VSS sg13_lv_nmos ad=0.1007p pd=0.91u as=0.1007p ps=0.91u w=0.53u l=0.13u
X6399 cml_tlatch_60.xmux.xn.S1 CKB3_N cml_tlatch_60.xtail.S1 VSS sg13_lv_nmos ad=89.3f pd=0.85u as=89.3f ps=0.85u w=0.47u l=0.16u
X6400 MOT24_N A3_8_P cml_tlatch_86.xmux.xn.S1 VSS sg13_lv_nmos ad=63.19999f pd=0.74u as=63.19999f ps=0.74u w=0.26u l=0.38u
X6401 cml_tlatch_57.xtail.S1 CKHA3_N cml_tlatch_57.xmux.xp.S1 VSS sg13_lv_nmos ad=89.3f pd=0.85u as=89.3f ps=0.85u w=0.47u l=0.16u
X6402 cml_tlatch_89.INN A2_2_P cml_tlatch_55.xmux.xn.S1 VSS sg13_lv_nmos ad=0.1082p pd=1.34u as=63.19999f ps=0.74u w=0.26u l=0.38u
X6403 cml_tlatch_9.OUTN cml_tlatch_9.OUTP cml_tlatch_9.xmux.xp.S1 VSS sg13_lv_nmos ad=56.9f pd=0.74u as=56.9f ps=0.74u w=0.17u l=0.17u
X6404 stub_bi_17.BOTP VDD VSS rppd l=5.17u w=1u
X6405 cml_tlatch_76.xmux.xp.S1 MOT23_P MOT23_N VSS sg13_lv_nmos ad=0.1019p pd=1.34u as=56.9f ps=0.74u w=0.17u l=0.17u
X6406 cml_tlatch_32.xmux.xp.S1 stub_bi_29.BOTN stub_bi_29.BOTP VSS sg13_lv_nmos ad=56.9f pd=0.74u as=56.9f ps=0.74u w=0.17u l=0.17u
X6407 cml_tlatch_90.xmux.xn.S1 CKJ_N cml_tlatch_90.xtail.S1 VSS sg13_lv_nmos ad=89.3f pd=0.85u as=89.3f ps=0.85u w=0.47u l=0.16u
X6408 cml_tlatch_54.OUTN cml_tlatch_54.OUTP cml_tlatch_54.xmux.xp.S1 VSS sg13_lv_nmos ad=56.9f pd=0.74u as=56.9f ps=0.74u w=0.17u l=0.17u
X6409 cml_tlatch_34.xtail.S1 CKB1_P cml_tlatch_34.xmux.xn.S1 VSS sg13_lv_nmos ad=89.3f pd=0.85u as=89.3f ps=0.85u w=0.47u l=0.16u
X6410 cml_tlatch_83.xmux.xn.S1 CKA2_N cml_tlatch_83.xtail.S1 VSS sg13_lv_nmos ad=89.3f pd=0.85u as=89.3f ps=0.85u w=0.47u l=0.16u
X6411 MOT31_N MOT31_P cml_tlatch_71.xmux.xp.S1 VSS sg13_lv_nmos ad=56.9f pd=0.74u as=56.9f ps=0.74u w=0.17u l=0.17u
X6412 cml_tlatch_85.xmux.xp.S1 cml_tlatch_58.INP cml_tlatch_58.INN VSS sg13_lv_nmos ad=56.9f pd=0.74u as=56.9f ps=0.74u w=0.17u l=0.17u
X6413 cml_tlatch_42.xtail.S1 CKA2_P cml_tlatch_42.xmux.xn.S1 VSS sg13_lv_nmos ad=89.3f pd=0.85u as=89.3f ps=0.85u w=0.47u l=0.16u
X6414 GA0_P CKB0_N cml_gate2_2.xrtail.R1 VSS sg13_lv_nmos ad=0.1007p pd=0.91u as=0.1007p ps=0.91u w=0.53u l=0.13u
X6415 cml_tlatch_35.xmux.xp.S1 cml_tlatch_35.OUTN cml_tlatch_35.OUTP VSS sg13_lv_nmos ad=56.9f pd=0.74u as=56.9f ps=0.74u w=0.17u l=0.17u
X6416 cml_tlatch_26.xmux.xp.S1 MOT6_P MOT6_N VSS sg13_lv_nmos ad=56.9f pd=0.74u as=56.9f ps=0.74u w=0.17u l=0.17u
X6417 cml_tlatch_16.xtail.S1 CKB0_P cml_tlatch_16.xmux.xp.S1 VSS sg13_lv_nmos ad=89.3f pd=0.85u as=89.3f ps=0.85u w=0.47u l=0.16u
X6418 cml_tlatch_64.xmux.xn.S1 cml_tlatch_65.OUTN A3_8_P VSS sg13_lv_nmos ad=63.19999f pd=0.74u as=63.19999f ps=0.74u w=0.26u l=0.38u
X6419 cml_tlatch_82.xmux.xp.S1 cml_tlatch_82.OUTN cml_tlatch_82.OUTP VSS sg13_lv_nmos ad=56.9f pd=0.74u as=56.9f ps=0.74u w=0.17u l=0.17u
X6420 cml_tlatch_99.OUTN cml_tlatch_99.OUTP cml_tlatch_99.xmux.xp.S1 VSS sg13_lv_nmos ad=56.9f pd=0.74u as=56.9f ps=0.74u w=0.17u l=0.17u
X6421 MOT4_N cml_tlatch_99.OUTP cml_tlatch_25.xmux.xn.S1 VSS sg13_lv_nmos ad=0.1082p pd=1.34u as=63.19999f ps=0.74u w=0.26u l=0.38u
X6422 stub_bi_63.BOTN stub_bi_49.BOTP cml_tlatch_79.xmux.xn.S1 VSS sg13_lv_nmos ad=63.19999f pd=0.74u as=63.19999f ps=0.74u w=0.26u l=0.38u
X6423 cml_tlatch_38.xmux.xp.S1 cml_tlatch_38.OUTP cml_tlatch_38.OUTN VSS sg13_lv_nmos ad=56.9f pd=0.74u as=56.9f ps=0.74u w=0.17u l=0.17u
X6424 VSS hs_to_clk_1.sg13_lv_nmos_2HGZLP_0.G VSS VSS sg13_lv_nmos ad=2.071p pd=11.28u as=0 ps=0 w=10.9u l=1.38u
X6425 cml_tlatch_7.xmux.xp.S1 MOT15_P MOT15_N VSS sg13_lv_nmos ad=56.9f pd=0.74u as=56.9f ps=0.74u w=0.17u l=0.17u
X6426 stub_bi_31.BOTP stub_bi_31.BOTN cml_tlatch_34.xmux.xp.S1 VSS sg13_lv_nmos ad=56.9f pd=0.74u as=56.9f ps=0.74u w=0.17u l=0.17u
X6427 J1_N J1_P cml_tlatch_93.xmux.xp.S1 VSS sg13_lv_nmos ad=56.9f pd=0.74u as=56.9f ps=0.74u w=0.17u l=0.17u
X6428 cml_tlatch_66.xmux.xp.S1 cml_tlatch_57.INN cml_tlatch_57.INP VSS sg13_lv_nmos ad=56.9f pd=0.74u as=56.9f ps=0.74u w=0.17u l=0.17u
X6429 cml_tlatch_58.INP cml_tlatch_58.INN cml_tlatch_85.xmux.xp.S1 VSS sg13_lv_nmos ad=56.9f pd=0.74u as=56.9f ps=0.74u w=0.17u l=0.17u
X6430 cml_tlatch_74.xmux.xp.S1 MOT19_P MOT19_N VSS sg13_lv_nmos ad=56.9f pd=0.74u as=56.9f ps=0.74u w=0.17u l=0.17u
X6431 A0_8_P A0_8_N cml_tlatch_2.xmux.xp.S1 VSS sg13_lv_nmos ad=56.9f pd=0.74u as=56.9f ps=0.74u w=0.17u l=0.17u
X6432 MOT10_N MOT10_P cml_tlatch_39.xmux.xp.S1 VSS sg13_lv_nmos ad=56.9f pd=0.74u as=56.9f ps=0.74u w=0.17u l=0.17u
X6433 A1_8_N A1_8_P cml_tlatch_21.xmux.xp.S1 VSS sg13_lv_nmos ad=56.9f pd=0.74u as=56.9f ps=0.74u w=0.17u l=0.17u
X6434 cml_tlatch_79.xmux.xn.S1 CKB2_N cml_tlatch_79.xtail.S1 VSS sg13_lv_nmos ad=89.3f pd=0.85u as=89.3f ps=0.85u w=0.47u l=0.16u
X6435 cml_tlatch_17.xtail.S1 CKHB0_P cml_tlatch_17.xmux.xn.S1 VSS sg13_lv_nmos ad=89.3f pd=0.85u as=89.3f ps=0.85u w=0.47u l=0.16u
X6436 cml_tlatch_92.xtail.S1 CKJ_N cml_tlatch_92.xmux.xn.S1 VSS sg13_lv_nmos ad=89.3f pd=0.85u as=89.3f ps=0.85u w=0.47u l=0.16u
X6437 cml_tlatch_14.xmux.xn.S1 stub_bi_19.BOTN cml_tlatch_5.INN VSS sg13_lv_nmos ad=63.19999f pd=0.74u as=63.19999f ps=0.74u w=0.26u l=0.38u
X6438 cml_tlatch_66.xmux.xn.S1 CKA3_N cml_tlatch_66.xtail.S1 VSS sg13_lv_nmos ad=89.3f pd=0.85u as=89.3f ps=0.85u w=0.47u l=0.16u
X6439 cml_tlatch_27.xmux.xn.S1 B0_2_N cml_tlatch_27.OUTP VSS sg13_lv_nmos ad=0.1082p pd=1.34u as=63.19999f ps=0.74u w=0.26u l=0.38u
X6440 cml_tlatch_89.INN cml_tlatch_89.INP cml_tlatch_55.xmux.xp.S1 VSS sg13_lv_nmos ad=56.9f pd=0.74u as=0.1019p ps=1.34u w=0.17u l=0.17u
X6441 cml_tlatch_39.INP cml_tlatch_39.INN cml_tlatch_23.xmux.xp.S1 VSS sg13_lv_nmos ad=56.9f pd=0.74u as=56.9f ps=0.74u w=0.17u l=0.17u
X6442 B2_8_P B2_8_N cml_tlatch_77.xmux.xp.S1 VSS sg13_lv_nmos ad=56.9f pd=0.74u as=56.9f ps=0.74u w=0.17u l=0.17u
X6443 VSS hs_to_clk_3.sg13_lv_nmos_2HGZLP_0.G VSS VSS sg13_lv_nmos ad=2.071p pd=11.28u as=0 ps=0 w=10.9u l=1.38u
X6444 cml_tlatch_53.xmux.xn.S1 CKA3_N cml_tlatch_53.xtail.S1 VSS sg13_lv_nmos ad=89.3f pd=0.85u as=89.3f ps=0.85u w=0.47u l=0.16u
X6445 hs_to_clk_6.D2 CK_P CKB2_N VSS sg13_lv_nmos ad=0.228p pd=1.58u as=0.408p ps=3.08u w=1.2u l=0.2u
X6446 cml_tlatch_14.xmux.xn.S1 stub_bi_19.BOTN cml_tlatch_5.INN VSS sg13_lv_nmos ad=63.19999f pd=0.74u as=63.19999f ps=0.74u w=0.26u l=0.38u
X6447 cml_tlatch_27.xmux.xn.S1 CKB0_P cml_tlatch_27.xtail.S1 VSS sg13_lv_nmos ad=89.3f pd=0.85u as=89.3f ps=0.85u w=0.47u l=0.16u
X6448 cml_tlatch_31.xtail.S1 CKA0_N cml_tlatch_31.xmux.xn.S1 VSS sg13_lv_nmos ad=89.3f pd=0.85u as=89.3f ps=0.85u w=0.47u l=0.16u
X6449 cml_tlatch_7.xmux.xp.S1 MOT15_N MOT15_P VSS sg13_lv_nmos ad=56.9f pd=0.74u as=56.9f ps=0.74u w=0.17u l=0.17u
X6450 MOT17_P MOT17_N cml_tlatch_73.xmux.xp.S1 VSS sg13_lv_nmos ad=56.9f pd=0.74u as=56.9f ps=0.74u w=0.17u l=0.17u
X6451 hs_to_clk_6.D2 CK_N CKB2_P VSS sg13_lv_nmos ad=0.408p pd=3.08u as=0.228p ps=1.58u w=1.2u l=0.2u
X6452 cml_tlatch_29.xtail.S1 CKB0_P cml_tlatch_29.xmux.xn.S1 VSS sg13_lv_nmos ad=89.3f pd=0.85u as=89.3f ps=0.85u w=0.47u l=0.16u
X6453 cml_tlatch_3.xmux.xp.S1 cml_tlatch_3.OUTP cml_tlatch_3.OUTN VSS sg13_lv_nmos ad=56.9f pd=0.74u as=56.9f ps=0.74u w=0.17u l=0.17u
X6454 cml_tlatch_95.INP cml_tlatch_95.INN cml_tlatch_36.xmux.xp.S1 VSS sg13_lv_nmos ad=56.9f pd=0.74u as=56.9f ps=0.74u w=0.17u l=0.17u
X6455 B3_2_P cml_tlatch_47.OUTN cml_tlatch_46.xmux.xn.S1 VSS sg13_lv_nmos ad=63.19999f pd=0.74u as=63.19999f ps=0.74u w=0.26u l=0.38u
X6456 cml_tlatch_39.INN cml_tlatch_39.INP cml_tlatch_23.xmux.xp.S1 VSS sg13_lv_nmos ad=56.9f pd=0.74u as=56.9f ps=0.74u w=0.17u l=0.17u
X6457 cml_tlatch_39.INP cml_tlatch_39.INN cml_tlatch_23.xmux.xp.S1 VSS sg13_lv_nmos ad=56.9f pd=0.74u as=56.9f ps=0.74u w=0.17u l=0.17u
X6458 cml_tlatch_94.xmux.xn.S1 CKB1_N cml_tlatch_94.xtail.S1 VSS sg13_lv_nmos ad=89.3f pd=0.85u as=89.3f ps=0.85u w=0.47u l=0.16u
X6459 cml_tlatch_95.xmux.xp.S1 cml_tlatch_40.INN cml_tlatch_40.INP VSS sg13_lv_nmos ad=56.9f pd=0.74u as=56.9f ps=0.74u w=0.17u l=0.17u
X6460 cml_tlatch_46.xmux.xn.S1 CKB3_N cml_tlatch_46.xtail.S1 VSS sg13_lv_nmos ad=89.3f pd=0.85u as=89.3f ps=0.85u w=0.47u l=0.16u
X6461 cml_tlatch_65.xtail.S1 CKA3_N cml_tlatch_65.xmux.xp.S1 VSS sg13_lv_nmos ad=89.3f pd=0.85u as=89.3f ps=0.85u w=0.47u l=0.16u
X6462 cml_tlatch_88.xmux.xn.S1 stub_bi_42.BOTP stub_bi_55.BOTN VSS sg13_lv_nmos ad=63.19999f pd=0.74u as=63.19999f ps=0.74u w=0.26u l=0.38u
X6463 VSS hs_to_clk_6.sg13_lv_nmos_2HGZLP_0.G VSS VSS sg13_lv_nmos ad=2.071p pd=11.28u as=0 ps=0 w=10.9u l=1.38u
X6464 cml_tlatch_89.xmux.xn.S1 CKA2_N cml_tlatch_89.xtail.S1 VSS sg13_lv_nmos ad=89.3f pd=0.85u as=89.3f ps=0.85u w=0.47u l=0.16u
X6465 cml_tlatch_27.OUTP cml_tlatch_27.OUTN cml_tlatch_27.xmux.xp.S1 VSS sg13_lv_nmos ad=56.9f pd=0.74u as=0.1019p ps=1.34u w=0.17u l=0.17u
X6466 cml_tlatch_4.xmux.xn.S1 B1_8_P MOT9_N VSS sg13_lv_nmos ad=63.19999f pd=0.74u as=63.19999f ps=0.74u w=0.26u l=0.38u
X6467 cml_tlatch_86.xmux.xp.S1 MOT24_N MOT24_P VSS sg13_lv_nmos ad=0.1019p pd=1.34u as=56.9f ps=0.74u w=0.17u l=0.17u
X6468 interco_bi_19.INP interco_bi_19.INN cml_tlatch_0.xmux.xp.S1 VSS sg13_lv_nmos ad=56.9f pd=0.74u as=56.9f ps=0.74u w=0.17u l=0.17u
X6469 cml_tlatch_11.xmux.xp.S1 CKB0_N cml_tlatch_11.xtail.S1 VSS sg13_lv_nmos ad=89.3f pd=0.85u as=89.3f ps=0.85u w=0.47u l=0.16u
X6470 cml_tlatch_16.xmux.xp.S1 cml_tlatch_16.OUTN cml_tlatch_16.OUTP VSS sg13_lv_nmos ad=56.9f pd=0.74u as=56.9f ps=0.74u w=0.17u l=0.17u
X6471 cml_tlatch_6.xtail.S1 CKHB1_P cml_tlatch_6.xmux.xn.S1 VSS sg13_lv_nmos ad=89.3f pd=0.85u as=89.3f ps=0.85u w=0.47u l=0.16u
X6472 cml_tlatch_24.xmux.xn.S1 cml_tlatch_8.OUTP MOT2_N VSS sg13_lv_nmos ad=63.19999f pd=0.74u as=63.19999f ps=0.74u w=0.26u l=0.38u
X6473 cml_tlatch_94.xmux.xp.S1 cml_tlatch_6.INP cml_tlatch_6.INN VSS sg13_lv_nmos ad=56.9f pd=0.74u as=56.9f ps=0.74u w=0.17u l=0.17u
X6474 B1_8_N stub_bi_17.BOTN cml_tlatch_12.xmux.xn.S1 VSS sg13_lv_nmos ad=63.19999f pd=0.74u as=63.19999f ps=0.74u w=0.26u l=0.38u
X6475 hs_to_clk_2.D2 POLN VSS VSS sg13_lv_nmos ad=3.4p pd=20.68u as=1.9p ps=10.38u w=10u l=0.13u
X6476 cml_tlatch_97.xmux.xn.S1 CKHA0_P cml_tlatch_97.xtail.S1 VSS sg13_lv_nmos ad=89.3f pd=0.85u as=89.3f ps=0.85u w=0.47u l=0.16u
X6477 cml_tlatch_24.xmux.xn.S1 cml_tlatch_8.OUTP MOT2_N VSS sg13_lv_nmos ad=63.19999f pd=0.74u as=63.19999f ps=0.74u w=0.26u l=0.38u
X6478 cml_tlatch_89.INN cml_tlatch_89.INP cml_tlatch_55.xmux.xp.S1 VSS sg13_lv_nmos ad=56.9f pd=0.74u as=56.9f ps=0.74u w=0.17u l=0.17u
X6479 cml_tlatch_22.OUTP cml_tlatch_22.OUTN cml_tlatch_22.xmux.xp.S1 VSS sg13_lv_nmos ad=56.9f pd=0.74u as=56.9f ps=0.74u w=0.17u l=0.17u
X6480 cml_tlatch_63.OUTN cml_tlatch_63.OUTP cml_tlatch_63.xmux.xp.S1 VSS sg13_lv_nmos ad=56.9f pd=0.74u as=56.9f ps=0.74u w=0.17u l=0.17u
X6481 cml_tlatch_42.xmux.xp.S1 cml_tlatch_56.INN cml_tlatch_56.INP VSS sg13_lv_nmos ad=56.9f pd=0.74u as=56.9f ps=0.74u w=0.17u l=0.17u
X6482 MOT3_P MOT3_N cml_tlatch_18.xmux.xp.S1 VSS sg13_lv_nmos ad=56.9f pd=0.74u as=0.1019p ps=1.34u w=0.17u l=0.17u
X6483 cml_tlatch_93.xmux.xp.S1 J1_P J1_N VSS sg13_lv_nmos ad=56.9f pd=0.74u as=56.9f ps=0.74u w=0.17u l=0.17u
X6484 cml_tlatch_47.xtail.S1 CKB3_N cml_tlatch_47.xmux.xp.S1 VSS sg13_lv_nmos ad=89.3f pd=0.85u as=89.3f ps=0.85u w=0.47u l=0.16u
X6485 A0_8_N A0_8_P cml_tlatch_2.xmux.xp.S1 VSS sg13_lv_nmos ad=56.9f pd=0.74u as=56.9f ps=0.74u w=0.17u l=0.17u
X6486 cml_tlatch_4.xmux.xp.S1 CKHB1_N cml_tlatch_4.xtail.S1 VSS sg13_lv_nmos ad=89.3f pd=0.85u as=89.3f ps=0.85u w=0.47u l=0.16u
X6487 hs_to_clk_4.sg13_lv_nmos_2HGZLP_0.G CKA2_N VSS rppd l=4.25u w=1u
X6488 cml_tlatch_24.xmux.xp.S1 CKHA0_N cml_tlatch_24.xtail.S1 VSS sg13_lv_nmos ad=89.3f pd=0.85u as=89.3f ps=0.85u w=0.47u l=0.16u
X6489 cml_tlatch_15.xmux.xp.S1 stub_bi_19.BOTN stub_bi_19.BOTP VSS sg13_lv_nmos ad=56.9f pd=0.74u as=56.9f ps=0.74u w=0.17u l=0.17u
X6490 cml_tlatch_80.xmux.xn.S1 CKB2_P cml_tlatch_80.xtail.S1 VSS sg13_lv_nmos ad=89.3f pd=0.85u as=89.3f ps=0.85u w=0.47u l=0.16u
X6491 stub_bi_17.BOTP stub_bi_17.BOTN cml_tlatch_13.xmux.xp.S1 VSS sg13_lv_nmos ad=56.9f pd=0.74u as=0.1019p ps=1.34u w=0.17u l=0.17u
X6492 cml_tlatch_11.xmux.xp.S1 cml_tlatch_11.OUTN cml_tlatch_11.OUTP VSS sg13_lv_nmos ad=56.9f pd=0.74u as=56.9f ps=0.74u w=0.17u l=0.17u
X6493 cml_tlatch_65.OUTP cml_tlatch_57.INN cml_tlatch_65.xmux.xn.S1 VSS sg13_lv_nmos ad=0.1082p pd=1.34u as=63.19999f ps=0.74u w=0.26u l=0.38u
X6494 cml_tlatch_27.xmux.xp.S1 CKB0_N cml_tlatch_27.xtail.S1 VSS sg13_lv_nmos ad=89.3f pd=0.85u as=89.3f ps=0.85u w=0.47u l=0.16u
X6495 ENB0_N ENB_P cml_drv_2.xrtail.R1 VSS sg13_lv_nmos ad=0.1012p pd=1.34u as=56.2f ps=0.74u w=0.16u l=0.19u
X6496 B2_2_N B2_2_P cml_tlatch_44.xmux.xp.S1 VSS sg13_lv_nmos ad=56.9f pd=0.74u as=56.9f ps=0.74u w=0.17u l=0.17u
X6497 A0_2_P A0_2_N cml_tlatch_31.xmux.xp.S1 VSS sg13_lv_nmos ad=56.9f pd=0.74u as=56.9f ps=0.74u w=0.17u l=0.17u
X6498 cml_tlatch_39.xmux.xn.S1 cml_tlatch_39.INN MOT10_P VSS sg13_lv_nmos ad=63.19999f pd=0.74u as=63.19999f ps=0.74u w=0.26u l=0.38u
X6499 cml_tlatch_21.xmux.xp.S1 CKA1_P cml_tlatch_21.xtail.S1 VSS sg13_lv_nmos ad=89.3f pd=0.85u as=89.3f ps=0.85u w=0.47u l=0.16u
X6500 cml_tlatch_10.xmux.xp.S1 B0_8_N B0_8_P VSS sg13_lv_nmos ad=56.9f pd=0.74u as=56.9f ps=0.74u w=0.17u l=0.17u
X6501 cml_tlatch_60.xmux.xp.S1 B3_8_P B3_8_N VSS sg13_lv_nmos ad=56.9f pd=0.74u as=56.9f ps=0.74u w=0.17u l=0.17u
X6502 cml_tlatch_27.OUTP cml_tlatch_27.OUTN cml_tlatch_27.xmux.xp.S1 VSS sg13_lv_nmos ad=56.9f pd=0.74u as=56.9f ps=0.74u w=0.17u l=0.17u
X6503 MOT26_P cml_tlatch_57.INN cml_tlatch_57.xmux.xn.S1 VSS sg13_lv_nmos ad=63.19999f pd=0.74u as=63.19999f ps=0.74u w=0.26u l=0.38u
X6504 cml_tlatch_66.xmux.xp.S1 cml_tlatch_57.INP cml_tlatch_57.INN VSS sg13_lv_nmos ad=56.9f pd=0.74u as=56.9f ps=0.74u w=0.17u l=0.17u
X6505 cml_tlatch_75.xtail.S1 CKHB2_P cml_tlatch_75.xmux.xn.S1 VSS sg13_lv_nmos ad=89.3f pd=0.85u as=89.3f ps=0.85u w=0.47u l=0.16u
X6506 cml_tlatch_4.xmux.xp.S1 MOT9_N MOT9_P VSS sg13_lv_nmos ad=56.9f pd=0.74u as=56.9f ps=0.74u w=0.17u l=0.17u
X6507 J1_N J1_P cml_tlatch_93.xmux.xp.S1 VSS sg13_lv_nmos ad=56.9f pd=0.74u as=56.9f ps=0.74u w=0.17u l=0.17u
X6508 cml_tlatch_66.xmux.xp.S1 cml_tlatch_57.INN cml_tlatch_57.INP VSS sg13_lv_nmos ad=56.9f pd=0.74u as=56.9f ps=0.74u w=0.17u l=0.17u
X6509 VSS POLN cml_tlatch_69.xtail.S1 VSS sg13_lv_nmos ad=2.7982p pd=17.14u as=1.5637p ps=8.61u w=8.23u l=0.13u
X6510 MOT14_P VDD VSS rppd l=5.17u w=1u
X6511 cml_tlatch_69.INP cml_tlatch_69.INN cml_tlatch_62.xmux.xp.S1 VSS sg13_lv_nmos ad=56.9f pd=0.74u as=56.9f ps=0.74u w=0.17u l=0.17u
X6512 cml_tlatch_74.xmux.xp.S1 MOT19_P MOT19_N VSS sg13_lv_nmos ad=0.1019p pd=1.34u as=56.9f ps=0.74u w=0.17u l=0.17u
X6513 cml_tlatch_7.xmux.xn.S1 CKHB1_P cml_tlatch_7.xtail.S1 VSS sg13_lv_nmos ad=89.3f pd=0.85u as=89.3f ps=0.85u w=0.47u l=0.16u
X6514 J4_P J4_N cml_tlatch_90.xmux.xp.S1 VSS sg13_lv_nmos ad=56.9f pd=0.74u as=56.9f ps=0.74u w=0.17u l=0.17u
X6515 MOT27_N MOT27_P cml_tlatch_69.xmux.xp.S1 VSS sg13_lv_nmos ad=56.9f pd=0.74u as=56.9f ps=0.74u w=0.17u l=0.17u
X6516 cml_tlatch_12.xmux.xp.S1 CKB1_P cml_tlatch_12.xtail.S1 VSS sg13_lv_nmos ad=89.3f pd=0.85u as=89.3f ps=0.85u w=0.47u l=0.16u
X6517 cml_tlatch_32.xmux.xn.S1 CKB1_P cml_tlatch_32.xtail.S1 VSS sg13_lv_nmos ad=89.3f pd=0.85u as=89.3f ps=0.85u w=0.47u l=0.16u
X6518 cml_tlatch_26.xtail.S1 CKHA0_P cml_tlatch_26.xmux.xn.S1 VSS sg13_lv_nmos ad=89.3f pd=0.85u as=89.3f ps=0.85u w=0.47u l=0.16u
X6519 cml_tlatch_45.xmux.xp.S1 cml_tlatch_45.OUTN cml_tlatch_45.OUTP VSS sg13_lv_nmos ad=56.9f pd=0.74u as=56.9f ps=0.74u w=0.17u l=0.17u
X6520 cml_tlatch_85.xmux.xn.S1 cml_tlatch_52.OUTP cml_tlatch_58.INN VSS sg13_lv_nmos ad=63.19999f pd=0.74u as=63.19999f ps=0.74u w=0.26u l=0.38u
X6521 cml_tlatch_47.OUTN D3_P cml_tlatch_47.xmux.xn.S1 VSS sg13_lv_nmos ad=63.19999f pd=0.74u as=63.19999f ps=0.74u w=0.26u l=0.38u
X6522 MOT0_N A0_8_P cml_tlatch_97.xmux.xn.S1 VSS sg13_lv_nmos ad=63.19999f pd=0.74u as=63.19999f ps=0.74u w=0.26u l=0.38u
X6523 cml_tlatch_14.xmux.xp.S1 cml_tlatch_5.INN cml_tlatch_5.INP VSS sg13_lv_nmos ad=56.9f pd=0.74u as=56.9f ps=0.74u w=0.17u l=0.17u
X6524 cml_tlatch_5.xmux.xp.S1 MOT11_P MOT11_N VSS sg13_lv_nmos ad=56.9f pd=0.74u as=56.9f ps=0.74u w=0.17u l=0.17u
X6525 cml_tlatch_63.xmux.xn.S1 cml_tlatch_70.INP cml_tlatch_63.OUTN VSS sg13_lv_nmos ad=0.1082p pd=1.34u as=63.19999f ps=0.74u w=0.26u l=0.38u
X6526 cml_gate2_5.sg13_lv_nmos_FTPY57_0.D0 ENA1_P GA3_N VSS sg13_lv_nmos ad=0.1007p pd=0.91u as=0.1007p ps=0.91u w=0.53u l=0.13u
X6527 cml_tlatch_19.xmux.xp.S1 MOT5_N MOT5_P VSS sg13_lv_nmos ad=56.9f pd=0.74u as=56.9f ps=0.74u w=0.17u l=0.17u
X6528 cml_tlatch_63.xmux.xn.S1 cml_tlatch_70.INP cml_tlatch_63.OUTN VSS sg13_lv_nmos ad=63.19999f pd=0.74u as=63.19999f ps=0.74u w=0.26u l=0.38u
X6529 stub_bi_17.BOTP stub_bi_17.BOTN cml_tlatch_13.xmux.xp.S1 VSS sg13_lv_nmos ad=56.9f pd=0.74u as=56.9f ps=0.74u w=0.17u l=0.17u
X6530 cml_tlatch_90.xtail.S1 CKJ_N cml_tlatch_90.xmux.xn.S1 VSS sg13_lv_nmos ad=89.3f pd=0.85u as=89.3f ps=0.85u w=0.47u l=0.16u
X6531 cml_tlatch_45.xtail.S1 CKB3_N cml_tlatch_45.xmux.xp.S1 VSS sg13_lv_nmos ad=89.3f pd=0.85u as=89.3f ps=0.85u w=0.47u l=0.16u
X6532 cml_tlatch_63.xmux.xp.S1 cml_tlatch_63.OUTN cml_tlatch_63.OUTP VSS sg13_lv_nmos ad=56.9f pd=0.74u as=56.9f ps=0.74u w=0.17u l=0.17u
X6533 cml_tlatch_65.xmux.xp.S1 cml_tlatch_65.OUTN cml_tlatch_65.OUTP VSS sg13_lv_nmos ad=56.9f pd=0.74u as=56.9f ps=0.74u w=0.17u l=0.17u
X6534 cml_tlatch_38.OUTP cml_tlatch_38.OUTN cml_tlatch_38.xmux.xp.S1 VSS sg13_lv_nmos ad=56.9f pd=0.74u as=56.9f ps=0.74u w=0.17u l=0.17u
X6535 cml_tlatch_93.xmux.xp.S1 J1_N J1_P VSS sg13_lv_nmos ad=56.9f pd=0.74u as=56.9f ps=0.74u w=0.17u l=0.17u
X6536 cml_tlatch_0.xmux.xn.S1 cml_tlatch_40.INP interco_bi_19.INN VSS sg13_lv_nmos ad=63.19999f pd=0.74u as=63.19999f ps=0.74u w=0.26u l=0.38u
X6537 cml_tlatch_89.OUTN cml_tlatch_89.OUTP cml_tlatch_89.xmux.xp.S1 VSS sg13_lv_nmos ad=56.9f pd=0.74u as=56.9f ps=0.74u w=0.17u l=0.17u
X6538 cml_tlatch_29.xmux.xp.S1 cml_tlatch_29.OUTN cml_tlatch_29.OUTP VSS sg13_lv_nmos ad=56.9f pd=0.74u as=56.9f ps=0.74u w=0.17u l=0.17u
X6539 cml_tlatch_13.xmux.xn.S1 cml_tlatch_5.INP stub_bi_17.BOTP VSS sg13_lv_nmos ad=63.19999f pd=0.74u as=63.19999f ps=0.74u w=0.26u l=0.38u
X6540 MOT14_P A1_2_N cml_tlatch_41.xmux.xn.S1 VSS sg13_lv_nmos ad=63.19999f pd=0.74u as=63.19999f ps=0.74u w=0.26u l=0.38u
X6541 cml_tlatch_82.xmux.xn.S1 CKA2_P cml_tlatch_82.xtail.S1 VSS sg13_lv_nmos ad=89.3f pd=0.85u as=89.3f ps=0.85u w=0.47u l=0.16u
X6542 cml_tlatch_23.xmux.xp.S1 CKA1_P cml_tlatch_23.xtail.S1 VSS sg13_lv_nmos ad=89.3f pd=0.85u as=89.3f ps=0.85u w=0.47u l=0.16u
X6543 cml_tlatch_37.xtail.S1 CKA1_P cml_tlatch_37.xmux.xp.S1 VSS sg13_lv_nmos ad=89.3f pd=0.85u as=89.3f ps=0.85u w=0.47u l=0.16u
X6544 cml_tlatch_13.xmux.xp.S1 stub_bi_17.BOTP stub_bi_17.BOTN VSS sg13_lv_nmos ad=56.9f pd=0.74u as=56.9f ps=0.74u w=0.17u l=0.17u
X6545 VSS POLN cml_tlatch_64.xtail.S1 VSS sg13_lv_nmos ad=2.7982p pd=17.14u as=1.5637p ps=8.61u w=8.23u l=0.13u
X6546 cml_tlatch_11.xmux.xn.S1 cml_tlatch_16.OUTN cml_tlatch_11.OUTP VSS sg13_lv_nmos ad=63.19999f pd=0.74u as=0.1082p ps=1.34u w=0.26u l=0.38u
X6547 cml_tlatch_9.xmux.xp.S1 CKA0_N cml_tlatch_9.xtail.S1 VSS sg13_lv_nmos ad=0.1598p pd=1.62u as=89.3f ps=0.85u w=0.47u l=0.16u
X6548 MOT14_N MOT14_P cml_tlatch_41.xmux.xp.S1 VSS sg13_lv_nmos ad=56.9f pd=0.74u as=56.9f ps=0.74u w=0.17u l=0.17u
X6549 cml_tlatch_50.xmux.xp.S1 MOT20_P MOT20_N VSS sg13_lv_nmos ad=56.9f pd=0.74u as=56.9f ps=0.74u w=0.17u l=0.17u
X6550 cml_tlatch_51.xmux.xn.S1 A2_2_P MOT22_N VSS sg13_lv_nmos ad=63.19999f pd=0.74u as=63.19999f ps=0.74u w=0.26u l=0.38u
X6551 MOT2_P MOT2_N cml_tlatch_24.xmux.xp.S1 VSS sg13_lv_nmos ad=56.9f pd=0.74u as=0.1019p ps=1.34u w=0.17u l=0.17u
X6552 cml_tlatch_17.xmux.xn.S1 CKHB0_P cml_tlatch_17.xtail.S1 VSS sg13_lv_nmos ad=89.3f pd=0.85u as=0.1598p ps=1.62u w=0.47u l=0.16u
X6553 cml_gate2_1.sg13_lv_nmos_FTPY57_0.D0 CKA0_P cml_gate2_1.xrtail.R1 VSS sg13_lv_nmos ad=0.1007p pd=0.91u as=0.1007p ps=0.91u w=0.53u l=0.13u
X6554 cml_tlatch_61.OUTN cml_tlatch_61.OUTP cml_tlatch_61.xmux.xp.S1 VSS sg13_lv_nmos ad=56.9f pd=0.74u as=56.9f ps=0.74u w=0.17u l=0.17u
X6555 GA3_P ENA1_N cml_gate2_5.sg13_lv_nmos_FTPY57_0.D0 VSS sg13_lv_nmos ad=0.1007p pd=0.91u as=0.1007p ps=0.91u w=0.53u l=0.13u
X6556 cml_tlatch_77.xtail.S1 POLN VSS VSS sg13_lv_nmos ad=1.5637p pd=8.61u as=2.7982p ps=17.14u w=8.23u l=0.13u
X6557 CLK_W_N J2_N cml_tlatch_91.xmux.xn.S1 VSS sg13_lv_nmos ad=63.19999f pd=0.74u as=63.19999f ps=0.74u w=0.26u l=0.38u
X6558 MOT3_P MOT3_N cml_tlatch_18.xmux.xp.S1 VSS sg13_lv_nmos ad=56.9f pd=0.74u as=56.9f ps=0.74u w=0.17u l=0.17u
X6559 A2_8_N A2_8_P cml_tlatch_81.xmux.xp.S1 VSS sg13_lv_nmos ad=56.9f pd=0.74u as=56.9f ps=0.74u w=0.17u l=0.17u
X6560 cml_tlatch_60.xmux.xp.S1 B3_8_P B3_8_N VSS sg13_lv_nmos ad=56.9f pd=0.74u as=56.9f ps=0.74u w=0.17u l=0.17u
X6561 A2_2_P A2_2_N cml_tlatch_56.xmux.xp.S1 VSS sg13_lv_nmos ad=56.9f pd=0.74u as=56.9f ps=0.74u w=0.17u l=0.17u
X6562 cml_gate2_9.sg13_lv_nmos_FTPY57_0.D0 NM1_P cml_gate2_9.xrtail.R1 VSS sg13_lv_nmos ad=0.1007p pd=0.91u as=0.1007p ps=0.91u w=0.53u l=0.13u
X6563 cml_tlatch_96.xmux.xp.S1 CKHA1_N cml_tlatch_96.xtail.S1 VSS sg13_lv_nmos ad=89.3f pd=0.85u as=89.3f ps=0.85u w=0.47u l=0.16u
X6564 cml_tlatch_44.xmux.xp.S1 B2_2_N B2_2_P VSS sg13_lv_nmos ad=56.9f pd=0.74u as=56.9f ps=0.74u w=0.17u l=0.17u
X6565 VSS hs_to_clk_1.sg13_lv_nmos_2HGZLP_0.G VSS VSS sg13_lv_nmos ad=2.071p pd=11.28u as=0 ps=0 w=10.9u l=1.38u
X6566 MOT30_N MOT30_P cml_tlatch_59.xmux.xp.S1 VSS sg13_lv_nmos ad=56.9f pd=0.74u as=56.9f ps=0.74u w=0.17u l=0.17u
X6567 J1_P J1_N cml_tlatch_93.xmux.xp.S1 VSS sg13_lv_nmos ad=56.9f pd=0.74u as=0.1019p ps=1.34u w=0.17u l=0.17u
X6568 cml_tlatch_75.xmux.xp.S1 MOT21_P MOT21_N VSS sg13_lv_nmos ad=56.9f pd=0.74u as=56.9f ps=0.74u w=0.17u l=0.17u
X6569 cml_tlatch_11.OUTP VDD VSS rppd l=5.17u w=1u
X6570 cml_tlatch_42.xmux.xp.S1 cml_tlatch_56.INP cml_tlatch_56.INN VSS sg13_lv_nmos ad=56.9f pd=0.74u as=56.9f ps=0.74u w=0.17u l=0.17u
X6571 cml_tlatch_11.xmux.xp.S1 cml_tlatch_11.OUTN cml_tlatch_11.OUTP VSS sg13_lv_nmos ad=56.9f pd=0.74u as=56.9f ps=0.74u w=0.17u l=0.17u
X6572 cml_tlatch_5.INN cml_tlatch_5.INP cml_tlatch_14.xmux.xp.S1 VSS sg13_lv_nmos ad=56.9f pd=0.74u as=56.9f ps=0.74u w=0.17u l=0.17u
X6573 A0_2_P A0_2_N cml_tlatch_31.xmux.xp.S1 VSS sg13_lv_nmos ad=56.9f pd=0.74u as=56.9f ps=0.74u w=0.17u l=0.17u
X6574 cml_tlatch_45.xmux.xp.S1 cml_tlatch_45.OUTN cml_tlatch_45.OUTP VSS sg13_lv_nmos ad=56.9f pd=0.74u as=56.9f ps=0.74u w=0.17u l=0.17u
X6575 cml_tlatch_89.INP cml_tlatch_89.INN cml_tlatch_55.xmux.xp.S1 VSS sg13_lv_nmos ad=56.9f pd=0.74u as=56.9f ps=0.74u w=0.17u l=0.17u
X6576 cml_tlatch_45.xmux.xn.S1 B3_2_P cml_tlatch_45.OUTN VSS sg13_lv_nmos ad=63.19999f pd=0.74u as=63.19999f ps=0.74u w=0.26u l=0.38u
X6577 cml_tlatch_97.xmux.xp.S1 MOT0_N MOT0_P VSS sg13_lv_nmos ad=56.9f pd=0.74u as=56.9f ps=0.74u w=0.17u l=0.17u
X6578 cml_tlatch_18.xtail.S1 CKHB0_P cml_tlatch_18.xmux.xn.S1 VSS sg13_lv_nmos ad=89.3f pd=0.85u as=89.3f ps=0.85u w=0.47u l=0.16u
X6579 cml_tlatch_34.xtail.S1 CKB1_P cml_tlatch_34.xmux.xn.S1 VSS sg13_lv_nmos ad=89.3f pd=0.85u as=89.3f ps=0.85u w=0.47u l=0.16u
X6580 cml_tlatch_73.xmux.xn.S1 CKHB2_P cml_tlatch_73.xtail.S1 VSS sg13_lv_nmos ad=89.3f pd=0.85u as=89.3f ps=0.85u w=0.47u l=0.16u
X6581 MOT21_P MOT21_N cml_tlatch_75.xmux.xp.S1 VSS sg13_lv_nmos ad=56.9f pd=0.74u as=56.9f ps=0.74u w=0.17u l=0.17u
X6582 cml_tlatch_64.xmux.xp.S1 A3_8_N A3_8_P VSS sg13_lv_nmos ad=56.9f pd=0.74u as=56.9f ps=0.74u w=0.17u l=0.17u
X6583 cml_tlatch_16.OUTP cml_tlatch_1.OUTN cml_tlatch_16.xmux.xn.S1 VSS sg13_lv_nmos ad=63.19999f pd=0.74u as=63.19999f ps=0.74u w=0.26u l=0.38u
X6584 B3_8_P B3_8_N cml_tlatch_60.xmux.xp.S1 VSS sg13_lv_nmos ad=56.9f pd=0.74u as=56.9f ps=0.74u w=0.17u l=0.17u
X6585 cml_tlatch_54.xmux.xp.S1 cml_tlatch_54.OUTN cml_tlatch_54.OUTP VSS sg13_lv_nmos ad=56.9f pd=0.74u as=56.9f ps=0.74u w=0.17u l=0.17u
X6586 cml_tlatch_82.OUTN cml_tlatch_83.OUTP cml_tlatch_82.xmux.xn.S1 VSS sg13_lv_nmos ad=63.19999f pd=0.74u as=63.19999f ps=0.74u w=0.26u l=0.38u
X6587 VSS POLN hs_to_clk_5.D2 VSS sg13_lv_nmos ad=1.9p pd=10.38u as=1.9p ps=10.38u w=10u l=0.13u
X6588 MOT22_P MOT22_N cml_tlatch_51.xmux.xp.S1 VSS sg13_lv_nmos ad=56.9f pd=0.74u as=56.9f ps=0.74u w=0.17u l=0.17u
X6589 cml_tlatch_36.xmux.xp.S1 cml_tlatch_95.INP cml_tlatch_95.INN VSS sg13_lv_nmos ad=56.9f pd=0.74u as=56.9f ps=0.74u w=0.17u l=0.17u
X6590 cml_tlatch_37.xtail.S1 CKA1_P cml_tlatch_37.xmux.xp.S1 VSS sg13_lv_nmos ad=89.3f pd=0.85u as=89.3f ps=0.85u w=0.47u l=0.16u
X6591 cml_tlatch_80.xmux.xp.S1 stub_bi_49.BOTN stub_bi_49.BOTP VSS sg13_lv_nmos ad=56.9f pd=0.74u as=56.9f ps=0.74u w=0.17u l=0.17u
X6592 MOT23_N MOT23_P cml_tlatch_76.xmux.xp.S1 VSS sg13_lv_nmos ad=56.9f pd=0.74u as=56.9f ps=0.74u w=0.17u l=0.17u
X6593 cml_tlatch_34.xmux.xp.S1 stub_bi_31.BOTP stub_bi_31.BOTN VSS sg13_lv_nmos ad=56.9f pd=0.74u as=56.9f ps=0.74u w=0.17u l=0.17u
X6594 cml_tlatch_47.xmux.xp.S1 CKB3_N cml_tlatch_47.xtail.S1 VSS sg13_lv_nmos ad=89.3f pd=0.85u as=89.3f ps=0.85u w=0.47u l=0.16u
X6595 MOT17_N MOT17_P cml_tlatch_73.xmux.xp.S1 VSS sg13_lv_nmos ad=56.9f pd=0.74u as=56.9f ps=0.74u w=0.17u l=0.17u
X6596 cml_tlatch_9.xmux.xp.S1 cml_tlatch_9.OUTN cml_tlatch_9.OUTP VSS sg13_lv_nmos ad=56.9f pd=0.74u as=56.9f ps=0.74u w=0.17u l=0.17u
X6597 cml_gate2_7.sg13_lv_nmos_FTPY57_0.D0 ENB0_N GB2_P VSS sg13_lv_nmos ad=0.1007p pd=0.91u as=0.1007p ps=0.91u w=0.53u l=0.13u
X6598 cml_tlatch_97.xtail.S1 POLN VSS VSS sg13_lv_nmos ad=1.5637p pd=8.61u as=1.5637p ps=8.61u w=8.23u l=0.13u
X6599 cml_tlatch_68.xmux.xp.S1 MOT25_P MOT25_N VSS sg13_lv_nmos ad=56.9f pd=0.74u as=56.9f ps=0.74u w=0.17u l=0.17u
X6600 MOT11_N cml_tlatch_5.INP cml_tlatch_5.xmux.xn.S1 VSS sg13_lv_nmos ad=63.19999f pd=0.74u as=63.19999f ps=0.74u w=0.26u l=0.38u
X6601 VSS POLN cml_tlatch_94.xtail.S1 VSS sg13_lv_nmos ad=2.7982p pd=17.14u as=1.5637p ps=8.61u w=8.23u l=0.13u
X6602 ENB1_N ENB_P cml_drv_0.xrtail.R1 VSS sg13_lv_nmos ad=0.1012p pd=1.34u as=56.2f ps=0.74u w=0.16u l=0.19u
X6603 cml_tlatch_80.xtail.S1 CKB2_P cml_tlatch_80.xmux.xn.S1 VSS sg13_lv_nmos ad=89.3f pd=0.85u as=89.3f ps=0.85u w=0.47u l=0.16u
X6604 cml_tlatch_45.xtail.S1 CKB3_P cml_tlatch_45.xmux.xn.S1 VSS sg13_lv_nmos ad=89.3f pd=0.85u as=89.3f ps=0.85u w=0.47u l=0.16u
X6605 cml_tlatch_25.xtail.S1 POLN VSS VSS sg13_lv_nmos ad=1.5637p pd=8.61u as=1.5637p ps=8.61u w=8.23u l=0.13u
X6606 cml_tlatch_19.xmux.xp.S1 MOT5_N MOT5_P VSS sg13_lv_nmos ad=56.9f pd=0.74u as=56.9f ps=0.74u w=0.17u l=0.17u
X6607 MOT12_N VDD VSS rppd l=5.17u w=1u
X6608 cml_tlatch_83.INP cml_tlatch_83.INN cml_tlatch_72.xmux.xp.S1 VSS sg13_lv_nmos ad=56.9f pd=0.74u as=56.9f ps=0.74u w=0.17u l=0.17u
X6609 cml_tlatch_91.xtail.S1 CKJ_P cml_tlatch_91.xmux.xn.S1 VSS sg13_lv_nmos ad=89.3f pd=0.85u as=89.3f ps=0.85u w=0.47u l=0.16u
X6610 B2_8_N B2_8_P cml_tlatch_77.xmux.xp.S1 VSS sg13_lv_nmos ad=56.9f pd=0.74u as=0.1019p ps=1.34u w=0.17u l=0.17u
X6611 cml_tlatch_99.xmux.xn.S1 CKA0_N cml_tlatch_99.xtail.S1 VSS sg13_lv_nmos ad=89.3f pd=0.85u as=89.3f ps=0.85u w=0.47u l=0.16u
X6612 cml_tlatch_89.OUTN cml_tlatch_89.OUTP cml_tlatch_89.xmux.xp.S1 VSS sg13_lv_nmos ad=56.9f pd=0.74u as=56.9f ps=0.74u w=0.17u l=0.17u
X6613 cml_tlatch_99.xmux.xp.S1 cml_tlatch_99.OUTN cml_tlatch_99.OUTP VSS sg13_lv_nmos ad=56.9f pd=0.74u as=56.9f ps=0.74u w=0.17u l=0.17u
X6614 cml_tlatch_88.xmux.xp.S1 stub_bi_55.BOTN stub_bi_55.BOTP VSS sg13_lv_nmos ad=56.9f pd=0.74u as=56.9f ps=0.74u w=0.17u l=0.17u
X6615 MOT24_P VDD VSS rppd l=5.17u w=1u
X6616 cml_tlatch_39.INP interco_bi_19.INN cml_tlatch_23.xmux.xn.S1 VSS sg13_lv_nmos ad=63.19999f pd=0.74u as=63.19999f ps=0.74u w=0.26u l=0.38u
X6617 cml_tlatch_87.xtail.S1 CKHA2_P cml_tlatch_87.xmux.xn.S1 VSS sg13_lv_nmos ad=89.3f pd=0.85u as=89.3f ps=0.85u w=0.47u l=0.16u
X6618 cml_tlatch_24.xmux.xn.S1 CKHA0_P cml_tlatch_24.xtail.S1 VSS sg13_lv_nmos ad=89.3f pd=0.85u as=89.3f ps=0.85u w=0.47u l=0.16u
X6619 cml_tlatch_20.xmux.xp.S1 MOT7_P MOT7_N VSS sg13_lv_nmos ad=56.9f pd=0.74u as=56.9f ps=0.74u w=0.17u l=0.17u
X6620 cml_tlatch_48.xmux.xp.S1 stub_bi_32.BOTN stub_bi_32.BOTP VSS sg13_lv_nmos ad=56.9f pd=0.74u as=56.9f ps=0.74u w=0.17u l=0.17u
X6621 cml_tlatch_28.xmux.xn.S1 cml_tlatch_29.OUTN B0_2_P VSS sg13_lv_nmos ad=0.1082p pd=1.34u as=63.19999f ps=0.74u w=0.26u l=0.38u
X6622 VSS POLN cml_tlatch_12.xtail.S1 VSS sg13_lv_nmos ad=1.5637p pd=8.61u as=1.5637p ps=8.61u w=8.23u l=0.13u
X6623 cml_gate2_5.sg13_lv_nmos_FTPY57_0.D0 ENA1_N GA3_P VSS sg13_lv_nmos ad=0.1007p pd=0.91u as=0.1007p ps=0.91u w=0.53u l=0.13u
X6624 cml_tlatch_20.xmux.xn.S1 B0_2_N MOT7_P VSS sg13_lv_nmos ad=63.19999f pd=0.74u as=63.19999f ps=0.74u w=0.26u l=0.38u
X6625 cml_tlatch_93.xmux.xn.S1 CKJ_P cml_tlatch_93.xtail.S1 VSS sg13_lv_nmos ad=89.3f pd=0.85u as=89.3f ps=0.85u w=0.47u l=0.16u
X6626 cml_tlatch_26.xmux.xn.S1 CKHA0_P cml_tlatch_26.xtail.S1 VSS sg13_lv_nmos ad=89.3f pd=0.85u as=89.3f ps=0.85u w=0.47u l=0.16u
X6627 MOT2_P MOT2_N cml_tlatch_24.xmux.xp.S1 VSS sg13_lv_nmos ad=56.9f pd=0.74u as=56.9f ps=0.74u w=0.17u l=0.17u
X6628 cml_tlatch_32.xtail.S1 CKB1_P cml_tlatch_32.xmux.xn.S1 VSS sg13_lv_nmos ad=89.3f pd=0.85u as=0.1598p ps=1.62u w=0.47u l=0.16u
X6629 stub_bi_42.BOTN stub_bi_42.BOTP cml_tlatch_43.xmux.xp.S1 VSS sg13_lv_nmos ad=56.9f pd=0.74u as=0.1019p ps=1.34u w=0.17u l=0.17u
X6630 cml_tlatch_28.xmux.xn.S1 CKB0_N cml_tlatch_28.xtail.S1 VSS sg13_lv_nmos ad=89.3f pd=0.85u as=89.3f ps=0.85u w=0.47u l=0.16u
X6631 cml_drv_1.xrtail.R1 ENA_N ENA1_P VSS sg13_lv_nmos ad=56.2f pd=0.74u as=56.2f ps=0.74u w=0.16u l=0.19u
X6632 cml_tlatch_82.xmux.xp.S1 cml_tlatch_82.OUTP cml_tlatch_82.OUTN VSS sg13_lv_nmos ad=56.9f pd=0.74u as=56.9f ps=0.74u w=0.17u l=0.17u
X6633 cml_tlatch_66.xtail.S1 CKA3_P cml_tlatch_66.xmux.xp.S1 VSS sg13_lv_nmos ad=89.3f pd=0.85u as=89.3f ps=0.85u w=0.47u l=0.16u
X6634 cml_tlatch_58.xtail.S1 CKHA3_N cml_tlatch_58.xmux.xp.S1 VSS sg13_lv_nmos ad=89.3f pd=0.85u as=0.1598p ps=1.62u w=0.47u l=0.16u
X6635 cml_tlatch_49.xtail.S1 CKHA2_N cml_tlatch_49.xmux.xp.S1 VSS sg13_lv_nmos ad=89.3f pd=0.85u as=89.3f ps=0.85u w=0.47u l=0.16u
X6636 B0_8_N B0_8_P cml_tlatch_10.xmux.xp.S1 VSS sg13_lv_nmos ad=56.9f pd=0.74u as=56.9f ps=0.74u w=0.17u l=0.17u
X6637 cml_tlatch_53.xmux.xp.S1 A3_2_P A3_2_N VSS sg13_lv_nmos ad=56.9f pd=0.74u as=56.9f ps=0.74u w=0.17u l=0.17u
X6638 CKHB3_P VDD VSS rppd l=13.09u w=1u
X6639 cml_tlatch_30.OUTP cml_tlatch_30.OUTN cml_tlatch_30.xmux.xp.S1 VSS sg13_lv_nmos ad=56.9f pd=0.74u as=0.1019p ps=1.34u w=0.17u l=0.17u
X6640 cml_tlatch_2.xmux.xp.S1 CKA0_P cml_tlatch_2.xtail.S1 VSS sg13_lv_nmos ad=89.3f pd=0.85u as=89.3f ps=0.85u w=0.47u l=0.16u
X6641 cml_tlatch_61.xtail.S1 CKB3_N cml_tlatch_61.xmux.xp.S1 VSS sg13_lv_nmos ad=89.3f pd=0.85u as=89.3f ps=0.85u w=0.47u l=0.16u
X6642 cml_tlatch_88.xmux.xn.S1 CKB2_N cml_tlatch_88.xtail.S1 VSS sg13_lv_nmos ad=89.3f pd=0.85u as=89.3f ps=0.85u w=0.47u l=0.16u
X6643 cml_tlatch_30.xmux.xp.S1 cml_tlatch_30.OUTP cml_tlatch_30.OUTN VSS sg13_lv_nmos ad=56.9f pd=0.74u as=56.9f ps=0.74u w=0.17u l=0.17u
X6644 GA0_N ENA0_P cml_gate2_2.sg13_lv_nmos_FTPY57_0.D0 VSS sg13_lv_nmos ad=0.1007p pd=0.91u as=0.1007p ps=0.91u w=0.53u l=0.13u
X6645 B1_8_P B1_8_N cml_tlatch_12.xmux.xp.S1 VSS sg13_lv_nmos ad=56.9f pd=0.74u as=56.9f ps=0.74u w=0.17u l=0.17u
X6646 A2_2_P cml_tlatch_56.INN cml_tlatch_56.xmux.xn.S1 VSS sg13_lv_nmos ad=63.19999f pd=0.74u as=63.19999f ps=0.74u w=0.26u l=0.38u
X6647 cml_tlatch_44.xmux.xp.S1 B2_2_N B2_2_P VSS sg13_lv_nmos ad=56.9f pd=0.74u as=56.9f ps=0.74u w=0.17u l=0.17u
X6648 cml_tlatch_99.xmux.xn.S1 cml_tlatch_30.OUTN cml_tlatch_99.OUTP VSS sg13_lv_nmos ad=63.19999f pd=0.74u as=63.19999f ps=0.74u w=0.26u l=0.38u
X6649 cml_tlatch_11.OUTN cml_tlatch_11.OUTP cml_tlatch_11.xmux.xp.S1 VSS sg13_lv_nmos ad=56.9f pd=0.74u as=56.9f ps=0.74u w=0.17u l=0.17u
X6650 cml_tlatch_54.xmux.xn.S1 CKA3_P cml_tlatch_54.xtail.S1 VSS sg13_lv_nmos ad=89.3f pd=0.85u as=89.3f ps=0.85u w=0.47u l=0.16u
X6651 cml_tlatch_34.xmux.xn.S1 D1_P stub_bi_31.BOTP VSS sg13_lv_nmos ad=63.19999f pd=0.74u as=63.19999f ps=0.74u w=0.26u l=0.38u
X6652 cml_tlatch_67.OUTN cml_tlatch_67.OUTP cml_tlatch_67.xmux.xp.S1 VSS sg13_lv_nmos ad=56.9f pd=0.74u as=56.9f ps=0.74u w=0.17u l=0.17u
X6653 cml_tlatch_67.xtail.S1 POLN VSS VSS sg13_lv_nmos ad=1.5637p pd=8.61u as=2.7982p ps=17.14u w=8.23u l=0.13u
X6654 cml_tlatch_35.xtail.S1 CKA0_N cml_tlatch_35.xmux.xp.S1 VSS sg13_lv_nmos ad=89.3f pd=0.85u as=89.3f ps=0.85u w=0.47u l=0.16u
X6655 cml_tlatch_52.OUTN cml_tlatch_52.OUTP cml_tlatch_52.xmux.xp.S1 VSS sg13_lv_nmos ad=56.9f pd=0.74u as=56.9f ps=0.74u w=0.17u l=0.17u
X6656 stub_bi_49.BOTN stub_bi_49.BOTP cml_tlatch_80.xmux.xp.S1 VSS sg13_lv_nmos ad=56.9f pd=0.74u as=56.9f ps=0.74u w=0.17u l=0.17u
X6657 MOT12_P MOT12_N cml_tlatch_40.xmux.xp.S1 VSS sg13_lv_nmos ad=56.9f pd=0.74u as=56.9f ps=0.74u w=0.17u l=0.17u
X6658 cml_tlatch_83.OUTP cml_tlatch_83.OUTN cml_tlatch_83.xmux.xp.S1 VSS sg13_lv_nmos ad=56.9f pd=0.74u as=56.9f ps=0.74u w=0.17u l=0.17u
X6659 cml_tlatch_47.OUTP D3_N cml_tlatch_47.xmux.xn.S1 VSS sg13_lv_nmos ad=63.19999f pd=0.74u as=63.19999f ps=0.74u w=0.26u l=0.38u
X6660 cml_tlatch_57.INN cml_tlatch_67.OUTP cml_tlatch_66.xmux.xn.S1 VSS sg13_lv_nmos ad=63.19999f pd=0.74u as=63.19999f ps=0.74u w=0.26u l=0.38u
X6661 cml_tlatch_88.xmux.xn.S1 stub_bi_42.BOTN stub_bi_55.BOTP VSS sg13_lv_nmos ad=0.1082p pd=1.34u as=63.19999f ps=0.74u w=0.26u l=0.38u
X6662 cml_tlatch_95.INP A1_2_N cml_tlatch_36.xmux.xn.S1 VSS sg13_lv_nmos ad=63.19999f pd=0.74u as=63.19999f ps=0.74u w=0.26u l=0.38u
X6663 VDD NM1_N VSS rppd l=13.09u w=1u
X6664 cml_tlatch_72.xtail.S1 CKA2_N cml_tlatch_72.xmux.xp.S1 VSS sg13_lv_nmos ad=89.3f pd=0.85u as=89.3f ps=0.85u w=0.47u l=0.16u
X6665 cml_gate2_4.sg13_lv_nmos_FTPY57_0.D0 ENA1_N GA2_P VSS sg13_lv_nmos ad=0.1007p pd=0.91u as=0.1007p ps=0.91u w=0.53u l=0.13u
X6666 MOT16_N MOT16_P cml_tlatch_87.xmux.xp.S1 VSS sg13_lv_nmos ad=56.9f pd=0.74u as=56.9f ps=0.74u w=0.17u l=0.17u
X6667 cml_tlatch_59.xmux.xp.S1 MOT30_N MOT30_P VSS sg13_lv_nmos ad=56.9f pd=0.74u as=56.9f ps=0.74u w=0.17u l=0.17u
X6668 cml_tlatch_50.xmux.xn.S1 cml_tlatch_89.OUTN MOT20_P VSS sg13_lv_nmos ad=63.19999f pd=0.74u as=63.19999f ps=0.74u w=0.26u l=0.38u
X6669 VDD A0_2_N VSS rppd l=5.17u w=1u
X6670 cml_tlatch_47.xmux.xn.S1 CKB3_P cml_tlatch_47.xtail.S1 VSS sg13_lv_nmos ad=89.3f pd=0.85u as=89.3f ps=0.85u w=0.47u l=0.16u
X6671 stub_bi_29.BOTP stub_bi_29.BOTN cml_tlatch_32.xmux.xp.S1 VSS sg13_lv_nmos ad=56.9f pd=0.74u as=56.9f ps=0.74u w=0.17u l=0.17u
X6672 MOT23_N MOT23_P cml_tlatch_76.xmux.xp.S1 VSS sg13_lv_nmos ad=56.9f pd=0.74u as=56.9f ps=0.74u w=0.17u l=0.17u
X6673 cml_tlatch_71.xmux.xp.S1 MOT31_P MOT31_N VSS sg13_lv_nmos ad=56.9f pd=0.74u as=56.9f ps=0.74u w=0.17u l=0.17u
X6674 VDD cml_tlatch_9.OUTP VSS rppd l=5.17u w=1u
X6675 cml_tlatch_84.xmux.xp.S1 CKB3_P cml_tlatch_84.xtail.S1 VSS sg13_lv_nmos ad=89.3f pd=0.85u as=89.3f ps=0.85u w=0.47u l=0.16u
X6676 cml_tlatch_35.OUTP cml_tlatch_35.OUTN cml_tlatch_35.xmux.xp.S1 VSS sg13_lv_nmos ad=56.9f pd=0.74u as=56.9f ps=0.74u w=0.17u l=0.17u
X6677 MOT14_P MOT14_N cml_tlatch_41.xmux.xp.S1 VSS sg13_lv_nmos ad=56.9f pd=0.74u as=56.9f ps=0.74u w=0.17u l=0.17u
X6678 J1_N J4_N cml_tlatch_93.xmux.xn.S1 VSS sg13_lv_nmos ad=63.19999f pd=0.74u as=0.1082p ps=1.34u w=0.26u l=0.38u
X6679 GB3_N ENB0_P cml_gate2_6.sg13_lv_nmos_FTPY57_0.D0 VSS sg13_lv_nmos ad=0.1007p pd=0.91u as=0.1007p ps=0.91u w=0.53u l=0.13u
X6680 cml_tlatch_92.xtail.S1 CKJ_P cml_tlatch_92.xmux.xp.S1 VSS sg13_lv_nmos ad=89.3f pd=0.85u as=89.3f ps=0.85u w=0.47u l=0.16u
X6681 cml_tlatch_82.OUTP cml_tlatch_82.OUTN cml_tlatch_82.xmux.xp.S1 VSS sg13_lv_nmos ad=56.9f pd=0.74u as=56.9f ps=0.74u w=0.17u l=0.17u
X6682 cml_tlatch_53.xmux.xp.S1 CKA3_P cml_tlatch_53.xtail.S1 VSS sg13_lv_nmos ad=0.1598p pd=1.62u as=89.3f ps=0.85u w=0.47u l=0.16u
X6683 cml_gate2_5.sg13_lv_nmos_FTPY57_0.D0 CKB3_P cml_gate2_5.xrtail.R1 VSS sg13_lv_nmos ad=0.1007p pd=0.91u as=0.1007p ps=0.91u w=0.53u l=0.13u
X6684 cml_tlatch_80.xtail.S1 CKB2_N cml_tlatch_80.xmux.xp.S1 VSS sg13_lv_nmos ad=89.3f pd=0.85u as=89.3f ps=0.85u w=0.47u l=0.16u
X6685 cml_tlatch_67.xtail.S1 CKA3_N cml_tlatch_67.xmux.xp.S1 VSS sg13_lv_nmos ad=89.3f pd=0.85u as=89.3f ps=0.85u w=0.47u l=0.16u
X6686 MOT19_N MOT19_P cml_tlatch_74.xmux.xp.S1 VSS sg13_lv_nmos ad=56.9f pd=0.74u as=56.9f ps=0.74u w=0.17u l=0.17u
X6687 cml_tlatch_93.xtail.S1 POLN VSS VSS sg13_lv_nmos ad=1.5637p pd=8.61u as=1.5637p ps=8.61u w=8.23u l=0.13u
X6688 cml_tlatch_2.xmux.xp.S1 A0_8_N A0_8_P VSS sg13_lv_nmos ad=56.9f pd=0.74u as=56.9f ps=0.74u w=0.17u l=0.17u
X6689 cml_tlatch_99.xmux.xp.S1 cml_tlatch_99.OUTN cml_tlatch_99.OUTP VSS sg13_lv_nmos ad=0.1019p pd=1.34u as=56.9f ps=0.74u w=0.17u l=0.17u
X6690 cml_tlatch_96.xmux.xn.S1 CKHA1_P cml_tlatch_96.xtail.S1 VSS sg13_lv_nmos ad=89.3f pd=0.85u as=89.3f ps=0.85u w=0.47u l=0.16u
X6691 cml_tlatch_73.xtail.S1 CKHB2_P cml_tlatch_73.xmux.xn.S1 VSS sg13_lv_nmos ad=89.3f pd=0.85u as=89.3f ps=0.85u w=0.47u l=0.16u
X6692 MOT17_N B2_8_P cml_tlatch_73.xmux.xn.S1 VSS sg13_lv_nmos ad=63.19999f pd=0.74u as=0.1082p ps=1.34u w=0.26u l=0.38u
X6693 GB1_P CKA1_N cml_gate2_0.xrtail.R1 VSS sg13_lv_nmos ad=0.1007p pd=0.91u as=0.1007p ps=0.91u w=0.53u l=0.13u
X6694 cml_tlatch_36.xtail.S1 CKA1_N cml_tlatch_36.xmux.xp.S1 VSS sg13_lv_nmos ad=89.3f pd=0.85u as=89.3f ps=0.85u w=0.47u l=0.16u
X6695 cml_tlatch_83.INP cml_tlatch_89.OUTN cml_tlatch_72.xmux.xn.S1 VSS sg13_lv_nmos ad=63.19999f pd=0.74u as=63.19999f ps=0.74u w=0.26u l=0.38u
X6696 cml_tlatch_19.xmux.xn.S1 cml_tlatch_98.OUTP MOT5_N VSS sg13_lv_nmos ad=63.19999f pd=0.74u as=63.19999f ps=0.74u w=0.26u l=0.38u
X6697 cml_tlatch_38.OUTN cml_tlatch_38.OUTP cml_tlatch_38.xmux.xp.S1 VSS sg13_lv_nmos ad=56.9f pd=0.74u as=56.9f ps=0.74u w=0.17u l=0.17u
X6698 cml_tlatch_56.INN D2_P cml_tlatch_42.xmux.xn.S1 VSS sg13_lv_nmos ad=63.19999f pd=0.74u as=63.19999f ps=0.74u w=0.26u l=0.38u
X6699 cml_tlatch_69.xmux.xp.S1 MOT27_N MOT27_P VSS sg13_lv_nmos ad=0.1019p pd=1.34u as=56.9f ps=0.74u w=0.17u l=0.17u
X6700 MOT15_P MOT15_N cml_tlatch_7.xmux.xp.S1 VSS sg13_lv_nmos ad=56.9f pd=0.74u as=56.9f ps=0.74u w=0.17u l=0.17u
X6701 MOT30_P MOT30_N cml_tlatch_59.xmux.xp.S1 VSS sg13_lv_nmos ad=56.9f pd=0.74u as=56.9f ps=0.74u w=0.17u l=0.17u
X6702 A3_2_P A3_2_N cml_tlatch_53.xmux.xp.S1 VSS sg13_lv_nmos ad=56.9f pd=0.74u as=56.9f ps=0.74u w=0.17u l=0.17u
X6703 cml_drvb_1.xrtail.R1 GB0_P CKHB0_N VSS sg13_lv_nmos ad=0.1463p pd=1.15u as=0.2618p ps=2.22u w=0.77u l=0.21u
X6704 cml_tlatch_45.OUTP B3_2_N cml_tlatch_45.xmux.xn.S1 VSS sg13_lv_nmos ad=63.19999f pd=0.74u as=63.19999f ps=0.74u w=0.26u l=0.38u
X6705 cml_tlatch_68.xtail.S1 CKHB3_P cml_tlatch_68.xmux.xn.S1 VSS sg13_lv_nmos ad=89.3f pd=0.85u as=89.3f ps=0.85u w=0.47u l=0.16u
X6706 CKJ_N CK_N hs_to_clk_8.D2 VSS sg13_lv_nmos ad=0.228p pd=1.58u as=0.408p ps=3.08u w=1.2u l=0.2u
X6707 cml_tlatch_72.xmux.xn.S1 cml_tlatch_89.OUTP cml_tlatch_83.INN VSS sg13_lv_nmos ad=63.19999f pd=0.74u as=63.19999f ps=0.74u w=0.26u l=0.38u
X6708 cml_tlatch_58.xmux.xp.S1 MOT28_N MOT28_P VSS sg13_lv_nmos ad=56.9f pd=0.74u as=56.9f ps=0.74u w=0.17u l=0.17u
X6709 stub_bi_62.BOTP stub_bi_62.BOTN cml_tlatch_78.xmux.xp.S1 VSS sg13_lv_nmos ad=56.9f pd=0.74u as=56.9f ps=0.74u w=0.17u l=0.17u
X6710 cml_tlatch_70.INN VDD VSS rppd l=5.17u w=1u
X6711 MOT26_N cml_tlatch_57.INP cml_tlatch_57.xmux.xn.S1 VSS sg13_lv_nmos ad=63.19999f pd=0.74u as=63.19999f ps=0.74u w=0.26u l=0.38u
X6712 VSS hs_to_clk_6.sg13_lv_nmos_2HGZLP_0.G VSS VSS sg13_lv_nmos ad=2.071p pd=11.28u as=0 ps=0 w=10.9u l=1.38u
X6713 stub_bi_63.BOTP stub_bi_63.BOTN cml_tlatch_79.xmux.xp.S1 VSS sg13_lv_nmos ad=56.9f pd=0.74u as=56.9f ps=0.74u w=0.17u l=0.17u
X6714 cml_tlatch_26.xmux.xp.S1 CKHA0_N cml_tlatch_26.xtail.S1 VSS sg13_lv_nmos ad=0.1598p pd=1.62u as=89.3f ps=0.85u w=0.47u l=0.16u
X6715 cml_tlatch_23.xmux.xp.S1 cml_tlatch_39.INP cml_tlatch_39.INN VSS sg13_lv_nmos ad=56.9f pd=0.74u as=56.9f ps=0.74u w=0.17u l=0.17u
X6716 cml_tlatch_23.xmux.xp.S1 cml_tlatch_39.INN cml_tlatch_39.INP VSS sg13_lv_nmos ad=56.9f pd=0.74u as=56.9f ps=0.74u w=0.17u l=0.17u
X6717 cml_tlatch_32.xtail.S1 CKB1_N cml_tlatch_32.xmux.xp.S1 VSS sg13_lv_nmos ad=89.3f pd=0.85u as=89.3f ps=0.85u w=0.47u l=0.16u
X6718 cml_tlatch_40.INP cml_tlatch_40.INN cml_tlatch_95.xmux.xp.S1 VSS sg13_lv_nmos ad=56.9f pd=0.74u as=56.9f ps=0.74u w=0.17u l=0.17u
X6719 cml_tlatch_88.xmux.xp.S1 stub_bi_55.BOTP stub_bi_55.BOTN VSS sg13_lv_nmos ad=56.9f pd=0.74u as=56.9f ps=0.74u w=0.17u l=0.17u
X6720 cml_tlatch_18.xmux.xp.S1 MOT3_P MOT3_N VSS sg13_lv_nmos ad=56.9f pd=0.74u as=56.9f ps=0.74u w=0.17u l=0.17u
X6721 cml_tlatch_55.xtail.S1 CKA2_N cml_tlatch_55.xmux.xp.S1 VSS sg13_lv_nmos ad=89.3f pd=0.85u as=89.3f ps=0.85u w=0.47u l=0.16u
X6722 MOT6_N MOT6_P cml_tlatch_26.xmux.xp.S1 VSS sg13_lv_nmos ad=56.9f pd=0.74u as=56.9f ps=0.74u w=0.17u l=0.17u
X6723 VSS POLN cml_tlatch_3.xtail.S1 VSS sg13_lv_nmos ad=2.7982p pd=17.14u as=1.5637p ps=8.61u w=8.23u l=0.13u
X6724 cml_tlatch_87.xmux.xp.S1 MOT16_N MOT16_P VSS sg13_lv_nmos ad=56.9f pd=0.74u as=56.9f ps=0.74u w=0.17u l=0.17u
X6725 MOT24_P MOT24_N cml_tlatch_86.xmux.xp.S1 VSS sg13_lv_nmos ad=56.9f pd=0.74u as=56.9f ps=0.74u w=0.17u l=0.17u
X6726 cml_tlatch_70.xmux.xn.S1 CKHB3_P cml_tlatch_70.xtail.S1 VSS sg13_lv_nmos ad=89.3f pd=0.85u as=89.3f ps=0.85u w=0.47u l=0.16u
X6727 cml_tlatch_77.xmux.xn.S1 stub_bi_62.BOTP B2_8_P VSS sg13_lv_nmos ad=63.19999f pd=0.74u as=63.19999f ps=0.74u w=0.26u l=0.38u
X6728 cml_tlatch_16.OUTP cml_tlatch_1.OUTN cml_tlatch_16.xmux.xn.S1 VSS sg13_lv_nmos ad=63.19999f pd=0.74u as=63.19999f ps=0.74u w=0.26u l=0.38u
X6729 ENB1_P VDD VSS rppd l=8.13u w=1u
X6730 cml_tlatch_96.xmux.xp.S1 MOT8_P MOT8_N VSS sg13_lv_nmos ad=56.9f pd=0.74u as=56.9f ps=0.74u w=0.17u l=0.17u
X6731 cml_tlatch_87.xmux.xn.S1 CKHA2_P cml_tlatch_87.xtail.S1 VSS sg13_lv_nmos ad=89.3f pd=0.85u as=89.3f ps=0.85u w=0.47u l=0.16u
X6732 cml_tlatch_67.OUTN cml_tlatch_67.OUTP cml_tlatch_67.xmux.xp.S1 VSS sg13_lv_nmos ad=56.9f pd=0.74u as=56.9f ps=0.74u w=0.17u l=0.17u
X6733 cml_tlatch_63.xmux.xp.S1 cml_tlatch_63.OUTP cml_tlatch_63.OUTN VSS sg13_lv_nmos ad=56.9f pd=0.74u as=56.9f ps=0.74u w=0.17u l=0.17u
X6734 cml_tlatch_56.INP cml_tlatch_56.INN cml_tlatch_42.xmux.xp.S1 VSS sg13_lv_nmos ad=56.9f pd=0.74u as=56.9f ps=0.74u w=0.17u l=0.17u
X6735 cml_tlatch_68.xtail.S1 CKHB3_N cml_tlatch_68.xmux.xp.S1 VSS sg13_lv_nmos ad=89.3f pd=0.85u as=0.1598p ps=1.62u w=0.47u l=0.16u
X6736 A1_2_N cml_tlatch_38.OUTP cml_tlatch_37.xmux.xn.S1 VSS sg13_lv_nmos ad=63.19999f pd=0.74u as=0.1082p ps=1.34u w=0.26u l=0.38u
X6737 cml_tlatch_93.xtail.S1 CKJ_P cml_tlatch_93.xmux.xn.S1 VSS sg13_lv_nmos ad=89.3f pd=0.85u as=89.3f ps=0.85u w=0.47u l=0.16u
X6738 cml_tlatch_18.xtail.S1 CKHB0_P cml_tlatch_18.xmux.xn.S1 VSS sg13_lv_nmos ad=89.3f pd=0.85u as=89.3f ps=0.85u w=0.47u l=0.16u
X6739 cml_gate2_8.xrtail.R1 NS1_N ENB_P VSS sg13_lv_nmos ad=0.1007p pd=0.91u as=0.1007p ps=0.91u w=0.53u l=0.13u
X6740 MOT23_N B2_2_P cml_tlatch_76.xmux.xn.S1 VSS sg13_lv_nmos ad=63.19999f pd=0.74u as=63.19999f ps=0.74u w=0.26u l=0.38u
X6741 cml_tlatch_89.INP A2_2_N cml_tlatch_55.xmux.xn.S1 VSS sg13_lv_nmos ad=0.1082p pd=1.34u as=63.19999f ps=0.74u w=0.26u l=0.38u
X6742 stub_bi_19.BOTP stub_bi_19.BOTN cml_tlatch_15.xmux.xp.S1 VSS sg13_lv_nmos ad=56.9f pd=0.74u as=56.9f ps=0.74u w=0.17u l=0.17u
X6743 J4_N CLK_W_N cml_tlatch_90.xmux.xn.S1 VSS sg13_lv_nmos ad=63.19999f pd=0.74u as=0.1082p ps=1.34u w=0.26u l=0.38u
X6744 cml_tlatch_98.xtail.S1 CKB0_P cml_tlatch_98.xmux.xp.S1 VSS sg13_lv_nmos ad=89.3f pd=0.85u as=89.3f ps=0.85u w=0.47u l=0.16u
X6745 cml_tlatch_64.xtail.S1 CKA3_P cml_tlatch_64.xmux.xp.S1 VSS sg13_lv_nmos ad=89.3f pd=0.85u as=89.3f ps=0.85u w=0.47u l=0.16u
X6746 cml_tlatch_86.xmux.xn.S1 CKHA3_P cml_tlatch_86.xtail.S1 VSS sg13_lv_nmos ad=89.3f pd=0.85u as=89.3f ps=0.85u w=0.47u l=0.16u
X6747 cml_tlatch_25.xmux.xp.S1 MOT4_P MOT4_N VSS sg13_lv_nmos ad=56.9f pd=0.74u as=56.9f ps=0.74u w=0.17u l=0.17u
X6748 cml_tlatch_61.xmux.xn.S1 cml_tlatch_69.INP cml_tlatch_61.OUTN VSS sg13_lv_nmos ad=63.19999f pd=0.74u as=0.1082p ps=1.34u w=0.26u l=0.38u
X6749 cml_tlatch_64.xmux.xp.S1 A3_8_P A3_8_N VSS sg13_lv_nmos ad=56.9f pd=0.74u as=56.9f ps=0.74u w=0.17u l=0.17u
X6750 cml_gate2_6.sg13_lv_nmos_FTPY57_0.D0 ENB0_P GB3_N VSS sg13_lv_nmos ad=0.1007p pd=0.91u as=0.1007p ps=0.91u w=0.53u l=0.13u
X6751 cml_tlatch_78.xtail.S1 CKB2_P cml_tlatch_78.xmux.xn.S1 VSS sg13_lv_nmos ad=89.3f pd=0.85u as=89.3f ps=0.85u w=0.47u l=0.16u
X6752 cml_tlatch_61.xmux.xp.S1 CKB3_N cml_tlatch_61.xtail.S1 VSS sg13_lv_nmos ad=89.3f pd=0.85u as=89.3f ps=0.85u w=0.47u l=0.16u
X6753 cml_tlatch_71.xmux.xp.S1 MOT31_N MOT31_P VSS sg13_lv_nmos ad=56.9f pd=0.74u as=56.9f ps=0.74u w=0.17u l=0.17u
X6754 cml_tlatch_88.xtail.S1 CKB2_N cml_tlatch_88.xmux.xn.S1 VSS sg13_lv_nmos ad=89.3f pd=0.85u as=89.3f ps=0.85u w=0.47u l=0.16u
X6755 cml_tlatch_27.xmux.xp.S1 cml_tlatch_27.OUTP cml_tlatch_27.OUTN VSS sg13_lv_nmos ad=56.9f pd=0.74u as=56.9f ps=0.74u w=0.17u l=0.17u
X6756 cml_tlatch_58.INN cml_tlatch_58.INP cml_tlatch_85.xmux.xp.S1 VSS sg13_lv_nmos ad=56.9f pd=0.74u as=56.9f ps=0.74u w=0.17u l=0.17u
X6757 cml_tlatch_86.xmux.xn.S1 A3_8_P MOT24_N VSS sg13_lv_nmos ad=63.19999f pd=0.74u as=63.19999f ps=0.74u w=0.26u l=0.38u
X6758 cml_tlatch_30.xmux.xn.S1 A0_2_P cml_tlatch_30.OUTN VSS sg13_lv_nmos ad=63.19999f pd=0.74u as=63.19999f ps=0.74u w=0.26u l=0.38u
X6759 cml_tlatch_27.xmux.xp.S1 cml_tlatch_27.OUTN cml_tlatch_27.OUTP VSS sg13_lv_nmos ad=56.9f pd=0.74u as=56.9f ps=0.74u w=0.17u l=0.17u
X6760 cml_tlatch_35.OUTP cml_tlatch_35.OUTN cml_tlatch_35.xmux.xp.S1 VSS sg13_lv_nmos ad=56.9f pd=0.74u as=56.9f ps=0.74u w=0.17u l=0.17u
X6761 cml_tlatch_97.xmux.xn.S1 A0_8_N MOT0_P VSS sg13_lv_nmos ad=63.19999f pd=0.74u as=63.19999f ps=0.74u w=0.26u l=0.38u
X6762 cml_tlatch_91.xmux.xn.S1 J2_N CLK_W_N VSS sg13_lv_nmos ad=63.19999f pd=0.74u as=63.19999f ps=0.74u w=0.26u l=0.38u
X6763 cml_tlatch_55.xmux.xn.S1 A2_2_P cml_tlatch_89.INN VSS sg13_lv_nmos ad=63.19999f pd=0.74u as=63.19999f ps=0.74u w=0.26u l=0.38u
X6764 MOT4_P cml_tlatch_99.OUTN cml_tlatch_25.xmux.xn.S1 VSS sg13_lv_nmos ad=0.1082p pd=1.34u as=63.19999f ps=0.74u w=0.26u l=0.38u
X6765 cml_tlatch_38.xmux.xp.S1 CKA1_N cml_tlatch_38.xtail.S1 VSS sg13_lv_nmos ad=89.3f pd=0.85u as=89.3f ps=0.85u w=0.47u l=0.16u
X6766 cml_tlatch_86.xmux.xn.S1 A3_8_P MOT24_N VSS sg13_lv_nmos ad=63.19999f pd=0.74u as=63.19999f ps=0.74u w=0.26u l=0.38u
X6767 cml_tlatch_74.xmux.xn.S1 stub_bi_63.BOTN MOT19_N VSS sg13_lv_nmos ad=63.19999f pd=0.74u as=63.19999f ps=0.74u w=0.26u l=0.38u
X6768 cml_tlatch_98.OUTN cml_tlatch_27.OUTP cml_tlatch_98.xmux.xn.S1 VSS sg13_lv_nmos ad=63.19999f pd=0.74u as=63.19999f ps=0.74u w=0.26u l=0.38u
X6769 cml_tlatch_12.xmux.xp.S1 B1_8_P B1_8_N VSS sg13_lv_nmos ad=56.9f pd=0.74u as=56.9f ps=0.74u w=0.17u l=0.17u
X6770 cml_tlatch_47.xmux.xp.S1 cml_tlatch_47.OUTP cml_tlatch_47.OUTN VSS sg13_lv_nmos ad=56.9f pd=0.74u as=56.9f ps=0.74u w=0.17u l=0.17u
X6771 cml_tlatch_35.xmux.xp.S1 cml_tlatch_35.OUTP cml_tlatch_35.OUTN VSS sg13_lv_nmos ad=56.9f pd=0.74u as=56.9f ps=0.74u w=0.17u l=0.17u
X6772 cml_tlatch_57.INP cml_tlatch_57.INN cml_tlatch_66.xmux.xp.S1 VSS sg13_lv_nmos ad=56.9f pd=0.74u as=56.9f ps=0.74u w=0.17u l=0.17u
X6773 MOT9_P MOT9_N cml_tlatch_4.xmux.xp.S1 VSS sg13_lv_nmos ad=56.9f pd=0.74u as=56.9f ps=0.74u w=0.17u l=0.17u
X6774 cml_tlatch_55.xmux.xn.S1 A2_2_P cml_tlatch_89.INN VSS sg13_lv_nmos ad=63.19999f pd=0.74u as=63.19999f ps=0.74u w=0.26u l=0.38u
X6775 cml_tlatch_62.xmux.xn.S1 CKB3_N cml_tlatch_62.xtail.S1 VSS sg13_lv_nmos ad=89.3f pd=0.85u as=89.3f ps=0.85u w=0.47u l=0.16u
X6776 MOT19_N MOT19_P cml_tlatch_74.xmux.xp.S1 VSS sg13_lv_nmos ad=56.9f pd=0.74u as=56.9f ps=0.74u w=0.17u l=0.17u
X6777 cml_tlatch_3.xmux.xn.S1 CKA0_P cml_tlatch_3.xtail.S1 VSS sg13_lv_nmos ad=0.1598p pd=1.62u as=89.3f ps=0.85u w=0.47u l=0.16u
X6778 cml_tlatch_46.xmux.xp.S1 B3_2_N B3_2_P VSS sg13_lv_nmos ad=56.9f pd=0.74u as=56.9f ps=0.74u w=0.17u l=0.17u
X6779 cml_tlatch_2.xmux.xp.S1 A0_8_N A0_8_P VSS sg13_lv_nmos ad=56.9f pd=0.74u as=56.9f ps=0.74u w=0.17u l=0.17u
X6780 cml_tlatch_52.xmux.xp.S1 cml_tlatch_52.OUTN cml_tlatch_52.OUTP VSS sg13_lv_nmos ad=56.9f pd=0.74u as=56.9f ps=0.74u w=0.17u l=0.17u
X6781 cml_tlatch_57.xmux.xp.S1 MOT26_N MOT26_P VSS sg13_lv_nmos ad=0.1019p pd=1.34u as=56.9f ps=0.74u w=0.17u l=0.17u
X6782 cml_tlatch_69.xmux.xp.S1 MOT27_P MOT27_N VSS sg13_lv_nmos ad=56.9f pd=0.74u as=56.9f ps=0.74u w=0.17u l=0.17u
X6783 cml_tlatch_91.xtail.S1 CKJ_P cml_tlatch_91.xmux.xn.S1 VSS sg13_lv_nmos ad=89.3f pd=0.85u as=89.3f ps=0.85u w=0.47u l=0.16u
X6784 cml_tlatch_51.xtail.S1 CKHA2_P cml_tlatch_51.xmux.xn.S1 VSS sg13_lv_nmos ad=89.3f pd=0.85u as=89.3f ps=0.85u w=0.47u l=0.16u
X6785 MOT1_P B0_8_N cml_tlatch_17.xmux.xn.S1 VSS sg13_lv_nmos ad=63.19999f pd=0.74u as=63.19999f ps=0.74u w=0.26u l=0.38u
X6786 A3_8_P cml_tlatch_65.OUTN cml_tlatch_64.xmux.xn.S1 VSS sg13_lv_nmos ad=63.19999f pd=0.74u as=63.19999f ps=0.74u w=0.26u l=0.38u
X6787 cml_tlatch_25.xmux.xn.S1 cml_tlatch_99.OUTP MOT4_N VSS sg13_lv_nmos ad=63.19999f pd=0.74u as=63.19999f ps=0.74u w=0.26u l=0.38u
X6788 cml_tlatch_31.xtail.S1 CKA0_P cml_tlatch_31.xmux.xp.S1 VSS sg13_lv_nmos ad=89.3f pd=0.85u as=89.3f ps=0.85u w=0.47u l=0.16u
X6789 cml_tlatch_23.xmux.xp.S1 cml_tlatch_39.INP cml_tlatch_39.INN VSS sg13_lv_nmos ad=56.9f pd=0.74u as=56.9f ps=0.74u w=0.17u l=0.17u
X6790 cml_tlatch_23.xmux.xp.S1 cml_tlatch_39.INN cml_tlatch_39.INP VSS sg13_lv_nmos ad=56.9f pd=0.74u as=56.9f ps=0.74u w=0.17u l=0.17u
X6791 cml_tlatch_5.INP cml_tlatch_5.INN cml_tlatch_14.xmux.xp.S1 VSS sg13_lv_nmos ad=56.9f pd=0.74u as=56.9f ps=0.74u w=0.17u l=0.17u
X6792 cml_tlatch_64.xmux.xn.S1 cml_tlatch_65.OUTP A3_8_N VSS sg13_lv_nmos ad=63.19999f pd=0.74u as=63.19999f ps=0.74u w=0.26u l=0.38u
X6793 cml_tlatch_24.xmux.xn.S1 CKHA0_P cml_tlatch_24.xtail.S1 VSS sg13_lv_nmos ad=89.3f pd=0.85u as=89.3f ps=0.85u w=0.47u l=0.16u
X6794 B1_8_P VDD VSS rppd l=5.17u w=1u
X6795 cml_tlatch_34.xmux.xp.S1 CKB1_N cml_tlatch_34.xtail.S1 VSS sg13_lv_nmos ad=89.3f pd=0.85u as=89.3f ps=0.85u w=0.47u l=0.16u
X6796 cml_tlatch_25.xmux.xn.S1 cml_tlatch_99.OUTP MOT4_N VSS sg13_lv_nmos ad=63.19999f pd=0.74u as=63.19999f ps=0.74u w=0.26u l=0.38u
X6797 GB0_P CKA0_N cml_gate2_1.xrtail.R1 VSS sg13_lv_nmos ad=0.1007p pd=0.91u as=0.1007p ps=0.91u w=0.53u l=0.13u
X6798 cml_tlatch_32.xmux.xp.S1 stub_bi_29.BOTP stub_bi_29.BOTN VSS sg13_lv_nmos ad=56.9f pd=0.74u as=56.9f ps=0.74u w=0.17u l=0.17u
X6799 GA3_P CKB3_N cml_gate2_5.xrtail.R1 VSS sg13_lv_nmos ad=0.1007p pd=0.91u as=0.1007p ps=0.91u w=0.53u l=0.13u
X6800 MOT5_P MOT5_N cml_tlatch_19.xmux.xp.S1 VSS sg13_lv_nmos ad=56.9f pd=0.74u as=0.1019p ps=1.34u w=0.17u l=0.17u
X6801 cml_tlatch_46.xmux.xp.S1 B3_2_N B3_2_P VSS sg13_lv_nmos ad=0.1019p pd=1.34u as=56.9f ps=0.74u w=0.17u l=0.17u
X6802 cml_tlatch_28.xmux.xn.S1 cml_tlatch_29.OUTP B0_2_N VSS sg13_lv_nmos ad=63.19999f pd=0.74u as=0.1082p ps=1.34u w=0.26u l=0.38u
X6803 cml_tlatch_70.INN cml_tlatch_70.INP cml_tlatch_84.xmux.xp.S1 VSS sg13_lv_nmos ad=56.9f pd=0.74u as=0.1019p ps=1.34u w=0.17u l=0.17u
X6804 cml_tlatch_23.xmux.xp.S1 cml_tlatch_39.INP cml_tlatch_39.INN VSS sg13_lv_nmos ad=56.9f pd=0.74u as=56.9f ps=0.74u w=0.17u l=0.17u
X6805 cml_tlatch_5.INN stub_bi_19.BOTN cml_tlatch_14.xmux.xn.S1 VSS sg13_lv_nmos ad=63.19999f pd=0.74u as=63.19999f ps=0.74u w=0.26u l=0.38u
X6806 cml_tlatch_66.xtail.S1 CKA3_P cml_tlatch_66.xmux.xp.S1 VSS sg13_lv_nmos ad=89.3f pd=0.85u as=89.3f ps=0.85u w=0.47u l=0.16u
X6807 B1_2_P B1_2_N cml_tlatch_33.xmux.xp.S1 VSS sg13_lv_nmos ad=56.9f pd=0.74u as=56.9f ps=0.74u w=0.17u l=0.17u
X6808 cml_tlatch_92.xmux.xp.S1 CKJ_P cml_tlatch_92.xtail.S1 VSS sg13_lv_nmos ad=89.3f pd=0.85u as=89.3f ps=0.85u w=0.47u l=0.16u
X6809 cml_gate2_7.sg13_lv_nmos_FTPY57_0.D0 ENB0_P GB2_N VSS sg13_lv_nmos ad=0.1007p pd=0.91u as=0.1007p ps=0.91u w=0.53u l=0.13u
X6810 cml_tlatch_1.OUTP cml_tlatch_1.OUTN cml_tlatch_1.xmux.xp.S1 VSS sg13_lv_nmos ad=56.9f pd=0.74u as=56.9f ps=0.74u w=0.17u l=0.17u
X6811 cml_tlatch_41.xmux.xp.S1 MOT14_P MOT14_N VSS sg13_lv_nmos ad=56.9f pd=0.74u as=56.9f ps=0.74u w=0.17u l=0.17u
X6812 MOT20_N MOT20_P cml_tlatch_50.xmux.xp.S1 VSS sg13_lv_nmos ad=56.9f pd=0.74u as=56.9f ps=0.74u w=0.17u l=0.17u
X6813 GA1_N ENA0_P cml_gate2_3.sg13_lv_nmos_FTPY57_0.D0 VSS sg13_lv_nmos ad=0.1007p pd=0.91u as=0.1007p ps=0.91u w=0.53u l=0.13u
X6814 cml_tlatch_74.xmux.xp.S1 CKHB2_N cml_tlatch_74.xtail.S1 VSS sg13_lv_nmos ad=89.3f pd=0.85u as=0.1598p ps=1.62u w=0.47u l=0.16u
X6815 cml_tlatch_16.OUTP cml_tlatch_16.OUTN cml_tlatch_16.xmux.xp.S1 VSS sg13_lv_nmos ad=56.9f pd=0.74u as=56.9f ps=0.74u w=0.17u l=0.17u
X6816 MOT1_N MOT1_P cml_tlatch_17.xmux.xp.S1 VSS sg13_lv_nmos ad=56.9f pd=0.74u as=56.9f ps=0.74u w=0.17u l=0.17u
X6817 cml_tlatch_61.xmux.xp.S1 cml_tlatch_61.OUTP cml_tlatch_61.OUTN VSS sg13_lv_nmos ad=56.9f pd=0.74u as=56.9f ps=0.74u w=0.17u l=0.17u
X6818 VSS POLN cml_tlatch_54.xtail.S1 VSS sg13_lv_nmos ad=2.7982p pd=17.14u as=1.5637p ps=8.61u w=8.23u l=0.13u
X6819 cml_tlatch_62.xtail.S1 CKB3_P cml_tlatch_62.xmux.xp.S1 VSS sg13_lv_nmos ad=0.1598p pd=1.62u as=89.3f ps=0.85u w=0.47u l=0.16u
X6820 VDD ENA0_N VSS rppd l=8.13u w=1u
X6821 cml_tlatch_55.xmux.xp.S1 cml_tlatch_89.INP cml_tlatch_89.INN VSS sg13_lv_nmos ad=56.9f pd=0.74u as=56.9f ps=0.74u w=0.17u l=0.17u
X6822 cml_tlatch_22.xmux.xp.S1 cml_tlatch_22.OUTN cml_tlatch_22.OUTP VSS sg13_lv_nmos ad=56.9f pd=0.74u as=56.9f ps=0.74u w=0.17u l=0.17u
X6823 cml_tlatch_15.xmux.xp.S1 stub_bi_19.BOTP stub_bi_19.BOTN VSS sg13_lv_nmos ad=56.9f pd=0.74u as=56.9f ps=0.74u w=0.17u l=0.17u
X6824 VDD cml_tlatch_52.OUTP VSS rppd l=5.17u w=1u
X6825 cml_tlatch_18.xmux.xp.S1 MOT3_N MOT3_P VSS sg13_lv_nmos ad=56.9f pd=0.74u as=56.9f ps=0.74u w=0.17u l=0.17u
X6826 A1_8_P A1_8_N cml_tlatch_21.xmux.xp.S1 VSS sg13_lv_nmos ad=56.9f pd=0.74u as=56.9f ps=0.74u w=0.17u l=0.17u
X6827 CLK_W_N CLK_W_P cml_tlatch_91.xmux.xp.S1 VSS sg13_lv_nmos ad=56.9f pd=0.74u as=56.9f ps=0.74u w=0.17u l=0.17u
X6828 cml_tlatch_86.xtail.S1 CKHA3_N cml_tlatch_86.xmux.xp.S1 VSS sg13_lv_nmos ad=89.3f pd=0.85u as=89.3f ps=0.85u w=0.47u l=0.16u
X6829 cml_tlatch_68.xmux.xp.S1 MOT25_N MOT25_P VSS sg13_lv_nmos ad=56.9f pd=0.74u as=56.9f ps=0.74u w=0.17u l=0.17u
X6830 cml_tlatch_9.xtail.S1 CKA0_N cml_tlatch_9.xmux.xp.S1 VSS sg13_lv_nmos ad=89.3f pd=0.85u as=89.3f ps=0.85u w=0.47u l=0.16u
X6831 cml_tlatch_81.xtail.S1 POLN VSS VSS sg13_lv_nmos ad=1.5637p pd=8.61u as=1.5637p ps=8.61u w=8.23u l=0.13u
X6832 cml_tlatch_48.xtail.S1 POLN VSS VSS sg13_lv_nmos ad=1.5637p pd=8.61u as=2.7982p ps=17.14u w=8.23u l=0.13u
X6833 cml_tlatch_59.xmux.xp.S1 MOT30_P MOT30_N VSS sg13_lv_nmos ad=56.9f pd=0.74u as=56.9f ps=0.74u w=0.17u l=0.17u
X6834 cml_tlatch_69.xmux.xp.S1 CKHB3_N cml_tlatch_69.xtail.S1 VSS sg13_lv_nmos ad=89.3f pd=0.85u as=89.3f ps=0.85u w=0.47u l=0.16u
X6835 MOT21_N MOT21_P cml_tlatch_75.xmux.xp.S1 VSS sg13_lv_nmos ad=56.9f pd=0.74u as=56.9f ps=0.74u w=0.17u l=0.17u
X6836 MOT2_N cml_tlatch_8.OUTP cml_tlatch_24.xmux.xn.S1 VSS sg13_lv_nmos ad=63.19999f pd=0.74u as=63.19999f ps=0.74u w=0.26u l=0.38u
X6837 cml_tlatch_47.xmux.xp.S1 cml_tlatch_47.OUTP cml_tlatch_47.OUTN VSS sg13_lv_nmos ad=56.9f pd=0.74u as=56.9f ps=0.74u w=0.17u l=0.17u
X6838 cml_tlatch_11.OUTP cml_tlatch_11.OUTN cml_tlatch_11.xmux.xp.S1 VSS sg13_lv_nmos ad=56.9f pd=0.74u as=56.9f ps=0.74u w=0.17u l=0.17u
X6839 VSS cml_drv_1.xrtail.R1 VSS rppd l=5.65u w=1u
X6840 cml_tlatch_56.INN cml_tlatch_56.INP cml_tlatch_42.xmux.xp.S1 VSS sg13_lv_nmos ad=56.9f pd=0.74u as=56.9f ps=0.74u w=0.17u l=0.17u
X6841 cml_tlatch_0.xmux.xn.S1 CKA1_P cml_tlatch_0.xtail.S1 VSS sg13_lv_nmos ad=89.3f pd=0.85u as=89.3f ps=0.85u w=0.47u l=0.16u
X6842 cml_tlatch_12.xmux.xn.S1 stub_bi_17.BOTN B1_8_N VSS sg13_lv_nmos ad=63.19999f pd=0.74u as=0.1082p ps=1.34u w=0.26u l=0.38u
X6843 cml_tlatch_25.xmux.xp.S1 MOT4_P MOT4_N VSS sg13_lv_nmos ad=56.9f pd=0.74u as=56.9f ps=0.74u w=0.17u l=0.17u
X6844 cml_tlatch_8.xmux.xp.S1 cml_tlatch_8.OUTP cml_tlatch_8.OUTN VSS sg13_lv_nmos ad=56.9f pd=0.74u as=56.9f ps=0.74u w=0.17u l=0.17u
X6845 B1_2_P VDD VSS rppd l=5.17u w=1u
X6846 B3_8_N B3_8_P cml_tlatch_60.xmux.xp.S1 VSS sg13_lv_nmos ad=56.9f pd=0.74u as=56.9f ps=0.74u w=0.17u l=0.17u
X6847 cml_gate2_8.xrtail.R1 NS1_P cml_gate2_8.sg13_lv_nmos_FTPY57_0.D0 VSS sg13_lv_nmos ad=0.1007p pd=0.91u as=0.1007p ps=0.91u w=0.53u l=0.13u
X6848 cml_tlatch_98.xmux.xp.S1 cml_tlatch_98.OUTP cml_tlatch_98.OUTN VSS sg13_lv_nmos ad=56.9f pd=0.74u as=56.9f ps=0.74u w=0.17u l=0.17u
X6849 cml_tlatch_61.OUTN cml_tlatch_61.OUTP cml_tlatch_61.xmux.xp.S1 VSS sg13_lv_nmos ad=56.9f pd=0.74u as=56.9f ps=0.74u w=0.17u l=0.17u
X6850 cml_tlatch_27.xmux.xp.S1 cml_tlatch_27.OUTN cml_tlatch_27.OUTP VSS sg13_lv_nmos ad=56.9f pd=0.74u as=56.9f ps=0.74u w=0.17u l=0.17u
X6851 A3_8_P A3_8_N cml_tlatch_64.xmux.xp.S1 VSS sg13_lv_nmos ad=56.9f pd=0.74u as=56.9f ps=0.74u w=0.17u l=0.17u
X6852 cml_gate2_4.xrtail.R1 CKB2_P cml_gate2_4.sg13_lv_nmos_FTPY57_0.D0 VSS sg13_lv_nmos ad=0.1007p pd=0.91u as=0.1007p ps=0.91u w=0.53u l=0.13u
X6853 cml_tlatch_1.xmux.xn.S1 cml_tlatch_98.OUTP cml_tlatch_1.OUTN VSS sg13_lv_nmos ad=63.19999f pd=0.74u as=0.1082p ps=1.34u w=0.26u l=0.38u
X6854 cml_tlatch_95.xmux.xp.S1 CKA1_P cml_tlatch_95.xtail.S1 VSS sg13_lv_nmos ad=89.3f pd=0.85u as=89.3f ps=0.85u w=0.47u l=0.16u
X6855 cml_tlatch_12.xmux.xp.S1 B1_8_P B1_8_N VSS sg13_lv_nmos ad=56.9f pd=0.74u as=56.9f ps=0.74u w=0.17u l=0.17u
X6856 MOT10_P cml_tlatch_39.INN cml_tlatch_39.xmux.xn.S1 VSS sg13_lv_nmos ad=63.19999f pd=0.74u as=63.19999f ps=0.74u w=0.26u l=0.38u
X6857 cml_tlatch_53.xmux.xp.S1 CKA3_P cml_tlatch_53.xtail.S1 VSS sg13_lv_nmos ad=89.3f pd=0.85u as=89.3f ps=0.85u w=0.47u l=0.16u
X6858 cml_tlatch_51.xmux.xp.S1 MOT22_N MOT22_P VSS sg13_lv_nmos ad=56.9f pd=0.74u as=56.9f ps=0.74u w=0.17u l=0.17u
X6859 cml_tlatch_20.xmux.xp.S1 CKHB0_N cml_tlatch_20.xtail.S1 VSS sg13_lv_nmos ad=89.3f pd=0.85u as=89.3f ps=0.85u w=0.47u l=0.16u
X6860 cml_tlatch_65.xmux.xn.S1 cml_tlatch_57.INN cml_tlatch_65.OUTP VSS sg13_lv_nmos ad=63.19999f pd=0.74u as=63.19999f ps=0.74u w=0.26u l=0.38u
X6861 cml_drvb_2.xrtail.R1 GA0_P CKHA0_N VSS sg13_lv_nmos ad=0.1463p pd=1.15u as=0.2618p ps=2.22u w=0.77u l=0.21u
X6862 cml_tlatch_45.OUTP cml_tlatch_45.OUTN cml_tlatch_45.xmux.xp.S1 VSS sg13_lv_nmos ad=56.9f pd=0.74u as=56.9f ps=0.74u w=0.17u l=0.17u
X6863 cml_tlatch_40.INP cml_tlatch_95.INN cml_tlatch_95.xmux.xn.S1 VSS sg13_lv_nmos ad=63.19999f pd=0.74u as=0.1082p ps=1.34u w=0.26u l=0.38u
X6864 cml_tlatch_56.INP D2_N cml_tlatch_42.xmux.xn.S1 VSS sg13_lv_nmos ad=63.19999f pd=0.74u as=63.19999f ps=0.74u w=0.26u l=0.38u
X6865 cml_tlatch_18.xmux.xn.S1 CKHB0_P cml_tlatch_18.xtail.S1 VSS sg13_lv_nmos ad=89.3f pd=0.85u as=0.1598p ps=1.62u w=0.47u l=0.16u
X6866 cml_tlatch_95.xmux.xn.S1 cml_tlatch_95.INP cml_tlatch_40.INN VSS sg13_lv_nmos ad=63.19999f pd=0.74u as=63.19999f ps=0.74u w=0.26u l=0.38u
X6867 cml_tlatch_63.xmux.xn.S1 cml_tlatch_70.INN cml_tlatch_63.OUTP VSS sg13_lv_nmos ad=0.1082p pd=1.34u as=63.19999f ps=0.74u w=0.26u l=0.38u
X6868 cml_gate2_2.sg13_lv_nmos_FTPY57_0.D0 ENA0_P GA0_N VSS sg13_lv_nmos ad=0.1007p pd=0.91u as=0.1007p ps=0.91u w=0.53u l=0.13u
X6869 cml_tlatch_84.xmux.xp.S1 cml_tlatch_70.INN cml_tlatch_70.INP VSS sg13_lv_nmos ad=56.9f pd=0.74u as=56.9f ps=0.74u w=0.17u l=0.17u
X6870 B1_2_P stub_bi_31.BOTP cml_tlatch_33.xmux.xn.S1 VSS sg13_lv_nmos ad=63.19999f pd=0.74u as=63.19999f ps=0.74u w=0.26u l=0.38u
X6871 cml_tlatch_32.xmux.xp.S1 stub_bi_29.BOTP stub_bi_29.BOTN VSS sg13_lv_nmos ad=56.9f pd=0.74u as=56.9f ps=0.74u w=0.17u l=0.17u
X6872 cml_tlatch_94.xmux.xp.S1 CKB1_P cml_tlatch_94.xtail.S1 VSS sg13_lv_nmos ad=89.3f pd=0.85u as=89.3f ps=0.85u w=0.47u l=0.16u
X6873 J2_P J1_N cml_tlatch_92.xmux.xn.S1 VSS sg13_lv_nmos ad=63.19999f pd=0.74u as=63.19999f ps=0.74u w=0.26u l=0.38u
X6874 cml_tlatch_91.xmux.xp.S1 CLK_W_N CLK_W_P VSS sg13_lv_nmos ad=56.9f pd=0.74u as=56.9f ps=0.74u w=0.17u l=0.17u
X6875 cml_tlatch_63.xmux.xn.S1 cml_tlatch_70.INN cml_tlatch_63.OUTP VSS sg13_lv_nmos ad=63.19999f pd=0.74u as=63.19999f ps=0.74u w=0.26u l=0.38u
X6876 MOT5_P MOT5_N cml_tlatch_19.xmux.xp.S1 VSS sg13_lv_nmos ad=56.9f pd=0.74u as=56.9f ps=0.74u w=0.17u l=0.17u
X6877 cml_drvb_3.xrtail.R1 GA1_N CKHA1_P VSS sg13_lv_nmos ad=0.1463p pd=1.15u as=0.2618p ps=2.22u w=0.77u l=0.21u
X6878 cml_tlatch_13.xmux.xp.S1 stub_bi_17.BOTN stub_bi_17.BOTP VSS sg13_lv_nmos ad=56.9f pd=0.74u as=56.9f ps=0.74u w=0.17u l=0.17u
X6879 cml_tlatch_63.OUTP cml_tlatch_63.OUTN cml_tlatch_63.xmux.xp.S1 VSS sg13_lv_nmos ad=56.9f pd=0.74u as=56.9f ps=0.74u w=0.17u l=0.17u
X6880 cml_tlatch_21.xmux.xp.S1 A1_8_N A1_8_P VSS sg13_lv_nmos ad=0.1019p pd=1.34u as=56.9f ps=0.74u w=0.17u l=0.17u
X6881 cml_tlatch_47.xmux.xn.S1 D3_P cml_tlatch_47.OUTN VSS sg13_lv_nmos ad=63.19999f pd=0.74u as=0.1082p ps=1.34u w=0.26u l=0.38u
X6882 cml_tlatch_78.xmux.xn.S1 CKB2_P cml_tlatch_78.xtail.S1 VSS sg13_lv_nmos ad=89.3f pd=0.85u as=89.3f ps=0.85u w=0.47u l=0.16u
X6883 cml_tlatch_38.xmux.xp.S1 cml_tlatch_38.OUTN cml_tlatch_38.OUTP VSS sg13_lv_nmos ad=56.9f pd=0.74u as=56.9f ps=0.74u w=0.17u l=0.17u
X6884 MOT31_P B3_2_N cml_tlatch_71.xmux.xn.S1 VSS sg13_lv_nmos ad=63.19999f pd=0.74u as=63.19999f ps=0.74u w=0.26u l=0.38u
X6885 cml_tlatch_39.xmux.xp.S1 CKHA1_N cml_tlatch_39.xtail.S1 VSS sg13_lv_nmos ad=89.3f pd=0.85u as=89.3f ps=0.85u w=0.47u l=0.16u
X6886 cml_tlatch_0.xmux.xn.S1 cml_tlatch_40.INN interco_bi_19.INP VSS sg13_lv_nmos ad=63.19999f pd=0.74u as=63.19999f ps=0.74u w=0.26u l=0.38u
X6887 cml_tlatch_89.xmux.xp.S1 cml_tlatch_89.OUTP cml_tlatch_89.OUTN VSS sg13_lv_nmos ad=56.9f pd=0.74u as=56.9f ps=0.74u w=0.17u l=0.17u
X6888 cml_tlatch_99.OUTP cml_tlatch_99.OUTN cml_tlatch_99.xmux.xp.S1 VSS sg13_lv_nmos ad=56.9f pd=0.74u as=56.9f ps=0.74u w=0.17u l=0.17u
X6889 cml_tlatch_65.xmux.xn.S1 CKA3_P cml_tlatch_65.xtail.S1 VSS sg13_lv_nmos ad=89.3f pd=0.85u as=0.1598p ps=1.62u w=0.47u l=0.16u
X6890 cml_tlatch_68.xtail.S1 CKHB3_P cml_tlatch_68.xmux.xn.S1 VSS sg13_lv_nmos ad=89.3f pd=0.85u as=89.3f ps=0.85u w=0.47u l=0.16u
X6891 MOT6_P MOT6_N cml_tlatch_26.xmux.xp.S1 VSS sg13_lv_nmos ad=56.9f pd=0.74u as=56.9f ps=0.74u w=0.17u l=0.17u
X6892 cml_tlatch_26.xmux.xp.S1 CKHA0_N cml_tlatch_26.xtail.S1 VSS sg13_lv_nmos ad=89.3f pd=0.85u as=89.3f ps=0.85u w=0.47u l=0.16u
X6893 cml_tlatch_32.xtail.S1 CKB1_N cml_tlatch_32.xmux.xp.S1 VSS sg13_lv_nmos ad=89.3f pd=0.85u as=89.3f ps=0.85u w=0.47u l=0.16u
X6894 MOT7_N MOT7_P cml_tlatch_20.xmux.xp.S1 VSS sg13_lv_nmos ad=56.9f pd=0.74u as=56.9f ps=0.74u w=0.17u l=0.17u
X6895 VDD J4_N VSS rppd l=5.17u w=1u
X6896 cml_tlatch_63.OUTN cml_tlatch_70.INP cml_tlatch_63.xmux.xn.S1 VSS sg13_lv_nmos ad=63.19999f pd=0.74u as=63.19999f ps=0.74u w=0.26u l=0.38u
X6897 stub_bi_32.BOTP stub_bi_32.BOTN cml_tlatch_48.xmux.xp.S1 VSS sg13_lv_nmos ad=56.9f pd=0.74u as=0.1019p ps=1.34u w=0.17u l=0.17u
X6898 CKHB3_P GB3_N cml_drvb_6.xrtail.R1 VSS sg13_lv_nmos ad=0.2618p pd=2.22u as=0.1463p ps=1.15u w=0.77u l=0.21u
X6899 VSS POLN hs_to_clk_7.D2 VSS sg13_lv_nmos ad=1.9p pd=10.38u as=1.9p ps=10.38u w=10u l=0.13u
X6900 cml_tlatch_24.xmux.xp.S1 MOT2_N MOT2_P VSS sg13_lv_nmos ad=56.9f pd=0.74u as=56.9f ps=0.74u w=0.17u l=0.17u
X6901 cml_tlatch_33.xmux.xp.S1 CKB1_P cml_tlatch_33.xtail.S1 VSS sg13_lv_nmos ad=89.3f pd=0.85u as=89.3f ps=0.85u w=0.47u l=0.16u
X6902 cml_tlatch_91.xmux.xn.S1 CKJ_P cml_tlatch_91.xtail.S1 VSS sg13_lv_nmos ad=89.3f pd=0.85u as=0.1598p ps=1.62u w=0.47u l=0.16u
X6903 cml_tlatch_74.xmux.xn.S1 CKHB2_P cml_tlatch_74.xtail.S1 VSS sg13_lv_nmos ad=89.3f pd=0.85u as=89.3f ps=0.85u w=0.47u l=0.16u
X6904 cml_tlatch_72.xmux.xp.S1 cml_tlatch_83.INP cml_tlatch_83.INN VSS sg13_lv_nmos ad=56.9f pd=0.74u as=56.9f ps=0.74u w=0.17u l=0.17u
X6905 cml_tlatch_82.OUTN cml_tlatch_82.OUTP cml_tlatch_82.xmux.xp.S1 VSS sg13_lv_nmos ad=56.9f pd=0.74u as=0.1019p ps=1.34u w=0.17u l=0.17u
X6906 VSS cml_drvb_2.xrtail.R1 VSS rppd l=2.72u w=1u
X6907 VSS POLN cml_tlatch_34.xtail.S1 VSS sg13_lv_nmos ad=1.5637p pd=8.61u as=1.5637p ps=8.61u w=8.23u l=0.13u
X6908 cml_tlatch_10.xmux.xp.S1 B0_8_P B0_8_N VSS sg13_lv_nmos ad=56.9f pd=0.74u as=56.9f ps=0.74u w=0.17u l=0.17u
X6909 cml_tlatch_8.xtail.S1 CKA0_P cml_tlatch_8.xmux.xp.S1 VSS sg13_lv_nmos ad=89.3f pd=0.85u as=89.3f ps=0.85u w=0.47u l=0.16u
X6910 A3_2_N A3_2_P cml_tlatch_53.xmux.xp.S1 VSS sg13_lv_nmos ad=56.9f pd=0.74u as=56.9f ps=0.74u w=0.17u l=0.17u
X6911 cml_tlatch_41.xmux.xn.S1 A1_2_N MOT14_P VSS sg13_lv_nmos ad=63.19999f pd=0.74u as=0.1082p ps=1.34u w=0.26u l=0.38u
X6912 CLK_W_P CLK_W_N cml_tlatch_91.xmux.xp.S1 VSS sg13_lv_nmos ad=56.9f pd=0.74u as=0.1019p ps=1.34u w=0.17u l=0.17u
X6913 cml_tlatch_30.OUTN cml_tlatch_30.OUTP cml_tlatch_30.xmux.xp.S1 VSS sg13_lv_nmos ad=56.9f pd=0.74u as=56.9f ps=0.74u w=0.17u l=0.17u
X6914 ENA_P NM1_N cml_gate2_9.xrtail.R1 VSS sg13_lv_nmos ad=0.1007p pd=0.91u as=0.1007p ps=0.91u w=0.53u l=0.13u
X6915 GA1_P ENA0_N cml_gate2_3.sg13_lv_nmos_FTPY57_0.D0 VSS sg13_lv_nmos ad=0.1007p pd=0.91u as=0.1007p ps=0.91u w=0.53u l=0.13u
X6916 VDD cml_tlatch_57.INN VSS rppd l=5.17u w=1u
X6917 B2_2_P B2_2_N cml_tlatch_44.xmux.xp.S1 VSS sg13_lv_nmos ad=56.9f pd=0.74u as=56.9f ps=0.74u w=0.17u l=0.17u
X6918 cml_tlatch_2.xmux.xn.S1 CKA0_N cml_tlatch_2.xtail.S1 VSS sg13_lv_nmos ad=89.3f pd=0.85u as=89.3f ps=0.85u w=0.47u l=0.16u
X6919 MOT22_N A2_2_P cml_tlatch_51.xmux.xn.S1 VSS sg13_lv_nmos ad=63.19999f pd=0.74u as=63.19999f ps=0.74u w=0.26u l=0.38u
X6920 cml_tlatch_70.xmux.xp.S1 MOT29_P MOT29_N VSS sg13_lv_nmos ad=56.9f pd=0.74u as=56.9f ps=0.74u w=0.17u l=0.17u
X6921 cml_tlatch_11.xmux.xp.S1 cml_tlatch_11.OUTP cml_tlatch_11.OUTN VSS sg13_lv_nmos ad=56.9f pd=0.74u as=56.9f ps=0.74u w=0.17u l=0.17u
X6922 cml_tlatch_6.xmux.xn.S1 CKHB1_P cml_tlatch_6.xtail.S1 VSS sg13_lv_nmos ad=89.3f pd=0.85u as=89.3f ps=0.85u w=0.47u l=0.16u
X6923 cml_tlatch_55.xmux.xn.S1 CKA2_P cml_tlatch_55.xtail.S1 VSS sg13_lv_nmos ad=89.3f pd=0.85u as=89.3f ps=0.85u w=0.47u l=0.16u
X6924 cml_tlatch_8.xmux.xp.S1 cml_tlatch_8.OUTP cml_tlatch_8.OUTN VSS sg13_lv_nmos ad=0.1019p pd=1.34u as=56.9f ps=0.74u w=0.17u l=0.17u
X6925 cml_tlatch_35.OUTP D0_N cml_tlatch_35.xmux.xn.S1 VSS sg13_lv_nmos ad=0.1082p pd=1.34u as=63.19999f ps=0.74u w=0.26u l=0.38u
X6926 cml_gate2_6.sg13_lv_nmos_FTPY57_0.D0 CKA3_P cml_gate2_6.xrtail.R1 VSS sg13_lv_nmos ad=0.1007p pd=0.91u as=0.1007p ps=0.91u w=0.53u l=0.13u
X6927 cml_tlatch_45.xmux.xn.S1 B3_2_N cml_tlatch_45.OUTP VSS sg13_lv_nmos ad=63.19999f pd=0.74u as=63.19999f ps=0.74u w=0.26u l=0.38u
X6928 MOT13_N MOT13_P cml_tlatch_6.xmux.xp.S1 VSS sg13_lv_nmos ad=56.9f pd=0.74u as=56.9f ps=0.74u w=0.17u l=0.17u
X6929 cml_tlatch_35.OUTP D0_N cml_tlatch_35.xmux.xn.S1 VSS sg13_lv_nmos ad=63.19999f pd=0.74u as=63.19999f ps=0.74u w=0.26u l=0.38u
X6930 cml_tlatch_80.xmux.xp.S1 stub_bi_49.BOTP stub_bi_49.BOTN VSS sg13_lv_nmos ad=56.9f pd=0.74u as=56.9f ps=0.74u w=0.17u l=0.17u
X6931 cml_tlatch_35.xtail.S1 CKA0_P cml_tlatch_35.xmux.xn.S1 VSS sg13_lv_nmos ad=89.3f pd=0.85u as=89.3f ps=0.85u w=0.47u l=0.16u
X6932 cml_tlatch_23.xmux.xn.S1 interco_bi_19.INN cml_tlatch_39.INP VSS sg13_lv_nmos ad=63.19999f pd=0.74u as=63.19999f ps=0.74u w=0.26u l=0.38u
X6933 cml_tlatch_83.xmux.xp.S1 cml_tlatch_83.OUTN cml_tlatch_83.OUTP VSS sg13_lv_nmos ad=56.9f pd=0.74u as=56.9f ps=0.74u w=0.17u l=0.17u
X6934 MOT26_P VDD VSS rppd l=5.17u w=1u
X6935 cml_tlatch_22.xmux.xp.S1 CKA1_N cml_tlatch_22.xtail.S1 VSS sg13_lv_nmos ad=89.3f pd=0.85u as=89.3f ps=0.85u w=0.47u l=0.16u
X6936 cml_tlatch_37.xmux.xp.S1 A1_2_P A1_2_N VSS sg13_lv_nmos ad=56.9f pd=0.74u as=56.9f ps=0.74u w=0.17u l=0.17u
X6937 cml_tlatch_77.xmux.xn.S1 CKB2_N cml_tlatch_77.xtail.S1 VSS sg13_lv_nmos ad=89.3f pd=0.85u as=89.3f ps=0.85u w=0.47u l=0.16u
X6938 cml_tlatch_10.xmux.xp.S1 B0_8_N B0_8_P VSS sg13_lv_nmos ad=0.1019p pd=1.34u as=56.9f ps=0.74u w=0.17u l=0.17u
X6939 cml_tlatch_25.xmux.xn.S1 CKHA0_P cml_tlatch_25.xtail.S1 VSS sg13_lv_nmos ad=89.3f pd=0.85u as=89.3f ps=0.85u w=0.47u l=0.16u
X6940 cml_tlatch_49.xtail.S1 CKHA2_P cml_tlatch_49.xmux.xn.S1 VSS sg13_lv_nmos ad=89.3f pd=0.85u as=89.3f ps=0.85u w=0.47u l=0.16u
X6941 cml_tlatch_51.xmux.xp.S1 MOT22_N MOT22_P VSS sg13_lv_nmos ad=56.9f pd=0.74u as=56.9f ps=0.74u w=0.17u l=0.17u
X6942 cml_tlatch_64.xmux.xn.S1 CKA3_N cml_tlatch_64.xtail.S1 VSS sg13_lv_nmos ad=89.3f pd=0.85u as=89.3f ps=0.85u w=0.47u l=0.16u
X6943 cml_tlatch_82.OUTN cml_tlatch_82.OUTP cml_tlatch_82.xmux.xp.S1 VSS sg13_lv_nmos ad=56.9f pd=0.74u as=56.9f ps=0.74u w=0.17u l=0.17u
X6944 cml_tlatch_95.INN cml_tlatch_95.INP cml_tlatch_36.xmux.xp.S1 VSS sg13_lv_nmos ad=56.9f pd=0.74u as=56.9f ps=0.74u w=0.17u l=0.17u
X6945 cml_tlatch_76.xmux.xp.S1 MOT23_P MOT23_N VSS sg13_lv_nmos ad=56.9f pd=0.74u as=56.9f ps=0.74u w=0.17u l=0.17u
X6946 cml_tlatch_27.xtail.S1 CKB0_N cml_tlatch_27.xmux.xp.S1 VSS sg13_lv_nmos ad=89.3f pd=0.85u as=89.3f ps=0.85u w=0.47u l=0.16u
X6947 cml_tlatch_16.xmux.xn.S1 cml_tlatch_1.OUTN cml_tlatch_16.OUTP VSS sg13_lv_nmos ad=63.19999f pd=0.74u as=63.19999f ps=0.74u w=0.26u l=0.38u
X6948 VSS hs_to_clk_8.sg13_lv_nmos_2HGZLP_0.G VSS VSS sg13_lv_nmos ad=2.071p pd=11.28u as=0 ps=0 w=10.9u l=1.38u
X6949 cml_tlatch_45.OUTN B3_2_P cml_tlatch_45.xmux.xn.S1 VSS sg13_lv_nmos ad=63.19999f pd=0.74u as=63.19999f ps=0.74u w=0.26u l=0.38u
X6950 cml_tlatch_23.xmux.xn.S1 CKA1_N cml_tlatch_23.xtail.S1 VSS sg13_lv_nmos ad=89.3f pd=0.85u as=89.3f ps=0.85u w=0.47u l=0.16u
X6951 cml_tlatch_41.xmux.xp.S1 MOT14_N MOT14_P VSS sg13_lv_nmos ad=56.9f pd=0.74u as=56.9f ps=0.74u w=0.17u l=0.17u
X6952 cml_tlatch_13.xmux.xp.S1 CKB1_N cml_tlatch_13.xtail.S1 VSS sg13_lv_nmos ad=89.3f pd=0.85u as=89.3f ps=0.85u w=0.47u l=0.16u
X6953 MOT29_N MOT29_P cml_tlatch_70.xmux.xp.S1 VSS sg13_lv_nmos ad=56.9f pd=0.74u as=56.9f ps=0.74u w=0.17u l=0.17u
X6954 interco_bi_19.INN interco_bi_19.INP cml_tlatch_0.xmux.xp.S1 VSS sg13_lv_nmos ad=56.9f pd=0.74u as=56.9f ps=0.74u w=0.17u l=0.17u
X6955 cml_tlatch_82.xmux.xp.S1 cml_tlatch_82.OUTN cml_tlatch_82.OUTP VSS sg13_lv_nmos ad=56.9f pd=0.74u as=56.9f ps=0.74u w=0.17u l=0.17u
X6956 cml_tlatch_50.xmux.xp.S1 MOT20_N MOT20_P VSS sg13_lv_nmos ad=56.9f pd=0.74u as=56.9f ps=0.74u w=0.17u l=0.17u
X6957 cml_tlatch_99.OUTP cml_tlatch_99.OUTN cml_tlatch_99.xmux.xp.S1 VSS sg13_lv_nmos ad=56.9f pd=0.74u as=56.9f ps=0.74u w=0.17u l=0.17u
X6958 cml_tlatch_52.xmux.xp.S1 CKA3_N cml_tlatch_52.xtail.S1 VSS sg13_lv_nmos ad=89.3f pd=0.85u as=89.3f ps=0.85u w=0.47u l=0.16u
X6959 cml_tlatch_59.xtail.S1 CKHA3_P cml_tlatch_59.xmux.xn.S1 VSS sg13_lv_nmos ad=89.3f pd=0.85u as=89.3f ps=0.85u w=0.47u l=0.16u
X6960 cml_tlatch_14.xmux.xn.S1 CKB1_N cml_tlatch_14.xtail.S1 VSS sg13_lv_nmos ad=89.3f pd=0.85u as=89.3f ps=0.85u w=0.47u l=0.16u
X6961 hs_to_clk_4.D2 POLN VSS VSS sg13_lv_nmos ad=3.4p pd=20.68u as=1.9p ps=10.38u w=10u l=0.13u
X6962 cml_tlatch_74.xmux.xp.S1 MOT19_N MOT19_P VSS sg13_lv_nmos ad=56.9f pd=0.74u as=56.9f ps=0.74u w=0.17u l=0.17u
X6963 cml_tlatch_80.xmux.xp.S1 stub_bi_49.BOTP stub_bi_49.BOTN VSS sg13_lv_nmos ad=56.9f pd=0.74u as=56.9f ps=0.74u w=0.17u l=0.17u
X6964 MOT7_N MOT7_P cml_tlatch_20.xmux.xp.S1 VSS sg13_lv_nmos ad=56.9f pd=0.74u as=56.9f ps=0.74u w=0.17u l=0.17u
X6965 MOT27_P MOT27_N cml_tlatch_69.xmux.xp.S1 VSS sg13_lv_nmos ad=56.9f pd=0.74u as=56.9f ps=0.74u w=0.17u l=0.17u
X6966 cml_tlatch_40.INN cml_tlatch_40.INP cml_tlatch_95.xmux.xp.S1 VSS sg13_lv_nmos ad=56.9f pd=0.74u as=56.9f ps=0.74u w=0.17u l=0.17u
X6967 cml_tlatch_53.xmux.xp.S1 A3_2_N A3_2_P VSS sg13_lv_nmos ad=56.9f pd=0.74u as=56.9f ps=0.74u w=0.17u l=0.17u
X6968 cml_tlatch_29.OUTN cml_tlatch_29.OUTP cml_tlatch_29.xmux.xp.S1 VSS sg13_lv_nmos ad=56.9f pd=0.74u as=56.9f ps=0.74u w=0.17u l=0.17u
X6969 cml_tlatch_45.xmux.xp.S1 CKB3_N cml_tlatch_45.xtail.S1 VSS sg13_lv_nmos ad=89.3f pd=0.85u as=89.3f ps=0.85u w=0.47u l=0.16u
X6970 stub_bi_63.BOTP stub_bi_49.BOTN cml_tlatch_79.xmux.xn.S1 VSS sg13_lv_nmos ad=63.19999f pd=0.74u as=63.19999f ps=0.74u w=0.26u l=0.38u
X6971 cml_tlatch_83.OUTN cml_tlatch_83.OUTP cml_tlatch_83.xmux.xp.S1 VSS sg13_lv_nmos ad=56.9f pd=0.74u as=56.9f ps=0.74u w=0.17u l=0.17u
X6972 cml_tlatch_79.xmux.xp.S1 stub_bi_63.BOTN stub_bi_63.BOTP VSS sg13_lv_nmos ad=56.9f pd=0.74u as=56.9f ps=0.74u w=0.17u l=0.17u
X6973 cml_tlatch_79.xmux.xp.S1 stub_bi_63.BOTP stub_bi_63.BOTN VSS sg13_lv_nmos ad=56.9f pd=0.74u as=56.9f ps=0.74u w=0.17u l=0.17u
X6974 cml_tlatch_10.xmux.xp.S1 B0_8_P B0_8_N VSS sg13_lv_nmos ad=56.9f pd=0.74u as=56.9f ps=0.74u w=0.17u l=0.17u
X6975 A1_2_P A1_2_N cml_tlatch_37.xmux.xp.S1 VSS sg13_lv_nmos ad=56.9f pd=0.74u as=56.9f ps=0.74u w=0.17u l=0.17u
X6976 stub_bi_55.BOTN stub_bi_55.BOTP cml_tlatch_88.xmux.xp.S1 VSS sg13_lv_nmos ad=56.9f pd=0.74u as=56.9f ps=0.74u w=0.17u l=0.17u
X6977 MOT3_N MOT3_P cml_tlatch_18.xmux.xp.S1 VSS sg13_lv_nmos ad=56.9f pd=0.74u as=56.9f ps=0.74u w=0.17u l=0.17u
X6978 MOT18_N MOT18_P cml_tlatch_49.xmux.xp.S1 VSS sg13_lv_nmos ad=56.9f pd=0.74u as=56.9f ps=0.74u w=0.17u l=0.17u
X6979 cml_tlatch_30.OUTN cml_tlatch_30.OUTP cml_tlatch_30.xmux.xp.S1 VSS sg13_lv_nmos ad=56.9f pd=0.74u as=56.9f ps=0.74u w=0.17u l=0.17u
X6980 MOT16_P MOT16_N cml_tlatch_87.xmux.xp.S1 VSS sg13_lv_nmos ad=56.9f pd=0.74u as=56.9f ps=0.74u w=0.17u l=0.17u
X6981 VDD MOT23_N VSS rppd l=5.17u w=1u
X6982 cml_tlatch_44.xmux.xn.S1 CKB2_N cml_tlatch_44.xtail.S1 VSS sg13_lv_nmos ad=89.3f pd=0.85u as=89.3f ps=0.85u w=0.47u l=0.16u
X6983 cml_tlatch_86.xmux.xp.S1 MOT24_N MOT24_P VSS sg13_lv_nmos ad=56.9f pd=0.74u as=56.9f ps=0.74u w=0.17u l=0.17u
X6984 cml_tlatch_95.xmux.xn.S1 CKA1_N cml_tlatch_95.xtail.S1 VSS sg13_lv_nmos ad=89.3f pd=0.85u as=89.3f ps=0.85u w=0.47u l=0.16u
X6985 cml_tlatch_53.xmux.xn.S1 CKA3_N cml_tlatch_53.xtail.S1 VSS sg13_lv_nmos ad=89.3f pd=0.85u as=89.3f ps=0.85u w=0.47u l=0.16u
X6986 A3_8_N cml_tlatch_65.OUTP cml_tlatch_64.xmux.xn.S1 VSS sg13_lv_nmos ad=0.1082p pd=1.34u as=63.19999f ps=0.74u w=0.26u l=0.38u
X6987 cml_tlatch_28.xmux.xp.S1 B0_2_N B0_2_P VSS sg13_lv_nmos ad=56.9f pd=0.74u as=56.9f ps=0.74u w=0.17u l=0.17u
X6988 cml_tlatch_0.xtail.S1 CKA1_N cml_tlatch_0.xmux.xp.S1 VSS sg13_lv_nmos ad=89.3f pd=0.85u as=89.3f ps=0.85u w=0.47u l=0.16u
X6989 cml_tlatch_11.xmux.xn.S1 cml_tlatch_16.OUTP cml_tlatch_11.OUTN VSS sg13_lv_nmos ad=0.1082p pd=1.34u as=63.19999f ps=0.74u w=0.26u l=0.38u
X6990 cml_tlatch_76.xmux.xp.S1 MOT23_N MOT23_P VSS sg13_lv_nmos ad=56.9f pd=0.74u as=56.9f ps=0.74u w=0.17u l=0.17u
X6991 cml_tlatch_77.xmux.xp.S1 B2_8_P B2_8_N VSS sg13_lv_nmos ad=56.9f pd=0.74u as=56.9f ps=0.74u w=0.17u l=0.17u
X6992 MOT8_N MOT8_P cml_tlatch_96.xmux.xp.S1 VSS sg13_lv_nmos ad=56.9f pd=0.74u as=56.9f ps=0.74u w=0.17u l=0.17u
X6993 cml_tlatch_93.xtail.S1 CKJ_N cml_tlatch_93.xmux.xp.S1 VSS sg13_lv_nmos ad=89.3f pd=0.85u as=89.3f ps=0.85u w=0.47u l=0.16u
X6994 A1_2_P A1_2_N cml_tlatch_37.xmux.xp.S1 VSS sg13_lv_nmos ad=56.9f pd=0.74u as=56.9f ps=0.74u w=0.17u l=0.17u
X6995 cml_tlatch_67.xmux.xp.S1 cml_tlatch_67.OUTP cml_tlatch_67.OUTN VSS sg13_lv_nmos ad=56.9f pd=0.74u as=56.9f ps=0.74u w=0.17u l=0.17u
X6996 cml_tlatch_26.xtail.S1 CKHA0_N cml_tlatch_26.xmux.xp.S1 VSS sg13_lv_nmos ad=89.3f pd=0.85u as=89.3f ps=0.85u w=0.47u l=0.16u
X6997 cml_tlatch_45.xmux.xp.S1 cml_tlatch_45.OUTP cml_tlatch_45.OUTN VSS sg13_lv_nmos ad=56.9f pd=0.74u as=56.9f ps=0.74u w=0.17u l=0.17u
X6998 MOT15_N MOT15_P cml_tlatch_7.xmux.xp.S1 VSS sg13_lv_nmos ad=56.9f pd=0.74u as=0.1019p ps=1.34u w=0.17u l=0.17u
X6999 VDD CLK_W_N VSS rppd l=5.17u w=1u
X7000 cml_tlatch_42.xmux.xp.S1 cml_tlatch_56.INN cml_tlatch_56.INP VSS sg13_lv_nmos ad=56.9f pd=0.74u as=56.9f ps=0.74u w=0.17u l=0.17u
X7001 cml_tlatch_8.OUTP cml_tlatch_8.OUTN cml_tlatch_8.xmux.xp.S1 VSS sg13_lv_nmos ad=56.9f pd=0.74u as=56.9f ps=0.74u w=0.17u l=0.17u
X7002 cml_tlatch_39.xmux.xn.S1 CKHA1_P cml_tlatch_39.xtail.S1 VSS sg13_lv_nmos ad=89.3f pd=0.85u as=89.3f ps=0.85u w=0.47u l=0.16u
X7003 cml_tlatch_74.xtail.S1 CKHB2_P cml_tlatch_74.xmux.xn.S1 VSS sg13_lv_nmos ad=89.3f pd=0.85u as=89.3f ps=0.85u w=0.47u l=0.16u
X7004 cml_gate2_1.xrtail.R1 CKA0_N GB0_P VSS sg13_lv_nmos ad=0.1007p pd=0.91u as=0.1007p ps=0.91u w=0.53u l=0.13u
X7005 CKHB1_N VDD VSS rppd l=13.09u w=1u
X7006 MOT24_P A3_8_N cml_tlatch_86.xmux.xn.S1 VSS sg13_lv_nmos ad=63.19999f pd=0.74u as=63.19999f ps=0.74u w=0.26u l=0.38u
X7007 cml_tlatch_15.xmux.xp.S1 stub_bi_19.BOTN stub_bi_19.BOTP VSS sg13_lv_nmos ad=56.9f pd=0.74u as=56.9f ps=0.74u w=0.17u l=0.17u
X7008 cml_tlatch_43.xmux.xp.S1 stub_bi_42.BOTP stub_bi_42.BOTN VSS sg13_lv_nmos ad=56.9f pd=0.74u as=56.9f ps=0.74u w=0.17u l=0.17u
X7009 cml_tlatch_70.xmux.xp.S1 MOT29_N MOT29_P VSS sg13_lv_nmos ad=0.1019p pd=1.34u as=56.9f ps=0.74u w=0.17u l=0.17u
X7010 MOT4_N MOT4_P cml_tlatch_25.xmux.xp.S1 VSS sg13_lv_nmos ad=56.9f pd=0.74u as=0.1019p ps=1.34u w=0.17u l=0.17u
X7011 cml_tlatch_20.xmux.xp.S1 CKHB0_N cml_tlatch_20.xtail.S1 VSS sg13_lv_nmos ad=89.3f pd=0.85u as=89.3f ps=0.85u w=0.47u l=0.16u
X7012 A3_8_N A3_8_P cml_tlatch_64.xmux.xp.S1 VSS sg13_lv_nmos ad=56.9f pd=0.74u as=0.1019p ps=1.34u w=0.17u l=0.17u
X7013 cml_tlatch_85.xmux.xp.S1 cml_tlatch_58.INP cml_tlatch_58.INN VSS sg13_lv_nmos ad=56.9f pd=0.74u as=56.9f ps=0.74u w=0.17u l=0.17u
X7014 cml_tlatch_9.xmux.xp.S1 cml_tlatch_9.OUTP cml_tlatch_9.OUTN VSS sg13_lv_nmos ad=56.9f pd=0.74u as=56.9f ps=0.74u w=0.17u l=0.17u
X7015 cml_tlatch_69.xtail.S1 CKHB3_P cml_tlatch_69.xmux.xn.S1 VSS sg13_lv_nmos ad=89.3f pd=0.85u as=89.3f ps=0.85u w=0.47u l=0.16u
X7016 cml_tlatch_54.xtail.S1 CKA3_N cml_tlatch_54.xmux.xp.S1 VSS sg13_lv_nmos ad=89.3f pd=0.85u as=89.3f ps=0.85u w=0.47u l=0.16u
X7017 MOT28_N cml_tlatch_58.INP cml_tlatch_58.xmux.xn.S1 VSS sg13_lv_nmos ad=63.19999f pd=0.74u as=63.19999f ps=0.74u w=0.26u l=0.38u
X7018 cml_tlatch_54.xmux.xp.S1 cml_tlatch_54.OUTP cml_tlatch_54.OUTN VSS sg13_lv_nmos ad=56.9f pd=0.74u as=56.9f ps=0.74u w=0.17u l=0.17u
X7019 cml_tlatch_51.xtail.S1 CKHA2_N cml_tlatch_51.xmux.xp.S1 VSS sg13_lv_nmos ad=89.3f pd=0.85u as=89.3f ps=0.85u w=0.47u l=0.16u
X7020 ENA1_N ENA_P cml_drv_1.xrtail.R1 VSS sg13_lv_nmos ad=56.2f pd=0.74u as=56.2f ps=0.74u w=0.16u l=0.19u
X7021 stub_bi_55.BOTP stub_bi_42.BOTN cml_tlatch_88.xmux.xn.S1 VSS sg13_lv_nmos ad=63.19999f pd=0.74u as=63.19999f ps=0.74u w=0.26u l=0.38u
X7022 cml_tlatch_94.xmux.xp.S1 CKB1_P cml_tlatch_94.xtail.S1 VSS sg13_lv_nmos ad=89.3f pd=0.85u as=89.3f ps=0.85u w=0.47u l=0.16u
X7023 VSS hs_to_clk_0.sg13_lv_nmos_2HGZLP_0.G VSS VSS sg13_lv_nmos ad=2.071p pd=11.28u as=0 ps=0 w=10.9u l=1.38u
X7024 cml_tlatch_46.xmux.xp.S1 CKB3_P cml_tlatch_46.xtail.S1 VSS sg13_lv_nmos ad=89.3f pd=0.85u as=89.3f ps=0.85u w=0.47u l=0.16u
X7025 cml_tlatch_49.xmux.xp.S1 MOT18_N MOT18_P VSS sg13_lv_nmos ad=56.9f pd=0.74u as=56.9f ps=0.74u w=0.17u l=0.17u
X7026 MOT21_P stub_bi_55.BOTP cml_tlatch_75.xmux.xn.S1 VSS sg13_lv_nmos ad=63.19999f pd=0.74u as=63.19999f ps=0.74u w=0.26u l=0.38u
X7027 cml_tlatch_74.xmux.xp.S1 MOT19_P MOT19_N VSS sg13_lv_nmos ad=56.9f pd=0.74u as=56.9f ps=0.74u w=0.17u l=0.17u
X7028 B0_2_N B0_2_P cml_tlatch_28.xmux.xp.S1 VSS sg13_lv_nmos ad=56.9f pd=0.74u as=56.9f ps=0.74u w=0.17u l=0.17u
X7029 cml_tlatch_72.xmux.xn.S1 CKA2_P cml_tlatch_72.xtail.S1 VSS sg13_lv_nmos ad=89.3f pd=0.85u as=0.1598p ps=1.62u w=0.47u l=0.16u
X7030 cml_tlatch_52.OUTP cml_tlatch_52.OUTN cml_tlatch_52.xmux.xp.S1 VSS sg13_lv_nmos ad=56.9f pd=0.74u as=0.1019p ps=1.34u w=0.17u l=0.17u
X7031 MOT26_P MOT26_N cml_tlatch_57.xmux.xp.S1 VSS sg13_lv_nmos ad=56.9f pd=0.74u as=56.9f ps=0.74u w=0.17u l=0.17u
X7032 cml_tlatch_99.xmux.xp.S1 cml_tlatch_99.OUTP cml_tlatch_99.OUTN VSS sg13_lv_nmos ad=56.9f pd=0.74u as=56.9f ps=0.74u w=0.17u l=0.17u
X7033 cml_tlatch_98.xtail.S1 POLN VSS VSS sg13_lv_nmos ad=1.5637p pd=8.61u as=2.7982p ps=17.14u w=8.23u l=0.13u
X7034 GB1_N ENB1_P cml_gate2_0.sg13_lv_nmos_FTPY57_0.D0 VSS sg13_lv_nmos ad=0.1007p pd=0.91u as=0.1007p ps=0.91u w=0.53u l=0.13u
X7035 cml_gate2_7.sg13_lv_nmos_FTPY57_0.D0 ENB0_N GB2_P VSS sg13_lv_nmos ad=0.1802p pd=1.74u as=0.1007p ps=0.91u w=0.53u l=0.13u
X7036 cml_tlatch_34.xmux.xp.S1 stub_bi_31.BOTN stub_bi_31.BOTP VSS sg13_lv_nmos ad=56.9f pd=0.74u as=56.9f ps=0.74u w=0.17u l=0.17u
X7037 cml_tlatch_49.xmux.xn.S1 CKHA2_P cml_tlatch_49.xtail.S1 VSS sg13_lv_nmos ad=89.3f pd=0.85u as=89.3f ps=0.85u w=0.47u l=0.16u
X7038 A2_8_P A2_8_N cml_tlatch_81.xmux.xp.S1 VSS sg13_lv_nmos ad=56.9f pd=0.74u as=56.9f ps=0.74u w=0.17u l=0.17u
X7039 cml_tlatch_39.xmux.xp.S1 MOT10_P MOT10_N VSS sg13_lv_nmos ad=56.9f pd=0.74u as=56.9f ps=0.74u w=0.17u l=0.17u
X7040 cml_tlatch_53.xmux.xp.S1 A3_2_N A3_2_P VSS sg13_lv_nmos ad=56.9f pd=0.74u as=56.9f ps=0.74u w=0.17u l=0.17u
X7041 cml_tlatch_86.xmux.xp.S1 MOT24_P MOT24_N VSS sg13_lv_nmos ad=56.9f pd=0.74u as=56.9f ps=0.74u w=0.17u l=0.17u
X7042 cml_tlatch_22.xmux.xp.S1 cml_tlatch_22.OUTP cml_tlatch_22.OUTN VSS sg13_lv_nmos ad=56.9f pd=0.74u as=56.9f ps=0.74u w=0.17u l=0.17u
X7043 VDD MOT17_N VSS rppd l=5.17u w=1u
X7044 B3_2_P B3_2_N cml_tlatch_46.xmux.xp.S1 VSS sg13_lv_nmos ad=56.9f pd=0.74u as=56.9f ps=0.74u w=0.17u l=0.17u
X7045 cml_tlatch_3.xtail.S1 CKA0_P cml_tlatch_3.xmux.xn.S1 VSS sg13_lv_nmos ad=89.3f pd=0.85u as=89.3f ps=0.85u w=0.47u l=0.16u
X7046 stub_bi_31.BOTN VDD VSS rppd l=5.17u w=1u
X7047 cml_tlatch_72.xmux.xn.S1 cml_tlatch_89.OUTN cml_tlatch_83.INP VSS sg13_lv_nmos ad=63.19999f pd=0.74u as=63.19999f ps=0.74u w=0.26u l=0.38u
X7048 MOT22_P A2_2_N cml_tlatch_51.xmux.xn.S1 VSS sg13_lv_nmos ad=0.1082p pd=1.34u as=63.19999f ps=0.74u w=0.26u l=0.38u
X7049 cml_tlatch_79.xmux.xp.S1 stub_bi_63.BOTN stub_bi_63.BOTP VSS sg13_lv_nmos ad=56.9f pd=0.74u as=56.9f ps=0.74u w=0.17u l=0.17u
X7050 cml_tlatch_99.xtail.S1 CKA0_N cml_tlatch_99.xmux.xn.S1 VSS sg13_lv_nmos ad=89.3f pd=0.85u as=89.3f ps=0.85u w=0.47u l=0.16u
X7051 cml_tlatch_39.INP cml_tlatch_39.INN cml_tlatch_23.xmux.xp.S1 VSS sg13_lv_nmos ad=56.9f pd=0.74u as=56.9f ps=0.74u w=0.17u l=0.17u
X7052 cml_tlatch_73.xmux.xp.S1 MOT17_N MOT17_P VSS sg13_lv_nmos ad=56.9f pd=0.74u as=56.9f ps=0.74u w=0.17u l=0.17u
X7053 cml_tlatch_22.xtail.S1 POLN VSS VSS sg13_lv_nmos ad=1.5637p pd=8.61u as=2.7982p ps=17.14u w=8.23u l=0.13u
X7054 cml_gate2_5.sg13_lv_nmos_FTPY57_0.D0 ENA1_N GA3_P VSS sg13_lv_nmos ad=0.1007p pd=0.91u as=0.1007p ps=0.91u w=0.53u l=0.13u
X7055 MOT3_N MOT3_P cml_tlatch_18.xmux.xp.S1 VSS sg13_lv_nmos ad=56.9f pd=0.74u as=56.9f ps=0.74u w=0.17u l=0.17u
X7056 cml_tlatch_33.xmux.xp.S1 B1_2_N B1_2_P VSS sg13_lv_nmos ad=56.9f pd=0.74u as=56.9f ps=0.74u w=0.17u l=0.17u
X7057 VSS POLN cml_tlatch_12.xtail.S1 VSS sg13_lv_nmos ad=2.7982p pd=17.14u as=1.5637p ps=8.61u w=8.23u l=0.13u
X7058 cml_gate2_8.sg13_lv_nmos_FTPY57_0.D0 NS1_P cml_gate2_8.xrtail.R1 VSS sg13_lv_nmos ad=0.1007p pd=0.91u as=0.1802p ps=1.74u w=0.53u l=0.13u
X7059 VSS hs_to_clk_6.sg13_lv_nmos_2HGZLP_0.G VSS VSS sg13_lv_nmos ad=2.071p pd=11.28u as=0 ps=0 w=10.9u l=1.38u
X7060 cml_tlatch_57.xmux.xn.S1 CKHA3_P cml_tlatch_57.xtail.S1 VSS sg13_lv_nmos ad=89.3f pd=0.85u as=89.3f ps=0.85u w=0.47u l=0.16u
X7061 cml_tlatch_1.xmux.xp.S1 cml_tlatch_1.OUTN cml_tlatch_1.OUTP VSS sg13_lv_nmos ad=56.9f pd=0.74u as=56.9f ps=0.74u w=0.17u l=0.17u
X7062 cml_tlatch_22.xmux.xn.S1 CKA1_P cml_tlatch_22.xtail.S1 VSS sg13_lv_nmos ad=89.3f pd=0.85u as=89.3f ps=0.85u w=0.47u l=0.16u
X7063 cml_tlatch_67.OUTP cml_tlatch_67.OUTN cml_tlatch_67.xmux.xp.S1 VSS sg13_lv_nmos ad=56.9f pd=0.74u as=56.9f ps=0.74u w=0.17u l=0.17u
X7064 cml_tlatch_41.xtail.S1 CKHA1_N cml_tlatch_41.xmux.xp.S1 VSS sg13_lv_nmos ad=89.3f pd=0.85u as=89.3f ps=0.85u w=0.47u l=0.16u
X7065 cml_tlatch_16.xmux.xp.S1 cml_tlatch_16.OUTN cml_tlatch_16.OUTP VSS sg13_lv_nmos ad=56.9f pd=0.74u as=56.9f ps=0.74u w=0.17u l=0.17u
X7066 cml_tlatch_57.xmux.xn.S1 cml_tlatch_57.INP MOT26_N VSS sg13_lv_nmos ad=63.19999f pd=0.74u as=63.19999f ps=0.74u w=0.26u l=0.38u
X7067 cml_tlatch_92.xmux.xn.S1 J1_N J2_P VSS sg13_lv_nmos ad=63.19999f pd=0.74u as=63.19999f ps=0.74u w=0.26u l=0.38u
X7068 ENB_N J2_P cml_gate2_8.sg13_lv_nmos_FTPY57_0.D0 VSS sg13_lv_nmos ad=0.1007p pd=0.91u as=0.1007p ps=0.91u w=0.53u l=0.13u
X7069 cml_tlatch_83.INN cml_tlatch_89.OUTP cml_tlatch_72.xmux.xn.S1 VSS sg13_lv_nmos ad=63.19999f pd=0.74u as=0.1082p ps=1.34u w=0.26u l=0.38u
X7070 cml_tlatch_57.xmux.xn.S1 cml_tlatch_57.INP MOT26_N VSS sg13_lv_nmos ad=63.19999f pd=0.74u as=63.19999f ps=0.74u w=0.26u l=0.38u
X7071 cml_tlatch_0.xmux.xp.S1 interco_bi_19.INN interco_bi_19.INP VSS sg13_lv_nmos ad=56.9f pd=0.74u as=56.9f ps=0.74u w=0.17u l=0.17u
X7072 cml_tlatch_32.xmux.xn.S1 B1_2_P stub_bi_29.BOTP VSS sg13_lv_nmos ad=63.19999f pd=0.74u as=63.19999f ps=0.74u w=0.26u l=0.38u
X7073 cml_tlatch_89.INN cml_tlatch_89.INP cml_tlatch_55.xmux.xp.S1 VSS sg13_lv_nmos ad=56.9f pd=0.74u as=56.9f ps=0.74u w=0.17u l=0.17u
X7074 cml_tlatch_55.xmux.xn.S1 CKA2_P cml_tlatch_55.xtail.S1 VSS sg13_lv_nmos ad=89.3f pd=0.85u as=89.3f ps=0.85u w=0.47u l=0.16u
X7075 stub_bi_19.BOTN stub_bi_19.BOTP cml_tlatch_15.xmux.xp.S1 VSS sg13_lv_nmos ad=56.9f pd=0.74u as=56.9f ps=0.74u w=0.17u l=0.17u
X7076 stub_bi_31.BOTN D1_N cml_tlatch_34.xmux.xn.S1 VSS sg13_lv_nmos ad=63.19999f pd=0.74u as=63.19999f ps=0.74u w=0.26u l=0.38u
X7077 cml_tlatch_6.INN cml_tlatch_6.INP cml_tlatch_94.xmux.xp.S1 VSS sg13_lv_nmos ad=56.9f pd=0.74u as=56.9f ps=0.74u w=0.17u l=0.17u
X7078 cml_tlatch_90.xmux.xp.S1 J4_P J4_N VSS sg13_lv_nmos ad=56.9f pd=0.74u as=56.9f ps=0.74u w=0.17u l=0.17u
X7079 cml_tlatch_30.xmux.xn.S1 CKA0_P cml_tlatch_30.xtail.S1 VSS sg13_lv_nmos ad=89.3f pd=0.85u as=89.3f ps=0.85u w=0.47u l=0.16u
X7080 cml_tlatch_2.xtail.S1 CKA0_P cml_tlatch_2.xmux.xp.S1 VSS sg13_lv_nmos ad=89.3f pd=0.85u as=89.3f ps=0.85u w=0.47u l=0.16u
X7081 VSS POLN cml_tlatch_45.xtail.S1 VSS sg13_lv_nmos ad=1.5637p pd=8.61u as=1.5637p ps=8.61u w=8.23u l=0.13u
X7082 MOT3_P cml_tlatch_16.OUTN cml_tlatch_18.xmux.xn.S1 VSS sg13_lv_nmos ad=63.19999f pd=0.74u as=63.19999f ps=0.74u w=0.26u l=0.38u
X7083 cml_tlatch_6.xmux.xn.S1 cml_tlatch_6.INP MOT13_N VSS sg13_lv_nmos ad=63.19999f pd=0.74u as=63.19999f ps=0.74u w=0.26u l=0.38u
X7084 cml_tlatch_63.OUTP VDD VSS rppd l=5.17u w=1u
X7085 J2_P J2_N cml_tlatch_92.xmux.xp.S1 VSS sg13_lv_nmos ad=56.9f pd=0.74u as=56.9f ps=0.74u w=0.17u l=0.17u
X7086 cml_tlatch_67.xtail.S1 CKA3_P cml_tlatch_67.xmux.xn.S1 VSS sg13_lv_nmos ad=89.3f pd=0.85u as=89.3f ps=0.85u w=0.47u l=0.16u
X7087 cml_tlatch_75.xmux.xp.S1 MOT21_P MOT21_N VSS sg13_lv_nmos ad=56.9f pd=0.74u as=56.9f ps=0.74u w=0.17u l=0.17u
X7088 cml_tlatch_77.xmux.xn.S1 CKB2_N cml_tlatch_77.xtail.S1 VSS sg13_lv_nmos ad=89.3f pd=0.85u as=89.3f ps=0.85u w=0.47u l=0.16u
X7089 cml_tlatch_25.xmux.xn.S1 CKHA0_P cml_tlatch_25.xtail.S1 VSS sg13_lv_nmos ad=89.3f pd=0.85u as=89.3f ps=0.85u w=0.47u l=0.16u
X7090 MOT4_N MOT4_P cml_tlatch_25.xmux.xp.S1 VSS sg13_lv_nmos ad=56.9f pd=0.74u as=56.9f ps=0.74u w=0.17u l=0.17u
X7091 ENB0_N VDD VSS rppd l=8.13u w=1u
X7092 cml_tlatch_42.xtail.S1 POLN VSS VSS sg13_lv_nmos ad=1.5637p pd=8.61u as=1.5637p ps=8.61u w=8.23u l=0.13u
X7093 cml_tlatch_8.OUTN cml_tlatch_8.OUTP cml_tlatch_8.xmux.xp.S1 VSS sg13_lv_nmos ad=56.9f pd=0.74u as=56.9f ps=0.74u w=0.17u l=0.17u
X7094 MOT11_N MOT11_P cml_tlatch_5.xmux.xp.S1 VSS sg13_lv_nmos ad=56.9f pd=0.74u as=0.1019p ps=1.34u w=0.17u l=0.17u
X7095 cml_tlatch_62.xmux.xp.S1 CKB3_P cml_tlatch_62.xtail.S1 VSS sg13_lv_nmos ad=89.3f pd=0.85u as=89.3f ps=0.85u w=0.47u l=0.16u
X7096 cml_tlatch_76.xmux.xn.S1 B2_2_P MOT23_N VSS sg13_lv_nmos ad=63.19999f pd=0.74u as=63.19999f ps=0.74u w=0.26u l=0.38u
X7097 cml_tlatch_75.xtail.S1 POLN VSS VSS sg13_lv_nmos ad=1.5637p pd=8.61u as=2.7982p ps=17.14u w=8.23u l=0.13u
X7098 cml_tlatch_98.OUTN cml_tlatch_98.OUTP cml_tlatch_98.xmux.xp.S1 VSS sg13_lv_nmos ad=56.9f pd=0.74u as=56.9f ps=0.74u w=0.17u l=0.17u
X7099 cml_tlatch_9.xmux.xp.S1 cml_tlatch_9.OUTP cml_tlatch_9.OUTN VSS sg13_lv_nmos ad=0.1019p pd=1.34u as=56.9f ps=0.74u w=0.17u l=0.17u
X7100 cml_tlatch_55.xmux.xn.S1 A2_2_N cml_tlatch_89.INP VSS sg13_lv_nmos ad=63.19999f pd=0.74u as=63.19999f ps=0.74u w=0.26u l=0.38u
X7101 cml_tlatch_35.xmux.xp.S1 CKA0_N cml_tlatch_35.xtail.S1 VSS sg13_lv_nmos ad=0.1598p pd=1.62u as=89.3f ps=0.85u w=0.47u l=0.16u
X7102 cml_tlatch_3.xmux.xp.S1 CKA0_N cml_tlatch_3.xtail.S1 VSS sg13_lv_nmos ad=89.3f pd=0.85u as=89.3f ps=0.85u w=0.47u l=0.16u
X7103 cml_tlatch_47.OUTN cml_tlatch_47.OUTP cml_tlatch_47.xmux.xp.S1 VSS sg13_lv_nmos ad=56.9f pd=0.74u as=56.9f ps=0.74u w=0.17u l=0.17u
X7104 B1_8_N B1_8_P cml_tlatch_12.xmux.xp.S1 VSS sg13_lv_nmos ad=56.9f pd=0.74u as=56.9f ps=0.74u w=0.17u l=0.17u
X7105 B0_8_P B0_8_N cml_tlatch_10.xmux.xp.S1 VSS sg13_lv_nmos ad=56.9f pd=0.74u as=56.9f ps=0.74u w=0.17u l=0.17u
X7106 cml_tlatch_55.xmux.xn.S1 A2_2_N cml_tlatch_89.INP VSS sg13_lv_nmos ad=63.19999f pd=0.74u as=63.19999f ps=0.74u w=0.26u l=0.38u
X7107 cml_tlatch_96.xmux.xn.S1 A1_8_P MOT8_N VSS sg13_lv_nmos ad=63.19999f pd=0.74u as=63.19999f ps=0.74u w=0.26u l=0.38u
X7108 cml_tlatch_93.xmux.xp.S1 CKJ_N cml_tlatch_93.xtail.S1 VSS sg13_lv_nmos ad=89.3f pd=0.85u as=89.3f ps=0.85u w=0.47u l=0.16u
X7109 MOT5_N MOT5_P cml_tlatch_19.xmux.xp.S1 VSS sg13_lv_nmos ad=56.9f pd=0.74u as=56.9f ps=0.74u w=0.17u l=0.17u
X7110 cml_tlatch_75.xmux.xp.S1 CKHB2_N cml_tlatch_75.xtail.S1 VSS sg13_lv_nmos ad=89.3f pd=0.85u as=0.1598p ps=1.62u w=0.47u l=0.16u
X7111 cml_tlatch_25.xmux.xn.S1 cml_tlatch_99.OUTN MOT4_P VSS sg13_lv_nmos ad=63.19999f pd=0.74u as=63.19999f ps=0.74u w=0.26u l=0.38u
X7112 cml_tlatch_65.OUTN cml_tlatch_65.OUTP cml_tlatch_65.xmux.xp.S1 VSS sg13_lv_nmos ad=56.9f pd=0.74u as=56.9f ps=0.74u w=0.17u l=0.17u
X7113 cml_tlatch_34.xmux.xp.S1 stub_bi_31.BOTN stub_bi_31.BOTP VSS sg13_lv_nmos ad=56.9f pd=0.74u as=56.9f ps=0.74u w=0.17u l=0.17u
X7114 cml_tlatch_57.INN cml_tlatch_57.INP cml_tlatch_66.xmux.xp.S1 VSS sg13_lv_nmos ad=56.9f pd=0.74u as=56.9f ps=0.74u w=0.17u l=0.17u
X7115 MOT24_N A3_8_P cml_tlatch_86.xmux.xn.S1 VSS sg13_lv_nmos ad=63.19999f pd=0.74u as=63.19999f ps=0.74u w=0.26u l=0.38u
X7116 MOT19_N stub_bi_63.BOTN cml_tlatch_74.xmux.xn.S1 VSS sg13_lv_nmos ad=63.19999f pd=0.74u as=63.19999f ps=0.74u w=0.26u l=0.38u
X7117 cml_tlatch_93.xmux.xp.S1 J1_P J1_N VSS sg13_lv_nmos ad=56.9f pd=0.74u as=56.9f ps=0.74u w=0.17u l=0.17u
X7118 cml_tlatch_98.xmux.xn.S1 cml_tlatch_27.OUTP cml_tlatch_98.OUTN VSS sg13_lv_nmos ad=63.19999f pd=0.74u as=63.19999f ps=0.74u w=0.26u l=0.38u
X7119 cml_tlatch_14.xmux.xn.S1 CKB1_N cml_tlatch_14.xtail.S1 VSS sg13_lv_nmos ad=89.3f pd=0.85u as=89.3f ps=0.85u w=0.47u l=0.16u
X7120 cml_tlatch_84.xtail.S1 CKB3_P cml_tlatch_84.xmux.xp.S1 VSS sg13_lv_nmos ad=89.3f pd=0.85u as=89.3f ps=0.85u w=0.47u l=0.16u
X7121 cml_tlatch_62.xmux.xp.S1 cml_tlatch_69.INN cml_tlatch_69.INP VSS sg13_lv_nmos ad=56.9f pd=0.74u as=56.9f ps=0.74u w=0.17u l=0.17u
X7122 cml_tlatch_85.xmux.xp.S1 cml_tlatch_58.INN cml_tlatch_58.INP VSS sg13_lv_nmos ad=56.9f pd=0.74u as=56.9f ps=0.74u w=0.17u l=0.17u
X7123 CLK_W_N J2_N cml_tlatch_91.xmux.xn.S1 VSS sg13_lv_nmos ad=63.19999f pd=0.74u as=63.19999f ps=0.74u w=0.26u l=0.38u
X7124 cml_tlatch_89.INN A2_2_P cml_tlatch_55.xmux.xn.S1 VSS sg13_lv_nmos ad=63.19999f pd=0.74u as=63.19999f ps=0.74u w=0.26u l=0.38u
X7125 cml_tlatch_70.INP cml_tlatch_70.INN cml_tlatch_84.xmux.xp.S1 VSS sg13_lv_nmos ad=56.9f pd=0.74u as=56.9f ps=0.74u w=0.17u l=0.17u
X7126 cml_tlatch_65.xmux.xn.S1 cml_tlatch_57.INP cml_tlatch_65.OUTN VSS sg13_lv_nmos ad=63.19999f pd=0.74u as=63.19999f ps=0.74u w=0.26u l=0.38u
X7127 cml_tlatch_25.xmux.xn.S1 cml_tlatch_99.OUTN MOT4_P VSS sg13_lv_nmos ad=63.19999f pd=0.74u as=63.19999f ps=0.74u w=0.26u l=0.38u
X7128 stub_bi_29.BOTN stub_bi_29.BOTP cml_tlatch_32.xmux.xp.S1 VSS sg13_lv_nmos ad=56.9f pd=0.74u as=56.9f ps=0.74u w=0.17u l=0.17u
X7129 cml_tlatch_5.xtail.S1 CKHB1_N cml_tlatch_5.xmux.xp.S1 VSS sg13_lv_nmos ad=89.3f pd=0.85u as=89.3f ps=0.85u w=0.47u l=0.16u
X7130 cml_tlatch_98.xmux.xn.S1 cml_tlatch_27.OUTP cml_tlatch_98.OUTN VSS sg13_lv_nmos ad=63.19999f pd=0.74u as=63.19999f ps=0.74u w=0.26u l=0.38u
X7131 cml_tlatch_19.xmux.xp.S1 MOT5_N MOT5_P VSS sg13_lv_nmos ad=56.9f pd=0.74u as=56.9f ps=0.74u w=0.17u l=0.17u
X7132 stub_bi_17.BOTP stub_bi_17.BOTN cml_tlatch_13.xmux.xp.S1 VSS sg13_lv_nmos ad=56.9f pd=0.74u as=56.9f ps=0.74u w=0.17u l=0.17u
X7133 stub_bi_42.BOTP stub_bi_42.BOTN cml_tlatch_43.xmux.xp.S1 VSS sg13_lv_nmos ad=56.9f pd=0.74u as=56.9f ps=0.74u w=0.17u l=0.17u
X7134 A1_8_P A1_8_N cml_tlatch_21.xmux.xp.S1 VSS sg13_lv_nmos ad=56.9f pd=0.74u as=56.9f ps=0.74u w=0.17u l=0.17u
X7135 cml_tlatch_57.xtail.S1 CKHA3_N cml_tlatch_57.xmux.xp.S1 VSS sg13_lv_nmos ad=89.3f pd=0.85u as=89.3f ps=0.85u w=0.47u l=0.16u
X7136 cml_gate2_4.sg13_lv_nmos_FTPY57_0.D0 ENA1_P GA2_N VSS sg13_lv_nmos ad=0.1007p pd=0.91u as=0.1007p ps=0.91u w=0.53u l=0.13u
X7137 cml_tlatch_70.xmux.xp.S1 CKHB3_N cml_tlatch_70.xtail.S1 VSS sg13_lv_nmos ad=89.3f pd=0.85u as=89.3f ps=0.85u w=0.47u l=0.16u
X7138 cml_tlatch_17.xmux.xn.S1 B0_8_N MOT1_P VSS sg13_lv_nmos ad=63.19999f pd=0.74u as=63.19999f ps=0.74u w=0.26u l=0.38u
X7139 cml_tlatch_26.xmux.xp.S1 MOT6_N MOT6_P VSS sg13_lv_nmos ad=56.9f pd=0.74u as=56.9f ps=0.74u w=0.17u l=0.17u
X7140 cml_tlatch_2.xmux.xn.S1 cml_tlatch_3.OUTP A0_8_N VSS sg13_lv_nmos ad=63.19999f pd=0.74u as=63.19999f ps=0.74u w=0.26u l=0.38u
X7141 MOT4_N cml_tlatch_99.OUTP cml_tlatch_25.xmux.xn.S1 VSS sg13_lv_nmos ad=63.19999f pd=0.74u as=63.19999f ps=0.74u w=0.26u l=0.38u
X7142 cml_tlatch_96.xtail.S1 CKHA1_P cml_tlatch_96.xmux.xn.S1 VSS sg13_lv_nmos ad=89.3f pd=0.85u as=89.3f ps=0.85u w=0.47u l=0.16u
X7143 cml_tlatch_51.xmux.xp.S1 CKHA2_N cml_tlatch_51.xtail.S1 VSS sg13_lv_nmos ad=89.3f pd=0.85u as=89.3f ps=0.85u w=0.47u l=0.16u
X7144 cml_tlatch_20.xmux.xp.S1 MOT7_P MOT7_N VSS sg13_lv_nmos ad=56.9f pd=0.74u as=56.9f ps=0.74u w=0.17u l=0.17u
X7145 cml_tlatch_41.xtail.S1 CKHA1_P cml_tlatch_41.xmux.xn.S1 VSS sg13_lv_nmos ad=0.1598p pd=1.62u as=89.3f ps=0.85u w=0.47u l=0.16u
X7146 cml_tlatch_94.xtail.S1 CKB1_P cml_tlatch_94.xmux.xp.S1 VSS sg13_lv_nmos ad=89.3f pd=0.85u as=0.1598p ps=1.62u w=0.47u l=0.16u
X7147 J1_P J1_N cml_tlatch_93.xmux.xp.S1 VSS sg13_lv_nmos ad=56.9f pd=0.74u as=56.9f ps=0.74u w=0.17u l=0.17u
X7148 cml_drv_3.xrtail.R1 ENA_N ENA0_P VSS sg13_lv_nmos ad=56.2f pd=0.74u as=56.2f ps=0.74u w=0.16u l=0.19u
X7149 cml_tlatch_46.xtail.S1 CKB3_P cml_tlatch_46.xmux.xp.S1 VSS sg13_lv_nmos ad=89.3f pd=0.85u as=89.3f ps=0.85u w=0.47u l=0.16u
X7150 cml_tlatch_44.xmux.xn.S1 CKB2_N cml_tlatch_44.xtail.S1 VSS sg13_lv_nmos ad=89.3f pd=0.85u as=89.3f ps=0.85u w=0.47u l=0.16u
X7151 cml_tlatch_63.xmux.xp.S1 cml_tlatch_63.OUTN cml_tlatch_63.OUTP VSS sg13_lv_nmos ad=56.9f pd=0.74u as=56.9f ps=0.74u w=0.17u l=0.17u
X7152 cml_tlatch_17.xmux.xp.S1 MOT1_P MOT1_N VSS sg13_lv_nmos ad=56.9f pd=0.74u as=56.9f ps=0.74u w=0.17u l=0.17u
X7153 cml_tlatch_83.INN cml_tlatch_83.INP cml_tlatch_72.xmux.xp.S1 VSS sg13_lv_nmos ad=56.9f pd=0.74u as=56.9f ps=0.74u w=0.17u l=0.17u
X7154 cml_tlatch_65.xtail.S1 CKA3_P cml_tlatch_65.xmux.xn.S1 VSS sg13_lv_nmos ad=89.3f pd=0.85u as=89.3f ps=0.85u w=0.47u l=0.16u
X7155 cml_tlatch_43.xtail.S1 POLN VSS VSS sg13_lv_nmos ad=1.5637p pd=8.61u as=1.5637p ps=8.61u w=8.23u l=0.13u
X7156 stub_bi_19.BOTN stub_bi_19.BOTP cml_tlatch_15.xmux.xp.S1 VSS sg13_lv_nmos ad=56.9f pd=0.74u as=56.9f ps=0.74u w=0.17u l=0.17u
X7157 VDD A2_2_N VSS rppd l=5.17u w=1u
X7158 VDD cml_tlatch_39.INP VSS rppd l=5.17u w=1u
X7159 cml_tlatch_59.xmux.xp.S1 CKHA3_N cml_tlatch_59.xtail.S1 VSS sg13_lv_nmos ad=89.3f pd=0.85u as=89.3f ps=0.85u w=0.47u l=0.16u
X7160 cml_tlatch_76.xtail.S1 CKHB2_N cml_tlatch_76.xmux.xp.S1 VSS sg13_lv_nmos ad=89.3f pd=0.85u as=89.3f ps=0.85u w=0.47u l=0.16u
X7161 cml_tlatch_78.xmux.xn.S1 stub_bi_63.BOTP stub_bi_62.BOTN VSS sg13_lv_nmos ad=63.19999f pd=0.74u as=63.19999f ps=0.74u w=0.26u l=0.38u
X7162 cml_tlatch_40.INN cml_tlatch_95.INP cml_tlatch_95.xmux.xn.S1 VSS sg13_lv_nmos ad=0.1082p pd=1.34u as=63.19999f ps=0.74u w=0.26u l=0.38u
X7163 cml_tlatch_75.xmux.xp.S1 MOT21_P MOT21_N VSS sg13_lv_nmos ad=56.9f pd=0.74u as=56.9f ps=0.74u w=0.17u l=0.17u
X7164 cml_tlatch_81.xmux.xp.S1 A2_8_P A2_8_N VSS sg13_lv_nmos ad=56.9f pd=0.74u as=56.9f ps=0.74u w=0.17u l=0.17u
X7165 B3_8_N VDD VSS rppd l=5.17u w=1u
X7166 cml_tlatch_11.OUTN cml_tlatch_11.OUTP cml_tlatch_11.xmux.xp.S1 VSS sg13_lv_nmos ad=56.9f pd=0.74u as=56.9f ps=0.74u w=0.17u l=0.17u
X7167 GA0_P ENA0_N cml_gate2_2.sg13_lv_nmos_FTPY57_0.D0 VSS sg13_lv_nmos ad=0.1007p pd=0.91u as=0.1007p ps=0.91u w=0.53u l=0.13u
X7168 cml_tlatch_8.OUTN cml_tlatch_8.OUTP cml_tlatch_8.xmux.xp.S1 VSS sg13_lv_nmos ad=56.9f pd=0.74u as=56.9f ps=0.74u w=0.17u l=0.17u
X7169 cml_tlatch_92.xmux.xp.S1 J2_P J2_N VSS sg13_lv_nmos ad=56.9f pd=0.74u as=56.9f ps=0.74u w=0.17u l=0.17u
X7170 cml_tlatch_53.xmux.xn.S1 cml_tlatch_54.OUTN A3_2_P VSS sg13_lv_nmos ad=63.19999f pd=0.74u as=63.19999f ps=0.74u w=0.26u l=0.38u
X7171 J1_P J4_P cml_tlatch_93.xmux.xn.S1 VSS sg13_lv_nmos ad=63.19999f pd=0.74u as=63.19999f ps=0.74u w=0.26u l=0.38u
X7172 cml_tlatch_29.xmux.xp.S1 cml_tlatch_29.OUTN cml_tlatch_29.OUTP VSS sg13_lv_nmos ad=56.9f pd=0.74u as=56.9f ps=0.74u w=0.17u l=0.17u
X7173 cml_tlatch_79.xmux.xn.S1 stub_bi_49.BOTN stub_bi_63.BOTP VSS sg13_lv_nmos ad=63.19999f pd=0.74u as=63.19999f ps=0.74u w=0.26u l=0.38u
X7174 cml_tlatch_6.xmux.xp.S1 MOT13_P MOT13_N VSS sg13_lv_nmos ad=56.9f pd=0.74u as=56.9f ps=0.74u w=0.17u l=0.17u
X7175 cml_tlatch_6.INP cml_tlatch_6.INN cml_tlatch_94.xmux.xp.S1 VSS sg13_lv_nmos ad=56.9f pd=0.74u as=56.9f ps=0.74u w=0.17u l=0.17u
X7176 cml_tlatch_62.xmux.xp.S1 cml_tlatch_69.INP cml_tlatch_69.INN VSS sg13_lv_nmos ad=56.9f pd=0.74u as=56.9f ps=0.74u w=0.17u l=0.17u
X7177 cml_tlatch_65.xtail.S1 CKA3_N cml_tlatch_65.xmux.xp.S1 VSS sg13_lv_nmos ad=89.3f pd=0.85u as=89.3f ps=0.85u w=0.47u l=0.16u
X7178 cml_tlatch_83.OUTP cml_tlatch_83.OUTN cml_tlatch_83.xmux.xp.S1 VSS sg13_lv_nmos ad=56.9f pd=0.74u as=56.9f ps=0.74u w=0.17u l=0.17u
X7179 cml_tlatch_89.xmux.xn.S1 CKA2_N cml_tlatch_89.xtail.S1 VSS sg13_lv_nmos ad=89.3f pd=0.85u as=0.1598p ps=1.62u w=0.47u l=0.16u
X7180 cml_tlatch_62.xmux.xp.S1 cml_tlatch_69.INN cml_tlatch_69.INP VSS sg13_lv_nmos ad=56.9f pd=0.74u as=56.9f ps=0.74u w=0.17u l=0.17u
X7181 cml_tlatch_44.xmux.xp.S1 B2_2_P B2_2_N VSS sg13_lv_nmos ad=56.9f pd=0.74u as=56.9f ps=0.74u w=0.17u l=0.17u
X7182 cml_tlatch_16.xmux.xn.S1 CKB0_N cml_tlatch_16.xtail.S1 VSS sg13_lv_nmos ad=89.3f pd=0.85u as=89.3f ps=0.85u w=0.47u l=0.16u
X7183 cml_tlatch_31.xmux.xp.S1 A0_2_N A0_2_P VSS sg13_lv_nmos ad=56.9f pd=0.74u as=56.9f ps=0.74u w=0.17u l=0.17u
X7184 A1_2_N A1_2_P cml_tlatch_37.xmux.xp.S1 VSS sg13_lv_nmos ad=56.9f pd=0.74u as=56.9f ps=0.74u w=0.17u l=0.17u
X7185 cml_tlatch_69.xtail.S1 CKHB3_P cml_tlatch_69.xmux.xn.S1 VSS sg13_lv_nmos ad=89.3f pd=0.85u as=89.3f ps=0.85u w=0.47u l=0.16u
X7186 B0_8_P B0_8_N cml_tlatch_10.xmux.xp.S1 VSS sg13_lv_nmos ad=56.9f pd=0.74u as=56.9f ps=0.74u w=0.17u l=0.17u
X7187 cml_tlatch_55.xmux.xp.S1 cml_tlatch_89.INN cml_tlatch_89.INP VSS sg13_lv_nmos ad=56.9f pd=0.74u as=56.9f ps=0.74u w=0.17u l=0.17u
X7188 cml_gate2_6.sg13_lv_nmos_FTPY57_0.D0 ENB0_P GB3_N VSS sg13_lv_nmos ad=0.1007p pd=0.91u as=0.1007p ps=0.91u w=0.53u l=0.13u
X7189 MOT0_P MOT0_N cml_tlatch_97.xmux.xp.S1 VSS sg13_lv_nmos ad=56.9f pd=0.74u as=56.9f ps=0.74u w=0.17u l=0.17u
X7190 VSS hs_to_clk_8.sg13_lv_nmos_2HGZLP_0.G VSS VSS sg13_lv_nmos ad=2.071p pd=11.28u as=0 ps=0 w=10.9u l=1.38u
X7191 cml_tlatch_48.xmux.xn.S1 CKB2_P cml_tlatch_48.xtail.S1 VSS sg13_lv_nmos ad=89.3f pd=0.85u as=89.3f ps=0.85u w=0.47u l=0.16u
X7192 cml_tlatch_62.xmux.xp.S1 cml_tlatch_69.INP cml_tlatch_69.INN VSS sg13_lv_nmos ad=0.1019p pd=1.34u as=56.9f ps=0.74u w=0.17u l=0.17u
X7193 cml_tlatch_54.xmux.xn.S1 CKA3_P cml_tlatch_54.xtail.S1 VSS sg13_lv_nmos ad=89.3f pd=0.85u as=89.3f ps=0.85u w=0.47u l=0.16u
X7194 A2_2_P A2_2_N cml_tlatch_56.xmux.xp.S1 VSS sg13_lv_nmos ad=56.9f pd=0.74u as=56.9f ps=0.74u w=0.17u l=0.17u
X7195 ENB1_N VDD VSS rppd l=8.13u w=1u
X7196 CKHA2_P GA2_N cml_drvb_4.xrtail.R1 VSS sg13_lv_nmos ad=0.2618p pd=2.22u as=0.1463p ps=1.15u w=0.77u l=0.21u
X7197 cml_tlatch_65.OUTP cml_tlatch_57.INN cml_tlatch_65.xmux.xn.S1 VSS sg13_lv_nmos ad=63.19999f pd=0.74u as=63.19999f ps=0.74u w=0.26u l=0.38u
X7198 cml_tlatch_77.xtail.S1 CKB2_N cml_tlatch_77.xmux.xn.S1 VSS sg13_lv_nmos ad=89.3f pd=0.85u as=0.1598p ps=1.62u w=0.47u l=0.16u
X7199 J1_P J1_N cml_tlatch_93.xmux.xp.S1 VSS sg13_lv_nmos ad=56.9f pd=0.74u as=56.9f ps=0.74u w=0.17u l=0.17u
X7200 J2_N J2_P cml_tlatch_92.xmux.xp.S1 VSS sg13_lv_nmos ad=56.9f pd=0.74u as=0.1019p ps=1.34u w=0.17u l=0.17u
X7201 cml_tlatch_39.xmux.xn.S1 cml_tlatch_39.INN MOT10_P VSS sg13_lv_nmos ad=63.19999f pd=0.74u as=0.1082p ps=1.34u w=0.26u l=0.38u
X7202 MOT20_P MOT20_N cml_tlatch_50.xmux.xp.S1 VSS sg13_lv_nmos ad=56.9f pd=0.74u as=56.9f ps=0.74u w=0.17u l=0.17u
X7203 cml_tlatch_5.INN cml_tlatch_5.INP cml_tlatch_14.xmux.xp.S1 VSS sg13_lv_nmos ad=56.9f pd=0.74u as=56.9f ps=0.74u w=0.17u l=0.17u
X7204 cml_tlatch_15.xtail.S1 CKB1_N cml_tlatch_15.xmux.xp.S1 VSS sg13_lv_nmos ad=0.1598p pd=1.62u as=89.3f ps=0.85u w=0.47u l=0.16u
X7205 GB3_P ENB0_N cml_gate2_6.sg13_lv_nmos_FTPY57_0.D0 VSS sg13_lv_nmos ad=0.1007p pd=0.91u as=0.1802p ps=1.74u w=0.53u l=0.13u
X7206 cml_tlatch_99.xmux.xp.S1 cml_tlatch_99.OUTN cml_tlatch_99.OUTP VSS sg13_lv_nmos ad=56.9f pd=0.74u as=56.9f ps=0.74u w=0.17u l=0.17u
X7207 cml_tlatch_62.xtail.S1 CKB3_N cml_tlatch_62.xmux.xn.S1 VSS sg13_lv_nmos ad=89.3f pd=0.85u as=89.3f ps=0.85u w=0.47u l=0.16u
X7208 hs_to_clk_6.D2 POLN VSS VSS sg13_lv_nmos ad=3.4p pd=20.68u as=1.9p ps=10.38u w=10u l=0.13u
X7209 cml_tlatch_26.xmux.xp.S1 MOT6_N MOT6_P VSS sg13_lv_nmos ad=0.1019p pd=1.34u as=56.9f ps=0.74u w=0.17u l=0.17u
X7210 cml_gate2_9.xrtail.R1 NM1_P cml_gate2_9.sg13_lv_nmos_FTPY57_0.D0 VSS sg13_lv_nmos ad=0.1007p pd=0.91u as=0.1007p ps=0.91u w=0.53u l=0.13u
X7211 cml_tlatch_51.xmux.xn.S1 CKHA2_P cml_tlatch_51.xtail.S1 VSS sg13_lv_nmos ad=89.3f pd=0.85u as=89.3f ps=0.85u w=0.47u l=0.16u
X7212 GA3_P CKB3_N cml_gate2_5.xrtail.R1 VSS sg13_lv_nmos ad=0.1007p pd=0.91u as=0.1007p ps=0.91u w=0.53u l=0.13u
X7213 GA3_N VDD VSS rppd l=7.42u w=1u
X7214 cml_tlatch_72.xmux.xp.S1 cml_tlatch_83.INN cml_tlatch_83.INP VSS sg13_lv_nmos ad=56.9f pd=0.74u as=56.9f ps=0.74u w=0.17u l=0.17u
X7215 cml_tlatch_63.OUTP cml_tlatch_70.INN cml_tlatch_63.xmux.xn.S1 VSS sg13_lv_nmos ad=63.19999f pd=0.74u as=63.19999f ps=0.74u w=0.26u l=0.38u
X7216 cml_tlatch_61.xmux.xp.S1 cml_tlatch_61.OUTN cml_tlatch_61.OUTP VSS sg13_lv_nmos ad=56.9f pd=0.74u as=56.9f ps=0.74u w=0.17u l=0.17u
X7217 MOT19_P MOT19_N cml_tlatch_74.xmux.xp.S1 VSS sg13_lv_nmos ad=56.9f pd=0.74u as=56.9f ps=0.74u w=0.17u l=0.17u
X7218 cml_tlatch_20.xmux.xp.S1 MOT7_P MOT7_N VSS sg13_lv_nmos ad=56.9f pd=0.74u as=56.9f ps=0.74u w=0.17u l=0.17u
X7219 cml_tlatch_69.xmux.xp.S1 MOT27_N MOT27_P VSS sg13_lv_nmos ad=56.9f pd=0.74u as=56.9f ps=0.74u w=0.17u l=0.17u
X7220 cml_tlatch_33.xmux.xn.S1 stub_bi_31.BOTP B1_2_P VSS sg13_lv_nmos ad=63.19999f pd=0.74u as=0.1082p ps=1.34u w=0.26u l=0.38u
X7221 B3_8_P B3_8_N cml_tlatch_60.xmux.xp.S1 VSS sg13_lv_nmos ad=56.9f pd=0.74u as=56.9f ps=0.74u w=0.17u l=0.17u
X7222 stub_bi_55.BOTP stub_bi_55.BOTN cml_tlatch_88.xmux.xp.S1 VSS sg13_lv_nmos ad=56.9f pd=0.74u as=56.9f ps=0.74u w=0.17u l=0.17u
X7223 cml_tlatch_95.xmux.xp.S1 cml_tlatch_40.INP cml_tlatch_40.INN VSS sg13_lv_nmos ad=56.9f pd=0.74u as=56.9f ps=0.74u w=0.17u l=0.17u
X7224 stub_bi_19.BOTP cml_tlatch_6.INP cml_tlatch_15.xmux.xn.S1 VSS sg13_lv_nmos ad=63.19999f pd=0.74u as=63.19999f ps=0.74u w=0.26u l=0.38u
X7225 cml_tlatch_71.xmux.xn.S1 B3_2_N MOT31_P VSS sg13_lv_nmos ad=63.19999f pd=0.74u as=63.19999f ps=0.74u w=0.26u l=0.38u
X7226 cml_tlatch_60.xtail.S1 CKB3_N cml_tlatch_60.xmux.xn.S1 VSS sg13_lv_nmos ad=89.3f pd=0.85u as=89.3f ps=0.85u w=0.47u l=0.16u
X7227 cml_tlatch_21.xmux.xn.S1 CKA1_N cml_tlatch_21.xtail.S1 VSS sg13_lv_nmos ad=0.1598p pd=1.62u as=89.3f ps=0.85u w=0.47u l=0.16u
X7228 cml_tlatch_29.xmux.xp.S1 cml_tlatch_29.OUTP cml_tlatch_29.OUTN VSS sg13_lv_nmos ad=56.9f pd=0.74u as=56.9f ps=0.74u w=0.17u l=0.17u
X7229 cml_tlatch_98.OUTP cml_tlatch_27.OUTN cml_tlatch_98.xmux.xn.S1 VSS sg13_lv_nmos ad=63.19999f pd=0.74u as=63.19999f ps=0.74u w=0.26u l=0.38u
X7230 MOT28_P VDD VSS rppd l=5.17u w=1u
X7231 cml_tlatch_7.xmux.xp.S1 CKHB1_N cml_tlatch_7.xtail.S1 VSS sg13_lv_nmos ad=89.3f pd=0.85u as=89.3f ps=0.85u w=0.47u l=0.16u
X7232 cml_tlatch_14.xtail.S1 CKB1_N cml_tlatch_14.xmux.xn.S1 VSS sg13_lv_nmos ad=89.3f pd=0.85u as=0.1598p ps=1.62u w=0.47u l=0.16u
X7233 cml_tlatch_63.xmux.xn.S1 cml_tlatch_70.INP cml_tlatch_63.OUTN VSS sg13_lv_nmos ad=63.19999f pd=0.74u as=63.19999f ps=0.74u w=0.26u l=0.38u
X7234 stub_bi_63.BOTN stub_bi_63.BOTP cml_tlatch_79.xmux.xp.S1 VSS sg13_lv_nmos ad=56.9f pd=0.74u as=0.1019p ps=1.34u w=0.17u l=0.17u
X7235 B0_8_N B0_8_P cml_tlatch_10.xmux.xp.S1 VSS sg13_lv_nmos ad=56.9f pd=0.74u as=56.9f ps=0.74u w=0.17u l=0.17u
X7236 cml_tlatch_58.xmux.xp.S1 MOT28_P MOT28_N VSS sg13_lv_nmos ad=0.1019p pd=1.34u as=56.9f ps=0.74u w=0.17u l=0.17u
X7237 cml_tlatch_50.xtail.S1 CKHA2_P cml_tlatch_50.xmux.xn.S1 VSS sg13_lv_nmos ad=89.3f pd=0.85u as=89.3f ps=0.85u w=0.47u l=0.16u
X7238 cml_tlatch_75.xmux.xn.S1 stub_bi_55.BOTP MOT21_P VSS sg13_lv_nmos ad=63.19999f pd=0.74u as=63.19999f ps=0.74u w=0.26u l=0.38u
X7239 cml_tlatch_18.xmux.xp.S1 MOT3_P MOT3_N VSS sg13_lv_nmos ad=56.9f pd=0.74u as=56.9f ps=0.74u w=0.17u l=0.17u
X7240 J4_P CLK_W_P cml_tlatch_90.xmux.xn.S1 VSS sg13_lv_nmos ad=63.19999f pd=0.74u as=63.19999f ps=0.74u w=0.26u l=0.38u
X7241 cml_tlatch_85.xtail.S1 CKA3_N cml_tlatch_85.xmux.xn.S1 VSS sg13_lv_nmos ad=89.3f pd=0.85u as=89.3f ps=0.85u w=0.47u l=0.16u
X7242 cml_tlatch_54.xmux.xn.S1 D3_P cml_tlatch_54.OUTN VSS sg13_lv_nmos ad=63.19999f pd=0.74u as=63.19999f ps=0.74u w=0.26u l=0.38u
X7243 cml_tlatch_98.xmux.xn.S1 CKB0_N cml_tlatch_98.xtail.S1 VSS sg13_lv_nmos ad=89.3f pd=0.85u as=89.3f ps=0.85u w=0.47u l=0.16u
X7244 B0_2_P B0_2_N cml_tlatch_28.xmux.xp.S1 VSS sg13_lv_nmos ad=56.9f pd=0.74u as=56.9f ps=0.74u w=0.17u l=0.17u
X7245 VSS POLN cml_tlatch_41.xtail.S1 VSS sg13_lv_nmos ad=2.7982p pd=17.14u as=1.5637p ps=8.61u w=8.23u l=0.13u
X7246 cml_tlatch_81.xmux.xp.S1 A2_8_P A2_8_N VSS sg13_lv_nmos ad=56.9f pd=0.74u as=56.9f ps=0.74u w=0.17u l=0.17u
X7247 cml_tlatch_30.xmux.xp.S1 cml_tlatch_30.OUTN cml_tlatch_30.OUTP VSS sg13_lv_nmos ad=56.9f pd=0.74u as=56.9f ps=0.74u w=0.17u l=0.17u
X7248 MOT23_P MOT23_N cml_tlatch_76.xmux.xp.S1 VSS sg13_lv_nmos ad=56.9f pd=0.74u as=56.9f ps=0.74u w=0.17u l=0.17u
X7249 B2_8_N B2_8_P cml_tlatch_77.xmux.xp.S1 VSS sg13_lv_nmos ad=56.9f pd=0.74u as=56.9f ps=0.74u w=0.17u l=0.17u
X7250 cml_tlatch_11.OUTN cml_tlatch_11.OUTP cml_tlatch_11.xmux.xp.S1 VSS sg13_lv_nmos ad=56.9f pd=0.74u as=56.9f ps=0.74u w=0.17u l=0.17u
X7251 cml_tlatch_12.xmux.xp.S1 B1_8_N B1_8_P VSS sg13_lv_nmos ad=0.1019p pd=1.34u as=56.9f ps=0.74u w=0.17u l=0.17u
X7252 cml_tlatch_37.xmux.xp.S1 A1_2_N A1_2_P VSS sg13_lv_nmos ad=56.9f pd=0.74u as=56.9f ps=0.74u w=0.17u l=0.17u
X7253 GB2_P ENB0_N cml_gate2_7.sg13_lv_nmos_FTPY57_0.D0 VSS sg13_lv_nmos ad=0.1007p pd=0.91u as=0.1007p ps=0.91u w=0.53u l=0.13u
X7254 cml_tlatch_41.xmux.xn.S1 CKHA1_P cml_tlatch_41.xtail.S1 VSS sg13_lv_nmos ad=89.3f pd=0.85u as=89.3f ps=0.85u w=0.47u l=0.16u
X7255 cml_tlatch_51.xmux.xn.S1 A2_2_P MOT22_N VSS sg13_lv_nmos ad=63.19999f pd=0.74u as=63.19999f ps=0.74u w=0.26u l=0.38u
X7256 cml_tlatch_44.xtail.S1 CKB2_N cml_tlatch_44.xmux.xn.S1 VSS sg13_lv_nmos ad=89.3f pd=0.85u as=0.1598p ps=1.62u w=0.47u l=0.16u
X7257 cml_tlatch_48.xmux.xp.S1 stub_bi_32.BOTN stub_bi_32.BOTP VSS sg13_lv_nmos ad=56.9f pd=0.74u as=56.9f ps=0.74u w=0.17u l=0.17u
X7258 cml_tlatch_8.xmux.xp.S1 cml_tlatch_8.OUTN cml_tlatch_8.OUTP VSS sg13_lv_nmos ad=56.9f pd=0.74u as=56.9f ps=0.74u w=0.17u l=0.17u
X7259 cml_tlatch_23.xmux.xp.S1 CKA1_P cml_tlatch_23.xtail.S1 VSS sg13_lv_nmos ad=89.3f pd=0.85u as=0.1598p ps=1.62u w=0.47u l=0.16u
X7260 cml_tlatch_20.xtail.S1 CKHB0_P cml_tlatch_20.xmux.xn.S1 VSS sg13_lv_nmos ad=89.3f pd=0.85u as=89.3f ps=0.85u w=0.47u l=0.16u
X7261 cml_tlatch_69.xtail.S1 CKHB3_N cml_tlatch_69.xmux.xp.S1 VSS sg13_lv_nmos ad=0.1598p pd=1.62u as=89.3f ps=0.85u w=0.47u l=0.16u
X7262 cml_tlatch_55.xmux.xp.S1 cml_tlatch_89.INN cml_tlatch_89.INP VSS sg13_lv_nmos ad=56.9f pd=0.74u as=56.9f ps=0.74u w=0.17u l=0.17u
X7263 stub_bi_42.BOTN stub_bi_42.BOTP cml_tlatch_43.xmux.xp.S1 VSS sg13_lv_nmos ad=56.9f pd=0.74u as=56.9f ps=0.74u w=0.17u l=0.17u
X7264 cml_tlatch_31.xmux.xn.S1 CKA0_N cml_tlatch_31.xtail.S1 VSS sg13_lv_nmos ad=89.3f pd=0.85u as=89.3f ps=0.85u w=0.47u l=0.16u
X7265 MOT9_N MOT9_P cml_tlatch_4.xmux.xp.S1 VSS sg13_lv_nmos ad=56.9f pd=0.74u as=56.9f ps=0.74u w=0.17u l=0.17u
X7266 cml_tlatch_63.xtail.S1 CKB3_P cml_tlatch_63.xmux.xn.S1 VSS sg13_lv_nmos ad=89.3f pd=0.85u as=89.3f ps=0.85u w=0.47u l=0.16u
X7267 cml_tlatch_75.xmux.xp.S1 MOT21_N MOT21_P VSS sg13_lv_nmos ad=56.9f pd=0.74u as=56.9f ps=0.74u w=0.17u l=0.17u
X7268 cml_tlatch_82.xmux.xp.S1 cml_tlatch_82.OUTP cml_tlatch_82.OUTN VSS sg13_lv_nmos ad=56.9f pd=0.74u as=56.9f ps=0.74u w=0.17u l=0.17u
X7269 MOT29_P MOT29_N cml_tlatch_70.xmux.xp.S1 VSS sg13_lv_nmos ad=56.9f pd=0.74u as=56.9f ps=0.74u w=0.17u l=0.17u
X7270 cml_tlatch_35.xmux.xn.S1 D0_N cml_tlatch_35.OUTP VSS sg13_lv_nmos ad=63.19999f pd=0.74u as=63.19999f ps=0.74u w=0.26u l=0.38u
X7271 cml_tlatch_76.xmux.xp.S1 CKHB2_N cml_tlatch_76.xtail.S1 VSS sg13_lv_nmos ad=89.3f pd=0.85u as=89.3f ps=0.85u w=0.47u l=0.16u
X7272 cml_tlatch_78.xmux.xn.S1 stub_bi_63.BOTN stub_bi_62.BOTP VSS sg13_lv_nmos ad=0.1082p pd=1.34u as=63.19999f ps=0.74u w=0.26u l=0.38u
X7273 cml_tlatch_39.INP interco_bi_19.INN cml_tlatch_23.xmux.xn.S1 VSS sg13_lv_nmos ad=63.19999f pd=0.74u as=63.19999f ps=0.74u w=0.26u l=0.38u
X7274 cml_tlatch_81.xtail.S1 CKA2_P cml_tlatch_81.xmux.xp.S1 VSS sg13_lv_nmos ad=89.3f pd=0.85u as=89.3f ps=0.85u w=0.47u l=0.16u
X7275 cml_tlatch_47.xmux.xp.S1 cml_tlatch_47.OUTN cml_tlatch_47.OUTP VSS sg13_lv_nmos ad=56.9f pd=0.74u as=56.9f ps=0.74u w=0.17u l=0.17u
X7276 cml_tlatch_45.OUTP B3_2_N cml_tlatch_45.xmux.xn.S1 VSS sg13_lv_nmos ad=63.19999f pd=0.74u as=63.19999f ps=0.74u w=0.26u l=0.38u
X7277 cml_tlatch_84.xtail.S1 POLN VSS VSS sg13_lv_nmos ad=1.5637p pd=8.61u as=1.5637p ps=8.61u w=8.23u l=0.13u
X7278 cml_drvb_9.xrtail.R1 CLK_W_P NM1_N VSS sg13_lv_nmos ad=0.1463p pd=1.15u as=0.2618p ps=2.22u w=0.77u l=0.21u
X7279 cml_tlatch_72.xmux.xn.S1 cml_tlatch_89.OUTP cml_tlatch_83.INN VSS sg13_lv_nmos ad=63.19999f pd=0.74u as=63.19999f ps=0.74u w=0.26u l=0.38u
X7280 cml_tlatch_9.OUTN cml_tlatch_9.OUTP cml_tlatch_9.xmux.xp.S1 VSS sg13_lv_nmos ad=56.9f pd=0.74u as=56.9f ps=0.74u w=0.17u l=0.17u
X7281 CKB0_N CK_P hs_to_clk_1.D2 VSS sg13_lv_nmos ad=0.228p pd=1.58u as=0.228p ps=1.58u w=1.2u l=0.2u
X7282 cml_tlatch_87.xmux.xp.S1 MOT16_P MOT16_N VSS sg13_lv_nmos ad=56.9f pd=0.74u as=56.9f ps=0.74u w=0.17u l=0.17u
X7283 cml_tlatch_46.xtail.S1 CKB3_N cml_tlatch_46.xmux.xn.S1 VSS sg13_lv_nmos ad=89.3f pd=0.85u as=89.3f ps=0.85u w=0.47u l=0.16u
X7284 cml_tlatch_37.xmux.xn.S1 CKA1_N cml_tlatch_37.xtail.S1 VSS sg13_lv_nmos ad=0.1598p pd=1.62u as=89.3f ps=0.85u w=0.47u l=0.16u
X7285 cml_tlatch_0.xmux.xp.S1 interco_bi_19.INP interco_bi_19.INN VSS sg13_lv_nmos ad=56.9f pd=0.74u as=56.9f ps=0.74u w=0.17u l=0.17u
X7286 cml_tlatch_32.xmux.xp.S1 stub_bi_29.BOTN stub_bi_29.BOTP VSS sg13_lv_nmos ad=56.9f pd=0.74u as=56.9f ps=0.74u w=0.17u l=0.17u
X7287 cml_tlatch_54.OUTN cml_tlatch_54.OUTP cml_tlatch_54.xmux.xp.S1 VSS sg13_lv_nmos ad=56.9f pd=0.74u as=0.1019p ps=1.34u w=0.17u l=0.17u
X7288 MOT31_N MOT31_P cml_tlatch_71.xmux.xp.S1 VSS sg13_lv_nmos ad=56.9f pd=0.74u as=56.9f ps=0.74u w=0.17u l=0.17u
X7289 cml_tlatch_95.xmux.xp.S1 cml_tlatch_40.INP cml_tlatch_40.INN VSS sg13_lv_nmos ad=56.9f pd=0.74u as=56.9f ps=0.74u w=0.17u l=0.17u
X7290 CKA3_P CK_P hs_to_clk_7.D2 VSS sg13_lv_nmos ad=0.408p pd=3.08u as=0.228p ps=1.58u w=1.2u l=0.2u
X7291 cml_tlatch_5.xtail.S1 CKHB1_N cml_tlatch_5.xmux.xp.S1 VSS sg13_lv_nmos ad=89.3f pd=0.85u as=89.3f ps=0.85u w=0.47u l=0.16u
X7292 cml_tlatch_45.xmux.xn.S1 B3_2_P cml_tlatch_45.OUTN VSS sg13_lv_nmos ad=63.19999f pd=0.74u as=0.1082p ps=1.34u w=0.26u l=0.38u
X7293 VSS POLN cml_tlatch_9.xtail.S1 VSS sg13_lv_nmos ad=1.5637p pd=8.61u as=1.5637p ps=8.61u w=8.23u l=0.13u
X7294 cml_tlatch_58.xmux.xp.S1 MOT28_N MOT28_P VSS sg13_lv_nmos ad=56.9f pd=0.74u as=56.9f ps=0.74u w=0.17u l=0.17u
X7295 cml_tlatch_71.xmux.xp.S1 CKHB3_N cml_tlatch_71.xtail.S1 VSS sg13_lv_nmos ad=89.3f pd=0.85u as=89.3f ps=0.85u w=0.47u l=0.16u
X7296 MOT25_N MOT25_P cml_tlatch_68.xmux.xp.S1 VSS sg13_lv_nmos ad=56.9f pd=0.74u as=56.9f ps=0.74u w=0.17u l=0.17u
X7297 MOT18_P MOT18_N cml_tlatch_49.xmux.xp.S1 VSS sg13_lv_nmos ad=56.9f pd=0.74u as=56.9f ps=0.74u w=0.17u l=0.17u
X7298 cml_tlatch_57.xmux.xp.S1 MOT26_N MOT26_P VSS sg13_lv_nmos ad=56.9f pd=0.74u as=56.9f ps=0.74u w=0.17u l=0.17u
X7299 cml_tlatch_43.xtail.S1 CKB2_P cml_tlatch_43.xmux.xn.S1 VSS sg13_lv_nmos ad=89.3f pd=0.85u as=89.3f ps=0.85u w=0.47u l=0.16u
X7300 cml_tlatch_77.xtail.S1 CKB2_P cml_tlatch_77.xmux.xp.S1 VSS sg13_lv_nmos ad=89.3f pd=0.85u as=89.3f ps=0.85u w=0.47u l=0.16u
X7301 cml_tlatch_99.OUTN cml_tlatch_99.OUTP cml_tlatch_99.xmux.xp.S1 VSS sg13_lv_nmos ad=56.9f pd=0.74u as=56.9f ps=0.74u w=0.17u l=0.17u
X7302 cml_tlatch_25.xtail.S1 CKHA0_N cml_tlatch_25.xmux.xp.S1 VSS sg13_lv_nmos ad=89.3f pd=0.85u as=89.3f ps=0.85u w=0.47u l=0.16u
X7303 cml_tlatch_91.xmux.xp.S1 CKJ_N cml_tlatch_91.xtail.S1 VSS sg13_lv_nmos ad=89.3f pd=0.85u as=89.3f ps=0.85u w=0.47u l=0.16u
X7304 cml_tlatch_64.xtail.S1 CKA3_P cml_tlatch_64.xmux.xp.S1 VSS sg13_lv_nmos ad=89.3f pd=0.85u as=89.3f ps=0.85u w=0.47u l=0.16u
X7305 VDD cml_tlatch_95.INN VSS rppd l=5.17u w=1u
X7306 stub_bi_49.BOTN stub_bi_49.BOTP cml_tlatch_80.xmux.xp.S1 VSS sg13_lv_nmos ad=56.9f pd=0.74u as=56.9f ps=0.74u w=0.17u l=0.17u
X7307 MOT12_P MOT12_N cml_tlatch_40.xmux.xp.S1 VSS sg13_lv_nmos ad=56.9f pd=0.74u as=56.9f ps=0.74u w=0.17u l=0.17u
X7308 GB0_N ENB1_P cml_gate2_1.sg13_lv_nmos_FTPY57_0.D0 VSS sg13_lv_nmos ad=0.1007p pd=0.91u as=0.1007p ps=0.91u w=0.53u l=0.13u
X7309 MOT10_N MOT10_P cml_tlatch_39.xmux.xp.S1 VSS sg13_lv_nmos ad=56.9f pd=0.74u as=56.9f ps=0.74u w=0.17u l=0.17u
X7310 cml_tlatch_10.xtail.S1 CKB0_P cml_tlatch_10.xmux.xp.S1 VSS sg13_lv_nmos ad=0.1598p pd=1.62u as=89.3f ps=0.85u w=0.47u l=0.16u
X7311 cml_tlatch_95.xmux.xp.S1 cml_tlatch_40.INP cml_tlatch_40.INN VSS sg13_lv_nmos ad=56.9f pd=0.74u as=56.9f ps=0.74u w=0.17u l=0.17u
X7312 cml_tlatch_90.xtail.S1 POLN VSS VSS sg13_lv_nmos ad=1.5637p pd=8.61u as=2.7982p ps=17.14u w=8.23u l=0.13u
X7313 VDD J2_P VSS rppd l=5.17u w=1u
X7314 A2_8_P cml_tlatch_82.OUTN cml_tlatch_81.xmux.xn.S1 VSS sg13_lv_nmos ad=63.19999f pd=0.74u as=63.19999f ps=0.74u w=0.26u l=0.38u
X7315 A3_2_P A3_2_N cml_tlatch_53.xmux.xp.S1 VSS sg13_lv_nmos ad=56.9f pd=0.74u as=56.9f ps=0.74u w=0.17u l=0.17u
X7316 CKB0_P CK_N hs_to_clk_1.D2 VSS sg13_lv_nmos ad=0.228p pd=1.58u as=0.228p ps=1.58u w=1.2u l=0.2u
X7317 cml_tlatch_40.xmux.xn.S1 CKHA1_P cml_tlatch_40.xtail.S1 VSS sg13_lv_nmos ad=89.3f pd=0.85u as=89.3f ps=0.85u w=0.47u l=0.16u
X7318 cml_tlatch_37.xtail.S1 CKA1_P cml_tlatch_37.xmux.xp.S1 VSS sg13_lv_nmos ad=89.3f pd=0.85u as=89.3f ps=0.85u w=0.47u l=0.16u
X7319 stub_bi_63.BOTP stub_bi_63.BOTN cml_tlatch_79.xmux.xp.S1 VSS sg13_lv_nmos ad=56.9f pd=0.74u as=56.9f ps=0.74u w=0.17u l=0.17u
X7320 MOT17_P MOT17_N cml_tlatch_73.xmux.xp.S1 VSS sg13_lv_nmos ad=56.9f pd=0.74u as=56.9f ps=0.74u w=0.17u l=0.17u
X7321 cml_tlatch_37.xmux.xp.S1 A1_2_N A1_2_P VSS sg13_lv_nmos ad=56.9f pd=0.74u as=56.9f ps=0.74u w=0.17u l=0.17u
X7322 cml_tlatch_69.INP cml_tlatch_63.OUTN cml_tlatch_62.xmux.xn.S1 VSS sg13_lv_nmos ad=63.19999f pd=0.74u as=63.19999f ps=0.74u w=0.26u l=0.38u
X7323 cml_tlatch_18.xmux.xp.S1 MOT3_P MOT3_N VSS sg13_lv_nmos ad=56.9f pd=0.74u as=56.9f ps=0.74u w=0.17u l=0.17u
X7324 B1_2_P B1_2_N cml_tlatch_33.xmux.xp.S1 VSS sg13_lv_nmos ad=56.9f pd=0.74u as=56.9f ps=0.74u w=0.17u l=0.17u
X7325 cml_tlatch_65.xtail.S1 CKA3_P cml_tlatch_65.xmux.xn.S1 VSS sg13_lv_nmos ad=89.3f pd=0.85u as=89.3f ps=0.85u w=0.47u l=0.16u
X7326 cml_drv_3.xrtail.R1 ENA_P ENA0_N VSS sg13_lv_nmos ad=56.2f pd=0.74u as=56.2f ps=0.74u w=0.16u l=0.19u
X7327 cml_tlatch_1.OUTP cml_tlatch_1.OUTN cml_tlatch_1.xmux.xp.S1 VSS sg13_lv_nmos ad=56.9f pd=0.74u as=56.9f ps=0.74u w=0.17u l=0.17u
X7328 cml_tlatch_83.xtail.S1 CKA2_P cml_tlatch_83.xmux.xp.S1 VSS sg13_lv_nmos ad=89.3f pd=0.85u as=89.3f ps=0.85u w=0.47u l=0.16u
X7329 cml_tlatch_59.xmux.xp.S1 CKHA3_N cml_tlatch_59.xtail.S1 VSS sg13_lv_nmos ad=89.3f pd=0.85u as=89.3f ps=0.85u w=0.47u l=0.16u
X7330 cml_tlatch_3.xmux.xp.S1 cml_tlatch_3.OUTN cml_tlatch_3.OUTP VSS sg13_lv_nmos ad=56.9f pd=0.74u as=56.9f ps=0.74u w=0.17u l=0.17u
X7331 cml_gate2_1.sg13_lv_nmos_FTPY57_0.D0 ENB1_N GB0_P VSS sg13_lv_nmos ad=0.1007p pd=0.91u as=0.1007p ps=0.91u w=0.53u l=0.13u
X7332 cml_tlatch_67.xmux.xp.S1 cml_tlatch_67.OUTN cml_tlatch_67.OUTP VSS sg13_lv_nmos ad=56.9f pd=0.74u as=56.9f ps=0.74u w=0.17u l=0.17u
X7333 MOT28_P MOT28_N cml_tlatch_58.xmux.xp.S1 VSS sg13_lv_nmos ad=56.9f pd=0.74u as=56.9f ps=0.74u w=0.17u l=0.17u
X7334 VSS POLN cml_tlatch_34.xtail.S1 VSS sg13_lv_nmos ad=2.7982p pd=17.14u as=1.5637p ps=8.61u w=8.23u l=0.13u
X7335 cml_tlatch_46.xmux.xp.S1 B3_2_P B3_2_N VSS sg13_lv_nmos ad=56.9f pd=0.74u as=56.9f ps=0.74u w=0.17u l=0.17u
X7336 cml_tlatch_28.xmux.xp.S1 B0_2_P B0_2_N VSS sg13_lv_nmos ad=56.9f pd=0.74u as=56.9f ps=0.74u w=0.17u l=0.17u
X7337 cml_tlatch_33.xtail.S1 CKB1_P cml_tlatch_33.xmux.xp.S1 VSS sg13_lv_nmos ad=89.3f pd=0.85u as=89.3f ps=0.85u w=0.47u l=0.16u
X7338 cml_tlatch_71.xmux.xp.S1 MOT31_N MOT31_P VSS sg13_lv_nmos ad=56.9f pd=0.74u as=56.9f ps=0.74u w=0.17u l=0.17u
X7339 cml_tlatch_61.xtail.S1 CKB3_P cml_tlatch_61.xmux.xn.S1 VSS sg13_lv_nmos ad=0.1598p pd=1.62u as=89.3f ps=0.85u w=0.47u l=0.16u
X7340 cml_tlatch_45.OUTN cml_tlatch_45.OUTP cml_tlatch_45.xmux.xp.S1 VSS sg13_lv_nmos ad=56.9f pd=0.74u as=56.9f ps=0.74u w=0.17u l=0.17u
X7341 GA1_P ENA0_N cml_gate2_3.sg13_lv_nmos_FTPY57_0.D0 VSS sg13_lv_nmos ad=0.1007p pd=0.91u as=0.1007p ps=0.91u w=0.53u l=0.13u
X7342 cml_tlatch_8.xmux.xp.S1 CKA0_P cml_tlatch_8.xtail.S1 VSS sg13_lv_nmos ad=0.1598p pd=1.62u as=89.3f ps=0.85u w=0.47u l=0.16u
X7343 MOT15_P MOT15_N cml_tlatch_7.xmux.xp.S1 VSS sg13_lv_nmos ad=56.9f pd=0.74u as=56.9f ps=0.74u w=0.17u l=0.17u
X7344 cml_tlatch_64.xmux.xn.S1 cml_tlatch_65.OUTP A3_8_N VSS sg13_lv_nmos ad=63.19999f pd=0.74u as=63.19999f ps=0.74u w=0.26u l=0.38u
X7345 VSS POLN cml_tlatch_88.xtail.S1 VSS sg13_lv_nmos ad=2.7982p pd=17.14u as=1.5637p ps=8.61u w=8.23u l=0.13u
X7346 cml_tlatch_2.xtail.S1 CKA0_N cml_tlatch_2.xmux.xn.S1 VSS sg13_lv_nmos ad=89.3f pd=0.85u as=89.3f ps=0.85u w=0.47u l=0.16u
X7347 cml_gate2_6.sg13_lv_nmos_FTPY57_0.D0 CKA3_P cml_gate2_6.xrtail.R1 VSS sg13_lv_nmos ad=0.1007p pd=0.91u as=0.1007p ps=0.91u w=0.53u l=0.13u
X7348 MOT6_N A0_2_P cml_tlatch_26.xmux.xn.S1 VSS sg13_lv_nmos ad=0.1082p pd=1.34u as=63.19999f ps=0.74u w=0.26u l=0.38u
X7349 cml_tlatch_27.OUTN B0_2_P cml_tlatch_27.xmux.xn.S1 VSS sg13_lv_nmos ad=63.19999f pd=0.74u as=63.19999f ps=0.74u w=0.26u l=0.38u
X7350 cml_tlatch_25.xmux.xp.S1 MOT4_P MOT4_N VSS sg13_lv_nmos ad=56.9f pd=0.74u as=56.9f ps=0.74u w=0.17u l=0.17u
X7351 cml_tlatch_50.xmux.xn.S1 CKHA2_P cml_tlatch_50.xtail.S1 VSS sg13_lv_nmos ad=89.3f pd=0.85u as=89.3f ps=0.85u w=0.47u l=0.16u
X7352 cml_tlatch_83.OUTP cml_tlatch_83.INN cml_tlatch_83.xmux.xn.S1 VSS sg13_lv_nmos ad=0.1082p pd=1.34u as=63.19999f ps=0.74u w=0.26u l=0.38u
X7353 cml_tlatch_57.xmux.xp.S1 MOT26_P MOT26_N VSS sg13_lv_nmos ad=56.9f pd=0.74u as=56.9f ps=0.74u w=0.17u l=0.17u
X7354 VDD MOT19_N VSS rppd l=5.17u w=1u
X7355 cml_tlatch_40.INP cml_tlatch_40.INN cml_tlatch_95.xmux.xp.S1 VSS sg13_lv_nmos ad=56.9f pd=0.74u as=56.9f ps=0.74u w=0.17u l=0.17u
X7356 cml_tlatch_98.xmux.xp.S1 cml_tlatch_98.OUTP cml_tlatch_98.OUTN VSS sg13_lv_nmos ad=56.9f pd=0.74u as=56.9f ps=0.74u w=0.17u l=0.17u
X7357 MOT30_N VDD VSS rppd l=5.17u w=1u
X7358 cml_tlatch_48.xmux.xn.S1 CKB2_P cml_tlatch_48.xtail.S1 VSS sg13_lv_nmos ad=89.3f pd=0.85u as=89.3f ps=0.85u w=0.47u l=0.16u
X7359 cml_tlatch_9.OUTN cml_tlatch_9.OUTP cml_tlatch_9.xmux.xp.S1 VSS sg13_lv_nmos ad=56.9f pd=0.74u as=56.9f ps=0.74u w=0.17u l=0.17u
X7360 cml_tlatch_86.xmux.xn.S1 A3_8_N MOT24_P VSS sg13_lv_nmos ad=63.19999f pd=0.74u as=63.19999f ps=0.74u w=0.26u l=0.38u
X7361 VSS hs_to_clk_5.sg13_lv_nmos_2HGZLP_0.G VSS VSS sg13_lv_nmos ad=2.071p pd=11.28u as=0 ps=0 w=10.9u l=1.38u
X7362 MOT28_P cml_tlatch_58.INN cml_tlatch_58.xmux.xn.S1 VSS sg13_lv_nmos ad=63.19999f pd=0.74u as=63.19999f ps=0.74u w=0.26u l=0.38u
X7363 cml_tlatch_67.xmux.xp.S1 cml_tlatch_67.OUTN cml_tlatch_67.OUTP VSS sg13_lv_nmos ad=56.9f pd=0.74u as=56.9f ps=0.74u w=0.17u l=0.17u
X7364 MOT18_P cml_tlatch_83.OUTN cml_tlatch_49.xmux.xn.S1 VSS sg13_lv_nmos ad=0.1082p pd=1.34u as=63.19999f ps=0.74u w=0.26u l=0.38u
X7365 MOT31_P MOT31_N cml_tlatch_71.xmux.xp.S1 VSS sg13_lv_nmos ad=56.9f pd=0.74u as=56.9f ps=0.74u w=0.17u l=0.17u
X7366 cml_tlatch_35.xmux.xn.S1 CKA0_P cml_tlatch_35.xtail.S1 VSS sg13_lv_nmos ad=89.3f pd=0.85u as=89.3f ps=0.85u w=0.47u l=0.16u
X7367 cml_tlatch_26.xtail.S1 POLN VSS VSS sg13_lv_nmos ad=1.5637p pd=8.61u as=1.5637p ps=8.61u w=8.23u l=0.13u
X7368 cml_tlatch_58.xmux.xn.S1 CKHA3_P cml_tlatch_58.xtail.S1 VSS sg13_lv_nmos ad=89.3f pd=0.85u as=89.3f ps=0.85u w=0.47u l=0.16u
X7369 cml_tlatch_23.xmux.xn.S1 interco_bi_19.INP cml_tlatch_39.INN VSS sg13_lv_nmos ad=63.19999f pd=0.74u as=63.19999f ps=0.74u w=0.26u l=0.38u
X7370 cml_gate2_6.xrtail.R1 CKA3_N GB3_P VSS sg13_lv_nmos ad=0.1007p pd=0.91u as=0.1007p ps=0.91u w=0.53u l=0.13u
X7371 cml_tlatch_35.xmux.xp.S1 cml_tlatch_35.OUTN cml_tlatch_35.OUTP VSS sg13_lv_nmos ad=56.9f pd=0.74u as=56.9f ps=0.74u w=0.17u l=0.17u
X7372 ENA_P J1_N cml_gate2_9.sg13_lv_nmos_FTPY57_0.D0 VSS sg13_lv_nmos ad=0.1007p pd=0.91u as=0.1007p ps=0.91u w=0.53u l=0.13u
X7373 cml_tlatch_56.xmux.xp.S1 CKA2_P cml_tlatch_56.xtail.S1 VSS sg13_lv_nmos ad=89.3f pd=0.85u as=89.3f ps=0.85u w=0.47u l=0.16u
X7374 cml_tlatch_15.xtail.S1 CKB1_N cml_tlatch_15.xmux.xp.S1 VSS sg13_lv_nmos ad=89.3f pd=0.85u as=89.3f ps=0.85u w=0.47u l=0.16u
X7375 B3_2_N cml_tlatch_47.OUTP cml_tlatch_46.xmux.xn.S1 VSS sg13_lv_nmos ad=63.19999f pd=0.74u as=63.19999f ps=0.74u w=0.26u l=0.38u
X7376 cml_tlatch_19.xmux.xp.S1 MOT5_P MOT5_N VSS sg13_lv_nmos ad=56.9f pd=0.74u as=56.9f ps=0.74u w=0.17u l=0.17u
X7377 stub_bi_62.BOTN stub_bi_62.BOTP cml_tlatch_78.xmux.xp.S1 VSS sg13_lv_nmos ad=56.9f pd=0.74u as=56.9f ps=0.74u w=0.17u l=0.17u
X7378 cml_tlatch_7.xmux.xp.S1 MOT15_P MOT15_N VSS sg13_lv_nmos ad=56.9f pd=0.74u as=56.9f ps=0.74u w=0.17u l=0.17u
X7379 stub_bi_31.BOTP stub_bi_31.BOTN cml_tlatch_34.xmux.xp.S1 VSS sg13_lv_nmos ad=56.9f pd=0.74u as=56.9f ps=0.74u w=0.17u l=0.17u
X7380 cml_tlatch_58.xmux.xn.S1 cml_tlatch_58.INP MOT28_N VSS sg13_lv_nmos ad=63.19999f pd=0.74u as=63.19999f ps=0.74u w=0.26u l=0.38u
X7381 cml_gate2_4.xrtail.R1 CKB2_N GA2_P VSS sg13_lv_nmos ad=0.1007p pd=0.91u as=0.1007p ps=0.91u w=0.53u l=0.13u
X7382 cml_tlatch_4.xtail.S1 CKHB1_P cml_tlatch_4.xmux.xn.S1 VSS sg13_lv_nmos ad=89.3f pd=0.85u as=0.1598p ps=1.62u w=0.47u l=0.16u
X7383 J1_N J1_P cml_tlatch_93.xmux.xp.S1 VSS sg13_lv_nmos ad=56.9f pd=0.74u as=56.9f ps=0.74u w=0.17u l=0.17u
X7384 cml_tlatch_66.xmux.xp.S1 cml_tlatch_57.INN cml_tlatch_57.INP VSS sg13_lv_nmos ad=56.9f pd=0.74u as=56.9f ps=0.74u w=0.17u l=0.17u
X7385 cml_tlatch_66.xmux.xp.S1 cml_tlatch_57.INP cml_tlatch_57.INN VSS sg13_lv_nmos ad=56.9f pd=0.74u as=56.9f ps=0.74u w=0.17u l=0.17u
X7386 cml_tlatch_93.xmux.xn.S1 J4_P J1_P VSS sg13_lv_nmos ad=63.19999f pd=0.74u as=63.19999f ps=0.74u w=0.26u l=0.38u
X7387 A3_2_P cml_tlatch_54.OUTN cml_tlatch_53.xmux.xn.S1 VSS sg13_lv_nmos ad=0.1082p pd=1.34u as=63.19999f ps=0.74u w=0.26u l=0.38u
X7388 cml_tlatch_58.INP cml_tlatch_58.INN cml_tlatch_85.xmux.xp.S1 VSS sg13_lv_nmos ad=56.9f pd=0.74u as=56.9f ps=0.74u w=0.17u l=0.17u
X7389 cml_tlatch_98.OUTP cml_tlatch_27.OUTN cml_tlatch_98.xmux.xn.S1 VSS sg13_lv_nmos ad=63.19999f pd=0.74u as=63.19999f ps=0.74u w=0.26u l=0.38u
X7390 cml_tlatch_90.xmux.xp.S1 CKJ_P cml_tlatch_90.xtail.S1 VSS sg13_lv_nmos ad=0.1598p pd=1.62u as=89.3f ps=0.85u w=0.47u l=0.16u
X7391 cml_tlatch_88.xmux.xn.S1 stub_bi_42.BOTN stub_bi_55.BOTP VSS sg13_lv_nmos ad=63.19999f pd=0.74u as=63.19999f ps=0.74u w=0.26u l=0.38u
X7392 cml_tlatch_35.xtail.S1 CKA0_N cml_tlatch_35.xmux.xp.S1 VSS sg13_lv_nmos ad=89.3f pd=0.85u as=89.3f ps=0.85u w=0.47u l=0.16u
X7393 cml_gate2_6.sg13_lv_nmos_FTPY57_0.D0 ENB0_N GB3_P VSS sg13_lv_nmos ad=0.1802p pd=1.74u as=0.1007p ps=0.91u w=0.53u l=0.13u
X7394 MOT27_N MOT27_P cml_tlatch_69.xmux.xp.S1 VSS sg13_lv_nmos ad=56.9f pd=0.74u as=56.9f ps=0.74u w=0.17u l=0.17u
X7395 cml_tlatch_58.xmux.xn.S1 cml_tlatch_58.INP MOT28_N VSS sg13_lv_nmos ad=63.19999f pd=0.74u as=63.19999f ps=0.74u w=0.26u l=0.38u
X7396 cml_tlatch_63.xmux.xn.S1 CKB3_P cml_tlatch_63.xtail.S1 VSS sg13_lv_nmos ad=89.3f pd=0.85u as=89.3f ps=0.85u w=0.47u l=0.16u
X7397 cml_tlatch_19.xmux.xn.S1 CKHB0_P cml_tlatch_19.xtail.S1 VSS sg13_lv_nmos ad=0.1598p pd=1.62u as=89.3f ps=0.85u w=0.47u l=0.16u
X7398 cml_tlatch_22.OUTN cml_tlatch_22.OUTP cml_tlatch_22.xmux.xp.S1 VSS sg13_lv_nmos ad=56.9f pd=0.74u as=56.9f ps=0.74u w=0.17u l=0.17u
X7399 cml_tlatch_54.xmux.xn.S1 D3_N cml_tlatch_54.OUTP VSS sg13_lv_nmos ad=63.19999f pd=0.74u as=63.19999f ps=0.74u w=0.26u l=0.38u
X7400 cml_tlatch_43.xmux.xp.S1 stub_bi_42.BOTN stub_bi_42.BOTP VSS sg13_lv_nmos ad=56.9f pd=0.74u as=56.9f ps=0.74u w=0.17u l=0.17u
X7401 cml_tlatch_99.xtail.S1 CKA0_P cml_tlatch_99.xmux.xp.S1 VSS sg13_lv_nmos ad=89.3f pd=0.85u as=89.3f ps=0.85u w=0.47u l=0.16u
X7402 cml_tlatch_39.INN cml_tlatch_39.INP cml_tlatch_23.xmux.xp.S1 VSS sg13_lv_nmos ad=56.9f pd=0.74u as=56.9f ps=0.74u w=0.17u l=0.17u
X7403 VSS POLN cml_tlatch_29.xtail.S1 VSS sg13_lv_nmos ad=1.5637p pd=8.61u as=1.5637p ps=8.61u w=8.23u l=0.13u
X7404 VSS cml_drvb_3.xrtail.R1 VSS rppd l=2.72u w=1u
X7405 cml_tlatch_14.xmux.xp.S1 cml_tlatch_5.INN cml_tlatch_5.INP VSS sg13_lv_nmos ad=56.9f pd=0.74u as=56.9f ps=0.74u w=0.17u l=0.17u
X7406 A0_8_P cml_tlatch_3.OUTN cml_tlatch_2.xmux.xn.S1 VSS sg13_lv_nmos ad=0.1082p pd=1.34u as=63.19999f ps=0.74u w=0.26u l=0.38u
X7407 cml_tlatch_64.xmux.xp.S1 A3_8_P A3_8_N VSS sg13_lv_nmos ad=56.9f pd=0.74u as=56.9f ps=0.74u w=0.17u l=0.17u
X7408 cml_tlatch_48.xmux.xn.S1 D2_P stub_bi_32.BOTP VSS sg13_lv_nmos ad=0.1082p pd=1.34u as=63.19999f ps=0.74u w=0.26u l=0.38u
X7409 cml_gate2_2.sg13_lv_nmos_FTPY57_0.D0 ENA0_N GA0_P VSS sg13_lv_nmos ad=0.1007p pd=0.91u as=0.1007p ps=0.91u w=0.53u l=0.13u
X7410 cml_tlatch_27.xmux.xp.S1 cml_tlatch_27.OUTP cml_tlatch_27.OUTN VSS sg13_lv_nmos ad=56.9f pd=0.74u as=56.9f ps=0.74u w=0.17u l=0.17u
X7411 cml_tlatch_21.xtail.S1 CKA1_N cml_tlatch_21.xmux.xn.S1 VSS sg13_lv_nmos ad=89.3f pd=0.85u as=89.3f ps=0.85u w=0.47u l=0.16u
X7412 MOT6_P MOT6_N cml_tlatch_26.xmux.xp.S1 VSS sg13_lv_nmos ad=56.9f pd=0.74u as=56.9f ps=0.74u w=0.17u l=0.17u
X7413 cml_tlatch_68.xmux.xp.S1 MOT25_N MOT25_P VSS sg13_lv_nmos ad=56.9f pd=0.74u as=56.9f ps=0.74u w=0.17u l=0.17u
X7414 A0_8_P cml_tlatch_3.OUTN cml_tlatch_2.xmux.xn.S1 VSS sg13_lv_nmos ad=63.19999f pd=0.74u as=63.19999f ps=0.74u w=0.26u l=0.38u
X7415 cml_tlatch_1.OUTP cml_tlatch_1.OUTN cml_tlatch_1.xmux.xp.S1 VSS sg13_lv_nmos ad=56.9f pd=0.74u as=56.9f ps=0.74u w=0.17u l=0.17u
X7416 cml_tlatch_17.xtail.S1 CKHB0_N cml_tlatch_17.xmux.xp.S1 VSS sg13_lv_nmos ad=89.3f pd=0.85u as=89.3f ps=0.85u w=0.47u l=0.16u
X7417 cml_tlatch_39.INN cml_tlatch_39.INP cml_tlatch_23.xmux.xp.S1 VSS sg13_lv_nmos ad=56.9f pd=0.74u as=56.9f ps=0.74u w=0.17u l=0.17u
X7418 cml_tlatch_76.xtail.S1 POLN VSS VSS sg13_lv_nmos ad=1.5637p pd=8.61u as=2.7982p ps=17.14u w=8.23u l=0.13u
X7419 MOT9_P MOT9_N cml_tlatch_4.xmux.xp.S1 VSS sg13_lv_nmos ad=56.9f pd=0.74u as=56.9f ps=0.74u w=0.17u l=0.17u
X7420 cml_tlatch_95.xmux.xp.S1 cml_tlatch_40.INN cml_tlatch_40.INP VSS sg13_lv_nmos ad=0.1019p pd=1.34u as=56.9f ps=0.74u w=0.17u l=0.17u
X7421 VSS POLN cml_tlatch_49.xtail.S1 VSS sg13_lv_nmos ad=1.5637p pd=8.61u as=1.5637p ps=8.61u w=8.23u l=0.13u
X7422 cml_tlatch_43.xmux.xn.S1 CKB2_P cml_tlatch_43.xtail.S1 VSS sg13_lv_nmos ad=89.3f pd=0.85u as=89.3f ps=0.85u w=0.47u l=0.16u
X7423 VSS POLN cml_tlatch_91.xtail.S1 VSS sg13_lv_nmos ad=2.7982p pd=17.14u as=1.5637p ps=8.61u w=8.23u l=0.13u
X7424 cml_tlatch_76.xmux.xn.S1 CKHB2_P cml_tlatch_76.xtail.S1 VSS sg13_lv_nmos ad=89.3f pd=0.85u as=89.3f ps=0.85u w=0.47u l=0.16u
X7425 cml_tlatch_72.xmux.xp.S1 cml_tlatch_83.INP cml_tlatch_83.INN VSS sg13_lv_nmos ad=56.9f pd=0.74u as=56.9f ps=0.74u w=0.17u l=0.17u
X7426 cml_tlatch_52.xmux.xp.S1 cml_tlatch_52.OUTN cml_tlatch_52.OUTP VSS sg13_lv_nmos ad=56.9f pd=0.74u as=56.9f ps=0.74u w=0.17u l=0.17u
X7427 cml_tlatch_83.INP cml_tlatch_89.OUTN cml_tlatch_72.xmux.xn.S1 VSS sg13_lv_nmos ad=63.19999f pd=0.74u as=0.1082p ps=1.34u w=0.26u l=0.38u
X7428 cml_tlatch_67.xtail.S1 CKA3_N cml_tlatch_67.xmux.xp.S1 VSS sg13_lv_nmos ad=89.3f pd=0.85u as=89.3f ps=0.85u w=0.47u l=0.16u
X7429 cml_tlatch_52.xmux.xn.S1 CKA3_P cml_tlatch_52.xtail.S1 VSS sg13_lv_nmos ad=89.3f pd=0.85u as=0.1598p ps=1.62u w=0.47u l=0.16u
X7430 cml_tlatch_32.xmux.xn.S1 B1_2_N stub_bi_29.BOTN VSS sg13_lv_nmos ad=63.19999f pd=0.74u as=63.19999f ps=0.74u w=0.26u l=0.38u
X7431 cml_tlatch_15.xmux.xp.S1 stub_bi_19.BOTP stub_bi_19.BOTN VSS sg13_lv_nmos ad=56.9f pd=0.74u as=56.9f ps=0.74u w=0.17u l=0.17u
X7432 cml_tlatch_39.xmux.xn.S1 cml_tlatch_39.INP MOT10_N VSS sg13_lv_nmos ad=63.19999f pd=0.74u as=63.19999f ps=0.74u w=0.26u l=0.38u
X7433 cml_tlatch_41.xmux.xn.S1 CKHA1_P cml_tlatch_41.xtail.S1 VSS sg13_lv_nmos ad=89.3f pd=0.85u as=89.3f ps=0.85u w=0.47u l=0.16u
X7434 cml_tlatch_84.xtail.S1 CKB3_N cml_tlatch_84.xmux.xn.S1 VSS sg13_lv_nmos ad=89.3f pd=0.85u as=89.3f ps=0.85u w=0.47u l=0.16u
X7435 cml_tlatch_89.xmux.xp.S1 CKA2_P cml_tlatch_89.xtail.S1 VSS sg13_lv_nmos ad=89.3f pd=0.85u as=89.3f ps=0.85u w=0.47u l=0.16u
X7436 MOT26_N cml_tlatch_57.INP cml_tlatch_57.xmux.xn.S1 VSS sg13_lv_nmos ad=63.19999f pd=0.74u as=63.19999f ps=0.74u w=0.26u l=0.38u
X7437 cml_tlatch_43.xmux.xp.S1 stub_bi_42.BOTN stub_bi_42.BOTP VSS sg13_lv_nmos ad=56.9f pd=0.74u as=56.9f ps=0.74u w=0.17u l=0.17u
X7438 MOT3_P MOT3_N cml_tlatch_18.xmux.xp.S1 VSS sg13_lv_nmos ad=56.9f pd=0.74u as=56.9f ps=0.74u w=0.17u l=0.17u
X7439 J2_P J1_N cml_tlatch_92.xmux.xn.S1 VSS sg13_lv_nmos ad=63.19999f pd=0.74u as=63.19999f ps=0.74u w=0.26u l=0.38u
X7440 stub_bi_32.BOTN stub_bi_32.BOTP cml_tlatch_48.xmux.xp.S1 VSS sg13_lv_nmos ad=56.9f pd=0.74u as=56.9f ps=0.74u w=0.17u l=0.17u
X7441 MOT25_P MOT25_N cml_tlatch_68.xmux.xp.S1 VSS sg13_lv_nmos ad=56.9f pd=0.74u as=56.9f ps=0.74u w=0.17u l=0.17u
X7442 cml_tlatch_8.xmux.xp.S1 cml_tlatch_8.OUTP cml_tlatch_8.OUTN VSS sg13_lv_nmos ad=56.9f pd=0.74u as=56.9f ps=0.74u w=0.17u l=0.17u
X7443 cml_tlatch_6.xtail.S1 CKHB1_N cml_tlatch_6.xmux.xp.S1 VSS sg13_lv_nmos ad=89.3f pd=0.85u as=89.3f ps=0.85u w=0.47u l=0.16u
X7444 cml_tlatch_29.OUTP cml_tlatch_29.OUTN cml_tlatch_29.xmux.xp.S1 VSS sg13_lv_nmos ad=56.9f pd=0.74u as=56.9f ps=0.74u w=0.17u l=0.17u
X7445 cml_tlatch_34.xmux.xn.S1 D1_N stub_bi_31.BOTN VSS sg13_lv_nmos ad=63.19999f pd=0.74u as=0.1082p ps=1.34u w=0.26u l=0.38u
X7446 cml_tlatch_42.xmux.xp.S1 cml_tlatch_56.INP cml_tlatch_56.INN VSS sg13_lv_nmos ad=56.9f pd=0.74u as=56.9f ps=0.74u w=0.17u l=0.17u
X7447 cml_tlatch_47.OUTN VDD VSS rppd l=5.17u w=1u
X7448 cml_tlatch_50.xmux.xp.S1 CKHA2_N cml_tlatch_50.xtail.S1 VSS sg13_lv_nmos ad=0.1598p pd=1.62u as=89.3f ps=0.85u w=0.47u l=0.16u
X7449 cml_tlatch_11.xmux.xp.S1 cml_tlatch_11.OUTN cml_tlatch_11.OUTP VSS sg13_lv_nmos ad=56.9f pd=0.74u as=56.9f ps=0.74u w=0.17u l=0.17u
X7450 cml_tlatch_41.xmux.xp.S1 MOT14_P MOT14_N VSS sg13_lv_nmos ad=56.9f pd=0.74u as=56.9f ps=0.74u w=0.17u l=0.17u
X7451 B2_2_N B2_2_P cml_tlatch_44.xmux.xp.S1 VSS sg13_lv_nmos ad=56.9f pd=0.74u as=56.9f ps=0.74u w=0.17u l=0.17u
X7452 A0_2_P A0_2_N cml_tlatch_31.xmux.xp.S1 VSS sg13_lv_nmos ad=56.9f pd=0.74u as=56.9f ps=0.74u w=0.17u l=0.17u
X7453 cml_tlatch_18.xmux.xn.S1 cml_tlatch_16.OUTN MOT3_P VSS sg13_lv_nmos ad=63.19999f pd=0.74u as=63.19999f ps=0.74u w=0.26u l=0.38u
X7454 cml_tlatch_90.xmux.xn.S1 CLK_W_P J4_P VSS sg13_lv_nmos ad=63.19999f pd=0.74u as=63.19999f ps=0.74u w=0.26u l=0.38u
X7455 MOT1_N MOT1_P cml_tlatch_17.xmux.xp.S1 VSS sg13_lv_nmos ad=56.9f pd=0.74u as=56.9f ps=0.74u w=0.17u l=0.17u
X7456 cml_tlatch_10.xmux.xp.S1 B0_8_N B0_8_P VSS sg13_lv_nmos ad=56.9f pd=0.74u as=56.9f ps=0.74u w=0.17u l=0.17u
X7457 cml_tlatch_39.xtail.S1 CKHA1_P cml_tlatch_39.xmux.xn.S1 VSS sg13_lv_nmos ad=89.3f pd=0.85u as=89.3f ps=0.85u w=0.47u l=0.16u
X7458 GA3_P VDD VSS rppd l=7.42u w=1u
X7459 cml_tlatch_37.xtail.S1 CKA1_N cml_tlatch_37.xmux.xn.S1 VSS sg13_lv_nmos ad=89.3f pd=0.85u as=89.3f ps=0.85u w=0.47u l=0.16u
X7460 cml_tlatch_61.xmux.xp.S1 cml_tlatch_61.OUTP cml_tlatch_61.OUTN VSS sg13_lv_nmos ad=56.9f pd=0.74u as=56.9f ps=0.74u w=0.17u l=0.17u
X7461 cml_tlatch_27.OUTP cml_tlatch_27.OUTN cml_tlatch_27.xmux.xp.S1 VSS sg13_lv_nmos ad=56.9f pd=0.74u as=56.9f ps=0.74u w=0.17u l=0.17u
X7462 cml_tlatch_19.xmux.xp.S1 MOT5_P MOT5_N VSS sg13_lv_nmos ad=0.1019p pd=1.34u as=56.9f ps=0.74u w=0.17u l=0.17u
X7463 cml_tlatch_66.xmux.xp.S1 cml_tlatch_57.INP cml_tlatch_57.INN VSS sg13_lv_nmos ad=56.9f pd=0.74u as=56.9f ps=0.74u w=0.17u l=0.17u
X7464 cml_tlatch_69.INN cml_tlatch_69.INP cml_tlatch_62.xmux.xp.S1 VSS sg13_lv_nmos ad=56.9f pd=0.74u as=56.9f ps=0.74u w=0.17u l=0.17u
X7465 cml_tlatch_89.INP A2_2_N cml_tlatch_55.xmux.xn.S1 VSS sg13_lv_nmos ad=63.19999f pd=0.74u as=63.19999f ps=0.74u w=0.26u l=0.38u
X7466 cml_tlatch_69.INP cml_tlatch_69.INN cml_tlatch_62.xmux.xp.S1 VSS sg13_lv_nmos ad=56.9f pd=0.74u as=56.9f ps=0.74u w=0.17u l=0.17u
X7467 cml_tlatch_56.xmux.xp.S1 A2_2_N A2_2_P VSS sg13_lv_nmos ad=56.9f pd=0.74u as=56.9f ps=0.74u w=0.17u l=0.17u
X7468 J4_P J4_N cml_tlatch_90.xmux.xp.S1 VSS sg13_lv_nmos ad=56.9f pd=0.74u as=56.9f ps=0.74u w=0.17u l=0.17u
X7469 MOT8_N A1_8_P cml_tlatch_96.xmux.xn.S1 VSS sg13_lv_nmos ad=63.19999f pd=0.74u as=63.19999f ps=0.74u w=0.26u l=0.38u
X7470 hs_to_clk_8.D2 POLN VSS VSS sg13_lv_nmos ad=3.4p pd=20.68u as=1.9p ps=10.38u w=10u l=0.13u
X7471 cml_tlatch_22.xmux.xn.S1 cml_tlatch_39.INP cml_tlatch_22.OUTN VSS sg13_lv_nmos ad=63.19999f pd=0.74u as=63.19999f ps=0.74u w=0.26u l=0.38u
X7472 cml_tlatch_98.xtail.S1 POLN VSS VSS sg13_lv_nmos ad=1.5637p pd=8.61u as=1.5637p ps=8.61u w=8.23u l=0.13u
X7473 GB1_N ENB1_P cml_gate2_0.sg13_lv_nmos_FTPY57_0.D0 VSS sg13_lv_nmos ad=0.1007p pd=0.91u as=0.1007p ps=0.91u w=0.53u l=0.13u
X7474 cml_tlatch_93.xmux.xp.S1 J1_N J1_P VSS sg13_lv_nmos ad=56.9f pd=0.74u as=56.9f ps=0.74u w=0.17u l=0.17u
X7475 cml_tlatch_60.xmux.xn.S1 cml_tlatch_61.OUTN B3_8_P VSS sg13_lv_nmos ad=0.1082p pd=1.34u as=63.19999f ps=0.74u w=0.26u l=0.38u
X7476 cml_tlatch_50.xmux.xp.S1 MOT20_N MOT20_P VSS sg13_lv_nmos ad=56.9f pd=0.74u as=56.9f ps=0.74u w=0.17u l=0.17u
X7477 cml_tlatch_14.xmux.xp.S1 cml_tlatch_5.INP cml_tlatch_5.INN VSS sg13_lv_nmos ad=56.9f pd=0.74u as=56.9f ps=0.74u w=0.17u l=0.17u
X7478 cml_tlatch_14.xmux.xp.S1 cml_tlatch_5.INN cml_tlatch_5.INP VSS sg13_lv_nmos ad=56.9f pd=0.74u as=56.9f ps=0.74u w=0.17u l=0.17u
X7479 VDD MOT21_P VSS rppd l=5.17u w=1u
X7480 cml_tlatch_74.xmux.xn.S1 stub_bi_63.BOTN MOT19_N VSS sg13_lv_nmos ad=63.19999f pd=0.74u as=63.19999f ps=0.74u w=0.26u l=0.38u
X7481 cml_tlatch_73.xtail.S1 POLN VSS VSS sg13_lv_nmos ad=1.5637p pd=8.61u as=2.7982p ps=17.14u w=8.23u l=0.13u
X7482 cml_tlatch_5.xmux.xp.S1 MOT11_P MOT11_N VSS sg13_lv_nmos ad=56.9f pd=0.74u as=56.9f ps=0.74u w=0.17u l=0.17u
X7483 ENA1_P ENA_N cml_drv_1.xrtail.R1 VSS sg13_lv_nmos ad=56.2f pd=0.74u as=56.2f ps=0.74u w=0.16u l=0.19u
X7484 cml_tlatch_60.xmux.xn.S1 cml_tlatch_61.OUTN B3_8_P VSS sg13_lv_nmos ad=63.19999f pd=0.74u as=63.19999f ps=0.74u w=0.26u l=0.38u
X7485 cml_tlatch_91.xmux.xn.S1 J2_N CLK_W_N VSS sg13_lv_nmos ad=63.19999f pd=0.74u as=63.19999f ps=0.74u w=0.26u l=0.38u
X7486 CLK_W_P CLK_W_N cml_tlatch_91.xmux.xp.S1 VSS sg13_lv_nmos ad=56.9f pd=0.74u as=56.9f ps=0.74u w=0.17u l=0.17u
X7487 cml_tlatch_48.xtail.S1 CKB2_P cml_tlatch_48.xmux.xn.S1 VSS sg13_lv_nmos ad=89.3f pd=0.85u as=0.1598p ps=1.62u w=0.47u l=0.16u
X7488 MOT4_P cml_tlatch_99.OUTN cml_tlatch_25.xmux.xn.S1 VSS sg13_lv_nmos ad=63.19999f pd=0.74u as=63.19999f ps=0.74u w=0.26u l=0.38u
X7489 cml_tlatch_98.OUTN cml_tlatch_27.OUTP cml_tlatch_98.xmux.xn.S1 VSS sg13_lv_nmos ad=63.19999f pd=0.74u as=63.19999f ps=0.74u w=0.26u l=0.38u
X7490 cml_tlatch_21.xmux.xn.S1 cml_tlatch_22.OUTN A1_8_P VSS sg13_lv_nmos ad=63.19999f pd=0.74u as=63.19999f ps=0.74u w=0.26u l=0.38u
X7491 CLK_W_P J2_P cml_tlatch_91.xmux.xn.S1 VSS sg13_lv_nmos ad=63.19999f pd=0.74u as=63.19999f ps=0.74u w=0.26u l=0.38u
X7492 cml_tlatch_83.INP cml_tlatch_83.INN cml_tlatch_72.xmux.xp.S1 VSS sg13_lv_nmos ad=56.9f pd=0.74u as=56.9f ps=0.74u w=0.17u l=0.17u
X7493 cml_tlatch_97.xtail.S1 CKHA0_N cml_tlatch_97.xmux.xp.S1 VSS sg13_lv_nmos ad=89.3f pd=0.85u as=89.3f ps=0.85u w=0.47u l=0.16u
X7494 cml_tlatch_93.xmux.xp.S1 J1_N J1_P VSS sg13_lv_nmos ad=0.1019p pd=1.34u as=56.9f ps=0.74u w=0.17u l=0.17u
X7495 cml_tlatch_89.OUTN cml_tlatch_89.OUTP cml_tlatch_89.xmux.xp.S1 VSS sg13_lv_nmos ad=56.9f pd=0.74u as=56.9f ps=0.74u w=0.17u l=0.17u
X7496 cml_tlatch_88.xmux.xp.S1 stub_bi_55.BOTN stub_bi_55.BOTP VSS sg13_lv_nmos ad=56.9f pd=0.74u as=56.9f ps=0.74u w=0.17u l=0.17u
X7497 cml_tlatch_70.INP cml_tlatch_45.OUTN cml_tlatch_84.xmux.xn.S1 VSS sg13_lv_nmos ad=63.19999f pd=0.74u as=63.19999f ps=0.74u w=0.26u l=0.38u
X7498 cml_tlatch_1.xmux.xp.S1 CKB0_N cml_tlatch_1.xtail.S1 VSS sg13_lv_nmos ad=89.3f pd=0.85u as=89.3f ps=0.85u w=0.47u l=0.16u
X7499 cml_tlatch_15.xmux.xp.S1 CKB1_N cml_tlatch_15.xtail.S1 VSS sg13_lv_nmos ad=89.3f pd=0.85u as=89.3f ps=0.85u w=0.47u l=0.16u
X7500 cml_tlatch_1.xmux.xn.S1 CKB0_P cml_tlatch_1.xtail.S1 VSS sg13_lv_nmos ad=89.3f pd=0.85u as=89.3f ps=0.85u w=0.47u l=0.16u
X7501 cml_tlatch_29.OUTN cml_tlatch_29.OUTP cml_tlatch_29.xmux.xp.S1 VSS sg13_lv_nmos ad=56.9f pd=0.74u as=56.9f ps=0.74u w=0.17u l=0.17u
X7502 cml_gate2_0.sg13_lv_nmos_FTPY57_0.D0 ENB1_N GB1_P VSS sg13_lv_nmos ad=0.1007p pd=0.91u as=0.1007p ps=0.91u w=0.53u l=0.13u
X7503 A0_8_N cml_tlatch_3.OUTP cml_tlatch_2.xmux.xn.S1 VSS sg13_lv_nmos ad=63.19999f pd=0.74u as=63.19999f ps=0.74u w=0.26u l=0.38u
X7504 cml_tlatch_50.xmux.xp.S1 MOT20_P MOT20_N VSS sg13_lv_nmos ad=56.9f pd=0.74u as=56.9f ps=0.74u w=0.17u l=0.17u
X7505 cml_tlatch_47.xtail.S1 CKB3_P cml_tlatch_47.xmux.xn.S1 VSS sg13_lv_nmos ad=89.3f pd=0.85u as=89.3f ps=0.85u w=0.47u l=0.16u
X7506 MOT28_N MOT28_P cml_tlatch_58.xmux.xp.S1 VSS sg13_lv_nmos ad=56.9f pd=0.74u as=56.9f ps=0.74u w=0.17u l=0.17u
X7507 cml_tlatch_43.xmux.xp.S1 CKB2_N cml_tlatch_43.xtail.S1 VSS sg13_lv_nmos ad=89.3f pd=0.85u as=89.3f ps=0.85u w=0.47u l=0.16u
X7508 MOT4_P MOT4_N cml_tlatch_25.xmux.xp.S1 VSS sg13_lv_nmos ad=56.9f pd=0.74u as=56.9f ps=0.74u w=0.17u l=0.17u
X7509 cml_tlatch_27.OUTN B0_2_P cml_tlatch_27.xmux.xn.S1 VSS sg13_lv_nmos ad=63.19999f pd=0.74u as=63.19999f ps=0.74u w=0.26u l=0.38u
X7510 MOT2_P MOT2_N cml_tlatch_24.xmux.xp.S1 VSS sg13_lv_nmos ad=56.9f pd=0.74u as=56.9f ps=0.74u w=0.17u l=0.17u
X7511 cml_tlatch_38.xmux.xn.S1 CKA1_P cml_tlatch_38.xtail.S1 VSS sg13_lv_nmos ad=0.1598p pd=1.62u as=89.3f ps=0.85u w=0.47u l=0.16u
X7512 cml_tlatch_52.xmux.xp.S1 CKA3_N cml_tlatch_52.xtail.S1 VSS sg13_lv_nmos ad=89.3f pd=0.85u as=89.3f ps=0.85u w=0.47u l=0.16u
X7513 cml_gate2_7.xrtail.R1 CKA2_P cml_gate2_7.sg13_lv_nmos_FTPY57_0.D0 VSS sg13_lv_nmos ad=0.1007p pd=0.91u as=0.1007p ps=0.91u w=0.53u l=0.13u
X7514 cml_tlatch_28.xmux.xp.S1 B0_2_N B0_2_P VSS sg13_lv_nmos ad=56.9f pd=0.74u as=56.9f ps=0.74u w=0.17u l=0.17u
X7515 cml_tlatch_41.xmux.xp.S1 CKHA1_N cml_tlatch_41.xtail.S1 VSS sg13_lv_nmos ad=89.3f pd=0.85u as=89.3f ps=0.85u w=0.47u l=0.16u
X7516 A2_8_N A2_8_P cml_tlatch_81.xmux.xp.S1 VSS sg13_lv_nmos ad=56.9f pd=0.74u as=56.9f ps=0.74u w=0.17u l=0.17u
X7517 cml_tlatch_76.xmux.xp.S1 MOT23_N MOT23_P VSS sg13_lv_nmos ad=56.9f pd=0.74u as=56.9f ps=0.74u w=0.17u l=0.17u
X7518 cml_tlatch_77.xmux.xp.S1 B2_8_P B2_8_N VSS sg13_lv_nmos ad=56.9f pd=0.74u as=56.9f ps=0.74u w=0.17u l=0.17u
X7519 B1_8_P B1_8_N cml_tlatch_12.xmux.xp.S1 VSS sg13_lv_nmos ad=56.9f pd=0.74u as=56.9f ps=0.74u w=0.17u l=0.17u
X7520 cml_tlatch_44.xmux.xp.S1 B2_2_N B2_2_P VSS sg13_lv_nmos ad=56.9f pd=0.74u as=56.9f ps=0.74u w=0.17u l=0.17u
X7521 cml_tlatch_83.xmux.xn.S1 CKA2_N cml_tlatch_83.xtail.S1 VSS sg13_lv_nmos ad=89.3f pd=0.85u as=89.3f ps=0.85u w=0.47u l=0.16u
X7522 cml_tlatch_42.xmux.xp.S1 cml_tlatch_56.INP cml_tlatch_56.INN VSS sg13_lv_nmos ad=56.9f pd=0.74u as=56.9f ps=0.74u w=0.17u l=0.17u
X7523 cml_tlatch_4.xmux.xn.S1 B1_8_N MOT9_P VSS sg13_lv_nmos ad=63.19999f pd=0.74u as=63.19999f ps=0.74u w=0.26u l=0.38u
X7524 stub_bi_32.BOTP stub_bi_32.BOTN cml_tlatch_48.xmux.xp.S1 VSS sg13_lv_nmos ad=56.9f pd=0.74u as=56.9f ps=0.74u w=0.17u l=0.17u
X7525 cml_tlatch_8.OUTP cml_tlatch_8.OUTN cml_tlatch_8.xmux.xp.S1 VSS sg13_lv_nmos ad=56.9f pd=0.74u as=56.9f ps=0.74u w=0.17u l=0.17u
X7526 cml_tlatch_62.xmux.xn.S1 cml_tlatch_63.OUTN cml_tlatch_69.INP VSS sg13_lv_nmos ad=63.19999f pd=0.74u as=63.19999f ps=0.74u w=0.26u l=0.38u
X7527 cml_gate2_1.sg13_lv_nmos_FTPY57_0.D0 ENB1_P GB0_N VSS sg13_lv_nmos ad=0.1007p pd=0.91u as=0.1007p ps=0.91u w=0.53u l=0.13u
X7528 cml_tlatch_30.xtail.S1 CKA0_P cml_tlatch_30.xmux.xn.S1 VSS sg13_lv_nmos ad=89.3f pd=0.85u as=89.3f ps=0.85u w=0.47u l=0.16u
X7529 cml_tlatch_89.INP cml_tlatch_89.INN cml_tlatch_55.xmux.xp.S1 VSS sg13_lv_nmos ad=56.9f pd=0.74u as=56.9f ps=0.74u w=0.17u l=0.17u
X7530 cml_tlatch_43.xmux.xp.S1 stub_bi_42.BOTP stub_bi_42.BOTN VSS sg13_lv_nmos ad=56.9f pd=0.74u as=56.9f ps=0.74u w=0.17u l=0.17u
X7531 cml_tlatch_9.OUTP cml_tlatch_99.OUTN cml_tlatch_9.xmux.xn.S1 VSS sg13_lv_nmos ad=63.19999f pd=0.74u as=63.19999f ps=0.74u w=0.26u l=0.38u
X7532 cml_tlatch_4.xmux.xp.S1 MOT9_P MOT9_N VSS sg13_lv_nmos ad=56.9f pd=0.74u as=56.9f ps=0.74u w=0.17u l=0.17u
X7533 GB2_P CKA2_N cml_gate2_7.xrtail.R1 VSS sg13_lv_nmos ad=0.1007p pd=0.91u as=0.1007p ps=0.91u w=0.53u l=0.13u
X7534 cml_tlatch_97.xmux.xp.S1 MOT0_N MOT0_P VSS sg13_lv_nmos ad=56.9f pd=0.74u as=56.9f ps=0.74u w=0.17u l=0.17u
X7535 MOT21_P MOT21_N cml_tlatch_75.xmux.xp.S1 VSS sg13_lv_nmos ad=56.9f pd=0.74u as=56.9f ps=0.74u w=0.17u l=0.17u
X7536 cml_tlatch_82.OUTN cml_tlatch_82.OUTP cml_tlatch_82.xmux.xp.S1 VSS sg13_lv_nmos ad=56.9f pd=0.74u as=56.9f ps=0.74u w=0.17u l=0.17u
X7537 cml_tlatch_52.OUTN cml_tlatch_52.OUTP cml_tlatch_52.xmux.xp.S1 VSS sg13_lv_nmos ad=56.9f pd=0.74u as=56.9f ps=0.74u w=0.17u l=0.17u
X7538 cml_tlatch_70.xmux.xp.S1 MOT29_N MOT29_P VSS sg13_lv_nmos ad=56.9f pd=0.74u as=56.9f ps=0.74u w=0.17u l=0.17u
X7539 cml_tlatch_75.xtail.S1 POLN VSS VSS sg13_lv_nmos ad=1.5637p pd=8.61u as=1.5637p ps=8.61u w=8.23u l=0.13u
X7540 cml_tlatch_10.xmux.xn.S1 CKB0_N cml_tlatch_10.xtail.S1 VSS sg13_lv_nmos ad=89.3f pd=0.85u as=89.3f ps=0.85u w=0.47u l=0.16u
X7541 B3_8_P B3_8_N cml_tlatch_60.xmux.xp.S1 VSS sg13_lv_nmos ad=56.9f pd=0.74u as=56.9f ps=0.74u w=0.17u l=0.17u
X7542 ENB_P J2_N cml_gate2_8.sg13_lv_nmos_FTPY57_0.D0 VSS sg13_lv_nmos ad=0.1007p pd=0.91u as=0.1007p ps=0.91u w=0.53u l=0.13u
X7543 cml_tlatch_84.xmux.xn.S1 CKB3_N cml_tlatch_84.xtail.S1 VSS sg13_lv_nmos ad=89.3f pd=0.85u as=89.3f ps=0.85u w=0.47u l=0.16u
X7544 CLK_W_P CLK_W_N cml_tlatch_91.xmux.xp.S1 VSS sg13_lv_nmos ad=56.9f pd=0.74u as=56.9f ps=0.74u w=0.17u l=0.17u
X7545 stub_bi_63.BOTP stub_bi_49.BOTN cml_tlatch_79.xmux.xn.S1 VSS sg13_lv_nmos ad=63.19999f pd=0.74u as=63.19999f ps=0.74u w=0.26u l=0.38u
X7546 MOT7_P MOT7_N cml_tlatch_20.xmux.xp.S1 VSS sg13_lv_nmos ad=56.9f pd=0.74u as=56.9f ps=0.74u w=0.17u l=0.17u
X7547 MOT22_P MOT22_N cml_tlatch_51.xmux.xp.S1 VSS sg13_lv_nmos ad=56.9f pd=0.74u as=56.9f ps=0.74u w=0.17u l=0.17u
X7548 MOT16_N MOT16_P cml_tlatch_87.xmux.xp.S1 VSS sg13_lv_nmos ad=56.9f pd=0.74u as=56.9f ps=0.74u w=0.17u l=0.17u
X7549 cml_tlatch_36.xmux.xp.S1 cml_tlatch_95.INP cml_tlatch_95.INN VSS sg13_lv_nmos ad=56.9f pd=0.74u as=56.9f ps=0.74u w=0.17u l=0.17u
X7550 MOT23_N MOT23_P cml_tlatch_76.xmux.xp.S1 VSS sg13_lv_nmos ad=56.9f pd=0.74u as=56.9f ps=0.74u w=0.17u l=0.17u
X7551 MOT7_P B0_2_N cml_tlatch_20.xmux.xn.S1 VSS sg13_lv_nmos ad=63.19999f pd=0.74u as=0.1082p ps=1.34u w=0.26u l=0.38u
X7552 stub_bi_29.BOTP stub_bi_29.BOTN cml_tlatch_32.xmux.xp.S1 VSS sg13_lv_nmos ad=56.9f pd=0.74u as=56.9f ps=0.74u w=0.17u l=0.17u
X7553 cml_tlatch_71.xmux.xp.S1 MOT31_P MOT31_N VSS sg13_lv_nmos ad=56.9f pd=0.74u as=56.9f ps=0.74u w=0.17u l=0.17u
X7554 cml_tlatch_42.xtail.S1 CKA2_N cml_tlatch_42.xmux.xp.S1 VSS sg13_lv_nmos ad=89.3f pd=0.85u as=89.3f ps=0.85u w=0.47u l=0.16u
X7555 cml_tlatch_69.xmux.xp.S1 CKHB3_N cml_tlatch_69.xtail.S1 VSS sg13_lv_nmos ad=89.3f pd=0.85u as=89.3f ps=0.85u w=0.47u l=0.16u
X7556 cml_tlatch_73.xmux.xp.S1 CKHB2_N cml_tlatch_73.xtail.S1 VSS sg13_lv_nmos ad=0.1598p pd=1.62u as=89.3f ps=0.85u w=0.47u l=0.16u
X7557 cml_drvb_7.xrtail.R1 GB2_P CKHB2_N VSS sg13_lv_nmos ad=0.1463p pd=1.15u as=0.2618p ps=2.22u w=0.77u l=0.21u
X7558 cml_tlatch_3.xtail.S1 CKA0_N cml_tlatch_3.xmux.xp.S1 VSS sg13_lv_nmos ad=89.3f pd=0.85u as=89.3f ps=0.85u w=0.47u l=0.16u
X7559 cml_tlatch_20.xmux.xn.S1 B0_2_P MOT7_N VSS sg13_lv_nmos ad=63.19999f pd=0.74u as=63.19999f ps=0.74u w=0.26u l=0.38u
X7560 cml_tlatch_50.xmux.xp.S1 MOT20_N MOT20_P VSS sg13_lv_nmos ad=56.9f pd=0.74u as=56.9f ps=0.74u w=0.17u l=0.17u
X7561 cml_tlatch_35.xmux.xn.S1 D0_P cml_tlatch_35.OUTN VSS sg13_lv_nmos ad=63.19999f pd=0.74u as=63.19999f ps=0.74u w=0.26u l=0.38u
X7562 cml_tlatch_19.xmux.xn.S1 CKHB0_P cml_tlatch_19.xtail.S1 VSS sg13_lv_nmos ad=89.3f pd=0.85u as=89.3f ps=0.85u w=0.47u l=0.16u
X7563 MOT14_P MOT14_N cml_tlatch_41.xmux.xp.S1 VSS sg13_lv_nmos ad=56.9f pd=0.74u as=56.9f ps=0.74u w=0.17u l=0.17u
X7564 cml_tlatch_68.xmux.xp.S1 MOT25_P MOT25_N VSS sg13_lv_nmos ad=56.9f pd=0.74u as=56.9f ps=0.74u w=0.17u l=0.17u
X7565 hs_to_clk_6.D2 CK_N CKB2_P VSS sg13_lv_nmos ad=0.228p pd=1.58u as=0.408p ps=3.08u w=1.2u l=0.2u
X7566 cml_tlatch_29.xtail.S1 CKB0_P cml_tlatch_29.xmux.xn.S1 VSS sg13_lv_nmos ad=89.3f pd=0.85u as=89.3f ps=0.85u w=0.47u l=0.16u
X7567 cml_tlatch_99.xmux.xp.S1 cml_tlatch_99.OUTP cml_tlatch_99.OUTN VSS sg13_lv_nmos ad=56.9f pd=0.74u as=56.9f ps=0.74u w=0.17u l=0.17u
X7568 cml_tlatch_0.xmux.xn.S1 CKA1_P cml_tlatch_0.xtail.S1 VSS sg13_lv_nmos ad=89.3f pd=0.85u as=89.3f ps=0.85u w=0.47u l=0.16u
X7569 VSS hs_to_clk_8.sg13_lv_nmos_2HGZLP_0.G VSS VSS sg13_lv_nmos ad=2.071p pd=11.28u as=0 ps=0 w=10.9u l=1.38u
X7570 cml_tlatch_83.INP cml_tlatch_83.INN cml_tlatch_72.xmux.xp.S1 VSS sg13_lv_nmos ad=56.9f pd=0.74u as=56.9f ps=0.74u w=0.17u l=0.17u
X7571 cml_tlatch_40.xmux.xp.S1 MOT12_N MOT12_P VSS sg13_lv_nmos ad=56.9f pd=0.74u as=56.9f ps=0.74u w=0.17u l=0.17u
X7572 cml_tlatch_80.xmux.xp.S1 stub_bi_49.BOTP stub_bi_49.BOTN VSS sg13_lv_nmos ad=56.9f pd=0.74u as=56.9f ps=0.74u w=0.17u l=0.17u
X7573 cml_tlatch_48.xtail.S1 CKB2_N cml_tlatch_48.xmux.xp.S1 VSS sg13_lv_nmos ad=89.3f pd=0.85u as=89.3f ps=0.85u w=0.47u l=0.16u
X7574 cml_tlatch_60.xmux.xp.S1 B3_8_N B3_8_P VSS sg13_lv_nmos ad=56.9f pd=0.74u as=56.9f ps=0.74u w=0.17u l=0.17u
X7575 cml_tlatch_88.xmux.xp.S1 stub_bi_55.BOTN stub_bi_55.BOTP VSS sg13_lv_nmos ad=56.9f pd=0.74u as=56.9f ps=0.74u w=0.17u l=0.17u
X7576 stub_bi_19.BOTN cml_tlatch_6.INN cml_tlatch_15.xmux.xn.S1 VSS sg13_lv_nmos ad=63.19999f pd=0.74u as=63.19999f ps=0.74u w=0.26u l=0.38u
X7577 A2_2_N cml_tlatch_56.INP cml_tlatch_56.xmux.xn.S1 VSS sg13_lv_nmos ad=63.19999f pd=0.74u as=63.19999f ps=0.74u w=0.26u l=0.38u
X7578 cml_tlatch_0.xtail.S1 POLN VSS VSS sg13_lv_nmos ad=1.5637p pd=8.61u as=2.7982p ps=17.14u w=8.23u l=0.13u
X7579 cml_tlatch_54.xtail.S1 CKA3_N cml_tlatch_54.xmux.xp.S1 VSS sg13_lv_nmos ad=89.3f pd=0.85u as=89.3f ps=0.85u w=0.47u l=0.16u
X7580 VDD MOT17_P VSS rppd l=5.17u w=1u
X7581 cml_tlatch_29.OUTN cml_tlatch_29.OUTP cml_tlatch_29.xmux.xp.S1 VSS sg13_lv_nmos ad=56.9f pd=0.74u as=56.9f ps=0.74u w=0.17u l=0.17u
X7582 cml_gate2_2.xrtail.R1 CKB0_P cml_gate2_2.sg13_lv_nmos_FTPY57_0.D0 VSS sg13_lv_nmos ad=0.1007p pd=0.91u as=0.1007p ps=0.91u w=0.53u l=0.13u
X7583 cml_tlatch_7.xmux.xn.S1 B1_2_N MOT15_P VSS sg13_lv_nmos ad=0.1082p pd=1.34u as=63.19999f ps=0.74u w=0.26u l=0.38u
X7584 cml_tlatch_15.xmux.xn.S1 CKB1_P cml_tlatch_15.xtail.S1 VSS sg13_lv_nmos ad=89.3f pd=0.85u as=89.3f ps=0.85u w=0.47u l=0.16u
X7585 MOT6_P A0_2_N cml_tlatch_26.xmux.xn.S1 VSS sg13_lv_nmos ad=63.19999f pd=0.74u as=63.19999f ps=0.74u w=0.26u l=0.38u
X7586 cml_tlatch_63.xmux.xn.S1 cml_tlatch_70.INN cml_tlatch_63.OUTP VSS sg13_lv_nmos ad=63.19999f pd=0.74u as=63.19999f ps=0.74u w=0.26u l=0.38u
X7587 cml_tlatch_73.xmux.xp.S1 MOT17_N MOT17_P VSS sg13_lv_nmos ad=56.9f pd=0.74u as=56.9f ps=0.74u w=0.17u l=0.17u
X7588 cml_tlatch_30.xtail.S1 CKA0_N cml_tlatch_30.xmux.xp.S1 VSS sg13_lv_nmos ad=89.3f pd=0.85u as=89.3f ps=0.85u w=0.47u l=0.16u
X7589 cml_tlatch_70.xtail.S1 CKHB3_N cml_tlatch_70.xmux.xp.S1 VSS sg13_lv_nmos ad=0.1598p pd=1.62u as=89.3f ps=0.85u w=0.47u l=0.16u
X7590 cml_tlatch_15.xmux.xn.S1 cml_tlatch_6.INP stub_bi_19.BOTP VSS sg13_lv_nmos ad=63.19999f pd=0.74u as=63.19999f ps=0.74u w=0.26u l=0.38u
X7591 B2_2_N VDD VSS rppd l=5.17u w=1u
X7592 cml_tlatch_89.OUTP cml_tlatch_89.OUTN cml_tlatch_89.xmux.xp.S1 VSS sg13_lv_nmos ad=56.9f pd=0.74u as=56.9f ps=0.74u w=0.17u l=0.17u
X7593 stub_bi_62.BOTP stub_bi_62.BOTN cml_tlatch_78.xmux.xp.S1 VSS sg13_lv_nmos ad=56.9f pd=0.74u as=56.9f ps=0.74u w=0.17u l=0.17u
X7594 cml_tlatch_10.xmux.xp.S1 CKB0_P cml_tlatch_10.xtail.S1 VSS sg13_lv_nmos ad=89.3f pd=0.85u as=89.3f ps=0.85u w=0.47u l=0.16u
X7595 cml_tlatch_9.xmux.xn.S1 CKA0_P cml_tlatch_9.xtail.S1 VSS sg13_lv_nmos ad=89.3f pd=0.85u as=0.1598p ps=1.62u w=0.47u l=0.16u
X7596 cml_tlatch_3.OUTP cml_tlatch_3.OUTN cml_tlatch_3.xmux.xp.S1 VSS sg13_lv_nmos ad=56.9f pd=0.74u as=56.9f ps=0.74u w=0.17u l=0.17u
X7597 cml_tlatch_38.xmux.xn.S1 D1_P cml_tlatch_38.OUTN VSS sg13_lv_nmos ad=63.19999f pd=0.74u as=63.19999f ps=0.74u w=0.26u l=0.38u
X7598 cml_tlatch_15.xmux.xn.S1 cml_tlatch_6.INP stub_bi_19.BOTP VSS sg13_lv_nmos ad=63.19999f pd=0.74u as=63.19999f ps=0.74u w=0.26u l=0.38u
X7599 cml_tlatch_98.xmux.xn.S1 cml_tlatch_27.OUTN cml_tlatch_98.OUTP VSS sg13_lv_nmos ad=63.19999f pd=0.74u as=63.19999f ps=0.74u w=0.26u l=0.38u
X7600 cml_tlatch_53.xmux.xp.S1 A3_2_P A3_2_N VSS sg13_lv_nmos ad=56.9f pd=0.74u as=56.9f ps=0.74u w=0.17u l=0.17u
X7601 B3_2_N B3_2_P cml_tlatch_46.xmux.xp.S1 VSS sg13_lv_nmos ad=56.9f pd=0.74u as=56.9f ps=0.74u w=0.17u l=0.17u
X7602 cml_tlatch_49.xmux.xp.S1 MOT18_P MOT18_N VSS sg13_lv_nmos ad=56.9f pd=0.74u as=56.9f ps=0.74u w=0.17u l=0.17u
X7603 cml_tlatch_76.xmux.xp.S1 MOT23_N MOT23_P VSS sg13_lv_nmos ad=56.9f pd=0.74u as=56.9f ps=0.74u w=0.17u l=0.17u
X7604 cml_tlatch_30.xmux.xp.S1 cml_tlatch_30.OUTP cml_tlatch_30.OUTN VSS sg13_lv_nmos ad=56.9f pd=0.74u as=56.9f ps=0.74u w=0.17u l=0.17u
X7605 cml_tlatch_89.xmux.xp.S1 CKA2_P cml_tlatch_89.xtail.S1 VSS sg13_lv_nmos ad=89.3f pd=0.85u as=89.3f ps=0.85u w=0.47u l=0.16u
X7606 A1_2_P A1_2_N cml_tlatch_37.xmux.xp.S1 VSS sg13_lv_nmos ad=56.9f pd=0.74u as=56.9f ps=0.74u w=0.17u l=0.17u
X7607 cml_tlatch_54.OUTP D3_N cml_tlatch_54.xmux.xn.S1 VSS sg13_lv_nmos ad=0.1082p pd=1.34u as=63.19999f ps=0.74u w=0.26u l=0.38u
X7608 cml_tlatch_21.xtail.S1 CKA1_P cml_tlatch_21.xmux.xp.S1 VSS sg13_lv_nmos ad=89.3f pd=0.85u as=89.3f ps=0.85u w=0.47u l=0.16u
X7609 MOT21_P stub_bi_55.BOTP cml_tlatch_75.xmux.xn.S1 VSS sg13_lv_nmos ad=63.19999f pd=0.74u as=63.19999f ps=0.74u w=0.26u l=0.38u
X7610 cml_tlatch_6.xtail.S1 CKHB1_N cml_tlatch_6.xmux.xp.S1 VSS sg13_lv_nmos ad=89.3f pd=0.85u as=89.3f ps=0.85u w=0.47u l=0.16u
X7611 cml_tlatch_36.xmux.xn.S1 CKA1_P cml_tlatch_36.xtail.S1 VSS sg13_lv_nmos ad=89.3f pd=0.85u as=89.3f ps=0.85u w=0.47u l=0.16u
X7612 cml_tlatch_21.xmux.xp.S1 A1_8_P A1_8_N VSS sg13_lv_nmos ad=56.9f pd=0.74u as=56.9f ps=0.74u w=0.17u l=0.17u
X7613 MOT1_P MOT1_N cml_tlatch_17.xmux.xp.S1 VSS sg13_lv_nmos ad=56.9f pd=0.74u as=56.9f ps=0.74u w=0.17u l=0.17u
X7614 cml_tlatch_7.xmux.xp.S1 MOT15_N MOT15_P VSS sg13_lv_nmos ad=56.9f pd=0.74u as=56.9f ps=0.74u w=0.17u l=0.17u
X7615 cml_tlatch_28.xmux.xp.S1 CKB0_P cml_tlatch_28.xtail.S1 VSS sg13_lv_nmos ad=89.3f pd=0.85u as=89.3f ps=0.85u w=0.47u l=0.16u
X7616 cml_tlatch_83.OUTN cml_tlatch_83.OUTP cml_tlatch_83.xmux.xp.S1 VSS sg13_lv_nmos ad=56.9f pd=0.74u as=56.9f ps=0.74u w=0.17u l=0.17u
X7617 cml_tlatch_45.xmux.xp.S1 cml_tlatch_45.OUTP cml_tlatch_45.OUTN VSS sg13_lv_nmos ad=56.9f pd=0.74u as=56.9f ps=0.74u w=0.17u l=0.17u
X7618 cml_tlatch_6.xtail.S1 POLN VSS VSS sg13_lv_nmos ad=1.5637p pd=8.61u as=2.7982p ps=17.14u w=8.23u l=0.13u
X7619 cml_tlatch_61.xmux.xn.S1 CKB3_P cml_tlatch_61.xtail.S1 VSS sg13_lv_nmos ad=89.3f pd=0.85u as=89.3f ps=0.85u w=0.47u l=0.16u
X7620 cml_tlatch_79.xmux.xp.S1 stub_bi_63.BOTP stub_bi_63.BOTN VSS sg13_lv_nmos ad=56.9f pd=0.74u as=56.9f ps=0.74u w=0.17u l=0.17u
X7621 VDD J1_P VSS rppd l=5.17u w=1u
X7622 cml_tlatch_79.xmux.xp.S1 CKB2_P cml_tlatch_79.xtail.S1 VSS sg13_lv_nmos ad=89.3f pd=0.85u as=89.3f ps=0.85u w=0.47u l=0.16u
X7623 cml_tlatch_72.xmux.xn.S1 cml_tlatch_89.OUTN cml_tlatch_83.INP VSS sg13_lv_nmos ad=63.19999f pd=0.74u as=63.19999f ps=0.74u w=0.26u l=0.38u
X7624 cml_tlatch_36.xmux.xp.S1 cml_tlatch_95.INN cml_tlatch_95.INP VSS sg13_lv_nmos ad=56.9f pd=0.74u as=56.9f ps=0.74u w=0.17u l=0.17u
X7625 cml_tlatch_8.xtail.S1 CKA0_P cml_tlatch_8.xmux.xp.S1 VSS sg13_lv_nmos ad=89.3f pd=0.85u as=89.3f ps=0.85u w=0.47u l=0.16u
X7626 cml_tlatch_9.xmux.xp.S1 cml_tlatch_9.OUTP cml_tlatch_9.OUTN VSS sg13_lv_nmos ad=56.9f pd=0.74u as=56.9f ps=0.74u w=0.17u l=0.17u
X7627 cml_tlatch_86.xmux.xp.S1 MOT24_P MOT24_N VSS sg13_lv_nmos ad=56.9f pd=0.74u as=56.9f ps=0.74u w=0.17u l=0.17u
X7628 stub_bi_29.BOTP stub_bi_29.BOTN cml_tlatch_32.xmux.xp.S1 VSS sg13_lv_nmos ad=56.9f pd=0.74u as=56.9f ps=0.74u w=0.17u l=0.17u
X7629 cml_tlatch_71.xmux.xp.S1 MOT31_P MOT31_N VSS sg13_lv_nmos ad=56.9f pd=0.74u as=56.9f ps=0.74u w=0.17u l=0.17u
X7630 cml_gate2_4.sg13_lv_nmos_FTPY57_0.D0 CKB2_P cml_gate2_4.xrtail.R1 VSS sg13_lv_nmos ad=0.1007p pd=0.91u as=0.1802p ps=1.74u w=0.53u l=0.13u
X7631 VSS POLN cml_tlatch_16.xtail.S1 VSS sg13_lv_nmos ad=1.5637p pd=8.61u as=1.5637p ps=8.61u w=8.23u l=0.13u
X7632 cml_tlatch_45.xmux.xn.S1 B3_2_N cml_tlatch_45.OUTP VSS sg13_lv_nmos ad=63.19999f pd=0.74u as=0.1082p ps=1.34u w=0.26u l=0.38u
X7633 cml_tlatch_58.INN cml_tlatch_58.INP cml_tlatch_85.xmux.xp.S1 VSS sg13_lv_nmos ad=56.9f pd=0.74u as=56.9f ps=0.74u w=0.17u l=0.17u
X7634 cml_tlatch_71.xtail.S1 CKHB3_P cml_tlatch_71.xmux.xn.S1 VSS sg13_lv_nmos ad=89.3f pd=0.85u as=89.3f ps=0.85u w=0.47u l=0.16u
X7635 cml_tlatch_35.OUTP cml_tlatch_35.OUTN cml_tlatch_35.xmux.xp.S1 VSS sg13_lv_nmos ad=56.9f pd=0.74u as=56.9f ps=0.74u w=0.17u l=0.17u
X7636 CKA1_N CK_N hs_to_clk_3.D2 VSS sg13_lv_nmos ad=0.228p pd=1.58u as=0.408p ps=3.08u w=1.2u l=0.2u
X7637 VSS POLN cml_tlatch_35.xtail.S1 VSS sg13_lv_nmos ad=1.5637p pd=8.61u as=1.5637p ps=8.61u w=8.23u l=0.13u
X7638 MOT8_N MOT8_P cml_tlatch_96.xmux.xp.S1 VSS sg13_lv_nmos ad=56.9f pd=0.74u as=56.9f ps=0.74u w=0.17u l=0.17u
X7639 MOT14_P MOT14_N cml_tlatch_41.xmux.xp.S1 VSS sg13_lv_nmos ad=56.9f pd=0.74u as=56.9f ps=0.74u w=0.17u l=0.17u
X7640 stub_bi_62.BOTP stub_bi_63.BOTN cml_tlatch_78.xmux.xn.S1 VSS sg13_lv_nmos ad=63.19999f pd=0.74u as=63.19999f ps=0.74u w=0.26u l=0.38u
X7641 cml_tlatch_99.xmux.xp.S1 cml_tlatch_99.OUTP cml_tlatch_99.OUTN VSS sg13_lv_nmos ad=56.9f pd=0.74u as=56.9f ps=0.74u w=0.17u l=0.17u
X7642 MOT5_N MOT5_P cml_tlatch_19.xmux.xp.S1 VSS sg13_lv_nmos ad=56.9f pd=0.74u as=56.9f ps=0.74u w=0.17u l=0.17u
X7643 cml_tlatch_78.xmux.xp.S1 stub_bi_62.BOTP stub_bi_62.BOTN VSS sg13_lv_nmos ad=56.9f pd=0.74u as=56.9f ps=0.74u w=0.17u l=0.17u
X7644 MOT15_N MOT15_P cml_tlatch_7.xmux.xp.S1 VSS sg13_lv_nmos ad=56.9f pd=0.74u as=56.9f ps=0.74u w=0.17u l=0.17u
X7645 cml_tlatch_57.INP cml_tlatch_57.INN cml_tlatch_66.xmux.xp.S1 VSS sg13_lv_nmos ad=56.9f pd=0.74u as=0.1019p ps=1.34u w=0.17u l=0.17u
X7646 MOT19_N MOT19_P cml_tlatch_74.xmux.xp.S1 VSS sg13_lv_nmos ad=56.9f pd=0.74u as=56.9f ps=0.74u w=0.17u l=0.17u
X7647 cml_tlatch_69.xmux.xp.S1 MOT27_P MOT27_N VSS sg13_lv_nmos ad=56.9f pd=0.74u as=56.9f ps=0.74u w=0.17u l=0.17u
X7648 cml_tlatch_2.xmux.xp.S1 A0_8_N A0_8_P VSS sg13_lv_nmos ad=56.9f pd=0.74u as=56.9f ps=0.74u w=0.17u l=0.17u
X7649 GB3_P ENB0_N cml_gate2_6.sg13_lv_nmos_FTPY57_0.D0 VSS sg13_lv_nmos ad=0.1007p pd=0.91u as=0.1007p ps=0.91u w=0.53u l=0.13u
X7650 cml_tlatch_97.xtail.S1 CKHA0_N cml_tlatch_97.xmux.xp.S1 VSS sg13_lv_nmos ad=89.3f pd=0.85u as=89.3f ps=0.85u w=0.47u l=0.16u
X7651 B1_2_N B1_2_P cml_tlatch_33.xmux.xp.S1 VSS sg13_lv_nmos ad=56.9f pd=0.74u as=56.9f ps=0.74u w=0.17u l=0.17u
X7652 MOT8_P MOT8_N cml_tlatch_96.xmux.xp.S1 VSS sg13_lv_nmos ad=56.9f pd=0.74u as=56.9f ps=0.74u w=0.17u l=0.17u
X7653 cml_tlatch_77.xmux.xn.S1 stub_bi_62.BOTN B2_8_N VSS sg13_lv_nmos ad=63.19999f pd=0.74u as=63.19999f ps=0.74u w=0.26u l=0.38u
X7654 A3_8_N A3_8_P cml_tlatch_64.xmux.xp.S1 VSS sg13_lv_nmos ad=56.9f pd=0.74u as=56.9f ps=0.74u w=0.17u l=0.17u
X7655 cml_tlatch_64.xmux.xn.S1 CKA3_N cml_tlatch_64.xtail.S1 VSS sg13_lv_nmos ad=89.3f pd=0.85u as=89.3f ps=0.85u w=0.47u l=0.16u
X7656 cml_tlatch_1.xmux.xn.S1 CKB0_P cml_tlatch_1.xtail.S1 VSS sg13_lv_nmos ad=89.3f pd=0.85u as=89.3f ps=0.85u w=0.47u l=0.16u
X7657 cml_tlatch_81.xmux.xp.S1 A2_8_N A2_8_P VSS sg13_lv_nmos ad=0.1019p pd=1.34u as=56.9f ps=0.74u w=0.17u l=0.17u
X7658 cml_tlatch_27.OUTN cml_tlatch_27.OUTP cml_tlatch_27.xmux.xp.S1 VSS sg13_lv_nmos ad=56.9f pd=0.74u as=56.9f ps=0.74u w=0.17u l=0.17u
X7659 MOT24_N MOT24_P cml_tlatch_86.xmux.xp.S1 VSS sg13_lv_nmos ad=56.9f pd=0.74u as=56.9f ps=0.74u w=0.17u l=0.17u
X7660 cml_tlatch_73.xmux.xp.S1 MOT17_N MOT17_P VSS sg13_lv_nmos ad=56.9f pd=0.74u as=56.9f ps=0.74u w=0.17u l=0.17u
X7661 cml_tlatch_46.xmux.xp.S1 B3_2_N B3_2_P VSS sg13_lv_nmos ad=56.9f pd=0.74u as=56.9f ps=0.74u w=0.17u l=0.17u
X7662 cml_tlatch_81.xmux.xn.S1 cml_tlatch_82.OUTN A2_8_P VSS sg13_lv_nmos ad=63.19999f pd=0.74u as=63.19999f ps=0.74u w=0.26u l=0.38u
X7663 cml_tlatch_52.xmux.xn.S1 A3_2_P cml_tlatch_52.OUTN VSS sg13_lv_nmos ad=63.19999f pd=0.74u as=63.19999f ps=0.74u w=0.26u l=0.38u
X7664 cml_tlatch_43.xmux.xp.S1 CKB2_N cml_tlatch_43.xtail.S1 VSS sg13_lv_nmos ad=89.3f pd=0.85u as=89.3f ps=0.85u w=0.47u l=0.16u
X7665 cml_gate2_4.sg13_lv_nmos_FTPY57_0.D0 ENA1_N GA2_P VSS sg13_lv_nmos ad=0.1007p pd=0.91u as=0.1007p ps=0.91u w=0.53u l=0.13u
X7666 cml_tlatch_54.xmux.xp.S1 cml_tlatch_54.OUTP cml_tlatch_54.OUTN VSS sg13_lv_nmos ad=56.9f pd=0.74u as=56.9f ps=0.74u w=0.17u l=0.17u
X7667 cml_tlatch_3.OUTP cml_tlatch_3.OUTN cml_tlatch_3.xmux.xp.S1 VSS sg13_lv_nmos ad=56.9f pd=0.74u as=56.9f ps=0.74u w=0.17u l=0.17u
X7668 cml_tlatch_19.xtail.S1 CKHB0_P cml_tlatch_19.xmux.xn.S1 VSS sg13_lv_nmos ad=89.3f pd=0.85u as=89.3f ps=0.85u w=0.47u l=0.16u
X7669 cml_tlatch_38.xtail.S1 CKA1_P cml_tlatch_38.xmux.xn.S1 VSS sg13_lv_nmos ad=89.3f pd=0.85u as=89.3f ps=0.85u w=0.47u l=0.16u
X7670 cml_tlatch_23.xmux.xp.S1 cml_tlatch_39.INP cml_tlatch_39.INN VSS sg13_lv_nmos ad=56.9f pd=0.74u as=56.9f ps=0.74u w=0.17u l=0.17u
X7671 cml_tlatch_4.xmux.xp.S1 MOT9_N MOT9_P VSS sg13_lv_nmos ad=56.9f pd=0.74u as=56.9f ps=0.74u w=0.17u l=0.17u
X7672 cml_tlatch_40.INP cml_tlatch_40.INN cml_tlatch_95.xmux.xp.S1 VSS sg13_lv_nmos ad=56.9f pd=0.74u as=56.9f ps=0.74u w=0.17u l=0.17u
X7673 cml_tlatch_44.xtail.S1 CKB2_P cml_tlatch_44.xmux.xp.S1 VSS sg13_lv_nmos ad=89.3f pd=0.85u as=89.3f ps=0.85u w=0.47u l=0.16u
X7674 B0_2_N B0_2_P cml_tlatch_28.xmux.xp.S1 VSS sg13_lv_nmos ad=56.9f pd=0.74u as=56.9f ps=0.74u w=0.17u l=0.17u
X7675 cml_tlatch_60.xmux.xn.S1 CKB3_N cml_tlatch_60.xtail.S1 VSS sg13_lv_nmos ad=89.3f pd=0.85u as=89.3f ps=0.85u w=0.47u l=0.16u
X7676 cml_tlatch_52.OUTP cml_tlatch_52.OUTN cml_tlatch_52.xmux.xp.S1 VSS sg13_lv_nmos ad=56.9f pd=0.74u as=56.9f ps=0.74u w=0.17u l=0.17u
X7677 MOT24_P MOT24_N cml_tlatch_86.xmux.xp.S1 VSS sg13_lv_nmos ad=56.9f pd=0.74u as=56.9f ps=0.74u w=0.17u l=0.17u
X7678 cml_tlatch_59.xtail.S1 CKHA3_P cml_tlatch_59.xmux.xn.S1 VSS sg13_lv_nmos ad=89.3f pd=0.85u as=0.1598p ps=1.62u w=0.47u l=0.16u
X7679 cml_tlatch_16.OUTP cml_tlatch_16.OUTN cml_tlatch_16.xmux.xp.S1 VSS sg13_lv_nmos ad=56.9f pd=0.74u as=56.9f ps=0.74u w=0.17u l=0.17u
X7680 cml_tlatch_7.xtail.S1 CKHB1_N cml_tlatch_7.xmux.xp.S1 VSS sg13_lv_nmos ad=89.3f pd=0.85u as=89.3f ps=0.85u w=0.47u l=0.16u
X7681 cml_tlatch_89.OUTP cml_tlatch_89.INN cml_tlatch_89.xmux.xn.S1 VSS sg13_lv_nmos ad=63.19999f pd=0.74u as=63.19999f ps=0.74u w=0.26u l=0.38u
X7682 MOT0_P A0_8_N cml_tlatch_97.xmux.xn.S1 VSS sg13_lv_nmos ad=63.19999f pd=0.74u as=0.1082p ps=1.34u w=0.26u l=0.38u
X7683 cml_tlatch_40.xtail.S1 CKHA1_N cml_tlatch_40.xmux.xp.S1 VSS sg13_lv_nmos ad=89.3f pd=0.85u as=89.3f ps=0.85u w=0.47u l=0.16u
X7684 VDD J4_P VSS rppd l=5.17u w=1u
X7685 cml_tlatch_83.xmux.xn.S1 CKA2_N cml_tlatch_83.xtail.S1 VSS sg13_lv_nmos ad=89.3f pd=0.85u as=89.3f ps=0.85u w=0.47u l=0.16u
X7686 cml_tlatch_91.xmux.xn.S1 J2_P CLK_W_P VSS sg13_lv_nmos ad=63.19999f pd=0.74u as=63.19999f ps=0.74u w=0.26u l=0.38u
X7687 cml_tlatch_55.xmux.xp.S1 cml_tlatch_89.INP cml_tlatch_89.INN VSS sg13_lv_nmos ad=56.9f pd=0.74u as=56.9f ps=0.74u w=0.17u l=0.17u
X7688 cml_tlatch_5.xtail.S1 CKHB1_P cml_tlatch_5.xmux.xn.S1 VSS sg13_lv_nmos ad=89.3f pd=0.85u as=0.1598p ps=1.62u w=0.47u l=0.16u
X7689 cml_tlatch_63.xmux.xp.S1 cml_tlatch_63.OUTP cml_tlatch_63.OUTN VSS sg13_lv_nmos ad=56.9f pd=0.74u as=56.9f ps=0.74u w=0.17u l=0.17u
X7690 cml_tlatch_19.xtail.S1 POLN VSS VSS sg13_lv_nmos ad=1.5637p pd=8.61u as=1.5637p ps=8.61u w=8.23u l=0.13u
X7691 cml_tlatch_48.xmux.xp.S1 stub_bi_32.BOTP stub_bi_32.BOTN VSS sg13_lv_nmos ad=56.9f pd=0.74u as=56.9f ps=0.74u w=0.17u l=0.17u
X7692 J4_N J4_P cml_tlatch_90.xmux.xp.S1 VSS sg13_lv_nmos ad=56.9f pd=0.74u as=56.9f ps=0.74u w=0.17u l=0.17u
X7693 cml_tlatch_84.xmux.xp.S1 cml_tlatch_70.INP cml_tlatch_70.INN VSS sg13_lv_nmos ad=56.9f pd=0.74u as=56.9f ps=0.74u w=0.17u l=0.17u
X7694 cml_tlatch_52.xtail.S1 CKA3_P cml_tlatch_52.xmux.xn.S1 VSS sg13_lv_nmos ad=89.3f pd=0.85u as=89.3f ps=0.85u w=0.47u l=0.16u
X7695 cml_tlatch_29.xmux.xp.S1 cml_tlatch_29.OUTN cml_tlatch_29.OUTP VSS sg13_lv_nmos ad=56.9f pd=0.74u as=56.9f ps=0.74u w=0.17u l=0.17u
X7696 cml_tlatch_75.xtail.S1 CKHB2_P cml_tlatch_75.xmux.xn.S1 VSS sg13_lv_nmos ad=89.3f pd=0.85u as=89.3f ps=0.85u w=0.47u l=0.16u
X7697 MOT1_N B0_8_P cml_tlatch_17.xmux.xn.S1 VSS sg13_lv_nmos ad=63.19999f pd=0.74u as=63.19999f ps=0.74u w=0.26u l=0.38u
X7698 A3_8_N cml_tlatch_65.OUTP cml_tlatch_64.xmux.xn.S1 VSS sg13_lv_nmos ad=63.19999f pd=0.74u as=63.19999f ps=0.74u w=0.26u l=0.38u
X7699 cml_tlatch_26.xmux.xn.S1 A0_2_P MOT6_N VSS sg13_lv_nmos ad=63.19999f pd=0.74u as=63.19999f ps=0.74u w=0.26u l=0.38u
X7700 cml_tlatch_67.OUTP cml_tlatch_67.OUTN cml_tlatch_67.xmux.xp.S1 VSS sg13_lv_nmos ad=56.9f pd=0.74u as=56.9f ps=0.74u w=0.17u l=0.17u
X7701 cml_tlatch_27.xmux.xn.S1 B0_2_P cml_tlatch_27.OUTN VSS sg13_lv_nmos ad=63.19999f pd=0.74u as=63.19999f ps=0.74u w=0.26u l=0.38u
X7702 cml_tlatch_31.xmux.xp.S1 A0_2_N A0_2_P VSS sg13_lv_nmos ad=56.9f pd=0.74u as=56.9f ps=0.74u w=0.17u l=0.17u
X7703 cml_tlatch_96.xmux.xn.S1 A1_8_N MOT8_P VSS sg13_lv_nmos ad=0.1082p pd=1.34u as=63.19999f ps=0.74u w=0.26u l=0.38u
X7704 CKHB0_N GB0_P cml_drvb_1.xrtail.R1 VSS sg13_lv_nmos ad=0.2618p pd=2.22u as=0.1463p ps=1.15u w=0.77u l=0.21u
X7705 cml_tlatch_95.xmux.xn.S1 CKA1_N cml_tlatch_95.xtail.S1 VSS sg13_lv_nmos ad=89.3f pd=0.85u as=89.3f ps=0.85u w=0.47u l=0.16u
X7706 cml_tlatch_82.xtail.S1 CKA2_N cml_tlatch_82.xmux.xp.S1 VSS sg13_lv_nmos ad=89.3f pd=0.85u as=89.3f ps=0.85u w=0.47u l=0.16u
X7707 cml_tlatch_83.xmux.xn.S1 cml_tlatch_83.INN cml_tlatch_83.OUTP VSS sg13_lv_nmos ad=63.19999f pd=0.74u as=63.19999f ps=0.74u w=0.26u l=0.38u
X7708 VSS hs_to_clk_5.sg13_lv_nmos_2HGZLP_0.G VSS VSS sg13_lv_nmos ad=2.071p pd=11.28u as=0 ps=0 w=10.9u l=1.38u
X7709 cml_tlatch_53.xmux.xn.S1 CKA3_N cml_tlatch_53.xtail.S1 VSS sg13_lv_nmos ad=89.3f pd=0.85u as=89.3f ps=0.85u w=0.47u l=0.16u
X7710 cml_tlatch_20.xmux.xn.S1 CKHB0_P cml_tlatch_20.xtail.S1 VSS sg13_lv_nmos ad=89.3f pd=0.85u as=89.3f ps=0.85u w=0.47u l=0.16u
X7711 cml_tlatch_84.xmux.xp.S1 cml_tlatch_70.INP cml_tlatch_70.INN VSS sg13_lv_nmos ad=0.1019p pd=1.34u as=56.9f ps=0.74u w=0.17u l=0.17u
X7712 cml_tlatch_26.xmux.xn.S1 A0_2_P MOT6_N VSS sg13_lv_nmos ad=63.19999f pd=0.74u as=63.19999f ps=0.74u w=0.26u l=0.38u
X7713 cml_tlatch_27.xmux.xp.S1 cml_tlatch_27.OUTN cml_tlatch_27.OUTP VSS sg13_lv_nmos ad=56.9f pd=0.74u as=56.9f ps=0.74u w=0.17u l=0.17u
X7714 cml_tlatch_31.xtail.S1 CKA0_N cml_tlatch_31.xmux.xn.S1 VSS sg13_lv_nmos ad=89.3f pd=0.85u as=89.3f ps=0.85u w=0.47u l=0.16u
X7715 VSS hs_to_clk_2.sg13_lv_nmos_2HGZLP_0.G VSS VSS sg13_lv_nmos ad=2.071p pd=11.28u as=0 ps=0 w=10.9u l=1.38u
X7716 cml_tlatch_11.xmux.xn.S1 CKB0_P cml_tlatch_11.xtail.S1 VSS sg13_lv_nmos ad=89.3f pd=0.85u as=89.3f ps=0.85u w=0.47u l=0.16u
X7717 cml_tlatch_83.xmux.xn.S1 cml_tlatch_83.INN cml_tlatch_83.OUTP VSS sg13_lv_nmos ad=63.19999f pd=0.74u as=63.19999f ps=0.74u w=0.26u l=0.38u
X7718 cml_tlatch_58.xmux.xn.S1 cml_tlatch_58.INN MOT28_P VSS sg13_lv_nmos ad=63.19999f pd=0.74u as=63.19999f ps=0.74u w=0.26u l=0.38u
X7719 cml_tlatch_29.xtail.S1 CKB0_P cml_tlatch_29.xmux.xn.S1 VSS sg13_lv_nmos ad=89.3f pd=0.85u as=89.3f ps=0.85u w=0.47u l=0.16u
X7720 cml_tlatch_22.OUTP cml_tlatch_22.OUTN cml_tlatch_22.xmux.xp.S1 VSS sg13_lv_nmos ad=56.9f pd=0.74u as=0.1019p ps=1.34u w=0.17u l=0.17u
X7721 cml_drv_2.xrtail.R1 ENB_N ENB0_P VSS sg13_lv_nmos ad=56.2f pd=0.74u as=56.2f ps=0.74u w=0.16u l=0.19u
X7722 cml_tlatch_57.INN cml_tlatch_57.INP cml_tlatch_66.xmux.xp.S1 VSS sg13_lv_nmos ad=56.9f pd=0.74u as=56.9f ps=0.74u w=0.17u l=0.17u
X7723 cml_tlatch_50.xtail.S1 CKHA2_N cml_tlatch_50.xmux.xp.S1 VSS sg13_lv_nmos ad=89.3f pd=0.85u as=89.3f ps=0.85u w=0.47u l=0.16u
X7724 VSS POLN cml_tlatch_50.xtail.S1 VSS sg13_lv_nmos ad=1.5637p pd=8.61u as=1.5637p ps=8.61u w=8.23u l=0.13u
X7725 cml_tlatch_6.INN cml_tlatch_6.INP cml_tlatch_94.xmux.xp.S1 VSS sg13_lv_nmos ad=56.9f pd=0.74u as=56.9f ps=0.74u w=0.17u l=0.17u
X7726 A2_2_P A2_2_N cml_tlatch_56.xmux.xp.S1 VSS sg13_lv_nmos ad=56.9f pd=0.74u as=56.9f ps=0.74u w=0.17u l=0.17u
X7727 cml_tlatch_46.xmux.xp.S1 B3_2_N B3_2_P VSS sg13_lv_nmos ad=56.9f pd=0.74u as=56.9f ps=0.74u w=0.17u l=0.17u
X7728 cml_tlatch_58.xmux.xn.S1 cml_tlatch_58.INN MOT28_P VSS sg13_lv_nmos ad=63.19999f pd=0.74u as=63.19999f ps=0.74u w=0.26u l=0.38u
X7729 cml_tlatch_69.xmux.xp.S1 MOT27_P MOT27_N VSS sg13_lv_nmos ad=56.9f pd=0.74u as=56.9f ps=0.74u w=0.17u l=0.17u
X7730 cml_tlatch_78.xtail.S1 CKB2_N cml_tlatch_78.xmux.xp.S1 VSS sg13_lv_nmos ad=89.3f pd=0.85u as=89.3f ps=0.85u w=0.47u l=0.16u
X7731 VSS POLN cml_tlatch_9.xtail.S1 VSS sg13_lv_nmos ad=2.7982p pd=17.14u as=1.5637p ps=8.61u w=8.23u l=0.13u
X7732 cml_tlatch_39.INN interco_bi_19.INP cml_tlatch_23.xmux.xn.S1 VSS sg13_lv_nmos ad=63.19999f pd=0.74u as=63.19999f ps=0.74u w=0.26u l=0.38u
X7733 cml_tlatch_94.xmux.xn.S1 CKB1_N cml_tlatch_94.xtail.S1 VSS sg13_lv_nmos ad=89.3f pd=0.85u as=89.3f ps=0.85u w=0.47u l=0.16u
X7734 cml_tlatch_46.xmux.xn.S1 CKB3_N cml_tlatch_46.xtail.S1 VSS sg13_lv_nmos ad=89.3f pd=0.85u as=89.3f ps=0.85u w=0.47u l=0.16u
X7735 J2_P J2_N cml_tlatch_92.xmux.xp.S1 VSS sg13_lv_nmos ad=56.9f pd=0.74u as=56.9f ps=0.74u w=0.17u l=0.17u
X7736 cml_gate2_8.sg13_lv_nmos_FTPY57_0.D0 J2_P ENB_N VSS sg13_lv_nmos ad=0.1007p pd=0.91u as=0.1007p ps=0.91u w=0.53u l=0.13u
X7737 cml_tlatch_65.xtail.S1 CKA3_N cml_tlatch_65.xmux.xp.S1 VSS sg13_lv_nmos ad=89.3f pd=0.85u as=89.3f ps=0.85u w=0.47u l=0.16u
X7738 cml_tlatch_40.xmux.xn.S1 cml_tlatch_40.INP MOT12_N VSS sg13_lv_nmos ad=63.19999f pd=0.74u as=63.19999f ps=0.74u w=0.26u l=0.38u
X7739 cml_tlatch_23.xmux.xp.S1 cml_tlatch_39.INP cml_tlatch_39.INN VSS sg13_lv_nmos ad=56.9f pd=0.74u as=56.9f ps=0.74u w=0.17u l=0.17u
X7740 cml_tlatch_12.xtail.S1 CKB1_N cml_tlatch_12.xmux.xn.S1 VSS sg13_lv_nmos ad=89.3f pd=0.85u as=89.3f ps=0.85u w=0.47u l=0.16u
X7741 CKB1_N CK_P hs_to_clk_2.D2 VSS sg13_lv_nmos ad=0.228p pd=1.58u as=0.228p ps=1.58u w=1.2u l=0.2u
X7742 cml_tlatch_2.xmux.xp.S1 A0_8_P A0_8_N VSS sg13_lv_nmos ad=56.9f pd=0.74u as=56.9f ps=0.74u w=0.17u l=0.17u
X7743 cml_tlatch_5.INN cml_tlatch_5.INP cml_tlatch_14.xmux.xp.S1 VSS sg13_lv_nmos ad=56.9f pd=0.74u as=56.9f ps=0.74u w=0.17u l=0.17u
X7744 cml_tlatch_5.INP cml_tlatch_5.INN cml_tlatch_14.xmux.xp.S1 VSS sg13_lv_nmos ad=56.9f pd=0.74u as=56.9f ps=0.74u w=0.17u l=0.17u
X7745 cml_tlatch_60.xtail.S1 POLN VSS VSS sg13_lv_nmos ad=1.5637p pd=8.61u as=1.5637p ps=8.61u w=8.23u l=0.13u
X7746 MOT11_N MOT11_P cml_tlatch_5.xmux.xp.S1 VSS sg13_lv_nmos ad=56.9f pd=0.74u as=56.9f ps=0.74u w=0.17u l=0.17u
X7747 cml_tlatch_6.xtail.S1 CKHB1_P cml_tlatch_6.xmux.xn.S1 VSS sg13_lv_nmos ad=89.3f pd=0.85u as=89.3f ps=0.85u w=0.47u l=0.16u
X7748 cml_tlatch_82.OUTP cml_tlatch_83.OUTN cml_tlatch_82.xmux.xn.S1 VSS sg13_lv_nmos ad=63.19999f pd=0.74u as=63.19999f ps=0.74u w=0.26u l=0.38u
X7749 MOT28_N cml_tlatch_58.INP cml_tlatch_58.xmux.xn.S1 VSS sg13_lv_nmos ad=63.19999f pd=0.74u as=63.19999f ps=0.74u w=0.26u l=0.38u
X7750 MOT5_P MOT5_N cml_tlatch_19.xmux.xp.S1 VSS sg13_lv_nmos ad=56.9f pd=0.74u as=56.9f ps=0.74u w=0.17u l=0.17u
X7751 cml_tlatch_13.xmux.xp.S1 stub_bi_17.BOTN stub_bi_17.BOTP VSS sg13_lv_nmos ad=56.9f pd=0.74u as=56.9f ps=0.74u w=0.17u l=0.17u
X7752 cml_tlatch_53.xmux.xn.S1 cml_tlatch_54.OUTN A3_2_P VSS sg13_lv_nmos ad=63.19999f pd=0.74u as=63.19999f ps=0.74u w=0.26u l=0.38u
X7753 cml_tlatch_90.xtail.S1 POLN VSS VSS sg13_lv_nmos ad=1.5637p pd=8.61u as=1.5637p ps=8.61u w=8.23u l=0.13u
X7754 J1_P J4_P cml_tlatch_93.xmux.xn.S1 VSS sg13_lv_nmos ad=63.19999f pd=0.74u as=63.19999f ps=0.74u w=0.26u l=0.38u
X7755 cml_tlatch_91.xtail.S1 CKJ_N cml_tlatch_91.xmux.xp.S1 VSS sg13_lv_nmos ad=89.3f pd=0.85u as=89.3f ps=0.85u w=0.47u l=0.16u
X7756 cml_tlatch_63.OUTP cml_tlatch_63.OUTN cml_tlatch_63.xmux.xp.S1 VSS sg13_lv_nmos ad=56.9f pd=0.74u as=0.1019p ps=1.34u w=0.17u l=0.17u
X7757 cml_tlatch_63.xtail.S1 CKB3_N cml_tlatch_63.xmux.xp.S1 VSS sg13_lv_nmos ad=89.3f pd=0.85u as=0.1598p ps=1.62u w=0.47u l=0.16u
X7758 cml_tlatch_27.xtail.S1 CKB0_P cml_tlatch_27.xmux.xn.S1 VSS sg13_lv_nmos ad=0.1598p pd=1.62u as=89.3f ps=0.85u w=0.47u l=0.16u
X7759 cml_tlatch_2.xmux.xn.S1 cml_tlatch_3.OUTN A0_8_P VSS sg13_lv_nmos ad=63.19999f pd=0.74u as=63.19999f ps=0.74u w=0.26u l=0.38u
X7760 stub_bi_32.BOTP D2_P cml_tlatch_48.xmux.xn.S1 VSS sg13_lv_nmos ad=63.19999f pd=0.74u as=63.19999f ps=0.74u w=0.26u l=0.38u
X7761 MOT20_N MOT20_P cml_tlatch_50.xmux.xp.S1 VSS sg13_lv_nmos ad=56.9f pd=0.74u as=56.9f ps=0.74u w=0.17u l=0.17u
X7762 cml_tlatch_23.xmux.xp.S1 CKA1_P cml_tlatch_23.xtail.S1 VSS sg13_lv_nmos ad=89.3f pd=0.85u as=89.3f ps=0.85u w=0.47u l=0.16u
X7763 cml_tlatch_25.xmux.xp.S1 MOT4_N MOT4_P VSS sg13_lv_nmos ad=56.9f pd=0.74u as=56.9f ps=0.74u w=0.17u l=0.17u
X7764 cml_tlatch_40.xtail.S1 CKHA1_P cml_tlatch_40.xmux.xn.S1 VSS sg13_lv_nmos ad=89.3f pd=0.85u as=89.3f ps=0.85u w=0.47u l=0.16u
X7765 cml_tlatch_58.xmux.xp.S1 MOT28_P MOT28_N VSS sg13_lv_nmos ad=56.9f pd=0.74u as=56.9f ps=0.74u w=0.17u l=0.17u
X7766 cml_gate2_1.sg13_lv_nmos_FTPY57_0.D0 ENB1_N GB0_P VSS sg13_lv_nmos ad=0.1007p pd=0.91u as=0.1007p ps=0.91u w=0.53u l=0.13u
X7767 cml_tlatch_97.xmux.xp.S1 CKHA0_N cml_tlatch_97.xtail.S1 VSS sg13_lv_nmos ad=89.3f pd=0.85u as=0.1598p ps=1.62u w=0.47u l=0.16u
X7768 cml_tlatch_70.INP cml_tlatch_70.INN cml_tlatch_84.xmux.xp.S1 VSS sg13_lv_nmos ad=56.9f pd=0.74u as=56.9f ps=0.74u w=0.17u l=0.17u
X7769 cml_tlatch_66.xtail.S1 POLN VSS VSS sg13_lv_nmos ad=1.5637p pd=8.61u as=1.5637p ps=8.61u w=8.23u l=0.13u
X7770 cml_tlatch_83.xmux.xp.S1 CKA2_P cml_tlatch_83.xtail.S1 VSS sg13_lv_nmos ad=0.1598p pd=1.62u as=89.3f ps=0.85u w=0.47u l=0.16u
X7771 stub_bi_42.BOTP stub_bi_42.BOTN cml_tlatch_43.xmux.xp.S1 VSS sg13_lv_nmos ad=56.9f pd=0.74u as=56.9f ps=0.74u w=0.17u l=0.17u
X7772 cml_tlatch_11.xtail.S1 CKB0_N cml_tlatch_11.xmux.xp.S1 VSS sg13_lv_nmos ad=0.1598p pd=1.62u as=89.3f ps=0.85u w=0.47u l=0.16u
X7773 cml_tlatch_18.xmux.xp.S1 MOT3_N MOT3_P VSS sg13_lv_nmos ad=56.9f pd=0.74u as=56.9f ps=0.74u w=0.17u l=0.17u
X7774 B3_8_N B3_8_P cml_tlatch_60.xmux.xp.S1 VSS sg13_lv_nmos ad=56.9f pd=0.74u as=56.9f ps=0.74u w=0.17u l=0.17u
X7775 cml_tlatch_1.xtail.S1 CKB0_P cml_tlatch_1.xmux.xn.S1 VSS sg13_lv_nmos ad=89.3f pd=0.85u as=0.1598p ps=1.62u w=0.47u l=0.16u
X7776 A1_8_P A1_8_N cml_tlatch_21.xmux.xp.S1 VSS sg13_lv_nmos ad=56.9f pd=0.74u as=56.9f ps=0.74u w=0.17u l=0.17u
X7777 CLK_W_N CLK_W_P cml_tlatch_91.xmux.xp.S1 VSS sg13_lv_nmos ad=56.9f pd=0.74u as=56.9f ps=0.74u w=0.17u l=0.17u
X7778 MOT10_N cml_tlatch_39.INP cml_tlatch_39.xmux.xn.S1 VSS sg13_lv_nmos ad=63.19999f pd=0.74u as=63.19999f ps=0.74u w=0.26u l=0.38u
X7779 cml_tlatch_38.OUTP cml_tlatch_38.OUTN cml_tlatch_38.xmux.xp.S1 VSS sg13_lv_nmos ad=56.9f pd=0.74u as=0.1019p ps=1.34u w=0.17u l=0.17u
X7780 cml_tlatch_12.xmux.xp.S1 B1_8_N B1_8_P VSS sg13_lv_nmos ad=56.9f pd=0.74u as=56.9f ps=0.74u w=0.17u l=0.17u
X7781 cml_tlatch_72.xtail.S1 CKA2_N cml_tlatch_72.xmux.xp.S1 VSS sg13_lv_nmos ad=89.3f pd=0.85u as=89.3f ps=0.85u w=0.47u l=0.16u
X7782 MOT8_P VDD VSS rppd l=5.17u w=1u
X7783 cml_tlatch_22.OUTN cml_tlatch_39.INP cml_tlatch_22.xmux.xn.S1 VSS sg13_lv_nmos ad=0.1082p pd=1.34u as=63.19999f ps=0.74u w=0.26u l=0.38u
X7784 B2_2_P B2_2_N cml_tlatch_44.xmux.xp.S1 VSS sg13_lv_nmos ad=56.9f pd=0.74u as=0.1019p ps=1.34u w=0.17u l=0.17u
X7785 cml_tlatch_43.xtail.S1 CKB2_N cml_tlatch_43.xmux.xp.S1 VSS sg13_lv_nmos ad=89.3f pd=0.85u as=0.1598p ps=1.62u w=0.47u l=0.16u
X7786 cml_tlatch_97.xtail.S1 CKHA0_P cml_tlatch_97.xmux.xn.S1 VSS sg13_lv_nmos ad=89.3f pd=0.85u as=89.3f ps=0.85u w=0.47u l=0.16u
X7787 MOT21_N MOT21_P cml_tlatch_75.xmux.xp.S1 VSS sg13_lv_nmos ad=56.9f pd=0.74u as=56.9f ps=0.74u w=0.17u l=0.17u
X7788 cml_tlatch_40.INN cml_tlatch_95.INP cml_tlatch_95.xmux.xn.S1 VSS sg13_lv_nmos ad=63.19999f pd=0.74u as=0.1082p ps=1.34u w=0.26u l=0.38u
X7789 cml_tlatch_65.OUTP cml_tlatch_65.OUTN cml_tlatch_65.xmux.xp.S1 VSS sg13_lv_nmos ad=56.9f pd=0.74u as=56.9f ps=0.74u w=0.17u l=0.17u
X7790 cml_tlatch_18.xtail.S1 POLN VSS VSS sg13_lv_nmos ad=1.5637p pd=8.61u as=1.5637p ps=8.61u w=8.23u l=0.13u
X7791 cml_tlatch_56.INN cml_tlatch_56.INP cml_tlatch_42.xmux.xp.S1 VSS sg13_lv_nmos ad=56.9f pd=0.74u as=56.9f ps=0.74u w=0.17u l=0.17u
X7792 cml_tlatch_48.xmux.xp.S1 stub_bi_32.BOTN stub_bi_32.BOTP VSS sg13_lv_nmos ad=56.9f pd=0.74u as=56.9f ps=0.74u w=0.17u l=0.17u
X7793 cml_tlatch_74.xtail.S1 POLN VSS VSS sg13_lv_nmos ad=1.5637p pd=8.61u as=2.7982p ps=17.14u w=8.23u l=0.13u
X7794 cml_tlatch_22.xmux.xn.S1 CKA1_P cml_tlatch_22.xtail.S1 VSS sg13_lv_nmos ad=89.3f pd=0.85u as=0.1598p ps=1.62u w=0.47u l=0.16u
X7795 cml_tlatch_33.xtail.S1 CKB1_N cml_tlatch_33.xmux.xn.S1 VSS sg13_lv_nmos ad=89.3f pd=0.85u as=89.3f ps=0.85u w=0.47u l=0.16u
X7796 cml_tlatch_92.xmux.xn.S1 J1_N J2_P VSS sg13_lv_nmos ad=63.19999f pd=0.74u as=63.19999f ps=0.74u w=0.26u l=0.38u
X7797 J2_N J2_P cml_tlatch_92.xmux.xp.S1 VSS sg13_lv_nmos ad=56.9f pd=0.74u as=56.9f ps=0.74u w=0.17u l=0.17u
X7798 cml_tlatch_31.xmux.xp.S1 A0_2_N A0_2_P VSS sg13_lv_nmos ad=56.9f pd=0.74u as=56.9f ps=0.74u w=0.17u l=0.17u
X7799 cml_tlatch_4.xtail.S1 CKHB1_N cml_tlatch_4.xmux.xp.S1 VSS sg13_lv_nmos ad=89.3f pd=0.85u as=89.3f ps=0.85u w=0.47u l=0.16u
X7800 cml_tlatch_45.OUTP cml_tlatch_45.OUTN cml_tlatch_45.xmux.xp.S1 VSS sg13_lv_nmos ad=56.9f pd=0.74u as=56.9f ps=0.74u w=0.17u l=0.17u
X7801 cml_tlatch_8.xmux.xn.S1 cml_tlatch_9.OUTP cml_tlatch_8.OUTN VSS sg13_lv_nmos ad=63.19999f pd=0.74u as=63.19999f ps=0.74u w=0.26u l=0.38u
X7802 B1_2_N stub_bi_31.BOTN cml_tlatch_33.xmux.xn.S1 VSS sg13_lv_nmos ad=63.19999f pd=0.74u as=63.19999f ps=0.74u w=0.26u l=0.38u
X7803 J2_N J1_P cml_tlatch_92.xmux.xn.S1 VSS sg13_lv_nmos ad=63.19999f pd=0.74u as=63.19999f ps=0.74u w=0.26u l=0.38u
X7804 cml_tlatch_98.xmux.xp.S1 cml_tlatch_98.OUTP cml_tlatch_98.OUTN VSS sg13_lv_nmos ad=0.1019p pd=1.34u as=56.9f ps=0.74u w=0.17u l=0.17u
X7805 cml_tlatch_94.xmux.xp.S1 cml_tlatch_6.INN cml_tlatch_6.INP VSS sg13_lv_nmos ad=0.1019p pd=1.34u as=56.9f ps=0.74u w=0.17u l=0.17u
X7806 MOT13_N MOT13_P cml_tlatch_6.xmux.xp.S1 VSS sg13_lv_nmos ad=56.9f pd=0.74u as=56.9f ps=0.74u w=0.17u l=0.17u
X7807 cml_tlatch_61.OUTN cml_tlatch_61.OUTP cml_tlatch_61.xmux.xp.S1 VSS sg13_lv_nmos ad=56.9f pd=0.74u as=56.9f ps=0.74u w=0.17u l=0.17u
X7808 cml_tlatch_71.xmux.xn.S1 B3_2_N MOT31_P VSS sg13_lv_nmos ad=63.19999f pd=0.74u as=0.1082p ps=1.34u w=0.26u l=0.38u
X7809 cml_tlatch_87.xmux.xp.S1 CKHA2_N cml_tlatch_87.xtail.S1 VSS sg13_lv_nmos ad=89.3f pd=0.85u as=89.3f ps=0.85u w=0.47u l=0.16u
X7810 cml_tlatch_24.xtail.S1 CKHA0_N cml_tlatch_24.xmux.xp.S1 VSS sg13_lv_nmos ad=89.3f pd=0.85u as=89.3f ps=0.85u w=0.47u l=0.16u
X7811 cml_tlatch_52.xmux.xp.S1 cml_tlatch_52.OUTP cml_tlatch_52.OUTN VSS sg13_lv_nmos ad=56.9f pd=0.74u as=56.9f ps=0.74u w=0.17u l=0.17u
X7812 cml_gate2_7.sg13_lv_nmos_FTPY57_0.D0 ENB0_P GB2_N VSS sg13_lv_nmos ad=0.1007p pd=0.91u as=0.1007p ps=0.91u w=0.53u l=0.13u
X7813 cml_tlatch_83.xmux.xp.S1 cml_tlatch_83.OUTN cml_tlatch_83.OUTP VSS sg13_lv_nmos ad=56.9f pd=0.74u as=56.9f ps=0.74u w=0.17u l=0.17u
X7814 MOT31_N B3_2_P cml_tlatch_71.xmux.xn.S1 VSS sg13_lv_nmos ad=63.19999f pd=0.74u as=63.19999f ps=0.74u w=0.26u l=0.38u
X7815 VSS cml_drvb_4.xrtail.R1 VSS rppd l=2.72u w=1u
X7816 cml_tlatch_45.xtail.S1 CKB3_N cml_tlatch_45.xmux.xp.S1 VSS sg13_lv_nmos ad=89.3f pd=0.85u as=89.3f ps=0.85u w=0.47u l=0.16u
X7817 VDD hs_to_clk_3.sg13_lv_nmos_2HGZLP_0.G VSS rppd l=0.68u w=1u
X7818 cml_tlatch_91.xmux.xp.S1 CLK_W_N CLK_W_P VSS sg13_lv_nmos ad=56.9f pd=0.74u as=56.9f ps=0.74u w=0.17u l=0.17u
X7819 cml_tlatch_20.xmux.xp.S1 MOT7_N MOT7_P VSS sg13_lv_nmos ad=56.9f pd=0.74u as=56.9f ps=0.74u w=0.17u l=0.17u
X7820 cml_tlatch_36.xmux.xp.S1 CKA1_N cml_tlatch_36.xtail.S1 VSS sg13_lv_nmos ad=0.1598p pd=1.62u as=89.3f ps=0.85u w=0.47u l=0.16u
X7821 cml_tlatch_51.xmux.xp.S1 MOT22_N MOT22_P VSS sg13_lv_nmos ad=56.9f pd=0.74u as=56.9f ps=0.74u w=0.17u l=0.17u
X7822 cml_tlatch_87.xmux.xp.S1 MOT16_P MOT16_N VSS sg13_lv_nmos ad=56.9f pd=0.74u as=56.9f ps=0.74u w=0.17u l=0.17u
X7823 VSS POLN cml_tlatch_77.xtail.S1 VSS sg13_lv_nmos ad=2.7982p pd=17.14u as=1.5637p ps=8.61u w=8.23u l=0.13u
X7824 J4_P CLK_W_P cml_tlatch_90.xmux.xn.S1 VSS sg13_lv_nmos ad=63.19999f pd=0.74u as=63.19999f ps=0.74u w=0.26u l=0.38u
X7825 ENA_P J1_N cml_gate2_9.sg13_lv_nmos_FTPY57_0.D0 VSS sg13_lv_nmos ad=0.1007p pd=0.91u as=0.1007p ps=0.91u w=0.53u l=0.13u
X7826 cml_gate2_6.xrtail.R1 CKA3_N GB3_P VSS sg13_lv_nmos ad=0.1007p pd=0.91u as=0.1007p ps=0.91u w=0.53u l=0.13u
X7827 cml_tlatch_88.xtail.S1 CKB2_P cml_tlatch_88.xmux.xp.S1 VSS sg13_lv_nmos ad=89.3f pd=0.85u as=89.3f ps=0.85u w=0.47u l=0.16u
X7828 cml_tlatch_67.OUTN cml_tlatch_58.INP cml_tlatch_67.xmux.xn.S1 VSS sg13_lv_nmos ad=63.19999f pd=0.74u as=63.19999f ps=0.74u w=0.26u l=0.38u
X7829 cml_tlatch_75.xmux.xn.S1 CKHB2_P cml_tlatch_75.xtail.S1 VSS sg13_lv_nmos ad=89.3f pd=0.85u as=89.3f ps=0.85u w=0.47u l=0.16u
X7830 cml_tlatch_41.xmux.xp.S1 MOT14_N MOT14_P VSS sg13_lv_nmos ad=56.9f pd=0.74u as=56.9f ps=0.74u w=0.17u l=0.17u
X7831 cml_tlatch_67.xtail.S1 CKA3_P cml_tlatch_67.xmux.xn.S1 VSS sg13_lv_nmos ad=89.3f pd=0.85u as=89.3f ps=0.85u w=0.47u l=0.16u
X7832 cml_tlatch_43.xmux.xn.S1 B2_2_P stub_bi_42.BOTP VSS sg13_lv_nmos ad=0.1082p pd=1.34u as=63.19999f ps=0.74u w=0.26u l=0.38u
X7833 VSS POLN cml_tlatch_1.xtail.S1 VSS sg13_lv_nmos ad=1.5637p pd=8.61u as=1.5637p ps=8.61u w=8.23u l=0.13u
X7834 cml_tlatch_91.xmux.xp.S1 CLK_W_N CLK_W_P VSS sg13_lv_nmos ad=0.1019p pd=1.34u as=56.9f ps=0.74u w=0.17u l=0.17u
X7835 cml_tlatch_12.xtail.S1 CKB1_P cml_tlatch_12.xmux.xp.S1 VSS sg13_lv_nmos ad=0.1598p pd=1.62u as=89.3f ps=0.85u w=0.47u l=0.16u
X7836 cml_gate2_3.sg13_lv_nmos_FTPY57_0.D0 CKB1_P cml_gate2_3.xrtail.R1 VSS sg13_lv_nmos ad=0.1007p pd=0.91u as=0.1007p ps=0.91u w=0.53u l=0.13u
X7837 cml_tlatch_72.xmux.xp.S1 cml_tlatch_83.INN cml_tlatch_83.INP VSS sg13_lv_nmos ad=56.9f pd=0.74u as=56.9f ps=0.74u w=0.17u l=0.17u
X7838 cml_tlatch_96.xmux.xn.S1 A1_8_P MOT8_N VSS sg13_lv_nmos ad=63.19999f pd=0.74u as=0.1082p ps=1.34u w=0.26u l=0.38u
X7839 VSS POLN cml_tlatch_29.xtail.S1 VSS sg13_lv_nmos ad=2.7982p pd=17.14u as=1.5637p ps=8.61u w=8.23u l=0.13u
X7840 VSS hs_to_clk_0.sg13_lv_nmos_2HGZLP_0.G VSS VSS sg13_lv_nmos ad=2.071p pd=11.28u as=0 ps=0 w=10.9u l=1.38u
X7841 cml_tlatch_99.OUTP cml_tlatch_99.OUTN cml_tlatch_99.xmux.xp.S1 VSS sg13_lv_nmos ad=56.9f pd=0.74u as=56.9f ps=0.74u w=0.17u l=0.17u
X7842 A1_2_N A1_2_P cml_tlatch_37.xmux.xp.S1 VSS sg13_lv_nmos ad=56.9f pd=0.74u as=56.9f ps=0.74u w=0.17u l=0.17u
X7843 cml_tlatch_73.xtail.S1 CKHB2_N cml_tlatch_73.xmux.xp.S1 VSS sg13_lv_nmos ad=89.3f pd=0.85u as=89.3f ps=0.85u w=0.47u l=0.16u
X7844 stub_bi_55.BOTP stub_bi_55.BOTN cml_tlatch_88.xmux.xp.S1 VSS sg13_lv_nmos ad=56.9f pd=0.74u as=56.9f ps=0.74u w=0.17u l=0.17u
X7845 B3_8_P cml_tlatch_61.OUTN cml_tlatch_60.xmux.xn.S1 VSS sg13_lv_nmos ad=63.19999f pd=0.74u as=63.19999f ps=0.74u w=0.26u l=0.38u
X7846 cml_tlatch_70.xmux.xn.S1 CKHB3_P cml_tlatch_70.xtail.S1 VSS sg13_lv_nmos ad=89.3f pd=0.85u as=89.3f ps=0.85u w=0.47u l=0.16u
X7847 MOT0_P MOT0_N cml_tlatch_97.xmux.xp.S1 VSS sg13_lv_nmos ad=56.9f pd=0.74u as=56.9f ps=0.74u w=0.17u l=0.17u
X7848 MOT0_N MOT0_P cml_tlatch_97.xmux.xp.S1 VSS sg13_lv_nmos ad=56.9f pd=0.74u as=56.9f ps=0.74u w=0.17u l=0.17u
X7849 cml_tlatch_5.xmux.xn.S1 cml_tlatch_5.INN MOT11_P VSS sg13_lv_nmos ad=63.19999f pd=0.74u as=63.19999f ps=0.74u w=0.26u l=0.38u
X7850 cml_drv_0.xrtail.R1 ENB_N ENB1_P VSS sg13_lv_nmos ad=56.2f pd=0.74u as=56.2f ps=0.74u w=0.16u l=0.19u
X7851 cml_tlatch_52.xmux.xp.S1 cml_tlatch_52.OUTP cml_tlatch_52.OUTN VSS sg13_lv_nmos ad=56.9f pd=0.74u as=56.9f ps=0.74u w=0.17u l=0.17u
X7852 MOT7_N MOT7_P cml_tlatch_20.xmux.xp.S1 VSS sg13_lv_nmos ad=56.9f pd=0.74u as=56.9f ps=0.74u w=0.17u l=0.17u
X7853 cml_tlatch_54.OUTP cml_tlatch_54.OUTN cml_tlatch_54.xmux.xp.S1 VSS sg13_lv_nmos ad=56.9f pd=0.74u as=56.9f ps=0.74u w=0.17u l=0.17u
X7854 cml_tlatch_25.xmux.xp.S1 MOT4_N MOT4_P VSS sg13_lv_nmos ad=0.1019p pd=1.34u as=56.9f ps=0.74u w=0.17u l=0.17u
X7855 cml_tlatch_24.xmux.xp.S1 MOT2_N MOT2_P VSS sg13_lv_nmos ad=56.9f pd=0.74u as=56.9f ps=0.74u w=0.17u l=0.17u
X7856 cml_tlatch_76.xtail.S1 POLN VSS VSS sg13_lv_nmos ad=1.5637p pd=8.61u as=1.5637p ps=8.61u w=8.23u l=0.13u
X7857 stub_bi_49.BOTP stub_bi_49.BOTN cml_tlatch_80.xmux.xp.S1 VSS sg13_lv_nmos ad=56.9f pd=0.74u as=56.9f ps=0.74u w=0.17u l=0.17u
X7858 cml_tlatch_82.xtail.S1 CKA2_P cml_tlatch_82.xmux.xn.S1 VSS sg13_lv_nmos ad=89.3f pd=0.85u as=89.3f ps=0.85u w=0.47u l=0.16u
X7859 VSS POLN cml_tlatch_49.xtail.S1 VSS sg13_lv_nmos ad=2.7982p pd=17.14u as=1.5637p ps=8.61u w=8.23u l=0.13u
X7860 cml_tlatch_78.xmux.xp.S1 stub_bi_62.BOTN stub_bi_62.BOTP VSS sg13_lv_nmos ad=56.9f pd=0.74u as=56.9f ps=0.74u w=0.17u l=0.17u
X7861 cml_tlatch_14.xtail.S1 POLN VSS VSS sg13_lv_nmos ad=1.5637p pd=8.61u as=2.7982p ps=17.14u w=8.23u l=0.13u
X7862 cml_tlatch_10.xmux.xp.S1 B0_8_P B0_8_N VSS sg13_lv_nmos ad=56.9f pd=0.74u as=56.9f ps=0.74u w=0.17u l=0.17u
X7863 J2_N J2_P cml_tlatch_92.xmux.xp.S1 VSS sg13_lv_nmos ad=56.9f pd=0.74u as=56.9f ps=0.74u w=0.17u l=0.17u
X7864 A3_2_N A3_2_P cml_tlatch_53.xmux.xp.S1 VSS sg13_lv_nmos ad=56.9f pd=0.74u as=56.9f ps=0.74u w=0.17u l=0.17u
X7865 MOT18_N MOT18_P cml_tlatch_49.xmux.xp.S1 VSS sg13_lv_nmos ad=56.9f pd=0.74u as=56.9f ps=0.74u w=0.17u l=0.17u
X7866 cml_tlatch_30.OUTN cml_tlatch_30.OUTP cml_tlatch_30.xmux.xp.S1 VSS sg13_lv_nmos ad=56.9f pd=0.74u as=56.9f ps=0.74u w=0.17u l=0.17u
X7867 cml_tlatch_2.xmux.xn.S1 cml_tlatch_3.OUTP A0_8_N VSS sg13_lv_nmos ad=63.19999f pd=0.74u as=63.19999f ps=0.74u w=0.26u l=0.38u
X7868 cml_tlatch_12.xmux.xp.S1 B1_8_N B1_8_P VSS sg13_lv_nmos ad=56.9f pd=0.74u as=56.9f ps=0.74u w=0.17u l=0.17u
X7869 cml_tlatch_76.xtail.S1 CKHB2_P cml_tlatch_76.xmux.xn.S1 VSS sg13_lv_nmos ad=89.3f pd=0.85u as=89.3f ps=0.85u w=0.47u l=0.16u
X7870 cml_gate2_2.sg13_lv_nmos_FTPY57_0.D0 ENA0_P GA0_N VSS sg13_lv_nmos ad=0.1007p pd=0.91u as=0.1007p ps=0.91u w=0.53u l=0.13u
X7871 cml_tlatch_70.xmux.xp.S1 CKHB3_N cml_tlatch_70.xtail.S1 VSS sg13_lv_nmos ad=89.3f pd=0.85u as=89.3f ps=0.85u w=0.47u l=0.16u
X7872 cml_tlatch_3.OUTP cml_tlatch_8.OUTN cml_tlatch_3.xmux.xn.S1 VSS sg13_lv_nmos ad=0.1082p pd=1.34u as=63.19999f ps=0.74u w=0.26u l=0.38u
X7873 cml_tlatch_52.xtail.S1 CKA3_P cml_tlatch_52.xmux.xn.S1 VSS sg13_lv_nmos ad=89.3f pd=0.85u as=89.3f ps=0.85u w=0.47u l=0.16u
X7874 cml_tlatch_3.OUTP cml_tlatch_8.OUTN cml_tlatch_3.xmux.xn.S1 VSS sg13_lv_nmos ad=63.19999f pd=0.74u as=63.19999f ps=0.74u w=0.26u l=0.38u
X7875 cml_tlatch_17.xmux.xp.S1 MOT1_N MOT1_P VSS sg13_lv_nmos ad=56.9f pd=0.74u as=56.9f ps=0.74u w=0.17u l=0.17u
X7876 cml_tlatch_29.OUTP D0_N cml_tlatch_29.xmux.xn.S1 VSS sg13_lv_nmos ad=63.19999f pd=0.74u as=63.19999f ps=0.74u w=0.26u l=0.38u
X7877 A0_2_N A0_2_P cml_tlatch_31.xmux.xp.S1 VSS sg13_lv_nmos ad=56.9f pd=0.74u as=56.9f ps=0.74u w=0.17u l=0.17u
X7878 cml_tlatch_38.xtail.S1 CKA1_N cml_tlatch_38.xmux.xp.S1 VSS sg13_lv_nmos ad=89.3f pd=0.85u as=89.3f ps=0.85u w=0.47u l=0.16u
X7879 MOT13_N MOT13_P cml_tlatch_6.xmux.xp.S1 VSS sg13_lv_nmos ad=56.9f pd=0.74u as=56.9f ps=0.74u w=0.17u l=0.17u
X7880 cml_tlatch_38.xmux.xp.S1 cml_tlatch_38.OUTP cml_tlatch_38.OUTN VSS sg13_lv_nmos ad=56.9f pd=0.74u as=56.9f ps=0.74u w=0.17u l=0.17u
X7881 cml_tlatch_6.INP VDD VSS rppd l=5.17u w=1u
X7882 cml_tlatch_45.xtail.S1 CKB3_P cml_tlatch_45.xmux.xn.S1 VSS sg13_lv_nmos ad=0.1598p pd=1.62u as=89.3f ps=0.85u w=0.47u l=0.16u
X7883 cml_tlatch_83.xmux.xp.S1 cml_tlatch_83.OUTN cml_tlatch_83.OUTP VSS sg13_lv_nmos ad=56.9f pd=0.74u as=56.9f ps=0.74u w=0.17u l=0.17u
X7884 cml_tlatch_83.xmux.xp.S1 cml_tlatch_83.OUTP cml_tlatch_83.OUTN VSS sg13_lv_nmos ad=56.9f pd=0.74u as=56.9f ps=0.74u w=0.17u l=0.17u
X7885 stub_bi_63.BOTN stub_bi_63.BOTP cml_tlatch_79.xmux.xp.S1 VSS sg13_lv_nmos ad=56.9f pd=0.74u as=56.9f ps=0.74u w=0.17u l=0.17u
X7886 cml_tlatch_37.xmux.xp.S1 A1_2_P A1_2_N VSS sg13_lv_nmos ad=0.1019p pd=1.34u as=56.9f ps=0.74u w=0.17u l=0.17u
X7887 VDD MOT19_P VSS rppd l=5.17u w=1u
X7888 cml_tlatch_20.xmux.xp.S1 MOT7_N MOT7_P VSS sg13_lv_nmos ad=0.1019p pd=1.34u as=56.9f ps=0.74u w=0.17u l=0.17u
X7889 cml_tlatch_99.xmux.xn.S1 CKA0_N cml_tlatch_99.xtail.S1 VSS sg13_lv_nmos ad=89.3f pd=0.85u as=89.3f ps=0.85u w=0.47u l=0.16u
X7890 cml_tlatch_87.xmux.xp.S1 MOT16_P MOT16_N VSS sg13_lv_nmos ad=56.9f pd=0.74u as=56.9f ps=0.74u w=0.17u l=0.17u
X7891 MOT30_P MOT30_N cml_tlatch_59.xmux.xp.S1 VSS sg13_lv_nmos ad=56.9f pd=0.74u as=56.9f ps=0.74u w=0.17u l=0.17u
X7892 cml_tlatch_69.INP cml_tlatch_63.OUTN cml_tlatch_62.xmux.xn.S1 VSS sg13_lv_nmos ad=63.19999f pd=0.74u as=63.19999f ps=0.74u w=0.26u l=0.38u
X7893 cml_tlatch_78.xmux.xp.S1 stub_bi_62.BOTN stub_bi_62.BOTP VSS sg13_lv_nmos ad=56.9f pd=0.74u as=56.9f ps=0.74u w=0.17u l=0.17u
X7894 cml_tlatch_32.xmux.xp.S1 stub_bi_29.BOTN stub_bi_29.BOTP VSS sg13_lv_nmos ad=56.9f pd=0.74u as=56.9f ps=0.74u w=0.17u l=0.17u
X7895 cml_tlatch_76.xmux.xp.S1 MOT23_P MOT23_N VSS sg13_lv_nmos ad=56.9f pd=0.74u as=56.9f ps=0.74u w=0.17u l=0.17u
X7896 MOT2_P cml_tlatch_8.OUTN cml_tlatch_24.xmux.xn.S1 VSS sg13_lv_nmos ad=63.19999f pd=0.74u as=63.19999f ps=0.74u w=0.26u l=0.38u
X7897 MOT31_N MOT31_P cml_tlatch_71.xmux.xp.S1 VSS sg13_lv_nmos ad=56.9f pd=0.74u as=56.9f ps=0.74u w=0.17u l=0.17u
X7898 cml_tlatch_85.xmux.xp.S1 cml_tlatch_58.INP cml_tlatch_58.INN VSS sg13_lv_nmos ad=56.9f pd=0.74u as=56.9f ps=0.74u w=0.17u l=0.17u
X7899 MOT11_P MOT11_N cml_tlatch_5.xmux.xp.S1 VSS sg13_lv_nmos ad=56.9f pd=0.74u as=56.9f ps=0.74u w=0.17u l=0.17u
X7900 cml_tlatch_35.xmux.xp.S1 cml_tlatch_35.OUTN cml_tlatch_35.OUTP VSS sg13_lv_nmos ad=56.9f pd=0.74u as=56.9f ps=0.74u w=0.17u l=0.17u
X7901 cml_tlatch_97.xmux.xn.S1 CKHA0_P cml_tlatch_97.xtail.S1 VSS sg13_lv_nmos ad=89.3f pd=0.85u as=89.3f ps=0.85u w=0.47u l=0.16u
X7902 cml_tlatch_41.xmux.xp.S1 MOT14_N MOT14_P VSS sg13_lv_nmos ad=56.9f pd=0.74u as=56.9f ps=0.74u w=0.17u l=0.17u
X7903 cml_tlatch_38.OUTN D1_P cml_tlatch_38.xmux.xn.S1 VSS sg13_lv_nmos ad=0.1082p pd=1.34u as=63.19999f ps=0.74u w=0.26u l=0.38u
X7904 cml_tlatch_79.xmux.xn.S1 stub_bi_49.BOTN stub_bi_63.BOTP VSS sg13_lv_nmos ad=63.19999f pd=0.74u as=0.1082p ps=1.34u w=0.26u l=0.38u
X7905 cml_tlatch_96.xmux.xp.S1 MOT8_P MOT8_N VSS sg13_lv_nmos ad=56.9f pd=0.74u as=56.9f ps=0.74u w=0.17u l=0.17u
X7906 stub_bi_62.BOTN stub_bi_62.BOTP cml_tlatch_78.xmux.xp.S1 VSS sg13_lv_nmos ad=56.9f pd=0.74u as=56.9f ps=0.74u w=0.17u l=0.17u
X7907 cml_tlatch_7.xmux.xp.S1 MOT15_P MOT15_N VSS sg13_lv_nmos ad=56.9f pd=0.74u as=56.9f ps=0.74u w=0.17u l=0.17u
X7908 cml_drv_1.xrtail.R1 ENA_N ENA1_P VSS sg13_lv_nmos ad=56.2f pd=0.74u as=56.2f ps=0.74u w=0.16u l=0.19u
X7909 cml_tlatch_61.xmux.xn.S1 cml_tlatch_69.INN cml_tlatch_61.OUTP VSS sg13_lv_nmos ad=0.1082p pd=1.34u as=63.19999f ps=0.74u w=0.26u l=0.38u
X7910 cml_tlatch_40.INN cml_tlatch_40.INP cml_tlatch_95.xmux.xp.S1 VSS sg13_lv_nmos ad=56.9f pd=0.74u as=56.9f ps=0.74u w=0.17u l=0.17u
X7911 cml_tlatch_79.xtail.S1 CKB2_N cml_tlatch_79.xmux.xn.S1 VSS sg13_lv_nmos ad=89.3f pd=0.85u as=89.3f ps=0.85u w=0.47u l=0.16u
X7912 cml_tlatch_6.INP stub_bi_29.BOTP cml_tlatch_94.xmux.xn.S1 VSS sg13_lv_nmos ad=63.19999f pd=0.74u as=63.19999f ps=0.74u w=0.26u l=0.38u
X7913 cml_tlatch_61.xmux.xn.S1 cml_tlatch_69.INN cml_tlatch_61.OUTP VSS sg13_lv_nmos ad=63.19999f pd=0.74u as=63.19999f ps=0.74u w=0.26u l=0.38u
X7914 cml_tlatch_35.OUTN D0_P cml_tlatch_35.xmux.xn.S1 VSS sg13_lv_nmos ad=63.19999f pd=0.74u as=63.19999f ps=0.74u w=0.26u l=0.38u
X7915 cml_tlatch_73.xtail.S1 POLN VSS VSS sg13_lv_nmos ad=1.5637p pd=8.61u as=1.5637p ps=8.61u w=8.23u l=0.13u
X7916 cml_tlatch_87.xtail.S1 CKHA2_N cml_tlatch_87.xmux.xp.S1 VSS sg13_lv_nmos ad=89.3f pd=0.85u as=89.3f ps=0.85u w=0.47u l=0.16u
X7917 cml_tlatch_22.xmux.xn.S1 cml_tlatch_39.INN cml_tlatch_22.OUTP VSS sg13_lv_nmos ad=63.19999f pd=0.74u as=63.19999f ps=0.74u w=0.26u l=0.38u
X7918 cml_tlatch_96.xmux.xp.S1 MOT8_N MOT8_P VSS sg13_lv_nmos ad=56.9f pd=0.74u as=56.9f ps=0.74u w=0.17u l=0.17u
X7919 interco_bi_19.INP interco_bi_19.INN cml_tlatch_0.xmux.xp.S1 VSS sg13_lv_nmos ad=56.9f pd=0.74u as=56.9f ps=0.74u w=0.17u l=0.17u
X7920 MOT27_P MOT27_N cml_tlatch_69.xmux.xp.S1 VSS sg13_lv_nmos ad=56.9f pd=0.74u as=56.9f ps=0.74u w=0.17u l=0.17u
X7921 cml_tlatch_64.xmux.xp.S1 A3_8_P A3_8_N VSS sg13_lv_nmos ad=56.9f pd=0.74u as=56.9f ps=0.74u w=0.17u l=0.17u
X7922 cml_gate2_5.sg13_lv_nmos_FTPY57_0.D0 ENA1_P GA3_N VSS sg13_lv_nmos ad=0.1007p pd=0.91u as=0.1007p ps=0.91u w=0.53u l=0.13u
X7923 A2_8_P A2_8_N cml_tlatch_81.xmux.xp.S1 VSS sg13_lv_nmos ad=56.9f pd=0.74u as=56.9f ps=0.74u w=0.17u l=0.17u
X7924 cml_tlatch_27.xmux.xp.S1 cml_tlatch_27.OUTP cml_tlatch_27.OUTN VSS sg13_lv_nmos ad=56.9f pd=0.74u as=56.9f ps=0.74u w=0.17u l=0.17u
X7925 cml_tlatch_40.INN cml_tlatch_40.INP cml_tlatch_95.xmux.xp.S1 VSS sg13_lv_nmos ad=56.9f pd=0.74u as=56.9f ps=0.74u w=0.17u l=0.17u
X7926 cml_tlatch_53.xmux.xp.S1 A3_2_N A3_2_P VSS sg13_lv_nmos ad=56.9f pd=0.74u as=56.9f ps=0.74u w=0.17u l=0.17u
X7927 cml_tlatch_15.xmux.xn.S1 cml_tlatch_6.INN stub_bi_19.BOTN VSS sg13_lv_nmos ad=63.19999f pd=0.74u as=63.19999f ps=0.74u w=0.26u l=0.38u
X7928 cml_tlatch_18.xmux.xn.S1 cml_tlatch_16.OUTP MOT3_N VSS sg13_lv_nmos ad=63.19999f pd=0.74u as=63.19999f ps=0.74u w=0.26u l=0.38u
X7929 MOT15_P B1_2_N cml_tlatch_7.xmux.xn.S1 VSS sg13_lv_nmos ad=63.19999f pd=0.74u as=63.19999f ps=0.74u w=0.26u l=0.38u
X7930 cml_gate2_0.sg13_lv_nmos_FTPY57_0.D0 ENB1_N GB1_P VSS sg13_lv_nmos ad=0.1007p pd=0.91u as=0.1007p ps=0.91u w=0.53u l=0.13u
X7931 cml_tlatch_7.xtail.S1 POLN VSS VSS sg13_lv_nmos ad=1.5637p pd=8.61u as=2.7982p ps=17.14u w=8.23u l=0.13u
X7932 cml_tlatch_54.OUTN cml_tlatch_54.OUTP cml_tlatch_54.xmux.xp.S1 VSS sg13_lv_nmos ad=56.9f pd=0.74u as=56.9f ps=0.74u w=0.17u l=0.17u
X7933 cml_tlatch_54.xmux.xn.S1 CKA3_P cml_tlatch_54.xtail.S1 VSS sg13_lv_nmos ad=89.3f pd=0.85u as=89.3f ps=0.85u w=0.47u l=0.16u
X7934 cml_tlatch_88.xmux.xp.S1 CKB2_P cml_tlatch_88.xtail.S1 VSS sg13_lv_nmos ad=89.3f pd=0.85u as=89.3f ps=0.85u w=0.47u l=0.16u
X7935 cml_tlatch_15.xmux.xn.S1 cml_tlatch_6.INN stub_bi_19.BOTN VSS sg13_lv_nmos ad=63.19999f pd=0.74u as=63.19999f ps=0.74u w=0.26u l=0.38u
X7936 cml_tlatch_86.xtail.S1 CKHA3_N cml_tlatch_86.xmux.xp.S1 VSS sg13_lv_nmos ad=89.3f pd=0.85u as=89.3f ps=0.85u w=0.47u l=0.16u
X7937 VSS POLN cml_tlatch_39.xtail.S1 VSS sg13_lv_nmos ad=1.5637p pd=8.61u as=1.5637p ps=8.61u w=8.23u l=0.13u
X7938 cml_tlatch_86.xmux.xn.S1 A3_8_N MOT24_P VSS sg13_lv_nmos ad=63.19999f pd=0.74u as=0.1082p ps=1.34u w=0.26u l=0.38u
X7939 cml_tlatch_79.xmux.xp.S1 stub_bi_63.BOTN stub_bi_63.BOTP VSS sg13_lv_nmos ad=56.9f pd=0.74u as=56.9f ps=0.74u w=0.17u l=0.17u
X7940 cml_tlatch_85.xmux.xp.S1 CKA3_P cml_tlatch_85.xtail.S1 VSS sg13_lv_nmos ad=89.3f pd=0.85u as=0.1598p ps=1.62u w=0.47u l=0.16u
X7941 MOT3_N MOT3_P cml_tlatch_18.xmux.xp.S1 VSS sg13_lv_nmos ad=56.9f pd=0.74u as=56.9f ps=0.74u w=0.17u l=0.17u
X7942 cml_tlatch_33.xmux.xp.S1 B1_2_N B1_2_P VSS sg13_lv_nmos ad=56.9f pd=0.74u as=56.9f ps=0.74u w=0.17u l=0.17u
X7943 cml_tlatch_28.xmux.xp.S1 B0_2_P B0_2_N VSS sg13_lv_nmos ad=56.9f pd=0.74u as=56.9f ps=0.74u w=0.17u l=0.17u
X7944 MOT15_P B1_2_N cml_tlatch_7.xmux.xn.S1 VSS sg13_lv_nmos ad=63.19999f pd=0.74u as=63.19999f ps=0.74u w=0.26u l=0.38u
X7945 cml_tlatch_52.xmux.xp.S1 cml_tlatch_52.OUTN cml_tlatch_52.OUTP VSS sg13_lv_nmos ad=56.9f pd=0.74u as=56.9f ps=0.74u w=0.17u l=0.17u
X7946 CKHA0_P GA0_N cml_drvb_2.xrtail.R1 VSS sg13_lv_nmos ad=0.2618p pd=2.22u as=0.1463p ps=1.15u w=0.77u l=0.21u
X7947 cml_tlatch_57.xmux.xp.S1 MOT26_P MOT26_N VSS sg13_lv_nmos ad=56.9f pd=0.74u as=56.9f ps=0.74u w=0.17u l=0.17u
X7948 cml_tlatch_86.xmux.xp.S1 MOT24_N MOT24_P VSS sg13_lv_nmos ad=56.9f pd=0.74u as=56.9f ps=0.74u w=0.17u l=0.17u
X7949 cml_tlatch_28.xtail.S1 CKB0_N cml_tlatch_28.xmux.xn.S1 VSS sg13_lv_nmos ad=0.1598p pd=1.62u as=89.3f ps=0.85u w=0.47u l=0.16u
X7950 cml_tlatch_72.xtail.S1 CKA2_N cml_tlatch_72.xmux.xp.S1 VSS sg13_lv_nmos ad=89.3f pd=0.85u as=89.3f ps=0.85u w=0.47u l=0.16u
X7951 cml_tlatch_58.xmux.xp.S1 CKHA3_N cml_tlatch_58.xtail.S1 VSS sg13_lv_nmos ad=89.3f pd=0.85u as=89.3f ps=0.85u w=0.47u l=0.16u
X7952 cml_tlatch_16.xmux.xp.S1 cml_tlatch_16.OUTN cml_tlatch_16.OUTP VSS sg13_lv_nmos ad=56.9f pd=0.74u as=56.9f ps=0.74u w=0.17u l=0.17u
X7953 cml_tlatch_28.xmux.xp.S1 B0_2_N B0_2_P VSS sg13_lv_nmos ad=0.1019p pd=1.34u as=56.9f ps=0.74u w=0.17u l=0.17u
X7954 stub_bi_19.BOTP cml_tlatch_6.INP cml_tlatch_15.xmux.xn.S1 VSS sg13_lv_nmos ad=63.19999f pd=0.74u as=63.19999f ps=0.74u w=0.26u l=0.38u
X7955 cml_tlatch_47.xmux.xn.S1 CKB3_P cml_tlatch_47.xtail.S1 VSS sg13_lv_nmos ad=89.3f pd=0.85u as=89.3f ps=0.85u w=0.47u l=0.16u
X7956 A0_8_P A0_8_N cml_tlatch_2.xmux.xp.S1 VSS sg13_lv_nmos ad=56.9f pd=0.74u as=56.9f ps=0.74u w=0.17u l=0.17u
X7957 MOT10_N MOT10_P cml_tlatch_39.xmux.xp.S1 VSS sg13_lv_nmos ad=56.9f pd=0.74u as=56.9f ps=0.74u w=0.17u l=0.17u
X7958 A1_8_N A1_8_P cml_tlatch_21.xmux.xp.S1 VSS sg13_lv_nmos ad=56.9f pd=0.74u as=56.9f ps=0.74u w=0.17u l=0.17u
X7959 cml_tlatch_17.xmux.xp.S1 MOT1_N MOT1_P VSS sg13_lv_nmos ad=0.1019p pd=1.34u as=56.9f ps=0.74u w=0.17u l=0.17u
X7960 VSS POLN cml_tlatch_53.xtail.S1 VSS sg13_lv_nmos ad=1.5637p pd=8.61u as=1.5637p ps=8.61u w=8.23u l=0.13u
X7961 cml_tlatch_89.INN cml_tlatch_89.INP cml_tlatch_55.xmux.xp.S1 VSS sg13_lv_nmos ad=56.9f pd=0.74u as=56.9f ps=0.74u w=0.17u l=0.17u
X7962 MOT30_N A3_2_P cml_tlatch_59.xmux.xn.S1 VSS sg13_lv_nmos ad=63.19999f pd=0.74u as=63.19999f ps=0.74u w=0.26u l=0.38u
X7963 cml_tlatch_75.xmux.xn.S1 stub_bi_55.BOTP MOT21_P VSS sg13_lv_nmos ad=63.19999f pd=0.74u as=63.19999f ps=0.74u w=0.26u l=0.38u
X7964 stub_bi_32.BOTN stub_bi_32.BOTP cml_tlatch_48.xmux.xp.S1 VSS sg13_lv_nmos ad=56.9f pd=0.74u as=56.9f ps=0.74u w=0.17u l=0.17u
X7965 cml_tlatch_90.xmux.xp.S1 J4_P J4_N VSS sg13_lv_nmos ad=56.9f pd=0.74u as=56.9f ps=0.74u w=0.17u l=0.17u
X7966 cml_tlatch_54.xmux.xn.S1 D3_N cml_tlatch_54.OUTP VSS sg13_lv_nmos ad=63.19999f pd=0.74u as=63.19999f ps=0.74u w=0.26u l=0.38u
X7967 MOT21_N stub_bi_55.BOTN cml_tlatch_75.xmux.xn.S1 VSS sg13_lv_nmos ad=63.19999f pd=0.74u as=63.19999f ps=0.74u w=0.26u l=0.38u
X7968 cml_tlatch_80.xtail.S1 CKB2_N cml_tlatch_80.xmux.xp.S1 VSS sg13_lv_nmos ad=0.1598p pd=1.62u as=89.3f ps=0.85u w=0.47u l=0.16u
X7969 VSS POLN cml_tlatch_65.xtail.S1 VSS sg13_lv_nmos ad=2.7982p pd=17.14u as=1.5637p ps=8.61u w=8.23u l=0.13u
X7970 cml_tlatch_24.xtail.S1 CKHA0_N cml_tlatch_24.xmux.xp.S1 VSS sg13_lv_nmos ad=89.3f pd=0.85u as=89.3f ps=0.85u w=0.47u l=0.16u
X7971 cml_tlatch_95.INP cml_tlatch_95.INN cml_tlatch_36.xmux.xp.S1 VSS sg13_lv_nmos ad=56.9f pd=0.74u as=56.9f ps=0.74u w=0.17u l=0.17u
X7972 MOT10_P MOT10_N cml_tlatch_39.xmux.xp.S1 VSS sg13_lv_nmos ad=56.9f pd=0.74u as=56.9f ps=0.74u w=0.17u l=0.17u
X7973 MOT4_N MOT4_P cml_tlatch_25.xmux.xp.S1 VSS sg13_lv_nmos ad=56.9f pd=0.74u as=56.9f ps=0.74u w=0.17u l=0.17u
X7974 VSS hs_to_clk_5.sg13_lv_nmos_2HGZLP_0.G VSS VSS sg13_lv_nmos ad=2.071p pd=11.28u as=0 ps=0 w=10.9u l=1.38u
X7975 cml_tlatch_85.xtail.S1 CKA3_N cml_tlatch_85.xmux.xn.S1 VSS sg13_lv_nmos ad=89.3f pd=0.85u as=89.3f ps=0.85u w=0.47u l=0.16u
X7976 GB2_P CKA2_N cml_gate2_7.xrtail.R1 VSS sg13_lv_nmos ad=0.1007p pd=0.91u as=0.1007p ps=0.91u w=0.53u l=0.13u
X7977 cml_tlatch_67.xmux.xp.S1 cml_tlatch_67.OUTN cml_tlatch_67.OUTP VSS sg13_lv_nmos ad=56.9f pd=0.74u as=56.9f ps=0.74u w=0.17u l=0.17u
X7978 cml_tlatch_36.xtail.S1 CKA1_N cml_tlatch_36.xmux.xp.S1 VSS sg13_lv_nmos ad=89.3f pd=0.85u as=89.3f ps=0.85u w=0.47u l=0.16u
X7979 MOT26_N MOT26_P cml_tlatch_57.xmux.xp.S1 VSS sg13_lv_nmos ad=56.9f pd=0.74u as=56.9f ps=0.74u w=0.17u l=0.17u
X7980 cml_tlatch_85.xmux.xp.S1 cml_tlatch_58.INP cml_tlatch_58.INN VSS sg13_lv_nmos ad=56.9f pd=0.74u as=56.9f ps=0.74u w=0.17u l=0.17u
X7981 cml_tlatch_78.xtail.S1 POLN VSS VSS sg13_lv_nmos ad=1.5637p pd=8.61u as=2.7982p ps=17.14u w=8.23u l=0.13u
X7982 cml_tlatch_98.OUTN cml_tlatch_98.OUTP cml_tlatch_98.xmux.xp.S1 VSS sg13_lv_nmos ad=56.9f pd=0.74u as=56.9f ps=0.74u w=0.17u l=0.17u
X7983 ENB_P J2_N cml_gate2_8.sg13_lv_nmos_FTPY57_0.D0 VSS sg13_lv_nmos ad=0.1007p pd=0.91u as=0.1007p ps=0.91u w=0.53u l=0.13u
X7984 cml_tlatch_70.INN cml_tlatch_70.INP cml_tlatch_84.xmux.xp.S1 VSS sg13_lv_nmos ad=56.9f pd=0.74u as=56.9f ps=0.74u w=0.17u l=0.17u
X7985 cml_tlatch_35.xmux.xp.S1 cml_tlatch_35.OUTN cml_tlatch_35.OUTP VSS sg13_lv_nmos ad=56.9f pd=0.74u as=56.9f ps=0.74u w=0.17u l=0.17u
X7986 cml_tlatch_27.OUTP cml_tlatch_27.OUTN cml_tlatch_27.xmux.xp.S1 VSS sg13_lv_nmos ad=56.9f pd=0.74u as=56.9f ps=0.74u w=0.17u l=0.17u
X7987 MOT16_N A2_8_P cml_tlatch_87.xmux.xn.S1 VSS sg13_lv_nmos ad=0.1082p pd=1.34u as=63.19999f ps=0.74u w=0.26u l=0.38u
X7988 GB0_P ENB1_N cml_gate2_1.sg13_lv_nmos_FTPY57_0.D0 VSS sg13_lv_nmos ad=0.1007p pd=0.91u as=0.1802p ps=1.74u w=0.53u l=0.13u
X7989 cml_tlatch_94.xmux.xp.S1 cml_tlatch_6.INP cml_tlatch_6.INN VSS sg13_lv_nmos ad=56.9f pd=0.74u as=56.9f ps=0.74u w=0.17u l=0.17u
X7990 cml_tlatch_12.xtail.S1 CKB1_P cml_tlatch_12.xmux.xp.S1 VSS sg13_lv_nmos ad=89.3f pd=0.85u as=89.3f ps=0.85u w=0.47u l=0.16u
X7991 cml_tlatch_74.xmux.xp.S1 MOT19_P MOT19_N VSS sg13_lv_nmos ad=56.9f pd=0.74u as=56.9f ps=0.74u w=0.17u l=0.17u
X7992 MOT26_P MOT26_N cml_tlatch_57.xmux.xp.S1 VSS sg13_lv_nmos ad=56.9f pd=0.74u as=56.9f ps=0.74u w=0.17u l=0.17u
X7993 MOT27_N MOT27_P cml_tlatch_69.xmux.xp.S1 VSS sg13_lv_nmos ad=56.9f pd=0.74u as=56.9f ps=0.74u w=0.17u l=0.17u
X7994 cml_tlatch_92.xmux.xp.S1 J2_N J2_P VSS sg13_lv_nmos ad=56.9f pd=0.74u as=56.9f ps=0.74u w=0.17u l=0.17u
X7995 cml_tlatch_65.OUTN cml_tlatch_65.OUTP cml_tlatch_65.xmux.xp.S1 VSS sg13_lv_nmos ad=56.9f pd=0.74u as=56.9f ps=0.74u w=0.17u l=0.17u
X7996 cml_tlatch_78.xmux.xn.S1 stub_bi_63.BOTN stub_bi_62.BOTP VSS sg13_lv_nmos ad=63.19999f pd=0.74u as=63.19999f ps=0.74u w=0.26u l=0.38u
X7997 cml_tlatch_4.xtail.S1 POLN VSS VSS sg13_lv_nmos ad=1.5637p pd=8.61u as=2.7982p ps=17.14u w=8.23u l=0.13u
X7998 A0_8_N A0_8_P cml_tlatch_2.xmux.xp.S1 VSS sg13_lv_nmos ad=56.9f pd=0.74u as=56.9f ps=0.74u w=0.17u l=0.17u
X7999 cml_tlatch_70.xmux.xn.S1 CKHB3_P cml_tlatch_70.xtail.S1 VSS sg13_lv_nmos ad=89.3f pd=0.85u as=89.3f ps=0.85u w=0.47u l=0.16u
X8000 cml_tlatch_5.xmux.xp.S1 MOT11_P MOT11_N VSS sg13_lv_nmos ad=56.9f pd=0.74u as=56.9f ps=0.74u w=0.17u l=0.17u
X8001 cml_tlatch_92.xmux.xn.S1 J1_P J2_N VSS sg13_lv_nmos ad=63.19999f pd=0.74u as=63.19999f ps=0.74u w=0.26u l=0.38u
X8002 cml_tlatch_77.xmux.xp.S1 B2_8_N B2_8_P VSS sg13_lv_nmos ad=0.1019p pd=1.34u as=56.9f ps=0.74u w=0.17u l=0.17u
X8003 CKHA1_P GA1_N cml_drvb_3.xrtail.R1 VSS sg13_lv_nmos ad=0.2618p pd=2.22u as=0.1463p ps=1.15u w=0.77u l=0.21u
X8004 cml_tlatch_22.xmux.xp.S1 cml_tlatch_22.OUTP cml_tlatch_22.OUTN VSS sg13_lv_nmos ad=56.9f pd=0.74u as=56.9f ps=0.74u w=0.17u l=0.17u
X8005 cml_tlatch_34.xtail.S1 CKB1_P cml_tlatch_34.xmux.xn.S1 VSS sg13_lv_nmos ad=89.3f pd=0.85u as=89.3f ps=0.85u w=0.47u l=0.16u
X8006 B3_2_P B3_2_N cml_tlatch_46.xmux.xp.S1 VSS sg13_lv_nmos ad=56.9f pd=0.74u as=56.9f ps=0.74u w=0.17u l=0.17u
X8007 cml_tlatch_52.xmux.xn.S1 A3_2_N cml_tlatch_52.OUTP VSS sg13_lv_nmos ad=63.19999f pd=0.74u as=63.19999f ps=0.74u w=0.26u l=0.38u
X8008 stub_bi_17.BOTP stub_bi_17.BOTN cml_tlatch_13.xmux.xp.S1 VSS sg13_lv_nmos ad=56.9f pd=0.74u as=56.9f ps=0.74u w=0.17u l=0.17u
X8009 cml_tlatch_47.xtail.S1 POLN VSS VSS sg13_lv_nmos ad=1.5637p pd=8.61u as=1.5637p ps=8.61u w=8.23u l=0.13u
X8010 cml_tlatch_36.xmux.xn.S1 A1_2_P cml_tlatch_95.INN VSS sg13_lv_nmos ad=63.19999f pd=0.74u as=63.19999f ps=0.74u w=0.26u l=0.38u
X8011 cml_tlatch_39.INN cml_tlatch_39.INP cml_tlatch_23.xmux.xp.S1 VSS sg13_lv_nmos ad=56.9f pd=0.74u as=56.9f ps=0.74u w=0.17u l=0.17u
X8012 cml_tlatch_33.xmux.xp.S1 B1_2_N B1_2_P VSS sg13_lv_nmos ad=56.9f pd=0.74u as=56.9f ps=0.74u w=0.17u l=0.17u
X8013 cml_tlatch_79.xmux.xn.S1 CKB2_N cml_tlatch_79.xtail.S1 VSS sg13_lv_nmos ad=89.3f pd=0.85u as=89.3f ps=0.85u w=0.47u l=0.16u
X8014 MOT4_P MOT4_N cml_tlatch_25.xmux.xp.S1 VSS sg13_lv_nmos ad=56.9f pd=0.74u as=56.9f ps=0.74u w=0.17u l=0.17u
X8015 cml_tlatch_66.xmux.xp.S1 cml_tlatch_57.INN cml_tlatch_57.INP VSS sg13_lv_nmos ad=56.9f pd=0.74u as=56.9f ps=0.74u w=0.17u l=0.17u
X8016 cml_tlatch_16.xmux.xp.S1 cml_tlatch_16.OUTN cml_tlatch_16.OUTP VSS sg13_lv_nmos ad=56.9f pd=0.74u as=56.9f ps=0.74u w=0.17u l=0.17u
X8017 A2_8_P cml_tlatch_82.OUTN cml_tlatch_81.xmux.xn.S1 VSS sg13_lv_nmos ad=63.19999f pd=0.74u as=0.1082p ps=1.34u w=0.26u l=0.38u
X8018 cml_tlatch_66.xmux.xn.S1 CKA3_N cml_tlatch_66.xtail.S1 VSS sg13_lv_nmos ad=89.3f pd=0.85u as=0.1598p ps=1.62u w=0.47u l=0.16u
X8019 cml_tlatch_64.xtail.S1 CKA3_P cml_tlatch_64.xmux.xp.S1 VSS sg13_lv_nmos ad=89.3f pd=0.85u as=89.3f ps=0.85u w=0.47u l=0.16u
X8020 VDD GB2_P VSS rppd l=7.42u w=1u
X8021 cml_tlatch_14.xmux.xn.S1 stub_bi_19.BOTP cml_tlatch_5.INP VSS sg13_lv_nmos ad=63.19999f pd=0.74u as=63.19999f ps=0.74u w=0.26u l=0.38u
X8022 cml_tlatch_22.xtail.S1 CKA1_N cml_tlatch_22.xmux.xp.S1 VSS sg13_lv_nmos ad=89.3f pd=0.85u as=89.3f ps=0.85u w=0.47u l=0.16u
X8023 cml_tlatch_89.INN cml_tlatch_89.INP cml_tlatch_55.xmux.xp.S1 VSS sg13_lv_nmos ad=56.9f pd=0.74u as=56.9f ps=0.74u w=0.17u l=0.17u
X8024 cml_tlatch_27.xmux.xn.S1 CKB0_P cml_tlatch_27.xtail.S1 VSS sg13_lv_nmos ad=89.3f pd=0.85u as=89.3f ps=0.85u w=0.47u l=0.16u
X8025 cml_tlatch_43.xmux.xp.S1 stub_bi_42.BOTN stub_bi_42.BOTP VSS sg13_lv_nmos ad=56.9f pd=0.74u as=56.9f ps=0.74u w=0.17u l=0.17u
X8026 cml_tlatch_10.xtail.S1 CKB0_P cml_tlatch_10.xmux.xp.S1 VSS sg13_lv_nmos ad=89.3f pd=0.85u as=89.3f ps=0.85u w=0.47u l=0.16u
X8027 stub_bi_19.BOTN stub_bi_19.BOTP cml_tlatch_15.xmux.xp.S1 VSS sg13_lv_nmos ad=56.9f pd=0.74u as=56.9f ps=0.74u w=0.17u l=0.17u
X8028 cml_tlatch_90.xmux.xp.S1 J4_P J4_N VSS sg13_lv_nmos ad=56.9f pd=0.74u as=56.9f ps=0.74u w=0.17u l=0.17u
X8029 cml_tlatch_30.xmux.xn.S1 A0_2_N cml_tlatch_30.OUTP VSS sg13_lv_nmos ad=63.19999f pd=0.74u as=63.19999f ps=0.74u w=0.26u l=0.38u
X8030 cml_tlatch_87.xtail.S1 CKHA2_P cml_tlatch_87.xmux.xn.S1 VSS sg13_lv_nmos ad=89.3f pd=0.85u as=89.3f ps=0.85u w=0.47u l=0.16u
X8031 VSS POLN cml_tlatch_13.xtail.S1 VSS sg13_lv_nmos ad=1.5637p pd=8.61u as=1.5637p ps=8.61u w=8.23u l=0.13u
X8032 cml_tlatch_65.xmux.xp.S1 cml_tlatch_65.OUTN cml_tlatch_65.OUTP VSS sg13_lv_nmos ad=56.9f pd=0.74u as=56.9f ps=0.74u w=0.17u l=0.17u
X8033 cml_tlatch_75.xmux.xp.S1 MOT21_P MOT21_N VSS sg13_lv_nmos ad=56.9f pd=0.74u as=56.9f ps=0.74u w=0.17u l=0.17u
X8034 cml_tlatch_47.OUTN cml_tlatch_47.OUTP cml_tlatch_47.xmux.xp.S1 VSS sg13_lv_nmos ad=56.9f pd=0.74u as=56.9f ps=0.74u w=0.17u l=0.17u
X8035 cml_tlatch_91.xtail.S1 CKJ_P cml_tlatch_91.xmux.xn.S1 VSS sg13_lv_nmos ad=89.3f pd=0.85u as=89.3f ps=0.85u w=0.47u l=0.16u
X8036 MOT5_P cml_tlatch_98.OUTN cml_tlatch_19.xmux.xn.S1 VSS sg13_lv_nmos ad=0.1082p pd=1.34u as=63.19999f ps=0.74u w=0.26u l=0.38u
X8037 cml_gate2_3.xrtail.R1 CKB1_P cml_gate2_3.sg13_lv_nmos_FTPY57_0.D0 VSS sg13_lv_nmos ad=0.1007p pd=0.91u as=0.1007p ps=0.91u w=0.53u l=0.13u
X8038 VSS POLN cml_tlatch_83.xtail.S1 VSS sg13_lv_nmos ad=1.5637p pd=8.61u as=1.5637p ps=8.61u w=8.23u l=0.13u
X8039 cml_tlatch_68.xmux.xp.S1 CKHB3_N cml_tlatch_68.xtail.S1 VSS sg13_lv_nmos ad=89.3f pd=0.85u as=89.3f ps=0.85u w=0.47u l=0.16u
X8040 cml_tlatch_8.OUTN cml_tlatch_8.OUTP cml_tlatch_8.xmux.xp.S1 VSS sg13_lv_nmos ad=56.9f pd=0.74u as=56.9f ps=0.74u w=0.17u l=0.17u
X8041 CLK_W_P J2_P cml_tlatch_91.xmux.xn.S1 VSS sg13_lv_nmos ad=63.19999f pd=0.74u as=63.19999f ps=0.74u w=0.26u l=0.38u
X8042 cml_tlatch_83.xtail.S1 CKA2_P cml_tlatch_83.xmux.xp.S1 VSS sg13_lv_nmos ad=89.3f pd=0.85u as=89.3f ps=0.85u w=0.47u l=0.16u
X8043 cml_tlatch_44.xmux.xn.S1 stub_bi_32.BOTP B2_2_P VSS sg13_lv_nmos ad=63.19999f pd=0.74u as=63.19999f ps=0.74u w=0.26u l=0.38u
X8044 cml_tlatch_29.xmux.xp.S1 CKB0_N cml_tlatch_29.xtail.S1 VSS sg13_lv_nmos ad=89.3f pd=0.85u as=89.3f ps=0.85u w=0.47u l=0.16u
X8045 VSS hs_to_clk_3.sg13_lv_nmos_2HGZLP_0.G VSS VSS sg13_lv_nmos ad=2.071p pd=11.28u as=0 ps=0 w=10.9u l=1.38u
X8046 A2_2_N A2_2_P cml_tlatch_56.xmux.xp.S1 VSS sg13_lv_nmos ad=56.9f pd=0.74u as=56.9f ps=0.74u w=0.17u l=0.17u
X8047 cml_tlatch_98.OUTN cml_tlatch_98.OUTP cml_tlatch_98.xmux.xp.S1 VSS sg13_lv_nmos ad=56.9f pd=0.74u as=56.9f ps=0.74u w=0.17u l=0.17u
X8048 cml_tlatch_11.xmux.xp.S1 CKB0_N cml_tlatch_11.xtail.S1 VSS sg13_lv_nmos ad=89.3f pd=0.85u as=89.3f ps=0.85u w=0.47u l=0.16u
X8049 cml_tlatch_6.xmux.xp.S1 MOT13_P MOT13_N VSS sg13_lv_nmos ad=56.9f pd=0.74u as=56.9f ps=0.74u w=0.17u l=0.17u
X8050 cml_tlatch_6.INP cml_tlatch_6.INN cml_tlatch_94.xmux.xp.S1 VSS sg13_lv_nmos ad=56.9f pd=0.74u as=56.9f ps=0.74u w=0.17u l=0.17u
X8051 cml_tlatch_27.OUTP cml_tlatch_27.OUTN cml_tlatch_27.xmux.xp.S1 VSS sg13_lv_nmos ad=56.9f pd=0.74u as=56.9f ps=0.74u w=0.17u l=0.17u
X8052 cml_tlatch_24.xtail.S1 POLN VSS VSS sg13_lv_nmos ad=1.5637p pd=8.61u as=2.7982p ps=17.14u w=8.23u l=0.13u
X8053 MOT14_N MOT14_P cml_tlatch_41.xmux.xp.S1 VSS sg13_lv_nmos ad=56.9f pd=0.74u as=56.9f ps=0.74u w=0.17u l=0.17u
X8054 cml_gate2_3.sg13_lv_nmos_FTPY57_0.D0 ENA0_P GA1_N VSS sg13_lv_nmos ad=0.1007p pd=0.91u as=0.1007p ps=0.91u w=0.53u l=0.13u
X8055 cml_tlatch_17.xmux.xn.S1 B0_8_P MOT1_N VSS sg13_lv_nmos ad=63.19999f pd=0.74u as=63.19999f ps=0.74u w=0.26u l=0.38u
X8056 MOT7_P MOT7_N cml_tlatch_20.xmux.xp.S1 VSS sg13_lv_nmos ad=56.9f pd=0.74u as=56.9f ps=0.74u w=0.17u l=0.17u
X8057 MOT8_P A1_8_N cml_tlatch_96.xmux.xn.S1 VSS sg13_lv_nmos ad=63.19999f pd=0.74u as=63.19999f ps=0.74u w=0.26u l=0.38u
X8058 VSS hs_to_clk_2.sg13_lv_nmos_2HGZLP_0.G VSS VSS sg13_lv_nmos ad=2.071p pd=11.28u as=0 ps=0 w=10.9u l=1.38u
X8059 cml_gate2_4.sg13_lv_nmos_FTPY57_0.D0 CKB2_P cml_gate2_4.xrtail.R1 VSS sg13_lv_nmos ad=0.1007p pd=0.91u as=0.1007p ps=0.91u w=0.53u l=0.13u
X8060 cml_tlatch_79.xtail.S1 CKB2_P cml_tlatch_79.xmux.xp.S1 VSS sg13_lv_nmos ad=89.3f pd=0.85u as=89.3f ps=0.85u w=0.47u l=0.16u
X8061 VSS POLN cml_tlatch_16.xtail.S1 VSS sg13_lv_nmos ad=2.7982p pd=17.14u as=1.5637p ps=8.61u w=8.23u l=0.13u
X8062 MOT6_N A0_2_P cml_tlatch_26.xmux.xn.S1 VSS sg13_lv_nmos ad=63.19999f pd=0.74u as=63.19999f ps=0.74u w=0.26u l=0.38u
X8063 MOT8_P A1_8_N cml_tlatch_96.xmux.xn.S1 VSS sg13_lv_nmos ad=63.19999f pd=0.74u as=63.19999f ps=0.74u w=0.26u l=0.38u
X8064 VSS POLN cml_tlatch_35.xtail.S1 VSS sg13_lv_nmos ad=2.7982p pd=17.14u as=1.5637p ps=8.61u w=8.23u l=0.13u
X8065 cml_tlatch_40.xmux.xn.S1 cml_tlatch_40.INN MOT12_P VSS sg13_lv_nmos ad=63.19999f pd=0.74u as=63.19999f ps=0.74u w=0.26u l=0.38u
X8066 MOT3_P MOT3_N cml_tlatch_18.xmux.xp.S1 VSS sg13_lv_nmos ad=56.9f pd=0.74u as=56.9f ps=0.74u w=0.17u l=0.17u
X8067 cml_tlatch_83.OUTP cml_tlatch_83.INN cml_tlatch_83.xmux.xn.S1 VSS sg13_lv_nmos ad=63.19999f pd=0.74u as=63.19999f ps=0.74u w=0.26u l=0.38u
X8068 cml_tlatch_61.xmux.xp.S1 cml_tlatch_61.OUTP cml_tlatch_61.OUTN VSS sg13_lv_nmos ad=56.9f pd=0.74u as=56.9f ps=0.74u w=0.17u l=0.17u
X8069 A0_8_N A0_8_P cml_tlatch_2.xmux.xp.S1 VSS sg13_lv_nmos ad=56.9f pd=0.74u as=56.9f ps=0.74u w=0.17u l=0.17u
X8070 cml_tlatch_24.xmux.xp.S1 CKHA0_N cml_tlatch_24.xtail.S1 VSS sg13_lv_nmos ad=89.3f pd=0.85u as=0.1598p ps=1.62u w=0.47u l=0.16u
X8071 cml_tlatch_62.xmux.xp.S1 cml_tlatch_69.INP cml_tlatch_69.INN VSS sg13_lv_nmos ad=56.9f pd=0.74u as=56.9f ps=0.74u w=0.17u l=0.17u
X8072 cml_tlatch_70.INP cml_tlatch_70.INN cml_tlatch_84.xmux.xp.S1 VSS sg13_lv_nmos ad=56.9f pd=0.74u as=56.9f ps=0.74u w=0.17u l=0.17u
X8073 VSS POLN cml_tlatch_48.xtail.S1 VSS sg13_lv_nmos ad=2.7982p pd=17.14u as=1.5637p ps=8.61u w=8.23u l=0.13u
X8074 MOT30_N MOT30_P cml_tlatch_59.xmux.xp.S1 VSS sg13_lv_nmos ad=56.9f pd=0.74u as=56.9f ps=0.74u w=0.17u l=0.17u
X8075 MOT28_P cml_tlatch_58.INN cml_tlatch_58.xmux.xn.S1 VSS sg13_lv_nmos ad=63.19999f pd=0.74u as=63.19999f ps=0.74u w=0.26u l=0.38u
X8076 cml_tlatch_19.xmux.xp.S1 MOT5_N MOT5_P VSS sg13_lv_nmos ad=56.9f pd=0.74u as=56.9f ps=0.74u w=0.17u l=0.17u
X8077 stub_bi_17.BOTP stub_bi_17.BOTN cml_tlatch_13.xmux.xp.S1 VSS sg13_lv_nmos ad=56.9f pd=0.74u as=56.9f ps=0.74u w=0.17u l=0.17u
X8078 cml_tlatch_11.xmux.xp.S1 cml_tlatch_11.OUTN cml_tlatch_11.OUTP VSS sg13_lv_nmos ad=56.9f pd=0.74u as=56.9f ps=0.74u w=0.17u l=0.17u
X8079 MOT12_N cml_tlatch_40.INP cml_tlatch_40.xmux.xn.S1 VSS sg13_lv_nmos ad=63.19999f pd=0.74u as=63.19999f ps=0.74u w=0.26u l=0.38u
X8080 MOT10_P VDD VSS rppd l=5.17u w=1u
X8081 cml_tlatch_24.xtail.S1 CKHA0_P cml_tlatch_24.xmux.xn.S1 VSS sg13_lv_nmos ad=89.3f pd=0.85u as=89.3f ps=0.85u w=0.47u l=0.16u
X8082 cml_tlatch_26.xmux.xp.S1 MOT6_N MOT6_P VSS sg13_lv_nmos ad=56.9f pd=0.74u as=56.9f ps=0.74u w=0.17u l=0.17u
X8083 cml_tlatch_34.xtail.S1 CKB1_N cml_tlatch_34.xmux.xp.S1 VSS sg13_lv_nmos ad=0.1598p pd=1.62u as=89.3f ps=0.85u w=0.47u l=0.16u
X8084 cml_tlatch_97.xmux.xp.S1 MOT0_P MOT0_N VSS sg13_lv_nmos ad=56.9f pd=0.74u as=56.9f ps=0.74u w=0.17u l=0.17u
X8085 cml_tlatch_82.xmux.xn.S1 cml_tlatch_83.OUTN cml_tlatch_82.OUTP VSS sg13_lv_nmos ad=63.19999f pd=0.74u as=63.19999f ps=0.74u w=0.26u l=0.38u
X8086 cml_tlatch_86.xtail.S1 CKHA3_N cml_tlatch_86.xmux.xp.S1 VSS sg13_lv_nmos ad=89.3f pd=0.85u as=89.3f ps=0.85u w=0.47u l=0.16u
X8087 cml_tlatch_20.xmux.xp.S1 MOT7_P MOT7_N VSS sg13_lv_nmos ad=56.9f pd=0.74u as=56.9f ps=0.74u w=0.17u l=0.17u
X8088 cml_tlatch_54.xmux.xp.S1 cml_tlatch_54.OUTN cml_tlatch_54.OUTP VSS sg13_lv_nmos ad=56.9f pd=0.74u as=56.9f ps=0.74u w=0.17u l=0.17u
X8089 A3_2_P cml_tlatch_54.OUTN cml_tlatch_53.xmux.xn.S1 VSS sg13_lv_nmos ad=63.19999f pd=0.74u as=63.19999f ps=0.74u w=0.26u l=0.38u
X8090 cml_tlatch_7.xmux.xn.S1 CKHB1_P cml_tlatch_7.xtail.S1 VSS sg13_lv_nmos ad=89.3f pd=0.85u as=89.3f ps=0.85u w=0.47u l=0.16u
X8091 cml_tlatch_93.xmux.xn.S1 J4_P J1_P VSS sg13_lv_nmos ad=63.19999f pd=0.74u as=63.19999f ps=0.74u w=0.26u l=0.38u
X8092 cml_tlatch_56.xmux.xp.S1 CKA2_P cml_tlatch_56.xtail.S1 VSS sg13_lv_nmos ad=89.3f pd=0.85u as=89.3f ps=0.85u w=0.47u l=0.16u
X8093 cml_tlatch_12.xmux.xp.S1 CKB1_P cml_tlatch_12.xtail.S1 VSS sg13_lv_nmos ad=89.3f pd=0.85u as=89.3f ps=0.85u w=0.47u l=0.16u
X8094 cml_tlatch_53.xmux.xn.S1 cml_tlatch_54.OUTP A3_2_N VSS sg13_lv_nmos ad=63.19999f pd=0.74u as=63.19999f ps=0.74u w=0.26u l=0.38u
X8095 J1_N J4_N cml_tlatch_93.xmux.xn.S1 VSS sg13_lv_nmos ad=63.19999f pd=0.74u as=63.19999f ps=0.74u w=0.26u l=0.38u
X8096 J4_P J4_N cml_tlatch_90.xmux.xp.S1 VSS sg13_lv_nmos ad=56.9f pd=0.74u as=56.9f ps=0.74u w=0.17u l=0.17u
X8097 cml_tlatch_84.xmux.xp.S1 cml_tlatch_70.INN cml_tlatch_70.INP VSS sg13_lv_nmos ad=56.9f pd=0.74u as=56.9f ps=0.74u w=0.17u l=0.17u
X8098 cml_tlatch_49.xmux.xp.S1 CKHA2_N cml_tlatch_49.xtail.S1 VSS sg13_lv_nmos ad=89.3f pd=0.85u as=89.3f ps=0.85u w=0.47u l=0.16u
X8099 cml_gate2_2.xrtail.R1 CKB0_N GA0_P VSS sg13_lv_nmos ad=0.1007p pd=0.91u as=0.1007p ps=0.91u w=0.53u l=0.13u
X8100 cml_tlatch_80.xmux.xp.S1 stub_bi_49.BOTN stub_bi_49.BOTP VSS sg13_lv_nmos ad=56.9f pd=0.74u as=56.9f ps=0.74u w=0.17u l=0.17u
X8101 A0_2_N cml_tlatch_35.OUTP cml_tlatch_31.xmux.xn.S1 VSS sg13_lv_nmos ad=0.1082p pd=1.34u as=63.19999f ps=0.74u w=0.26u l=0.38u
X8102 cml_tlatch_48.xmux.xn.S1 D2_P stub_bi_32.BOTP VSS sg13_lv_nmos ad=63.19999f pd=0.74u as=63.19999f ps=0.74u w=0.26u l=0.38u
X8103 cml_tlatch_92.xmux.xp.S1 J2_P J2_N VSS sg13_lv_nmos ad=56.9f pd=0.74u as=56.9f ps=0.74u w=0.17u l=0.17u
X8104 cml_tlatch_49.xmux.xp.S1 MOT18_P MOT18_N VSS sg13_lv_nmos ad=56.9f pd=0.74u as=56.9f ps=0.74u w=0.17u l=0.17u
X8105 A0_2_N cml_tlatch_35.OUTP cml_tlatch_31.xmux.xn.S1 VSS sg13_lv_nmos ad=63.19999f pd=0.74u as=63.19999f ps=0.74u w=0.26u l=0.38u
X8106 cml_tlatch_30.xmux.xp.S1 cml_tlatch_30.OUTP cml_tlatch_30.OUTN VSS sg13_lv_nmos ad=56.9f pd=0.74u as=56.9f ps=0.74u w=0.17u l=0.17u
X8107 cml_tlatch_44.xmux.xp.S1 CKB2_P cml_tlatch_44.xtail.S1 VSS sg13_lv_nmos ad=89.3f pd=0.85u as=89.3f ps=0.85u w=0.47u l=0.16u
X8108 cml_tlatch_23.xtail.S1 POLN VSS VSS sg13_lv_nmos ad=1.5637p pd=8.61u as=1.5637p ps=8.61u w=8.23u l=0.13u
X8109 cml_tlatch_95.xmux.xp.S1 CKA1_P cml_tlatch_95.xtail.S1 VSS sg13_lv_nmos ad=89.3f pd=0.85u as=89.3f ps=0.85u w=0.47u l=0.16u
X8110 cml_gate2_9.xrtail.R1 NM1_N ENA_P VSS sg13_lv_nmos ad=0.1007p pd=0.91u as=0.1007p ps=0.91u w=0.53u l=0.13u
X8111 cml_tlatch_53.xmux.xp.S1 CKA3_P cml_tlatch_53.xtail.S1 VSS sg13_lv_nmos ad=89.3f pd=0.85u as=89.3f ps=0.85u w=0.47u l=0.16u
X8112 stub_bi_49.BOTP stub_bi_55.BOTN cml_tlatch_80.xmux.xn.S1 VSS sg13_lv_nmos ad=63.19999f pd=0.74u as=63.19999f ps=0.74u w=0.26u l=0.38u
X8113 MOT29_N MOT29_P cml_tlatch_70.xmux.xp.S1 VSS sg13_lv_nmos ad=56.9f pd=0.74u as=56.9f ps=0.74u w=0.17u l=0.17u
X8114 B0_2_P B0_2_N cml_tlatch_28.xmux.xp.S1 VSS sg13_lv_nmos ad=56.9f pd=0.74u as=56.9f ps=0.74u w=0.17u l=0.17u
X8115 cml_tlatch_11.OUTN cml_tlatch_11.OUTP cml_tlatch_11.xmux.xp.S1 VSS sg13_lv_nmos ad=56.9f pd=0.74u as=56.9f ps=0.74u w=0.17u l=0.17u
X8116 cml_gate2_9.sg13_lv_nmos_FTPY57_0.D0 J1_P ENA_N VSS sg13_lv_nmos ad=0.1007p pd=0.91u as=0.1007p ps=0.91u w=0.53u l=0.13u
X8117 B2_8_N B2_8_P cml_tlatch_77.xmux.xp.S1 VSS sg13_lv_nmos ad=56.9f pd=0.74u as=56.9f ps=0.74u w=0.17u l=0.17u
X8118 cml_tlatch_89.OUTN cml_tlatch_89.OUTP cml_tlatch_89.xmux.xp.S1 VSS sg13_lv_nmos ad=56.9f pd=0.74u as=56.9f ps=0.74u w=0.17u l=0.17u
X8119 MOT1_P MOT1_N cml_tlatch_17.xmux.xp.S1 VSS sg13_lv_nmos ad=56.9f pd=0.74u as=56.9f ps=0.74u w=0.17u l=0.17u
X8120 cml_tlatch_40.xmux.xp.S1 CKHA1_N cml_tlatch_40.xtail.S1 VSS sg13_lv_nmos ad=89.3f pd=0.85u as=89.3f ps=0.85u w=0.47u l=0.16u
X8121 cml_tlatch_92.xmux.xp.S1 J2_P J2_N VSS sg13_lv_nmos ad=0.1019p pd=1.34u as=56.9f ps=0.74u w=0.17u l=0.17u
X8122 VDD cml_tlatch_99.OUTP VSS rppd l=5.17u w=1u
X8123 cml_tlatch_31.xmux.xp.S1 A0_2_P A0_2_N VSS sg13_lv_nmos ad=56.9f pd=0.74u as=56.9f ps=0.74u w=0.17u l=0.17u
X8124 cml_tlatch_9.xmux.xp.S1 CKA0_N cml_tlatch_9.xtail.S1 VSS sg13_lv_nmos ad=89.3f pd=0.85u as=89.3f ps=0.85u w=0.47u l=0.16u
X8125 cml_tlatch_29.xmux.xp.S1 cml_tlatch_29.OUTN cml_tlatch_29.OUTP VSS sg13_lv_nmos ad=0.1019p pd=1.34u as=56.9f ps=0.74u w=0.17u l=0.17u
X8126 cml_tlatch_6.xmux.xp.S1 MOT13_P MOT13_N VSS sg13_lv_nmos ad=56.9f pd=0.74u as=56.9f ps=0.74u w=0.17u l=0.17u
X8127 cml_tlatch_39.xmux.xn.S1 cml_tlatch_39.INP MOT10_N VSS sg13_lv_nmos ad=63.19999f pd=0.74u as=0.1082p ps=1.34u w=0.26u l=0.38u
X8128 cml_tlatch_62.xmux.xp.S1 cml_tlatch_69.INP cml_tlatch_69.INN VSS sg13_lv_nmos ad=56.9f pd=0.74u as=56.9f ps=0.74u w=0.17u l=0.17u
X8129 cml_tlatch_83.OUTN cml_tlatch_83.OUTP cml_tlatch_83.xmux.xp.S1 VSS sg13_lv_nmos ad=56.9f pd=0.74u as=56.9f ps=0.74u w=0.17u l=0.17u
X8130 cml_tlatch_83.OUTP cml_tlatch_83.OUTN cml_tlatch_83.xmux.xp.S1 VSS sg13_lv_nmos ad=56.9f pd=0.74u as=56.9f ps=0.74u w=0.17u l=0.17u
X8131 A1_2_N A1_2_P cml_tlatch_37.xmux.xp.S1 VSS sg13_lv_nmos ad=56.9f pd=0.74u as=56.9f ps=0.74u w=0.17u l=0.17u
X8132 cml_tlatch_79.xmux.xp.S1 stub_bi_63.BOTP stub_bi_63.BOTN VSS sg13_lv_nmos ad=56.9f pd=0.74u as=56.9f ps=0.74u w=0.17u l=0.17u
X8133 MOT2_P MOT2_N cml_tlatch_24.xmux.xp.S1 VSS sg13_lv_nmos ad=56.9f pd=0.74u as=56.9f ps=0.74u w=0.17u l=0.17u
X8134 MOT2_N MOT2_P cml_tlatch_24.xmux.xp.S1 VSS sg13_lv_nmos ad=56.9f pd=0.74u as=56.9f ps=0.74u w=0.17u l=0.17u
X8135 cml_drv_1.xrtail.R1 ENA_N ENA1_P VSS sg13_lv_nmos ad=56.2f pd=0.74u as=56.2f ps=0.74u w=0.16u l=0.19u
X8136 cml_tlatch_78.xmux.xn.S1 CKB2_P cml_tlatch_78.xtail.S1 VSS sg13_lv_nmos ad=89.3f pd=0.85u as=89.3f ps=0.85u w=0.47u l=0.16u
X8137 stub_bi_42.BOTN stub_bi_42.BOTP cml_tlatch_43.xmux.xp.S1 VSS sg13_lv_nmos ad=56.9f pd=0.74u as=56.9f ps=0.74u w=0.17u l=0.17u
X8138 cml_tlatch_8.OUTN cml_tlatch_9.OUTP cml_tlatch_8.xmux.xn.S1 VSS sg13_lv_nmos ad=63.19999f pd=0.74u as=63.19999f ps=0.74u w=0.26u l=0.38u
X8139 cml_tlatch_82.xmux.xp.S1 cml_tlatch_82.OUTP cml_tlatch_82.OUTN VSS sg13_lv_nmos ad=56.9f pd=0.74u as=56.9f ps=0.74u w=0.17u l=0.17u
X8140 MOT23_N MOT23_P cml_tlatch_76.xmux.xp.S1 VSS sg13_lv_nmos ad=56.9f pd=0.74u as=0.1019p ps=1.34u w=0.17u l=0.17u
X8141 cml_tlatch_33.xmux.xn.S1 stub_bi_31.BOTN B1_2_N VSS sg13_lv_nmos ad=63.19999f pd=0.74u as=0.1082p ps=1.34u w=0.26u l=0.38u
X8142 cml_tlatch_67.OUTP cml_tlatch_58.INN cml_tlatch_67.xmux.xn.S1 VSS sg13_lv_nmos ad=63.19999f pd=0.74u as=63.19999f ps=0.74u w=0.26u l=0.38u
X8143 cml_tlatch_71.xmux.xn.S1 B3_2_P MOT31_N VSS sg13_lv_nmos ad=63.19999f pd=0.74u as=63.19999f ps=0.74u w=0.26u l=0.38u
X8144 cml_tlatch_5.xmux.xp.S1 MOT11_N MOT11_P VSS sg13_lv_nmos ad=56.9f pd=0.74u as=56.9f ps=0.74u w=0.17u l=0.17u
X8145 MOT14_P MOT14_N cml_tlatch_41.xmux.xp.S1 VSS sg13_lv_nmos ad=56.9f pd=0.74u as=56.9f ps=0.74u w=0.17u l=0.17u
X8146 cml_tlatch_43.xmux.xn.S1 B2_2_N stub_bi_42.BOTN VSS sg13_lv_nmos ad=0.1082p pd=1.34u as=63.19999f ps=0.74u w=0.26u l=0.38u
X8147 cml_tlatch_45.xmux.xn.S1 CKB3_P cml_tlatch_45.xtail.S1 VSS sg13_lv_nmos ad=89.3f pd=0.85u as=89.3f ps=0.85u w=0.47u l=0.16u
X8148 VSS POLN cml_tlatch_50.xtail.S1 VSS sg13_lv_nmos ad=2.7982p pd=17.14u as=1.5637p ps=8.61u w=8.23u l=0.13u
X8149 cml_tlatch_44.xmux.xp.S1 B2_2_N B2_2_P VSS sg13_lv_nmos ad=56.9f pd=0.74u as=56.9f ps=0.74u w=0.17u l=0.17u
X8150 cml_tlatch_91.xmux.xn.S1 CKJ_P cml_tlatch_91.xtail.S1 VSS sg13_lv_nmos ad=89.3f pd=0.85u as=89.3f ps=0.85u w=0.47u l=0.16u
X8151 cml_tlatch_99.xmux.xn.S1 cml_tlatch_30.OUTP cml_tlatch_99.OUTN VSS sg13_lv_nmos ad=63.19999f pd=0.74u as=63.19999f ps=0.74u w=0.26u l=0.38u
X8152 VSS hs_to_clk_8.sg13_lv_nmos_2HGZLP_0.G VSS VSS sg13_lv_nmos ad=2.071p pd=11.28u as=0 ps=0 w=10.9u l=1.38u
X8153 GA2_P CKB2_N cml_gate2_4.xrtail.R1 VSS sg13_lv_nmos ad=0.1007p pd=0.91u as=0.1802p ps=1.74u w=0.53u l=0.13u
X8154 cml_tlatch_90.xmux.xn.S1 CLK_W_P J4_P VSS sg13_lv_nmos ad=63.19999f pd=0.74u as=63.19999f ps=0.74u w=0.26u l=0.38u
X8155 MOT20_P MOT20_N cml_tlatch_50.xmux.xp.S1 VSS sg13_lv_nmos ad=56.9f pd=0.74u as=56.9f ps=0.74u w=0.17u l=0.17u
X8156 cml_tlatch_75.xmux.xn.S1 stub_bi_55.BOTN MOT21_N VSS sg13_lv_nmos ad=63.19999f pd=0.74u as=63.19999f ps=0.74u w=0.26u l=0.38u
X8157 cml_tlatch_9.OUTN cml_tlatch_99.OUTP cml_tlatch_9.xmux.xn.S1 VSS sg13_lv_nmos ad=0.1082p pd=1.34u as=63.19999f ps=0.74u w=0.26u l=0.38u
X8158 J4_N CLK_W_N cml_tlatch_90.xmux.xn.S1 VSS sg13_lv_nmos ad=63.19999f pd=0.74u as=63.19999f ps=0.74u w=0.26u l=0.38u
X8159 cml_tlatch_73.xmux.xn.S1 CKHB2_P cml_tlatch_73.xtail.S1 VSS sg13_lv_nmos ad=89.3f pd=0.85u as=0.1598p ps=1.62u w=0.47u l=0.16u
X8160 cml_tlatch_9.OUTN cml_tlatch_99.OUTP cml_tlatch_9.xmux.xn.S1 VSS sg13_lv_nmos ad=63.19999f pd=0.74u as=63.19999f ps=0.74u w=0.26u l=0.38u
X8161 cml_tlatch_4.xmux.xp.S1 MOT9_P MOT9_N VSS sg13_lv_nmos ad=56.9f pd=0.74u as=56.9f ps=0.74u w=0.17u l=0.17u
X8162 cml_tlatch_97.xmux.xp.S1 MOT0_P MOT0_N VSS sg13_lv_nmos ad=0.1019p pd=1.34u as=56.9f ps=0.74u w=0.17u l=0.17u
X8163 MOT27_N cml_tlatch_69.INP cml_tlatch_69.xmux.xn.S1 VSS sg13_lv_nmos ad=63.19999f pd=0.74u as=63.19999f ps=0.74u w=0.26u l=0.38u
X8164 cml_tlatch_52.OUTN cml_tlatch_52.OUTP cml_tlatch_52.xmux.xp.S1 VSS sg13_lv_nmos ad=56.9f pd=0.74u as=56.9f ps=0.74u w=0.17u l=0.17u
X8165 MOT12_P MOT12_N cml_tlatch_40.xmux.xp.S1 VSS sg13_lv_nmos ad=56.9f pd=0.74u as=56.9f ps=0.74u w=0.17u l=0.17u
X8166 cml_tlatch_0.xmux.xp.S1 interco_bi_19.INN interco_bi_19.INP VSS sg13_lv_nmos ad=56.9f pd=0.74u as=56.9f ps=0.74u w=0.17u l=0.17u
X8167 B1_8_P stub_bi_17.BOTP cml_tlatch_12.xmux.xn.S1 VSS sg13_lv_nmos ad=63.19999f pd=0.74u as=63.19999f ps=0.74u w=0.26u l=0.38u
X8168 stub_bi_42.BOTP B2_2_P cml_tlatch_43.xmux.xn.S1 VSS sg13_lv_nmos ad=63.19999f pd=0.74u as=63.19999f ps=0.74u w=0.26u l=0.38u
X8169 stub_bi_49.BOTN stub_bi_49.BOTP cml_tlatch_80.xmux.xp.S1 VSS sg13_lv_nmos ad=56.9f pd=0.74u as=56.9f ps=0.74u w=0.17u l=0.17u
X8170 cml_tlatch_2.xmux.xn.S1 CKA0_N cml_tlatch_2.xtail.S1 VSS sg13_lv_nmos ad=89.3f pd=0.85u as=89.3f ps=0.85u w=0.47u l=0.16u
X8171 cml_tlatch_12.xmux.xn.S1 CKB1_N cml_tlatch_12.xtail.S1 VSS sg13_lv_nmos ad=89.3f pd=0.85u as=89.3f ps=0.85u w=0.47u l=0.16u
X8172 cml_tlatch_69.xmux.xp.S1 MOT27_N MOT27_P VSS sg13_lv_nmos ad=56.9f pd=0.74u as=56.9f ps=0.74u w=0.17u l=0.17u
X8173 cml_tlatch_81.xmux.xp.S1 A2_8_N A2_8_P VSS sg13_lv_nmos ad=56.9f pd=0.74u as=56.9f ps=0.74u w=0.17u l=0.17u
X8174 B3_8_P B3_8_N cml_tlatch_60.xmux.xp.S1 VSS sg13_lv_nmos ad=56.9f pd=0.74u as=56.9f ps=0.74u w=0.17u l=0.17u
X8175 cml_tlatch_95.xmux.xp.S1 cml_tlatch_40.INP cml_tlatch_40.INN VSS sg13_lv_nmos ad=56.9f pd=0.74u as=56.9f ps=0.74u w=0.17u l=0.17u
X8176 A3_2_P A3_2_N cml_tlatch_53.xmux.xp.S1 VSS sg13_lv_nmos ad=56.9f pd=0.74u as=0.1019p ps=1.34u w=0.17u l=0.17u
X8177 cml_tlatch_81.xmux.xn.S1 CKA2_N cml_tlatch_81.xtail.S1 VSS sg13_lv_nmos ad=89.3f pd=0.85u as=89.3f ps=0.85u w=0.47u l=0.16u
X8178 cml_tlatch_6.xmux.xn.S1 CKHB1_P cml_tlatch_6.xtail.S1 VSS sg13_lv_nmos ad=89.3f pd=0.85u as=89.3f ps=0.85u w=0.47u l=0.16u
X8179 cml_tlatch_92.xtail.S1 CKJ_N cml_tlatch_92.xmux.xn.S1 VSS sg13_lv_nmos ad=89.3f pd=0.85u as=89.3f ps=0.85u w=0.47u l=0.16u
X8180 cml_tlatch_60.xmux.xn.S1 cml_tlatch_61.OUTN B3_8_P VSS sg13_lv_nmos ad=63.19999f pd=0.74u as=63.19999f ps=0.74u w=0.26u l=0.38u
X8181 cml_tlatch_68.xmux.xn.S1 CKHB3_P cml_tlatch_68.xtail.S1 VSS sg13_lv_nmos ad=89.3f pd=0.85u as=89.3f ps=0.85u w=0.47u l=0.16u
X8182 stub_bi_19.BOTP VDD VSS rppd l=5.17u w=1u
X8183 cml_tlatch_54.xmux.xp.S1 cml_tlatch_54.OUTP cml_tlatch_54.OUTN VSS sg13_lv_nmos ad=56.9f pd=0.74u as=56.9f ps=0.74u w=0.17u l=0.17u
X8184 MOT23_N MOT23_P cml_tlatch_76.xmux.xp.S1 VSS sg13_lv_nmos ad=56.9f pd=0.74u as=56.9f ps=0.74u w=0.17u l=0.17u
X8185 interco_bi_19.INN interco_bi_19.INP cml_tlatch_0.xmux.xp.S1 VSS sg13_lv_nmos ad=56.9f pd=0.74u as=0.1019p ps=1.34u w=0.17u l=0.17u
X8186 stub_bi_63.BOTP stub_bi_63.BOTN cml_tlatch_79.xmux.xp.S1 VSS sg13_lv_nmos ad=56.9f pd=0.74u as=0.1019p ps=1.34u w=0.17u l=0.17u
X8187 cml_tlatch_18.xmux.xp.S1 MOT3_P MOT3_N VSS sg13_lv_nmos ad=56.9f pd=0.74u as=56.9f ps=0.74u w=0.17u l=0.17u
X8188 cml_tlatch_49.xmux.xp.S1 MOT18_P MOT18_N VSS sg13_lv_nmos ad=56.9f pd=0.74u as=56.9f ps=0.74u w=0.17u l=0.17u
X8189 cml_tlatch_30.xmux.xp.S1 cml_tlatch_30.OUTP cml_tlatch_30.OUTN VSS sg13_lv_nmos ad=56.9f pd=0.74u as=56.9f ps=0.74u w=0.17u l=0.17u
X8190 cml_tlatch_89.xmux.xp.S1 cml_tlatch_89.OUTN cml_tlatch_89.OUTP VSS sg13_lv_nmos ad=0.1019p pd=1.34u as=56.9f ps=0.74u w=0.17u l=0.17u
X8191 cml_tlatch_35.xtail.S1 CKA0_P cml_tlatch_35.xmux.xn.S1 VSS sg13_lv_nmos ad=89.3f pd=0.85u as=89.3f ps=0.85u w=0.47u l=0.16u
X8192 ENA_N J1_P cml_gate2_9.sg13_lv_nmos_FTPY57_0.D0 VSS sg13_lv_nmos ad=0.1007p pd=0.91u as=0.1007p ps=0.91u w=0.53u l=0.13u
X8193 VDD cml_tlatch_89.OUTN VSS rppd l=5.17u w=1u
X8194 MOT13_P MOT13_N cml_tlatch_6.xmux.xp.S1 VSS sg13_lv_nmos ad=56.9f pd=0.74u as=56.9f ps=0.74u w=0.17u l=0.17u
X8195 B0_2_P B0_2_N cml_tlatch_28.xmux.xp.S1 VSS sg13_lv_nmos ad=56.9f pd=0.74u as=56.9f ps=0.74u w=0.17u l=0.17u
X8196 MOT23_P MOT23_N cml_tlatch_76.xmux.xp.S1 VSS sg13_lv_nmos ad=56.9f pd=0.74u as=56.9f ps=0.74u w=0.17u l=0.17u
X8197 B2_8_N B2_8_P cml_tlatch_77.xmux.xp.S1 VSS sg13_lv_nmos ad=56.9f pd=0.74u as=56.9f ps=0.74u w=0.17u l=0.17u
X8198 cml_tlatch_24.xmux.xn.S1 CKHA0_P cml_tlatch_24.xtail.S1 VSS sg13_lv_nmos ad=89.3f pd=0.85u as=89.3f ps=0.85u w=0.47u l=0.16u
X8199 cml_tlatch_39.xmux.xp.S1 MOT10_P MOT10_N VSS sg13_lv_nmos ad=56.9f pd=0.74u as=56.9f ps=0.74u w=0.17u l=0.17u
X8200 cml_tlatch_21.xmux.xp.S1 A1_8_P A1_8_N VSS sg13_lv_nmos ad=56.9f pd=0.74u as=56.9f ps=0.74u w=0.17u l=0.17u
X8201 cml_tlatch_23.xmux.xn.S1 CKA1_N cml_tlatch_23.xtail.S1 VSS sg13_lv_nmos ad=89.3f pd=0.85u as=89.3f ps=0.85u w=0.47u l=0.16u
X8202 cml_tlatch_45.OUTN cml_tlatch_45.OUTP cml_tlatch_45.xmux.xp.S1 VSS sg13_lv_nmos ad=56.9f pd=0.74u as=0.1019p ps=1.34u w=0.17u l=0.17u
X8203 cml_tlatch_85.xtail.S1 CKA3_P cml_tlatch_85.xmux.xp.S1 VSS sg13_lv_nmos ad=89.3f pd=0.85u as=89.3f ps=0.85u w=0.47u l=0.16u
X8204 cml_tlatch_18.xmux.xp.S1 CKHB0_N cml_tlatch_18.xtail.S1 VSS sg13_lv_nmos ad=89.3f pd=0.85u as=89.3f ps=0.85u w=0.47u l=0.16u
X8205 cml_tlatch_85.xmux.xn.S1 cml_tlatch_52.OUTN cml_tlatch_58.INP VSS sg13_lv_nmos ad=63.19999f pd=0.74u as=63.19999f ps=0.74u w=0.26u l=0.38u
X8206 cml_tlatch_38.OUTN cml_tlatch_38.OUTP cml_tlatch_38.xmux.xp.S1 VSS sg13_lv_nmos ad=56.9f pd=0.74u as=56.9f ps=0.74u w=0.17u l=0.17u
X8207 cml_tlatch_28.xmux.xn.S1 CKB0_N cml_tlatch_28.xtail.S1 VSS sg13_lv_nmos ad=89.3f pd=0.85u as=89.3f ps=0.85u w=0.47u l=0.16u
X8208 MOT15_P MOT15_N cml_tlatch_7.xmux.xp.S1 VSS sg13_lv_nmos ad=56.9f pd=0.74u as=56.9f ps=0.74u w=0.17u l=0.17u
X8209 cml_tlatch_49.xtail.S1 CKHA2_N cml_tlatch_49.xmux.xp.S1 VSS sg13_lv_nmos ad=89.3f pd=0.85u as=89.3f ps=0.85u w=0.47u l=0.16u
X8210 cml_tlatch_74.xtail.S1 POLN VSS VSS sg13_lv_nmos ad=1.5637p pd=8.61u as=1.5637p ps=8.61u w=8.23u l=0.13u
X8211 cml_tlatch_3.xmux.xn.S1 cml_tlatch_8.OUTN cml_tlatch_3.OUTP VSS sg13_lv_nmos ad=63.19999f pd=0.74u as=63.19999f ps=0.74u w=0.26u l=0.38u
X8212 cml_tlatch_29.xmux.xn.S1 D0_N cml_tlatch_29.OUTP VSS sg13_lv_nmos ad=63.19999f pd=0.74u as=63.19999f ps=0.74u w=0.26u l=0.38u
X8213 cml_tlatch_86.xtail.S1 CKHA3_P cml_tlatch_86.xmux.xn.S1 VSS sg13_lv_nmos ad=89.3f pd=0.85u as=89.3f ps=0.85u w=0.47u l=0.16u
X8214 stub_bi_42.BOTN stub_bi_42.BOTP cml_tlatch_43.xmux.xp.S1 VSS sg13_lv_nmos ad=56.9f pd=0.74u as=56.9f ps=0.74u w=0.17u l=0.17u
X8215 cml_tlatch_98.xmux.xp.S1 CKB0_P cml_tlatch_98.xtail.S1 VSS sg13_lv_nmos ad=89.3f pd=0.85u as=89.3f ps=0.85u w=0.47u l=0.16u
X8216 cml_tlatch_31.xmux.xn.S1 cml_tlatch_35.OUTN A0_2_P VSS sg13_lv_nmos ad=63.19999f pd=0.74u as=63.19999f ps=0.74u w=0.26u l=0.38u
X8217 cml_tlatch_39.xmux.xp.S1 MOT10_N MOT10_P VSS sg13_lv_nmos ad=56.9f pd=0.74u as=56.9f ps=0.74u w=0.17u l=0.17u
X8218 cml_tlatch_36.xmux.xp.S1 cml_tlatch_95.INN cml_tlatch_95.INP VSS sg13_lv_nmos ad=56.9f pd=0.74u as=56.9f ps=0.74u w=0.17u l=0.17u
X8219 cml_tlatch_52.xmux.xp.S1 CKA3_N cml_tlatch_52.xtail.S1 VSS sg13_lv_nmos ad=89.3f pd=0.85u as=89.3f ps=0.85u w=0.47u l=0.16u
X8220 MOT29_P MOT29_N cml_tlatch_70.xmux.xp.S1 VSS sg13_lv_nmos ad=56.9f pd=0.74u as=56.9f ps=0.74u w=0.17u l=0.17u
X8221 stub_bi_62.BOTP stub_bi_62.BOTN cml_tlatch_78.xmux.xp.S1 VSS sg13_lv_nmos ad=56.9f pd=0.74u as=56.9f ps=0.74u w=0.17u l=0.17u
X8222 cml_tlatch_29.xmux.xn.S1 D0_N cml_tlatch_29.OUTP VSS sg13_lv_nmos ad=63.19999f pd=0.74u as=63.19999f ps=0.74u w=0.26u l=0.38u
X8223 cml_tlatch_81.xmux.xn.S1 cml_tlatch_82.OUTN A2_8_P VSS sg13_lv_nmos ad=63.19999f pd=0.74u as=63.19999f ps=0.74u w=0.26u l=0.38u
X8224 cml_tlatch_23.xmux.xp.S1 cml_tlatch_39.INN cml_tlatch_39.INP VSS sg13_lv_nmos ad=56.9f pd=0.74u as=56.9f ps=0.74u w=0.17u l=0.17u
X8225 cml_tlatch_33.xmux.xn.S1 CKB1_N cml_tlatch_33.xtail.S1 VSS sg13_lv_nmos ad=89.3f pd=0.85u as=89.3f ps=0.85u w=0.47u l=0.16u
X8226 cml_tlatch_56.xtail.S1 POLN VSS VSS sg13_lv_nmos ad=1.5637p pd=8.61u as=2.7982p ps=17.14u w=8.23u l=0.13u
X8227 B3_2_N B3_2_P cml_tlatch_46.xmux.xp.S1 VSS sg13_lv_nmos ad=56.9f pd=0.74u as=56.9f ps=0.74u w=0.17u l=0.17u
X8228 cml_tlatch_58.INN cml_tlatch_58.INP cml_tlatch_85.xmux.xp.S1 VSS sg13_lv_nmos ad=56.9f pd=0.74u as=56.9f ps=0.74u w=0.17u l=0.17u
X8229 A2_8_N cml_tlatch_82.OUTP cml_tlatch_81.xmux.xn.S1 VSS sg13_lv_nmos ad=63.19999f pd=0.74u as=63.19999f ps=0.74u w=0.26u l=0.38u
X8230 cml_tlatch_9.OUTN cml_tlatch_9.OUTP cml_tlatch_9.xmux.xp.S1 VSS sg13_lv_nmos ad=56.9f pd=0.74u as=56.9f ps=0.74u w=0.17u l=0.17u
X8231 cml_tlatch_4.xmux.xp.S1 CKHB1_N cml_tlatch_4.xtail.S1 VSS sg13_lv_nmos ad=89.3f pd=0.85u as=89.3f ps=0.85u w=0.47u l=0.16u
X8232 cml_gate2_1.xrtail.R1 CKA0_P cml_gate2_1.sg13_lv_nmos_FTPY57_0.D0 VSS sg13_lv_nmos ad=0.1007p pd=0.91u as=0.1007p ps=0.91u w=0.53u l=0.13u
X8233 cml_tlatch_56.xmux.xn.S1 CKA2_N cml_tlatch_56.xtail.S1 VSS sg13_lv_nmos ad=89.3f pd=0.85u as=89.3f ps=0.85u w=0.47u l=0.16u
X8234 cml_tlatch_52.xtail.S1 POLN VSS VSS sg13_lv_nmos ad=1.5637p pd=8.61u as=2.7982p ps=17.14u w=8.23u l=0.13u
X8235 cml_tlatch_57.xtail.S1 CKHA3_N cml_tlatch_57.xmux.xp.S1 VSS sg13_lv_nmos ad=89.3f pd=0.85u as=89.3f ps=0.85u w=0.47u l=0.16u
X8236 VSS POLN cml_tlatch_40.xtail.S1 VSS sg13_lv_nmos ad=1.5637p pd=8.61u as=1.5637p ps=8.61u w=8.23u l=0.13u
X8237 cml_tlatch_0.xmux.xp.S1 interco_bi_19.INN interco_bi_19.INP VSS sg13_lv_nmos ad=56.9f pd=0.74u as=56.9f ps=0.74u w=0.17u l=0.17u
X8238 cml_tlatch_82.xtail.S1 POLN VSS VSS sg13_lv_nmos ad=1.5637p pd=8.61u as=1.5637p ps=8.61u w=8.23u l=0.13u
X8239 cml_tlatch_62.xmux.xn.S1 cml_tlatch_63.OUTN cml_tlatch_69.INP VSS sg13_lv_nmos ad=63.19999f pd=0.74u as=0.1082p ps=1.34u w=0.26u l=0.38u
X8240 cml_tlatch_95.xmux.xp.S1 cml_tlatch_40.INP cml_tlatch_40.INN VSS sg13_lv_nmos ad=56.9f pd=0.74u as=56.9f ps=0.74u w=0.17u l=0.17u
X8241 cml_tlatch_6.INN cml_tlatch_6.INP cml_tlatch_94.xmux.xp.S1 VSS sg13_lv_nmos ad=56.9f pd=0.74u as=56.9f ps=0.74u w=0.17u l=0.17u
X8242 cml_tlatch_45.xmux.xp.S1 CKB3_N cml_tlatch_45.xtail.S1 VSS sg13_lv_nmos ad=89.3f pd=0.85u as=89.3f ps=0.85u w=0.47u l=0.16u
X8243 MOT19_N MOT19_P cml_tlatch_74.xmux.xp.S1 VSS sg13_lv_nmos ad=56.9f pd=0.74u as=0.1019p ps=1.34u w=0.17u l=0.17u
X8244 cml_tlatch_57.xmux.xp.S1 MOT26_N MOT26_P VSS sg13_lv_nmos ad=56.9f pd=0.74u as=56.9f ps=0.74u w=0.17u l=0.17u
X8245 cml_tlatch_67.OUTN cml_tlatch_67.OUTP cml_tlatch_67.xmux.xp.S1 VSS sg13_lv_nmos ad=56.9f pd=0.74u as=56.9f ps=0.74u w=0.17u l=0.17u
X8246 cml_tlatch_13.xtail.S1 CKB1_N cml_tlatch_13.xmux.xp.S1 VSS sg13_lv_nmos ad=0.1598p pd=1.62u as=89.3f ps=0.85u w=0.47u l=0.16u
X8247 cml_tlatch_65.xmux.xp.S1 cml_tlatch_65.OUTP cml_tlatch_65.OUTN VSS sg13_lv_nmos ad=56.9f pd=0.74u as=56.9f ps=0.74u w=0.17u l=0.17u
X8248 VSS POLN cml_tlatch_1.xtail.S1 VSS sg13_lv_nmos ad=2.7982p pd=17.14u as=1.5637p ps=8.61u w=8.23u l=0.13u
X8249 cml_tlatch_34.xtail.S1 CKB1_N cml_tlatch_34.xmux.xp.S1 VSS sg13_lv_nmos ad=89.3f pd=0.85u as=89.3f ps=0.85u w=0.47u l=0.16u
X8250 MOT12_P MOT12_N cml_tlatch_40.xmux.xp.S1 VSS sg13_lv_nmos ad=56.9f pd=0.74u as=56.9f ps=0.74u w=0.17u l=0.17u
X8251 cml_tlatch_0.xmux.xp.S1 interco_bi_19.INN interco_bi_19.INP VSS sg13_lv_nmos ad=56.9f pd=0.74u as=56.9f ps=0.74u w=0.17u l=0.17u
X8252 CKB0_P hs_to_clk_1.sg13_lv_nmos_2HGZLP_0.G VSS rppd l=4.25u w=1u
X8253 GB0_P CKA0_N cml_gate2_1.xrtail.R1 VSS sg13_lv_nmos ad=0.1007p pd=0.91u as=0.1007p ps=0.91u w=0.53u l=0.13u
X8254 cml_tlatch_81.xmux.xp.S1 A2_8_N A2_8_P VSS sg13_lv_nmos ad=56.9f pd=0.74u as=56.9f ps=0.74u w=0.17u l=0.17u
X8255 cml_tlatch_33.xmux.xp.S1 B1_2_P B1_2_N VSS sg13_lv_nmos ad=0.1019p pd=1.34u as=56.9f ps=0.74u w=0.17u l=0.17u
X8256 cml_tlatch_61.OUTP cml_tlatch_69.INN cml_tlatch_61.xmux.xn.S1 VSS sg13_lv_nmos ad=63.19999f pd=0.74u as=63.19999f ps=0.74u w=0.26u l=0.38u
X8257 cml_tlatch_94.xmux.xn.S1 stub_bi_29.BOTP cml_tlatch_6.INP VSS sg13_lv_nmos ad=63.19999f pd=0.74u as=0.1082p ps=1.34u w=0.26u l=0.38u
X8258 cml_tlatch_48.xmux.xn.S1 D2_N stub_bi_32.BOTN VSS sg13_lv_nmos ad=63.19999f pd=0.74u as=63.19999f ps=0.74u w=0.26u l=0.38u
X8259 cml_tlatch_35.xmux.xn.S1 D0_P cml_tlatch_35.OUTN VSS sg13_lv_nmos ad=63.19999f pd=0.74u as=63.19999f ps=0.74u w=0.26u l=0.38u
X8260 cml_tlatch_26.xtail.S1 CKHA0_N cml_tlatch_26.xmux.xp.S1 VSS sg13_lv_nmos ad=89.3f pd=0.85u as=89.3f ps=0.85u w=0.47u l=0.16u
X8261 MOT17_P MOT17_N cml_tlatch_73.xmux.xp.S1 VSS sg13_lv_nmos ad=56.9f pd=0.74u as=56.9f ps=0.74u w=0.17u l=0.17u
X8262 B1_2_P B1_2_N cml_tlatch_33.xmux.xp.S1 VSS sg13_lv_nmos ad=56.9f pd=0.74u as=56.9f ps=0.74u w=0.17u l=0.17u
X8263 cml_tlatch_1.OUTP cml_tlatch_1.OUTN cml_tlatch_1.xmux.xp.S1 VSS sg13_lv_nmos ad=56.9f pd=0.74u as=56.9f ps=0.74u w=0.17u l=0.17u
X8264 cml_tlatch_3.xmux.xp.S1 cml_tlatch_3.OUTN cml_tlatch_3.OUTP VSS sg13_lv_nmos ad=56.9f pd=0.74u as=56.9f ps=0.74u w=0.17u l=0.17u
X8265 VSS POLN cml_tlatch_31.xtail.S1 VSS sg13_lv_nmos ad=1.5637p pd=8.61u as=1.5637p ps=8.61u w=8.23u l=0.13u
X8266 cml_tlatch_22.xmux.xn.S1 CKA1_P cml_tlatch_22.xtail.S1 VSS sg13_lv_nmos ad=89.3f pd=0.85u as=89.3f ps=0.85u w=0.47u l=0.16u
X8267 cml_tlatch_90.xtail.S1 CKJ_N cml_tlatch_90.xmux.xn.S1 VSS sg13_lv_nmos ad=89.3f pd=0.85u as=89.3f ps=0.85u w=0.47u l=0.16u
X8268 cml_tlatch_57.INP cml_tlatch_57.INN cml_tlatch_66.xmux.xp.S1 VSS sg13_lv_nmos ad=56.9f pd=0.74u as=56.9f ps=0.74u w=0.17u l=0.17u
X8269 cml_tlatch_16.OUTP cml_tlatch_16.OUTN cml_tlatch_16.xmux.xp.S1 VSS sg13_lv_nmos ad=56.9f pd=0.74u as=56.9f ps=0.74u w=0.17u l=0.17u
X8270 MOT9_P MOT9_N cml_tlatch_4.xmux.xp.S1 VSS sg13_lv_nmos ad=56.9f pd=0.74u as=56.9f ps=0.74u w=0.17u l=0.17u
X8271 stub_bi_19.BOTN cml_tlatch_6.INN cml_tlatch_15.xmux.xn.S1 VSS sg13_lv_nmos ad=63.19999f pd=0.74u as=63.19999f ps=0.74u w=0.26u l=0.38u
X8272 cml_tlatch_93.xmux.xp.S1 J1_P J1_N VSS sg13_lv_nmos ad=56.9f pd=0.74u as=56.9f ps=0.74u w=0.17u l=0.17u
X8273 MOT19_N MOT19_P cml_tlatch_74.xmux.xp.S1 VSS sg13_lv_nmos ad=56.9f pd=0.74u as=56.9f ps=0.74u w=0.17u l=0.17u
X8274 cml_tlatch_2.xmux.xp.S1 A0_8_N A0_8_P VSS sg13_lv_nmos ad=56.9f pd=0.74u as=56.9f ps=0.74u w=0.17u l=0.17u
X8275 cml_tlatch_7.xmux.xn.S1 B1_2_N MOT15_P VSS sg13_lv_nmos ad=63.19999f pd=0.74u as=63.19999f ps=0.74u w=0.26u l=0.38u
X8276 cml_tlatch_16.xmux.xp.S1 CKB0_P cml_tlatch_16.xtail.S1 VSS sg13_lv_nmos ad=89.3f pd=0.85u as=89.3f ps=0.85u w=0.47u l=0.16u
X8277 cml_tlatch_82.xmux.xn.S1 CKA2_P cml_tlatch_82.xtail.S1 VSS sg13_lv_nmos ad=0.1598p pd=1.62u as=89.3f ps=0.85u w=0.47u l=0.16u
X8278 cml_tlatch_65.xmux.xp.S1 cml_tlatch_65.OUTP cml_tlatch_65.OUTN VSS sg13_lv_nmos ad=56.9f pd=0.74u as=56.9f ps=0.74u w=0.17u l=0.17u
X8279 MOT18_N cml_tlatch_83.OUTP cml_tlatch_49.xmux.xn.S1 VSS sg13_lv_nmos ad=0.1082p pd=1.34u as=63.19999f ps=0.74u w=0.26u l=0.38u
X8280 cml_tlatch_16.xmux.xn.S1 CKB0_N cml_tlatch_16.xtail.S1 VSS sg13_lv_nmos ad=89.3f pd=0.85u as=89.3f ps=0.85u w=0.47u l=0.16u
X8281 cml_tlatch_55.xmux.xp.S1 cml_tlatch_89.INP cml_tlatch_89.INN VSS sg13_lv_nmos ad=56.9f pd=0.74u as=56.9f ps=0.74u w=0.17u l=0.17u
X8282 cml_gate2_7.sg13_lv_nmos_FTPY57_0.D0 CKA2_P cml_gate2_7.xrtail.R1 VSS sg13_lv_nmos ad=0.1007p pd=0.91u as=0.1802p ps=1.74u w=0.53u l=0.13u
X8283 cml_tlatch_54.xtail.S1 CKA3_N cml_tlatch_54.xmux.xp.S1 VSS sg13_lv_nmos ad=89.3f pd=0.85u as=89.3f ps=0.85u w=0.47u l=0.16u
X8284 J4_N J4_P cml_tlatch_90.xmux.xp.S1 VSS sg13_lv_nmos ad=56.9f pd=0.74u as=56.9f ps=0.74u w=0.17u l=0.17u
X8285 MOT15_P MOT15_N cml_tlatch_7.xmux.xp.S1 VSS sg13_lv_nmos ad=56.9f pd=0.74u as=56.9f ps=0.74u w=0.17u l=0.17u
X8286 cml_tlatch_5.xtail.S1 POLN VSS VSS sg13_lv_nmos ad=1.5637p pd=8.61u as=2.7982p ps=17.14u w=8.23u l=0.13u
X8287 VSS POLN cml_tlatch_37.xtail.S1 VSS sg13_lv_nmos ad=1.5637p pd=8.61u as=1.5637p ps=8.61u w=8.23u l=0.13u
X8288 cml_tlatch_65.OUTP cml_tlatch_65.OUTN cml_tlatch_65.xmux.xp.S1 VSS sg13_lv_nmos ad=56.9f pd=0.74u as=56.9f ps=0.74u w=0.17u l=0.17u
X8289 cml_tlatch_32.xtail.S1 CKB1_N cml_tlatch_32.xmux.xp.S1 VSS sg13_lv_nmos ad=89.3f pd=0.85u as=89.3f ps=0.85u w=0.47u l=0.16u
X8290 cml_tlatch_66.xtail.S1 CKA3_N cml_tlatch_66.xmux.xn.S1 VSS sg13_lv_nmos ad=89.3f pd=0.85u as=89.3f ps=0.85u w=0.47u l=0.16u
X8291 cml_tlatch_25.xmux.xp.S1 MOT4_P MOT4_N VSS sg13_lv_nmos ad=56.9f pd=0.74u as=56.9f ps=0.74u w=0.17u l=0.17u
X8292 VSS hs_to_clk_3.sg13_lv_nmos_2HGZLP_0.G VSS VSS sg13_lv_nmos ad=2.071p pd=11.28u as=0 ps=0 w=10.9u l=1.38u
X8293 cml_tlatch_93.xmux.xn.S1 J4_N J1_N VSS sg13_lv_nmos ad=63.19999f pd=0.74u as=63.19999f ps=0.74u w=0.26u l=0.38u
X8294 A3_2_N cml_tlatch_54.OUTP cml_tlatch_53.xmux.xn.S1 VSS sg13_lv_nmos ad=0.1082p pd=1.34u as=63.19999f ps=0.74u w=0.26u l=0.38u
X8295 cml_tlatch_59.xmux.xn.S1 A3_2_P MOT30_N VSS sg13_lv_nmos ad=63.19999f pd=0.74u as=63.19999f ps=0.74u w=0.26u l=0.38u
X8296 cml_tlatch_29.OUTP cml_tlatch_29.OUTN cml_tlatch_29.xmux.xp.S1 VSS sg13_lv_nmos ad=56.9f pd=0.74u as=56.9f ps=0.74u w=0.17u l=0.17u
X8297 cml_gate2_8.xrtail.R1 NS1_P cml_gate2_8.sg13_lv_nmos_FTPY57_0.D0 VSS sg13_lv_nmos ad=0.1007p pd=0.91u as=0.1007p ps=0.91u w=0.53u l=0.13u
X8298 VSS hs_to_clk_5.sg13_lv_nmos_2HGZLP_0.G VSS VSS sg13_lv_nmos ad=2.071p pd=11.28u as=0 ps=0 w=10.9u l=1.38u
X8299 cml_tlatch_54.OUTP D3_N cml_tlatch_54.xmux.xn.S1 VSS sg13_lv_nmos ad=63.19999f pd=0.74u as=63.19999f ps=0.74u w=0.26u l=0.38u
X8300 cml_tlatch_40.INP cml_tlatch_40.INN cml_tlatch_95.xmux.xp.S1 VSS sg13_lv_nmos ad=56.9f pd=0.74u as=56.9f ps=0.74u w=0.17u l=0.17u
X8301 cml_tlatch_98.xmux.xp.S1 cml_tlatch_98.OUTP cml_tlatch_98.OUTN VSS sg13_lv_nmos ad=56.9f pd=0.74u as=56.9f ps=0.74u w=0.17u l=0.17u
X8302 cml_tlatch_94.xmux.xp.S1 cml_tlatch_6.INN cml_tlatch_6.INP VSS sg13_lv_nmos ad=56.9f pd=0.74u as=56.9f ps=0.74u w=0.17u l=0.17u
X8303 cml_tlatch_59.xmux.xn.S1 A3_2_P MOT30_N VSS sg13_lv_nmos ad=63.19999f pd=0.74u as=63.19999f ps=0.74u w=0.26u l=0.38u
X8304 cml_tlatch_95.INN A1_2_P cml_tlatch_36.xmux.xn.S1 VSS sg13_lv_nmos ad=0.1082p pd=1.34u as=63.19999f ps=0.74u w=0.26u l=0.38u
X8305 cml_tlatch_41.xmux.xp.S1 MOT14_P MOT14_N VSS sg13_lv_nmos ad=56.9f pd=0.74u as=56.9f ps=0.74u w=0.17u l=0.17u
X8306 cml_drv_1.xrtail.R1 ENA_P ENA1_N VSS sg13_lv_nmos ad=56.2f pd=0.74u as=56.2f ps=0.74u w=0.16u l=0.19u
X8307 VSS hs_to_clk_2.sg13_lv_nmos_2HGZLP_0.G VSS VSS sg13_lv_nmos ad=2.071p pd=11.28u as=0 ps=0 w=10.9u l=1.38u
X8308 cml_tlatch_20.xtail.S1 CKHB0_N cml_tlatch_20.xmux.xp.S1 VSS sg13_lv_nmos ad=89.3f pd=0.85u as=89.3f ps=0.85u w=0.47u l=0.16u
X8309 cml_tlatch_36.xmux.xn.S1 CKA1_P cml_tlatch_36.xtail.S1 VSS sg13_lv_nmos ad=89.3f pd=0.85u as=0.1598p ps=1.62u w=0.47u l=0.16u
X8310 cml_gate2_5.xrtail.R1 VSS VSS rppd l=4.86u w=1u
X8311 cml_tlatch_80.xmux.xn.S1 stub_bi_55.BOTN stub_bi_49.BOTP VSS sg13_lv_nmos ad=63.19999f pd=0.74u as=63.19999f ps=0.74u w=0.26u l=0.38u
X8312 cml_tlatch_99.xtail.S1 CKA0_N cml_tlatch_99.xmux.xn.S1 VSS sg13_lv_nmos ad=89.3f pd=0.85u as=89.3f ps=0.85u w=0.47u l=0.16u
X8313 cml_tlatch_8.OUTP cml_tlatch_9.OUTN cml_tlatch_8.xmux.xn.S1 VSS sg13_lv_nmos ad=63.19999f pd=0.74u as=63.19999f ps=0.74u w=0.26u l=0.38u
X8314 cml_tlatch_19.xmux.xp.S1 MOT5_P MOT5_N VSS sg13_lv_nmos ad=56.9f pd=0.74u as=56.9f ps=0.74u w=0.17u l=0.17u
X8315 cml_tlatch_22.xmux.xp.S1 cml_tlatch_22.OUTN cml_tlatch_22.OUTP VSS sg13_lv_nmos ad=56.9f pd=0.74u as=56.9f ps=0.74u w=0.17u l=0.17u
X8316 cml_tlatch_66.xmux.xp.S1 cml_tlatch_57.INP cml_tlatch_57.INN VSS sg13_lv_nmos ad=56.9f pd=0.74u as=56.9f ps=0.74u w=0.17u l=0.17u
X8317 cml_tlatch_56.xmux.xp.S1 A2_2_N A2_2_P VSS sg13_lv_nmos ad=56.9f pd=0.74u as=56.9f ps=0.74u w=0.17u l=0.17u
X8318 cml_tlatch_59.xmux.xp.S1 MOT30_P MOT30_N VSS sg13_lv_nmos ad=56.9f pd=0.74u as=56.9f ps=0.74u w=0.17u l=0.17u
X8319 cml_tlatch_72.xtail.S1 CKA2_P cml_tlatch_72.xmux.xn.S1 VSS sg13_lv_nmos ad=89.3f pd=0.85u as=89.3f ps=0.85u w=0.47u l=0.16u
X8320 cml_tlatch_11.OUTP cml_tlatch_11.OUTN cml_tlatch_11.xmux.xp.S1 VSS sg13_lv_nmos ad=56.9f pd=0.74u as=56.9f ps=0.74u w=0.17u l=0.17u
X8321 cml_tlatch_26.xtail.S1 CKHA0_P cml_tlatch_26.xmux.xn.S1 VSS sg13_lv_nmos ad=89.3f pd=0.85u as=89.3f ps=0.85u w=0.47u l=0.16u
X8322 cml_tlatch_13.xmux.xp.S1 stub_bi_17.BOTN stub_bi_17.BOTP VSS sg13_lv_nmos ad=56.9f pd=0.74u as=56.9f ps=0.74u w=0.17u l=0.17u
X8323 cml_tlatch_14.xmux.xp.S1 cml_tlatch_5.INP cml_tlatch_5.INN VSS sg13_lv_nmos ad=56.9f pd=0.74u as=56.9f ps=0.74u w=0.17u l=0.17u
X8324 B0_8_P cml_tlatch_11.OUTN cml_tlatch_10.xmux.xn.S1 VSS sg13_lv_nmos ad=63.19999f pd=0.74u as=63.19999f ps=0.74u w=0.26u l=0.38u
X8325 cml_tlatch_36.xmux.xn.S1 A1_2_N cml_tlatch_95.INP VSS sg13_lv_nmos ad=63.19999f pd=0.74u as=63.19999f ps=0.74u w=0.26u l=0.38u
X8326 cml_tlatch_92.xtail.S1 CKJ_N cml_tlatch_92.xmux.xn.S1 VSS sg13_lv_nmos ad=89.3f pd=0.85u as=89.3f ps=0.85u w=0.47u l=0.16u
X8327 B3_8_N B3_8_P cml_tlatch_60.xmux.xp.S1 VSS sg13_lv_nmos ad=56.9f pd=0.74u as=56.9f ps=0.74u w=0.17u l=0.17u
X8328 cml_tlatch_27.xmux.xp.S1 cml_tlatch_27.OUTP cml_tlatch_27.OUTN VSS sg13_lv_nmos ad=0.1019p pd=1.34u as=56.9f ps=0.74u w=0.17u l=0.17u
X8329 cml_tlatch_49.xtail.S1 CKHA2_P cml_tlatch_49.xmux.xn.S1 VSS sg13_lv_nmos ad=89.3f pd=0.85u as=89.3f ps=0.85u w=0.47u l=0.16u
X8330 MOT0_N MOT0_P cml_tlatch_97.xmux.xp.S1 VSS sg13_lv_nmos ad=56.9f pd=0.74u as=56.9f ps=0.74u w=0.17u l=0.17u
X8331 MOT6_P MOT6_N cml_tlatch_26.xmux.xp.S1 VSS sg13_lv_nmos ad=56.9f pd=0.74u as=56.9f ps=0.74u w=0.17u l=0.17u
X8332 cml_tlatch_71.xtail.S1 CKHB3_P cml_tlatch_71.xmux.xn.S1 VSS sg13_lv_nmos ad=89.3f pd=0.85u as=89.3f ps=0.85u w=0.47u l=0.16u
X8333 GA1_P CKB1_N cml_gate2_3.xrtail.R1 VSS sg13_lv_nmos ad=0.1007p pd=0.91u as=0.1007p ps=0.91u w=0.53u l=0.13u
X8334 cml_tlatch_60.xtail.S1 CKB3_P cml_tlatch_60.xmux.xp.S1 VSS sg13_lv_nmos ad=89.3f pd=0.85u as=0.1598p ps=1.62u w=0.47u l=0.16u
X8335 cml_tlatch_80.xtail.S1 CKB2_P cml_tlatch_80.xmux.xn.S1 VSS sg13_lv_nmos ad=89.3f pd=0.85u as=89.3f ps=0.85u w=0.47u l=0.16u
X8336 cml_tlatch_3.xmux.xn.S1 CKA0_P cml_tlatch_3.xtail.S1 VSS sg13_lv_nmos ad=89.3f pd=0.85u as=89.3f ps=0.85u w=0.47u l=0.16u
X8337 J2_N J1_P cml_tlatch_92.xmux.xn.S1 VSS sg13_lv_nmos ad=63.19999f pd=0.74u as=63.19999f ps=0.74u w=0.26u l=0.38u
X8338 cml_tlatch_54.OUTP cml_tlatch_54.OUTN cml_tlatch_54.xmux.xp.S1 VSS sg13_lv_nmos ad=56.9f pd=0.74u as=56.9f ps=0.74u w=0.17u l=0.17u
X8339 cml_tlatch_12.xmux.xp.S1 B1_8_P B1_8_N VSS sg13_lv_nmos ad=56.9f pd=0.74u as=56.9f ps=0.74u w=0.17u l=0.17u
X8340 cml_tlatch_67.xtail.S1 CKA3_P cml_tlatch_67.xmux.xn.S1 VSS sg13_lv_nmos ad=89.3f pd=0.85u as=89.3f ps=0.85u w=0.47u l=0.16u
X8341 cml_tlatch_77.xmux.xn.S1 CKB2_N cml_tlatch_77.xtail.S1 VSS sg13_lv_nmos ad=89.3f pd=0.85u as=89.3f ps=0.85u w=0.47u l=0.16u
X8342 MOT9_P MOT9_N cml_tlatch_4.xmux.xp.S1 VSS sg13_lv_nmos ad=56.9f pd=0.74u as=56.9f ps=0.74u w=0.17u l=0.17u
X8343 cml_tlatch_90.xmux.xp.S1 J4_N J4_P VSS sg13_lv_nmos ad=56.9f pd=0.74u as=56.9f ps=0.74u w=0.17u l=0.17u
X8344 stub_bi_49.BOTP stub_bi_49.BOTN cml_tlatch_80.xmux.xp.S1 VSS sg13_lv_nmos ad=56.9f pd=0.74u as=56.9f ps=0.74u w=0.17u l=0.17u
X8345 cml_tlatch_45.OUTP cml_tlatch_45.OUTN cml_tlatch_45.xmux.xp.S1 VSS sg13_lv_nmos ad=56.9f pd=0.74u as=56.9f ps=0.74u w=0.17u l=0.17u
X8346 cml_tlatch_34.xmux.xp.S1 CKB1_N cml_tlatch_34.xtail.S1 VSS sg13_lv_nmos ad=89.3f pd=0.85u as=89.3f ps=0.85u w=0.47u l=0.16u
X8347 cml_tlatch_90.xmux.xn.S1 CLK_W_N J4_N VSS sg13_lv_nmos ad=63.19999f pd=0.74u as=63.19999f ps=0.74u w=0.26u l=0.38u
X8348 cml_tlatch_85.xtail.S1 CKA3_P cml_tlatch_85.xmux.xp.S1 VSS sg13_lv_nmos ad=89.3f pd=0.85u as=89.3f ps=0.85u w=0.47u l=0.16u
X8349 cml_tlatch_18.xmux.xp.S1 CKHB0_N cml_tlatch_18.xtail.S1 VSS sg13_lv_nmos ad=89.3f pd=0.85u as=89.3f ps=0.85u w=0.47u l=0.16u
X8350 cml_tlatch_32.xmux.xp.S1 stub_bi_29.BOTP stub_bi_29.BOTN VSS sg13_lv_nmos ad=56.9f pd=0.74u as=56.9f ps=0.74u w=0.17u l=0.17u
X8351 MOT5_P MOT5_N cml_tlatch_19.xmux.xp.S1 VSS sg13_lv_nmos ad=56.9f pd=0.74u as=56.9f ps=0.74u w=0.17u l=0.17u
X8352 cml_tlatch_95.INN cml_tlatch_95.INP cml_tlatch_36.xmux.xp.S1 VSS sg13_lv_nmos ad=56.9f pd=0.74u as=56.9f ps=0.74u w=0.17u l=0.17u
X8353 GA2_N ENA1_P cml_gate2_4.sg13_lv_nmos_FTPY57_0.D0 VSS sg13_lv_nmos ad=0.1007p pd=0.91u as=0.1007p ps=0.91u w=0.53u l=0.13u
X8354 cml_tlatch_38.xmux.xp.S1 cml_tlatch_38.OUTN cml_tlatch_38.OUTP VSS sg13_lv_nmos ad=56.9f pd=0.74u as=56.9f ps=0.74u w=0.17u l=0.17u
X8355 cml_tlatch_81.xtail.S1 CKA2_P cml_tlatch_81.xmux.xp.S1 VSS sg13_lv_nmos ad=89.3f pd=0.85u as=89.3f ps=0.85u w=0.47u l=0.16u
X8356 cml_tlatch_55.xtail.S1 CKA2_P cml_tlatch_55.xmux.xn.S1 VSS sg13_lv_nmos ad=89.3f pd=0.85u as=89.3f ps=0.85u w=0.47u l=0.16u
X8357 cml_tlatch_8.xmux.xn.S1 CKA0_N cml_tlatch_8.xtail.S1 VSS sg13_lv_nmos ad=89.3f pd=0.85u as=0.1598p ps=1.62u w=0.47u l=0.16u
X8358 cml_tlatch_89.xmux.xp.S1 cml_tlatch_89.OUTP cml_tlatch_89.OUTN VSS sg13_lv_nmos ad=56.9f pd=0.74u as=56.9f ps=0.74u w=0.17u l=0.17u
X8359 cml_tlatch_22.OUTN cml_tlatch_39.INP cml_tlatch_22.xmux.xn.S1 VSS sg13_lv_nmos ad=63.19999f pd=0.74u as=0.1082p ps=1.34u w=0.26u l=0.38u
X8360 cml_tlatch_29.OUTP cml_tlatch_29.OUTN cml_tlatch_29.xmux.xp.S1 VSS sg13_lv_nmos ad=56.9f pd=0.74u as=56.9f ps=0.74u w=0.17u l=0.17u
X8361 cml_tlatch_30.OUTP A0_2_N cml_tlatch_30.xmux.xn.S1 VSS sg13_lv_nmos ad=63.19999f pd=0.74u as=63.19999f ps=0.74u w=0.26u l=0.38u
X8362 A0_2_N A0_2_P cml_tlatch_31.xmux.xp.S1 VSS sg13_lv_nmos ad=56.9f pd=0.74u as=56.9f ps=0.74u w=0.17u l=0.17u
X8363 cml_gate2_2.sg13_lv_nmos_FTPY57_0.D0 ENA0_N GA0_P VSS sg13_lv_nmos ad=0.1007p pd=0.91u as=0.1007p ps=0.91u w=0.53u l=0.13u
X8364 GB3_P ENB0_N cml_gate2_6.sg13_lv_nmos_FTPY57_0.D0 VSS sg13_lv_nmos ad=0.1007p pd=0.91u as=0.1007p ps=0.91u w=0.53u l=0.13u
X8365 cml_tlatch_84.xtail.S1 CKB3_P cml_tlatch_84.xmux.xp.S1 VSS sg13_lv_nmos ad=0.1598p pd=1.62u as=89.3f ps=0.85u w=0.47u l=0.16u
X8366 MOT17_P B2_8_N cml_tlatch_73.xmux.xn.S1 VSS sg13_lv_nmos ad=63.19999f pd=0.74u as=63.19999f ps=0.74u w=0.26u l=0.38u
X8367 MOT13_N MOT13_P cml_tlatch_6.xmux.xp.S1 VSS sg13_lv_nmos ad=56.9f pd=0.74u as=56.9f ps=0.74u w=0.17u l=0.17u
X8368 cml_tlatch_94.xmux.xp.S1 cml_tlatch_6.INN cml_tlatch_6.INP VSS sg13_lv_nmos ad=56.9f pd=0.74u as=56.9f ps=0.74u w=0.17u l=0.17u
X8369 cml_tlatch_60.xmux.xn.S1 cml_tlatch_61.OUTP B3_8_N VSS sg13_lv_nmos ad=0.1082p pd=1.34u as=63.19999f ps=0.74u w=0.26u l=0.38u
X8370 stub_bi_32.BOTP stub_bi_32.BOTN cml_tlatch_48.xmux.xp.S1 VSS sg13_lv_nmos ad=56.9f pd=0.74u as=56.9f ps=0.74u w=0.17u l=0.17u
X8371 MOT12_P VDD VSS rppd l=5.17u w=1u
X8372 cml_tlatch_41.xmux.xp.S1 MOT14_P MOT14_N VSS sg13_lv_nmos ad=0.1019p pd=1.34u as=56.9f ps=0.74u w=0.17u l=0.17u
X8373 cml_tlatch_69.INP cml_tlatch_69.INN cml_tlatch_62.xmux.xp.S1 VSS sg13_lv_nmos ad=56.9f pd=0.74u as=56.9f ps=0.74u w=0.17u l=0.17u
X8374 cml_tlatch_19.xmux.xn.S1 cml_tlatch_98.OUTN MOT5_P VSS sg13_lv_nmos ad=63.19999f pd=0.74u as=63.19999f ps=0.74u w=0.26u l=0.38u
X8375 cml_tlatch_25.xtail.S1 CKHA0_P cml_tlatch_25.xmux.xn.S1 VSS sg13_lv_nmos ad=89.3f pd=0.85u as=89.3f ps=0.85u w=0.47u l=0.16u
X8376 cml_tlatch_60.xmux.xn.S1 cml_tlatch_61.OUTP B3_8_N VSS sg13_lv_nmos ad=63.19999f pd=0.74u as=63.19999f ps=0.74u w=0.26u l=0.38u
X8377 cml_tlatch_62.xtail.S1 CKB3_P cml_tlatch_62.xmux.xp.S1 VSS sg13_lv_nmos ad=89.3f pd=0.85u as=89.3f ps=0.85u w=0.47u l=0.16u
X8378 cml_tlatch_57.xtail.S1 CKHA3_N cml_tlatch_57.xmux.xp.S1 VSS sg13_lv_nmos ad=89.3f pd=0.85u as=89.3f ps=0.85u w=0.47u l=0.16u
X8379 cml_tlatch_24.xmux.xp.S1 MOT2_P MOT2_N VSS sg13_lv_nmos ad=56.9f pd=0.74u as=56.9f ps=0.74u w=0.17u l=0.17u
X8380 cml_tlatch_91.xmux.xn.S1 J2_P CLK_W_P VSS sg13_lv_nmos ad=63.19999f pd=0.74u as=63.19999f ps=0.74u w=0.26u l=0.38u
X8381 cml_tlatch_64.xmux.xp.S1 A3_8_N A3_8_P VSS sg13_lv_nmos ad=0.1019p pd=1.34u as=56.9f ps=0.74u w=0.17u l=0.17u
X8382 cml_tlatch_19.xmux.xn.S1 cml_tlatch_98.OUTN MOT5_P VSS sg13_lv_nmos ad=63.19999f pd=0.74u as=63.19999f ps=0.74u w=0.26u l=0.38u
X8383 cml_tlatch_21.xmux.xn.S1 cml_tlatch_22.OUTP A1_8_N VSS sg13_lv_nmos ad=63.19999f pd=0.74u as=63.19999f ps=0.74u w=0.26u l=0.38u
X8384 cml_tlatch_82.OUTN cml_tlatch_82.OUTP cml_tlatch_82.xmux.xp.S1 VSS sg13_lv_nmos ad=56.9f pd=0.74u as=56.9f ps=0.74u w=0.17u l=0.17u
X8385 cml_drvb_6.xrtail.R1 GB3_P CKHB3_N VSS sg13_lv_nmos ad=0.1463p pd=1.15u as=0.2618p ps=2.22u w=0.77u l=0.21u
X8386 cml_tlatch_27.xmux.xp.S1 CKB0_N cml_tlatch_27.xtail.S1 VSS sg13_lv_nmos ad=89.3f pd=0.85u as=89.3f ps=0.85u w=0.47u l=0.16u
X8387 cml_tlatch_96.xtail.S1 CKHA1_P cml_tlatch_96.xmux.xn.S1 VSS sg13_lv_nmos ad=0.1598p pd=1.62u as=89.3f ps=0.85u w=0.47u l=0.16u
X8388 cml_tlatch_0.xtail.S1 CKA1_N cml_tlatch_0.xmux.xp.S1 VSS sg13_lv_nmos ad=89.3f pd=0.85u as=89.3f ps=0.85u w=0.47u l=0.16u
X8389 cml_tlatch_51.xmux.xp.S1 CKHA2_N cml_tlatch_51.xtail.S1 VSS sg13_lv_nmos ad=89.3f pd=0.85u as=89.3f ps=0.85u w=0.47u l=0.16u
X8390 cml_drv_3.xrtail.R1 ENA_N ENA0_P VSS sg13_lv_nmos ad=56.2f pd=0.74u as=56.2f ps=0.74u w=0.16u l=0.19u
X8391 cml_tlatch_70.INN cml_tlatch_45.OUTP cml_tlatch_84.xmux.xn.S1 VSS sg13_lv_nmos ad=63.19999f pd=0.74u as=63.19999f ps=0.74u w=0.26u l=0.38u
X8392 cml_tlatch_69.INN cml_tlatch_69.INP cml_tlatch_62.xmux.xp.S1 VSS sg13_lv_nmos ad=56.9f pd=0.74u as=56.9f ps=0.74u w=0.17u l=0.17u
X8393 cml_tlatch_13.xtail.S1 CKB1_N cml_tlatch_13.xmux.xp.S1 VSS sg13_lv_nmos ad=89.3f pd=0.85u as=89.3f ps=0.85u w=0.47u l=0.16u
X8394 CLK_W_N CLK_W_P cml_tlatch_91.xmux.xp.S1 VSS sg13_lv_nmos ad=56.9f pd=0.74u as=56.9f ps=0.74u w=0.17u l=0.17u
X8395 cml_tlatch_56.xmux.xp.S1 A2_2_N A2_2_P VSS sg13_lv_nmos ad=56.9f pd=0.74u as=56.9f ps=0.74u w=0.17u l=0.17u
X8396 VSS hs_to_clk_0.sg13_lv_nmos_2HGZLP_0.G VSS VSS sg13_lv_nmos ad=2.071p pd=11.28u as=0 ps=0 w=10.9u l=1.38u
X8397 cml_tlatch_44.xmux.xn.S1 CKB2_N cml_tlatch_44.xtail.S1 VSS sg13_lv_nmos ad=89.3f pd=0.85u as=89.3f ps=0.85u w=0.47u l=0.16u
X8398 B2_2_P B2_2_N cml_tlatch_44.xmux.xp.S1 VSS sg13_lv_nmos ad=56.9f pd=0.74u as=56.9f ps=0.74u w=0.17u l=0.17u
X8399 VDD cml_tlatch_9.OUTN VSS rppd l=5.17u w=1u
X8400 cml_tlatch_14.xmux.xn.S1 stub_bi_19.BOTN cml_tlatch_5.INN VSS sg13_lv_nmos ad=0.1082p pd=1.34u as=63.19999f ps=0.74u w=0.26u l=0.38u
X8401 cml_tlatch_58.INP cml_tlatch_52.OUTN cml_tlatch_85.xmux.xn.S1 VSS sg13_lv_nmos ad=0.1082p pd=1.34u as=63.19999f ps=0.74u w=0.26u l=0.38u
X8402 cml_tlatch_96.xmux.xn.S1 A1_8_N MOT8_P VSS sg13_lv_nmos ad=63.19999f pd=0.74u as=63.19999f ps=0.74u w=0.26u l=0.38u
X8403 cml_tlatch_50.xmux.xp.S1 MOT20_N MOT20_P VSS sg13_lv_nmos ad=56.9f pd=0.74u as=56.9f ps=0.74u w=0.17u l=0.17u
X8404 cml_tlatch_11.xmux.xp.S1 cml_tlatch_11.OUTP cml_tlatch_11.OUTN VSS sg13_lv_nmos ad=56.9f pd=0.74u as=56.9f ps=0.74u w=0.17u l=0.17u
X8405 MOT12_P cml_tlatch_40.INN cml_tlatch_40.xmux.xn.S1 VSS sg13_lv_nmos ad=63.19999f pd=0.74u as=63.19999f ps=0.74u w=0.26u l=0.38u
X8406 cml_tlatch_14.xmux.xp.S1 cml_tlatch_5.INP cml_tlatch_5.INN VSS sg13_lv_nmos ad=56.9f pd=0.74u as=56.9f ps=0.74u w=0.17u l=0.17u
X8407 MOT12_N MOT12_P cml_tlatch_40.xmux.xp.S1 VSS sg13_lv_nmos ad=56.9f pd=0.74u as=56.9f ps=0.74u w=0.17u l=0.17u
X8408 cml_tlatch_83.INP cml_tlatch_83.INN cml_tlatch_72.xmux.xp.S1 VSS sg13_lv_nmos ad=56.9f pd=0.74u as=56.9f ps=0.74u w=0.17u l=0.17u
X8409 cml_tlatch_52.xmux.xp.S1 cml_tlatch_52.OUTP cml_tlatch_52.OUTN VSS sg13_lv_nmos ad=56.9f pd=0.74u as=56.9f ps=0.74u w=0.17u l=0.17u
X8410 cml_tlatch_80.xmux.xp.S1 stub_bi_49.BOTP stub_bi_49.BOTN VSS sg13_lv_nmos ad=56.9f pd=0.74u as=56.9f ps=0.74u w=0.17u l=0.17u
X8411 cml_tlatch_20.xmux.xp.S1 CKHB0_N cml_tlatch_20.xtail.S1 VSS sg13_lv_nmos ad=89.3f pd=0.85u as=89.3f ps=0.85u w=0.47u l=0.16u
X8412 cml_tlatch_40.xmux.xp.S1 MOT12_N MOT12_P VSS sg13_lv_nmos ad=56.9f pd=0.74u as=56.9f ps=0.74u w=0.17u l=0.17u
X8413 cml_tlatch_29.OUTP VDD VSS rppd l=5.17u w=1u
X8414 cml_tlatch_60.xmux.xp.S1 B3_8_N B3_8_P VSS sg13_lv_nmos ad=56.9f pd=0.74u as=56.9f ps=0.74u w=0.17u l=0.17u
X8415 cml_tlatch_88.xmux.xp.S1 stub_bi_55.BOTN stub_bi_55.BOTP VSS sg13_lv_nmos ad=56.9f pd=0.74u as=56.9f ps=0.74u w=0.17u l=0.17u
X8416 ENB_P VDD VSS rppd l=7.42u w=1u
X8417 cml_tlatch_51.xmux.xp.S1 MOT22_N MOT22_P VSS sg13_lv_nmos ad=56.9f pd=0.74u as=56.9f ps=0.74u w=0.17u l=0.17u
X8418 B0_8_N cml_tlatch_11.OUTP cml_tlatch_10.xmux.xn.S1 VSS sg13_lv_nmos ad=63.19999f pd=0.74u as=63.19999f ps=0.74u w=0.26u l=0.38u
X8419 cml_tlatch_29.OUTN cml_tlatch_29.OUTP cml_tlatch_29.xmux.xp.S1 VSS sg13_lv_nmos ad=56.9f pd=0.74u as=56.9f ps=0.74u w=0.17u l=0.17u
X8420 cml_tlatch_40.xmux.xn.S1 cml_tlatch_40.INP MOT12_N VSS sg13_lv_nmos ad=63.19999f pd=0.74u as=0.1082p ps=1.34u w=0.26u l=0.38u
X8421 cml_tlatch_90.xtail.S1 CKJ_N cml_tlatch_90.xmux.xn.S1 VSS sg13_lv_nmos ad=89.3f pd=0.85u as=89.3f ps=0.85u w=0.47u l=0.16u
X8422 cml_tlatch_34.xmux.xn.S1 CKB1_P cml_tlatch_34.xtail.S1 VSS sg13_lv_nmos ad=89.3f pd=0.85u as=89.3f ps=0.85u w=0.47u l=0.16u
X8423 cml_tlatch_4.xmux.xn.S1 B1_8_P MOT9_N VSS sg13_lv_nmos ad=63.19999f pd=0.74u as=63.19999f ps=0.74u w=0.26u l=0.38u
X8424 cml_gate2_5.sg13_lv_nmos_FTPY57_0.D0 ENA1_N GA3_P VSS sg13_lv_nmos ad=0.1007p pd=0.91u as=0.1007p ps=0.91u w=0.53u l=0.13u
X8425 cml_tlatch_42.xmux.xn.S1 CKA2_P cml_tlatch_42.xtail.S1 VSS sg13_lv_nmos ad=89.3f pd=0.85u as=89.3f ps=0.85u w=0.47u l=0.16u
X8426 MOT28_N MOT28_P cml_tlatch_58.xmux.xp.S1 VSS sg13_lv_nmos ad=56.9f pd=0.74u as=56.9f ps=0.74u w=0.17u l=0.17u
X8427 cml_tlatch_82.OUTP cml_tlatch_83.OUTN cml_tlatch_82.xmux.xn.S1 VSS sg13_lv_nmos ad=63.19999f pd=0.74u as=0.1082p ps=1.34u w=0.26u l=0.38u
X8428 cml_tlatch_46.xmux.xp.S1 CKB3_P cml_tlatch_46.xtail.S1 VSS sg13_lv_nmos ad=89.3f pd=0.85u as=89.3f ps=0.85u w=0.47u l=0.16u
X8429 cml_tlatch_65.xtail.S1 CKA3_N cml_tlatch_65.xmux.xp.S1 VSS sg13_lv_nmos ad=89.3f pd=0.85u as=89.3f ps=0.85u w=0.47u l=0.16u
X8430 cml_tlatch_16.xmux.xn.S1 CKB0_N cml_tlatch_16.xtail.S1 VSS sg13_lv_nmos ad=89.3f pd=0.85u as=89.3f ps=0.85u w=0.47u l=0.16u
X8431 cml_tlatch_89.OUTP cml_tlatch_89.OUTN cml_tlatch_89.xmux.xp.S1 VSS sg13_lv_nmos ad=56.9f pd=0.74u as=56.9f ps=0.74u w=0.17u l=0.17u
X8432 stub_bi_49.BOTN stub_bi_55.BOTP cml_tlatch_80.xmux.xn.S1 VSS sg13_lv_nmos ad=63.19999f pd=0.74u as=63.19999f ps=0.74u w=0.26u l=0.38u
X8433 cml_tlatch_59.xmux.xn.S1 A3_2_N MOT30_P VSS sg13_lv_nmos ad=0.1082p pd=1.34u as=63.19999f ps=0.74u w=0.26u l=0.38u
X8434 cml_tlatch_28.xmux.xp.S1 B0_2_N B0_2_P VSS sg13_lv_nmos ad=56.9f pd=0.74u as=56.9f ps=0.74u w=0.17u l=0.17u
X8435 cml_tlatch_6.xmux.xp.S1 MOT13_N MOT13_P VSS sg13_lv_nmos ad=56.9f pd=0.74u as=56.9f ps=0.74u w=0.17u l=0.17u
X8436 cml_tlatch_0.xtail.S1 CKA1_N cml_tlatch_0.xmux.xp.S1 VSS sg13_lv_nmos ad=89.3f pd=0.85u as=89.3f ps=0.85u w=0.47u l=0.16u
X8437 cml_tlatch_92.xmux.xn.S1 CKJ_N cml_tlatch_92.xtail.S1 VSS sg13_lv_nmos ad=89.3f pd=0.85u as=0.1598p ps=1.62u w=0.47u l=0.16u
X8438 cml_tlatch_76.xmux.xp.S1 MOT23_N MOT23_P VSS sg13_lv_nmos ad=56.9f pd=0.74u as=56.9f ps=0.74u w=0.17u l=0.17u
X8439 cml_tlatch_77.xmux.xp.S1 B2_8_P B2_8_N VSS sg13_lv_nmos ad=56.9f pd=0.74u as=56.9f ps=0.74u w=0.17u l=0.17u
X8440 cml_tlatch_66.xtail.S1 CKA3_N cml_tlatch_66.xmux.xn.S1 VSS sg13_lv_nmos ad=89.3f pd=0.85u as=89.3f ps=0.85u w=0.47u l=0.16u
X8441 cml_tlatch_99.OUTP cml_tlatch_99.OUTN cml_tlatch_99.xmux.xp.S1 VSS sg13_lv_nmos ad=56.9f pd=0.74u as=56.9f ps=0.74u w=0.17u l=0.17u
X8442 cml_tlatch_31.xmux.xn.S1 cml_tlatch_35.OUTP A0_2_N VSS sg13_lv_nmos ad=63.19999f pd=0.74u as=63.19999f ps=0.74u w=0.26u l=0.38u
X8443 VSS POLN cml_tlatch_67.xtail.S1 VSS sg13_lv_nmos ad=2.7982p pd=17.14u as=1.5637p ps=8.61u w=8.23u l=0.13u
X8444 VDD A0_8_N VSS rppd l=5.17u w=1u
X8445 MOT7_N B0_2_P cml_tlatch_20.xmux.xn.S1 VSS sg13_lv_nmos ad=63.19999f pd=0.74u as=0.1082p ps=1.34u w=0.26u l=0.38u
X8446 cml_tlatch_27.xtail.S1 CKB0_P cml_tlatch_27.xmux.xn.S1 VSS sg13_lv_nmos ad=89.3f pd=0.85u as=89.3f ps=0.85u w=0.47u l=0.16u
X8447 cml_tlatch_74.xmux.xn.S1 CKHB2_P cml_tlatch_74.xtail.S1 VSS sg13_lv_nmos ad=89.3f pd=0.85u as=0.1598p ps=1.62u w=0.47u l=0.16u
X8448 stub_bi_32.BOTP stub_bi_32.BOTN cml_tlatch_48.xmux.xp.S1 VSS sg13_lv_nmos ad=56.9f pd=0.74u as=56.9f ps=0.74u w=0.17u l=0.17u
X8449 cml_tlatch_38.xmux.xp.S1 cml_tlatch_38.OUTP cml_tlatch_38.OUTN VSS sg13_lv_nmos ad=56.9f pd=0.74u as=56.9f ps=0.74u w=0.17u l=0.17u
X8450 VSS POLN cml_tlatch_13.xtail.S1 VSS sg13_lv_nmos ad=2.7982p pd=17.14u as=1.5637p ps=8.61u w=8.23u l=0.13u
X8451 cml_tlatch_77.xtail.S1 CKB2_N cml_tlatch_77.xmux.xn.S1 VSS sg13_lv_nmos ad=89.3f pd=0.85u as=89.3f ps=0.85u w=0.47u l=0.16u
X8452 cml_tlatch_7.xmux.xp.S1 MOT15_N MOT15_P VSS sg13_lv_nmos ad=56.9f pd=0.74u as=56.9f ps=0.74u w=0.17u l=0.17u
X8453 cml_gate2_3.xrtail.R1 CKB1_P cml_gate2_3.sg13_lv_nmos_FTPY57_0.D0 VSS sg13_lv_nmos ad=0.1007p pd=0.91u as=0.1007p ps=0.91u w=0.53u l=0.13u
X8454 cml_tlatch_80.xtail.S1 POLN VSS VSS sg13_lv_nmos ad=1.5637p pd=8.61u as=2.7982p ps=17.14u w=8.23u l=0.13u
X8455 cml_tlatch_24.xmux.xp.S1 MOT2_P MOT2_N VSS sg13_lv_nmos ad=0.1019p pd=1.34u as=56.9f ps=0.74u w=0.17u l=0.17u
X8456 cml_tlatch_43.xmux.xp.S1 stub_bi_42.BOTP stub_bi_42.BOTN VSS sg13_lv_nmos ad=56.9f pd=0.74u as=56.9f ps=0.74u w=0.17u l=0.17u
X8457 cml_tlatch_62.xtail.S1 CKB3_N cml_tlatch_62.xmux.xn.S1 VSS sg13_lv_nmos ad=0.1598p pd=1.62u as=89.3f ps=0.85u w=0.47u l=0.16u
X8458 cml_tlatch_87.xmux.xn.S1 CKHA2_P cml_tlatch_87.xtail.S1 VSS sg13_lv_nmos ad=89.3f pd=0.85u as=89.3f ps=0.85u w=0.47u l=0.16u
X8459 cml_tlatch_82.OUTN cml_tlatch_82.OUTP cml_tlatch_82.xmux.xp.S1 VSS sg13_lv_nmos ad=56.9f pd=0.74u as=56.9f ps=0.74u w=0.17u l=0.17u
X8460 cml_tlatch_4.xtail.S1 CKHB1_P cml_tlatch_4.xmux.xn.S1 VSS sg13_lv_nmos ad=89.3f pd=0.85u as=89.3f ps=0.85u w=0.47u l=0.16u
X8461 cml_gate2_0.sg13_lv_nmos_FTPY57_0.D0 CKA1_P cml_gate2_0.xrtail.R1 VSS sg13_lv_nmos ad=0.1007p pd=0.91u as=0.1007p ps=0.91u w=0.53u l=0.13u
X8462 cml_tlatch_70.xmux.xp.S1 MOT29_N MOT29_P VSS sg13_lv_nmos ad=56.9f pd=0.74u as=56.9f ps=0.74u w=0.17u l=0.17u
X8463 cml_tlatch_78.xmux.xp.S1 stub_bi_62.BOTN stub_bi_62.BOTP VSS sg13_lv_nmos ad=56.9f pd=0.74u as=56.9f ps=0.74u w=0.17u l=0.17u
X8464 cml_tlatch_51.xmux.xn.S1 CKHA2_P cml_tlatch_51.xtail.S1 VSS sg13_lv_nmos ad=0.1598p pd=1.62u as=89.3f ps=0.85u w=0.47u l=0.16u
X8465 cml_tlatch_10.xmux.xp.S1 B0_8_P B0_8_N VSS sg13_lv_nmos ad=56.9f pd=0.74u as=56.9f ps=0.74u w=0.17u l=0.17u
X8466 cml_tlatch_89.xtail.S1 CKA2_N cml_tlatch_89.xmux.xn.S1 VSS sg13_lv_nmos ad=89.3f pd=0.85u as=89.3f ps=0.85u w=0.47u l=0.16u
X8467 cml_tlatch_69.xmux.xn.S1 CKHB3_P cml_tlatch_69.xtail.S1 VSS sg13_lv_nmos ad=89.3f pd=0.85u as=89.3f ps=0.85u w=0.47u l=0.16u
X8468 cml_tlatch_93.xtail.S1 CKJ_P cml_tlatch_93.xmux.xn.S1 VSS sg13_lv_nmos ad=89.3f pd=0.85u as=89.3f ps=0.85u w=0.47u l=0.16u
X8469 cml_tlatch_59.xmux.xp.S1 MOT30_N MOT30_P VSS sg13_lv_nmos ad=56.9f pd=0.74u as=56.9f ps=0.74u w=0.17u l=0.17u
X8470 MOT16_N MOT16_P cml_tlatch_87.xmux.xp.S1 VSS sg13_lv_nmos ad=56.9f pd=0.74u as=56.9f ps=0.74u w=0.17u l=0.17u
X8471 cml_tlatch_11.xtail.S1 CKB0_N cml_tlatch_11.xmux.xp.S1 VSS sg13_lv_nmos ad=89.3f pd=0.85u as=89.3f ps=0.85u w=0.47u l=0.16u
X8472 cml_tlatch_7.xmux.xn.S1 B1_2_P MOT15_N VSS sg13_lv_nmos ad=0.1082p pd=1.34u as=63.19999f ps=0.74u w=0.26u l=0.38u
X8473 cml_gate2_5.xrtail.R1 CKB3_P cml_gate2_5.sg13_lv_nmos_FTPY57_0.D0 VSS sg13_lv_nmos ad=0.1007p pd=0.91u as=0.1007p ps=0.91u w=0.53u l=0.13u
X8474 stub_bi_29.BOTP stub_bi_29.BOTN cml_tlatch_32.xmux.xp.S1 VSS sg13_lv_nmos ad=56.9f pd=0.74u as=56.9f ps=0.74u w=0.17u l=0.17u
X8475 cml_tlatch_71.xmux.xp.S1 MOT31_P MOT31_N VSS sg13_lv_nmos ad=56.9f pd=0.74u as=56.9f ps=0.74u w=0.17u l=0.17u
X8476 MOT0_N A0_8_P cml_tlatch_97.xmux.xn.S1 VSS sg13_lv_nmos ad=63.19999f pd=0.74u as=63.19999f ps=0.74u w=0.26u l=0.38u
X8477 cml_tlatch_8.xmux.xn.S1 cml_tlatch_9.OUTP cml_tlatch_8.OUTN VSS sg13_lv_nmos ad=63.19999f pd=0.74u as=63.19999f ps=0.74u w=0.26u l=0.38u
X8478 MOT28_P MOT28_N cml_tlatch_58.xmux.xp.S1 VSS sg13_lv_nmos ad=56.9f pd=0.74u as=56.9f ps=0.74u w=0.17u l=0.17u
X8479 MOT8_N MOT8_P cml_tlatch_96.xmux.xp.S1 VSS sg13_lv_nmos ad=56.9f pd=0.74u as=56.9f ps=0.74u w=0.17u l=0.17u
X8480 cml_tlatch_38.OUTN D1_P cml_tlatch_38.xmux.xn.S1 VSS sg13_lv_nmos ad=63.19999f pd=0.74u as=0.1082p ps=1.34u w=0.26u l=0.38u
X8481 cml_tlatch_88.xtail.S1 CKB2_N cml_tlatch_88.xmux.xn.S1 VSS sg13_lv_nmos ad=89.3f pd=0.85u as=89.3f ps=0.85u w=0.47u l=0.16u
X8482 cml_tlatch_99.xmux.xp.S1 cml_tlatch_99.OUTP cml_tlatch_99.OUTN VSS sg13_lv_nmos ad=56.9f pd=0.74u as=56.9f ps=0.74u w=0.17u l=0.17u
X8483 cml_gate2_0.xrtail.R1 CKA1_N GB1_P VSS sg13_lv_nmos ad=0.1007p pd=0.91u as=0.1007p ps=0.91u w=0.53u l=0.13u
X8484 cml_tlatch_67.xmux.xp.S1 cml_tlatch_67.OUTP cml_tlatch_67.OUTN VSS sg13_lv_nmos ad=56.9f pd=0.74u as=56.9f ps=0.74u w=0.17u l=0.17u
X8485 cml_tlatch_85.xtail.S1 CKA3_N cml_tlatch_85.xmux.xn.S1 VSS sg13_lv_nmos ad=89.3f pd=0.85u as=89.3f ps=0.85u w=0.47u l=0.16u
X8486 cml_tlatch_25.xmux.xn.S1 CKHA0_P cml_tlatch_25.xtail.S1 VSS sg13_lv_nmos ad=89.3f pd=0.85u as=89.3f ps=0.85u w=0.47u l=0.16u
X8487 stub_bi_42.BOTN B2_2_N cml_tlatch_43.xmux.xn.S1 VSS sg13_lv_nmos ad=63.19999f pd=0.74u as=63.19999f ps=0.74u w=0.26u l=0.38u
X8488 cml_tlatch_40.xmux.xp.S1 MOT12_N MOT12_P VSS sg13_lv_nmos ad=56.9f pd=0.74u as=56.9f ps=0.74u w=0.17u l=0.17u
X8489 cml_tlatch_80.xmux.xp.S1 stub_bi_49.BOTP stub_bi_49.BOTN VSS sg13_lv_nmos ad=56.9f pd=0.74u as=56.9f ps=0.74u w=0.17u l=0.17u
X8490 cml_tlatch_0.xmux.xn.S1 cml_tlatch_40.INP interco_bi_19.INN VSS sg13_lv_nmos ad=63.19999f pd=0.74u as=63.19999f ps=0.74u w=0.26u l=0.38u
X8491 MOT23_P B2_2_N cml_tlatch_76.xmux.xn.S1 VSS sg13_lv_nmos ad=63.19999f pd=0.74u as=0.1082p ps=1.34u w=0.26u l=0.38u
X8492 cml_tlatch_40.INN cml_tlatch_40.INP cml_tlatch_95.xmux.xp.S1 VSS sg13_lv_nmos ad=56.9f pd=0.74u as=56.9f ps=0.74u w=0.17u l=0.17u
X8493 cml_tlatch_19.xmux.xp.S1 CKHB0_N cml_tlatch_19.xtail.S1 VSS sg13_lv_nmos ad=89.3f pd=0.85u as=89.3f ps=0.85u w=0.47u l=0.16u
X8494 cml_gate2_1.sg13_lv_nmos_FTPY57_0.D0 ENB1_P GB0_N VSS sg13_lv_nmos ad=0.1007p pd=0.91u as=0.1007p ps=0.91u w=0.53u l=0.13u
X8495 B1_2_N B1_2_P cml_tlatch_33.xmux.xp.S1 VSS sg13_lv_nmos ad=56.9f pd=0.74u as=56.9f ps=0.74u w=0.17u l=0.17u
X8496 cml_tlatch_74.xtail.S1 CKHB2_N cml_tlatch_74.xmux.xp.S1 VSS sg13_lv_nmos ad=89.3f pd=0.85u as=89.3f ps=0.85u w=0.47u l=0.16u
X8497 MOT14_N VDD VSS rppd l=5.17u w=1u
X8498 MOT21_N stub_bi_55.BOTN cml_tlatch_75.xmux.xn.S1 VSS sg13_lv_nmos ad=63.19999f pd=0.74u as=63.19999f ps=0.74u w=0.26u l=0.38u
X8499 cml_tlatch_9.xmux.xn.S1 cml_tlatch_99.OUTP cml_tlatch_9.OUTN VSS sg13_lv_nmos ad=63.19999f pd=0.74u as=63.19999f ps=0.74u w=0.26u l=0.38u
X8500 cml_tlatch_96.xmux.xn.S1 CKHA1_P cml_tlatch_96.xtail.S1 VSS sg13_lv_nmos ad=89.3f pd=0.85u as=89.3f ps=0.85u w=0.47u l=0.16u
X8501 cml_tlatch_69.xmux.xn.S1 cml_tlatch_69.INP MOT27_N VSS sg13_lv_nmos ad=63.19999f pd=0.74u as=63.19999f ps=0.74u w=0.26u l=0.38u
X8502 A3_8_N A3_8_P cml_tlatch_64.xmux.xp.S1 VSS sg13_lv_nmos ad=56.9f pd=0.74u as=56.9f ps=0.74u w=0.17u l=0.17u
X8503 cml_tlatch_13.xmux.xp.S1 CKB1_N cml_tlatch_13.xtail.S1 VSS sg13_lv_nmos ad=89.3f pd=0.85u as=89.3f ps=0.85u w=0.47u l=0.16u
X8504 cml_tlatch_12.xmux.xn.S1 stub_bi_17.BOTP B1_8_P VSS sg13_lv_nmos ad=63.19999f pd=0.74u as=63.19999f ps=0.74u w=0.26u l=0.38u
X8505 cml_tlatch_73.xmux.xp.S1 MOT17_N MOT17_P VSS sg13_lv_nmos ad=56.9f pd=0.74u as=56.9f ps=0.74u w=0.17u l=0.17u
X8506 cml_tlatch_43.xmux.xn.S1 B2_2_P stub_bi_42.BOTP VSS sg13_lv_nmos ad=63.19999f pd=0.74u as=63.19999f ps=0.74u w=0.26u l=0.38u
X8507 cml_tlatch_27.OUTN cml_tlatch_27.OUTP cml_tlatch_27.xmux.xp.S1 VSS sg13_lv_nmos ad=56.9f pd=0.74u as=56.9f ps=0.74u w=0.17u l=0.17u
X8508 cml_tlatch_44.xtail.S1 CKB2_N cml_tlatch_44.xmux.xn.S1 VSS sg13_lv_nmos ad=89.3f pd=0.85u as=89.3f ps=0.85u w=0.47u l=0.16u
X8509 cml_tlatch_57.xtail.S1 CKHA3_P cml_tlatch_57.xmux.xn.S1 VSS sg13_lv_nmos ad=89.3f pd=0.85u as=89.3f ps=0.85u w=0.47u l=0.16u
X8510 cml_tlatch_12.xmux.xn.S1 stub_bi_17.BOTP B1_8_P VSS sg13_lv_nmos ad=63.19999f pd=0.74u as=63.19999f ps=0.74u w=0.26u l=0.38u
X8511 VDD CKHA0_N VSS rppd l=13.09u w=1u
X8512 cml_tlatch_88.xmux.xp.S1 stub_bi_55.BOTP stub_bi_55.BOTN VSS sg13_lv_nmos ad=0.1019p pd=1.34u as=56.9f ps=0.74u w=0.17u l=0.17u
X8513 cml_tlatch_3.OUTP cml_tlatch_3.OUTN cml_tlatch_3.xmux.xp.S1 VSS sg13_lv_nmos ad=56.9f pd=0.74u as=56.9f ps=0.74u w=0.17u l=0.17u
X8514 cml_tlatch_66.xmux.xp.S1 cml_tlatch_57.INN cml_tlatch_57.INP VSS sg13_lv_nmos ad=56.9f pd=0.74u as=56.9f ps=0.74u w=0.17u l=0.17u
X8515 cml_tlatch_4.xmux.xp.S1 MOT9_N MOT9_P VSS sg13_lv_nmos ad=56.9f pd=0.74u as=56.9f ps=0.74u w=0.17u l=0.17u
X8516 B3_2_N B3_2_P cml_tlatch_46.xmux.xp.S1 VSS sg13_lv_nmos ad=56.9f pd=0.74u as=56.9f ps=0.74u w=0.17u l=0.17u
X8517 B0_2_N B0_2_P cml_tlatch_28.xmux.xp.S1 VSS sg13_lv_nmos ad=56.9f pd=0.74u as=56.9f ps=0.74u w=0.17u l=0.17u
X8518 A0_8_P A0_8_N cml_tlatch_2.xmux.xp.S1 VSS sg13_lv_nmos ad=56.9f pd=0.74u as=56.9f ps=0.74u w=0.17u l=0.17u
X8519 cml_tlatch_52.OUTP cml_tlatch_52.OUTN cml_tlatch_52.xmux.xp.S1 VSS sg13_lv_nmos ad=56.9f pd=0.74u as=56.9f ps=0.74u w=0.17u l=0.17u
X8520 MOT31_P MOT31_N cml_tlatch_71.xmux.xp.S1 VSS sg13_lv_nmos ad=56.9f pd=0.74u as=56.9f ps=0.74u w=0.17u l=0.17u
X8521 cml_tlatch_98.xtail.S1 CKB0_N cml_tlatch_98.xmux.xn.S1 VSS sg13_lv_nmos ad=0.1598p pd=1.62u as=89.3f ps=0.85u w=0.47u l=0.16u
X8522 cml_tlatch_81.xtail.S1 CKA2_P cml_tlatch_81.xmux.xp.S1 VSS sg13_lv_nmos ad=89.3f pd=0.85u as=89.3f ps=0.85u w=0.47u l=0.16u
X8523 VSS POLN cml_tlatch_15.xtail.S1 VSS sg13_lv_nmos ad=1.5637p pd=8.61u as=1.5637p ps=8.61u w=8.23u l=0.13u
X8524 cml_tlatch_92.xmux.xp.S1 CKJ_P cml_tlatch_92.xtail.S1 VSS sg13_lv_nmos ad=89.3f pd=0.85u as=89.3f ps=0.85u w=0.47u l=0.16u
X8525 cml_tlatch_96.xmux.xp.S1 MOT8_N MOT8_P VSS sg13_lv_nmos ad=56.9f pd=0.74u as=56.9f ps=0.74u w=0.17u l=0.17u
X8526 ENB_P NS1_N cml_gate2_8.xrtail.R1 VSS sg13_lv_nmos ad=0.1007p pd=0.91u as=0.1007p ps=0.91u w=0.53u l=0.13u
X8527 VSS hs_to_clk_0.sg13_lv_nmos_2HGZLP_0.G VSS VSS sg13_lv_nmos ad=3.706p pd=22.48u as=0 ps=0 w=10.9u l=1.38u
X8528 cml_tlatch_67.xmux.xp.S1 CKA3_N cml_tlatch_67.xtail.S1 VSS sg13_lv_nmos ad=0.1598p pd=1.62u as=89.3f ps=0.85u w=0.47u l=0.16u
X8529 cml_tlatch_7.xmux.xp.S1 MOT15_N MOT15_P VSS sg13_lv_nmos ad=56.9f pd=0.74u as=56.9f ps=0.74u w=0.17u l=0.17u
X8530 cml_tlatch_90.xmux.xn.S1 CKJ_N cml_tlatch_90.xtail.S1 VSS sg13_lv_nmos ad=89.3f pd=0.85u as=0.1598p ps=1.62u w=0.47u l=0.16u
X8531 cml_tlatch_53.xmux.xp.S1 A3_2_N A3_2_P VSS sg13_lv_nmos ad=56.9f pd=0.74u as=56.9f ps=0.74u w=0.17u l=0.17u
X8532 ENB0_N ENB_P cml_drv_2.xrtail.R1 VSS sg13_lv_nmos ad=56.2f pd=0.74u as=56.2f ps=0.74u w=0.16u l=0.19u
X8533 cml_tlatch_77.xtail.S1 CKB2_P cml_tlatch_77.xmux.xp.S1 VSS sg13_lv_nmos ad=0.1598p pd=1.62u as=89.3f ps=0.85u w=0.47u l=0.16u
X8534 VSS hs_to_clk_5.sg13_lv_nmos_2HGZLP_0.G VSS VSS sg13_lv_nmos ad=2.071p pd=11.28u as=0 ps=0 w=10.9u l=1.38u
X8535 VDD cml_tlatch_83.INP VSS rppd l=5.17u w=1u
X8536 cml_tlatch_82.xtail.S1 CKA2_P cml_tlatch_82.xmux.xn.S1 VSS sg13_lv_nmos ad=89.3f pd=0.85u as=89.3f ps=0.85u w=0.47u l=0.16u
X8537 cml_tlatch_79.xmux.xp.S1 stub_bi_63.BOTN stub_bi_63.BOTP VSS sg13_lv_nmos ad=56.9f pd=0.74u as=56.9f ps=0.74u w=0.17u l=0.17u
X8538 cml_tlatch_23.xtail.S1 CKA1_P cml_tlatch_23.xmux.xp.S1 VSS sg13_lv_nmos ad=89.3f pd=0.85u as=89.3f ps=0.85u w=0.47u l=0.16u
X8539 cml_tlatch_39.INP cml_tlatch_39.INN cml_tlatch_23.xmux.xp.S1 VSS sg13_lv_nmos ad=56.9f pd=0.74u as=56.9f ps=0.74u w=0.17u l=0.17u
X8540 cml_tlatch_16.xtail.S1 CKB0_N cml_tlatch_16.xmux.xn.S1 VSS sg13_lv_nmos ad=89.3f pd=0.85u as=0.1598p ps=1.62u w=0.47u l=0.16u
X8541 cml_tlatch_46.xmux.xp.S1 B3_2_P B3_2_N VSS sg13_lv_nmos ad=56.9f pd=0.74u as=56.9f ps=0.74u w=0.17u l=0.17u
X8542 cml_tlatch_9.xtail.S1 CKA0_N cml_tlatch_9.xmux.xp.S1 VSS sg13_lv_nmos ad=89.3f pd=0.85u as=89.3f ps=0.85u w=0.47u l=0.16u
X8543 cml_tlatch_1.xmux.xp.S1 cml_tlatch_1.OUTN cml_tlatch_1.OUTP VSS sg13_lv_nmos ad=56.9f pd=0.74u as=56.9f ps=0.74u w=0.17u l=0.17u
X8544 MOT14_N MOT14_P cml_tlatch_41.xmux.xp.S1 VSS sg13_lv_nmos ad=56.9f pd=0.74u as=56.9f ps=0.74u w=0.17u l=0.17u
X8545 A0_2_P cml_tlatch_35.OUTN cml_tlatch_31.xmux.xn.S1 VSS sg13_lv_nmos ad=63.19999f pd=0.74u as=63.19999f ps=0.74u w=0.26u l=0.38u
X8546 cml_gate2_3.xrtail.R1 CKB1_N GA1_P VSS sg13_lv_nmos ad=0.1007p pd=0.91u as=0.1007p ps=0.91u w=0.53u l=0.13u
X8547 cml_tlatch_67.OUTP cml_tlatch_67.OUTN cml_tlatch_67.xmux.xp.S1 VSS sg13_lv_nmos ad=56.9f pd=0.74u as=56.9f ps=0.74u w=0.17u l=0.17u
X8548 cml_gate2_6.sg13_lv_nmos_FTPY57_0.D0 ENB0_P GB3_N VSS sg13_lv_nmos ad=0.1007p pd=0.91u as=0.1007p ps=0.91u w=0.53u l=0.13u
X8549 cml_tlatch_29.OUTP D0_N cml_tlatch_29.xmux.xn.S1 VSS sg13_lv_nmos ad=63.19999f pd=0.74u as=63.19999f ps=0.74u w=0.26u l=0.38u
X8550 cml_tlatch_76.xtail.S1 CKHB2_N cml_tlatch_76.xmux.xp.S1 VSS sg13_lv_nmos ad=89.3f pd=0.85u as=89.3f ps=0.85u w=0.47u l=0.16u
X8551 cml_tlatch_46.xtail.S1 POLN VSS VSS sg13_lv_nmos ad=1.5637p pd=8.61u as=2.7982p ps=17.14u w=8.23u l=0.13u
X8552 cml_tlatch_84.xmux.xp.S1 cml_tlatch_70.INP cml_tlatch_70.INN VSS sg13_lv_nmos ad=56.9f pd=0.74u as=56.9f ps=0.74u w=0.17u l=0.17u
X8553 cml_tlatch_78.xtail.S1 CKB2_P cml_tlatch_78.xmux.xn.S1 VSS sg13_lv_nmos ad=89.3f pd=0.85u as=89.3f ps=0.85u w=0.47u l=0.16u
X8554 MOT8_N MOT8_P cml_tlatch_96.xmux.xp.S1 VSS sg13_lv_nmos ad=56.9f pd=0.74u as=56.9f ps=0.74u w=0.17u l=0.17u
X8555 cml_tlatch_81.xmux.xn.S1 cml_tlatch_82.OUTP A2_8_N VSS sg13_lv_nmos ad=63.19999f pd=0.74u as=63.19999f ps=0.74u w=0.26u l=0.38u
X8556 cml_tlatch_61.OUTN VDD VSS rppd l=5.17u w=1u
X8557 cml_tlatch_14.xtail.S1 CKB1_P cml_tlatch_14.xmux.xp.S1 VSS sg13_lv_nmos ad=89.3f pd=0.85u as=89.3f ps=0.85u w=0.47u l=0.16u
X8558 cml_tlatch_3.xmux.xn.S1 cml_tlatch_8.OUTP cml_tlatch_3.OUTN VSS sg13_lv_nmos ad=63.19999f pd=0.74u as=63.19999f ps=0.74u w=0.26u l=0.38u
X8559 MOT5_N MOT5_P cml_tlatch_19.xmux.xp.S1 VSS sg13_lv_nmos ad=56.9f pd=0.74u as=56.9f ps=0.74u w=0.17u l=0.17u
X8560 cml_gate2_3.sg13_lv_nmos_FTPY57_0.D0 ENA0_N GA1_P VSS sg13_lv_nmos ad=0.1007p pd=0.91u as=0.1007p ps=0.91u w=0.53u l=0.13u
X8561 cml_tlatch_78.xmux.xp.S1 stub_bi_62.BOTP stub_bi_62.BOTN VSS sg13_lv_nmos ad=56.9f pd=0.74u as=56.9f ps=0.74u w=0.17u l=0.17u
X8562 cml_tlatch_22.OUTP cml_tlatch_22.OUTN cml_tlatch_22.xmux.xp.S1 VSS sg13_lv_nmos ad=56.9f pd=0.74u as=56.9f ps=0.74u w=0.17u l=0.17u
X8563 B0_8_N cml_tlatch_11.OUTP cml_tlatch_10.xmux.xn.S1 VSS sg13_lv_nmos ad=63.19999f pd=0.74u as=63.19999f ps=0.74u w=0.26u l=0.38u
X8564 cml_tlatch_83.xtail.S1 CKA2_P cml_tlatch_83.xmux.xp.S1 VSS sg13_lv_nmos ad=89.3f pd=0.85u as=89.3f ps=0.85u w=0.47u l=0.16u
X8565 cml_tlatch_57.INN cml_tlatch_57.INP cml_tlatch_66.xmux.xp.S1 VSS sg13_lv_nmos ad=56.9f pd=0.74u as=0.1019p ps=1.34u w=0.17u l=0.17u
X8566 cml_tlatch_96.xtail.S1 CKHA1_N cml_tlatch_96.xmux.xp.S1 VSS sg13_lv_nmos ad=89.3f pd=0.85u as=0.1598p ps=1.62u w=0.47u l=0.16u
X8567 GA2_P CKB2_N cml_gate2_4.xrtail.R1 VSS sg13_lv_nmos ad=0.1007p pd=0.91u as=0.1007p ps=0.91u w=0.53u l=0.13u
X8568 cml_tlatch_69.xmux.xp.S1 MOT27_P MOT27_N VSS sg13_lv_nmos ad=56.9f pd=0.74u as=56.9f ps=0.74u w=0.17u l=0.17u
X8569 cml_tlatch_5.xmux.xp.S1 CKHB1_N cml_tlatch_5.xtail.S1 VSS sg13_lv_nmos ad=89.3f pd=0.85u as=89.3f ps=0.85u w=0.47u l=0.16u
X8570 MOT30_N MOT30_P cml_tlatch_59.xmux.xp.S1 VSS sg13_lv_nmos ad=56.9f pd=0.74u as=56.9f ps=0.74u w=0.17u l=0.17u
X8571 cml_tlatch_73.xmux.xn.S1 B2_8_N MOT17_P VSS sg13_lv_nmos ad=63.19999f pd=0.74u as=63.19999f ps=0.74u w=0.26u l=0.38u
X8572 MOT20_N cml_tlatch_89.OUTP cml_tlatch_50.xmux.xn.S1 VSS sg13_lv_nmos ad=0.1082p pd=1.34u as=63.19999f ps=0.74u w=0.26u l=0.38u
X8573 cml_tlatch_25.xmux.xp.S1 CKHA0_N cml_tlatch_25.xtail.S1 VSS sg13_lv_nmos ad=0.1598p pd=1.62u as=89.3f ps=0.85u w=0.47u l=0.16u
X8574 cml_tlatch_11.xmux.xp.S1 cml_tlatch_11.OUTN cml_tlatch_11.OUTP VSS sg13_lv_nmos ad=56.9f pd=0.74u as=56.9f ps=0.74u w=0.17u l=0.17u
X8575 cml_tlatch_57.xtail.S1 POLN VSS VSS sg13_lv_nmos ad=1.5637p pd=8.61u as=2.7982p ps=17.14u w=8.23u l=0.13u
X8576 stub_bi_17.BOTN cml_tlatch_5.INN cml_tlatch_13.xmux.xn.S1 VSS sg13_lv_nmos ad=63.19999f pd=0.74u as=63.19999f ps=0.74u w=0.26u l=0.38u
X8577 MOT4_N MOT4_P cml_tlatch_25.xmux.xp.S1 VSS sg13_lv_nmos ad=56.9f pd=0.74u as=56.9f ps=0.74u w=0.17u l=0.17u
X8578 cml_tlatch_89.OUTN cml_tlatch_89.INP cml_tlatch_89.xmux.xn.S1 VSS sg13_lv_nmos ad=63.19999f pd=0.74u as=63.19999f ps=0.74u w=0.26u l=0.38u
X8579 A3_8_N A3_8_P cml_tlatch_64.xmux.xp.S1 VSS sg13_lv_nmos ad=56.9f pd=0.74u as=56.9f ps=0.74u w=0.17u l=0.17u
X8580 cml_tlatch_66.xmux.xn.S1 cml_tlatch_67.OUTN cml_tlatch_57.INP VSS sg13_lv_nmos ad=63.19999f pd=0.74u as=63.19999f ps=0.74u w=0.26u l=0.38u
X8581 cml_tlatch_27.OUTN cml_tlatch_27.OUTP cml_tlatch_27.xmux.xp.S1 VSS sg13_lv_nmos ad=56.9f pd=0.74u as=56.9f ps=0.74u w=0.17u l=0.17u
X8582 cml_tlatch_60.xmux.xp.S1 B3_8_P B3_8_N VSS sg13_lv_nmos ad=56.9f pd=0.74u as=56.9f ps=0.74u w=0.17u l=0.17u
X8583 MOT25_P MOT25_N cml_tlatch_68.xmux.xp.S1 VSS sg13_lv_nmos ad=56.9f pd=0.74u as=56.9f ps=0.74u w=0.17u l=0.17u
X8584 cml_tlatch_61.xmux.xn.S1 cml_tlatch_69.INN cml_tlatch_61.OUTP VSS sg13_lv_nmos ad=63.19999f pd=0.74u as=63.19999f ps=0.74u w=0.26u l=0.38u
X8585 cml_tlatch_47.OUTN cml_tlatch_47.OUTP cml_tlatch_47.xmux.xp.S1 VSS sg13_lv_nmos ad=56.9f pd=0.74u as=56.9f ps=0.74u w=0.17u l=0.17u
X8586 cml_tlatch_2.xtail.S1 CKA0_N cml_tlatch_2.xmux.xn.S1 VSS sg13_lv_nmos ad=89.3f pd=0.85u as=89.3f ps=0.85u w=0.47u l=0.16u
X8587 B1_8_N B1_8_P cml_tlatch_12.xmux.xp.S1 VSS sg13_lv_nmos ad=56.9f pd=0.74u as=56.9f ps=0.74u w=0.17u l=0.17u
X8588 stub_bi_55.BOTP VDD VSS rppd l=5.17u w=1u
X8589 cml_tlatch_4.xmux.xp.S1 MOT9_N MOT9_P VSS sg13_lv_nmos ad=56.9f pd=0.74u as=56.9f ps=0.74u w=0.17u l=0.17u
X8590 cml_tlatch_37.xmux.xp.S1 CKA1_P cml_tlatch_37.xtail.S1 VSS sg13_lv_nmos ad=89.3f pd=0.85u as=89.3f ps=0.85u w=0.47u l=0.16u
X8591 cml_tlatch_52.OUTP cml_tlatch_52.OUTN cml_tlatch_52.xmux.xp.S1 VSS sg13_lv_nmos ad=56.9f pd=0.74u as=56.9f ps=0.74u w=0.17u l=0.17u
X8592 A2_2_P cml_tlatch_56.INN cml_tlatch_56.xmux.xn.S1 VSS sg13_lv_nmos ad=63.19999f pd=0.74u as=63.19999f ps=0.74u w=0.26u l=0.38u
X8593 cml_tlatch_47.xtail.S1 CKB3_N cml_tlatch_47.xmux.xp.S1 VSS sg13_lv_nmos ad=89.3f pd=0.85u as=0.1598p ps=1.62u w=0.47u l=0.16u
X8594 cml_tlatch_45.xmux.xp.S1 cml_tlatch_45.OUTN cml_tlatch_45.OUTP VSS sg13_lv_nmos ad=56.9f pd=0.74u as=56.9f ps=0.74u w=0.17u l=0.17u
X8595 cml_tlatch_68.xtail.S1 CKHB3_P cml_tlatch_68.xmux.xn.S1 VSS sg13_lv_nmos ad=0.1598p pd=1.62u as=89.3f ps=0.85u w=0.47u l=0.16u
X8596 cml_tlatch_65.OUTN cml_tlatch_65.OUTP cml_tlatch_65.xmux.xp.S1 VSS sg13_lv_nmos ad=56.9f pd=0.74u as=56.9f ps=0.74u w=0.17u l=0.17u
X8597 cml_tlatch_34.xmux.xp.S1 stub_bi_31.BOTN stub_bi_31.BOTP VSS sg13_lv_nmos ad=56.9f pd=0.74u as=56.9f ps=0.74u w=0.17u l=0.17u
X8598 cml_tlatch_59.xtail.S1 CKHA3_N cml_tlatch_59.xmux.xp.S1 VSS sg13_lv_nmos ad=89.3f pd=0.85u as=89.3f ps=0.85u w=0.47u l=0.16u
X8599 cml_tlatch_48.xmux.xn.S1 CKB2_P cml_tlatch_48.xtail.S1 VSS sg13_lv_nmos ad=89.3f pd=0.85u as=89.3f ps=0.85u w=0.47u l=0.16u
X8600 cml_tlatch_74.xmux.xp.S1 CKHB2_N cml_tlatch_74.xtail.S1 VSS sg13_lv_nmos ad=89.3f pd=0.85u as=89.3f ps=0.85u w=0.47u l=0.16u
X8601 stub_bi_29.BOTN stub_bi_29.BOTP cml_tlatch_32.xmux.xp.S1 VSS sg13_lv_nmos ad=56.9f pd=0.74u as=56.9f ps=0.74u w=0.17u l=0.17u
X8602 cml_tlatch_35.xmux.xn.S1 CKA0_P cml_tlatch_35.xtail.S1 VSS sg13_lv_nmos ad=0.1598p pd=1.62u as=89.3f ps=0.85u w=0.47u l=0.16u
X8603 cml_tlatch_33.xmux.xp.S1 CKB1_P cml_tlatch_33.xtail.S1 VSS sg13_lv_nmos ad=89.3f pd=0.85u as=89.3f ps=0.85u w=0.47u l=0.16u
X8604 CKHA1_N GA1_P cml_drvb_3.xrtail.R1 VSS sg13_lv_nmos ad=0.2618p pd=2.22u as=0.1463p ps=1.15u w=0.77u l=0.21u
X8605 cml_tlatch_36.xmux.xp.S1 cml_tlatch_95.INP cml_tlatch_95.INN VSS sg13_lv_nmos ad=56.9f pd=0.74u as=56.9f ps=0.74u w=0.17u l=0.17u
X8606 cml_tlatch_63.xmux.xp.S1 cml_tlatch_63.OUTN cml_tlatch_63.OUTP VSS sg13_lv_nmos ad=56.9f pd=0.74u as=56.9f ps=0.74u w=0.17u l=0.17u
X8607 stub_bi_42.BOTP stub_bi_42.BOTN cml_tlatch_43.xmux.xp.S1 VSS sg13_lv_nmos ad=56.9f pd=0.74u as=56.9f ps=0.74u w=0.17u l=0.17u
X8608 MOT29_P cml_tlatch_70.INN cml_tlatch_70.xmux.xn.S1 VSS sg13_lv_nmos ad=63.19999f pd=0.74u as=63.19999f ps=0.74u w=0.26u l=0.38u
X8609 cml_tlatch_48.xmux.xp.S1 stub_bi_32.BOTP stub_bi_32.BOTN VSS sg13_lv_nmos ad=56.9f pd=0.74u as=56.9f ps=0.74u w=0.17u l=0.17u
X8610 cml_tlatch_38.OUTP cml_tlatch_38.OUTN cml_tlatch_38.xmux.xp.S1 VSS sg13_lv_nmos ad=56.9f pd=0.74u as=56.9f ps=0.74u w=0.17u l=0.17u
X8611 cml_tlatch_89.OUTN cml_tlatch_89.OUTP cml_tlatch_89.xmux.xp.S1 VSS sg13_lv_nmos ad=56.9f pd=0.74u as=56.9f ps=0.74u w=0.17u l=0.17u
X8612 cml_tlatch_84.xmux.xp.S1 cml_tlatch_70.INP cml_tlatch_70.INN VSS sg13_lv_nmos ad=56.9f pd=0.74u as=56.9f ps=0.74u w=0.17u l=0.17u
X8613 cml_tlatch_29.xmux.xp.S1 cml_tlatch_29.OUTN cml_tlatch_29.OUTP VSS sg13_lv_nmos ad=56.9f pd=0.74u as=56.9f ps=0.74u w=0.17u l=0.17u
X8614 cml_tlatch_4.xtail.S1 CKHB1_P cml_tlatch_4.xmux.xn.S1 VSS sg13_lv_nmos ad=89.3f pd=0.85u as=89.3f ps=0.85u w=0.47u l=0.16u
X8615 VSS hs_to_clk_3.sg13_lv_nmos_2HGZLP_0.G VSS VSS sg13_lv_nmos ad=2.071p pd=11.28u as=0 ps=0 w=10.9u l=1.38u
X8616 MOT16_P A2_8_N cml_tlatch_87.xmux.xn.S1 VSS sg13_lv_nmos ad=63.19999f pd=0.74u as=0.1082p ps=1.34u w=0.26u l=0.38u
X8617 VDD A2_8_N VSS rppd l=5.17u w=1u
X8618 cml_tlatch_42.xtail.S1 CKA2_N cml_tlatch_42.xmux.xp.S1 VSS sg13_lv_nmos ad=89.3f pd=0.85u as=89.3f ps=0.85u w=0.47u l=0.16u
X8619 cml_tlatch_95.INP A1_2_N cml_tlatch_36.xmux.xn.S1 VSS sg13_lv_nmos ad=0.1082p pd=1.34u as=63.19999f ps=0.74u w=0.26u l=0.38u
X8620 cml_drv_3.xrtail.R1 ENA_N ENA0_P VSS sg13_lv_nmos ad=56.2f pd=0.74u as=0.1012p ps=1.34u w=0.16u l=0.19u
X8621 cml_tlatch_69.xmux.xp.S1 CKHB3_N cml_tlatch_69.xtail.S1 VSS sg13_lv_nmos ad=89.3f pd=0.85u as=89.3f ps=0.85u w=0.47u l=0.16u
X8622 MOT14_N MOT14_P cml_tlatch_41.xmux.xp.S1 VSS sg13_lv_nmos ad=56.9f pd=0.74u as=56.9f ps=0.74u w=0.17u l=0.17u
X8623 cml_tlatch_41.xmux.xn.S1 A1_2_P MOT14_N VSS sg13_lv_nmos ad=63.19999f pd=0.74u as=63.19999f ps=0.74u w=0.26u l=0.38u
X8624 cml_tlatch_0.xtail.S1 CKA1_P cml_tlatch_0.xmux.xn.S1 VSS sg13_lv_nmos ad=89.3f pd=0.85u as=89.3f ps=0.85u w=0.47u l=0.16u
X8625 cml_tlatch_93.xtail.S1 CKJ_P cml_tlatch_93.xmux.xn.S1 VSS sg13_lv_nmos ad=89.3f pd=0.85u as=89.3f ps=0.85u w=0.47u l=0.16u
X8626 cml_tlatch_82.xmux.xn.S1 cml_tlatch_83.OUTN cml_tlatch_82.OUTP VSS sg13_lv_nmos ad=63.19999f pd=0.74u as=63.19999f ps=0.74u w=0.26u l=0.38u
X8627 cml_tlatch_31.xmux.xp.S1 A0_2_N A0_2_P VSS sg13_lv_nmos ad=56.9f pd=0.74u as=56.9f ps=0.74u w=0.17u l=0.17u
X8628 cml_tlatch_50.xtail.S1 CKHA2_P cml_tlatch_50.xmux.xn.S1 VSS sg13_lv_nmos ad=89.3f pd=0.85u as=89.3f ps=0.85u w=0.47u l=0.16u
X8629 cml_tlatch_28.xtail.S1 CKB0_N cml_tlatch_28.xmux.xn.S1 VSS sg13_lv_nmos ad=89.3f pd=0.85u as=89.3f ps=0.85u w=0.47u l=0.16u
X8630 cml_tlatch_63.xmux.xp.S1 cml_tlatch_63.OUTN cml_tlatch_63.OUTP VSS sg13_lv_nmos ad=0.1019p pd=1.34u as=56.9f ps=0.74u w=0.17u l=0.17u
X8631 MOT2_N MOT2_P cml_tlatch_24.xmux.xp.S1 VSS sg13_lv_nmos ad=56.9f pd=0.74u as=56.9f ps=0.74u w=0.17u l=0.17u
X8632 VSS hs_to_clk_2.sg13_lv_nmos_2HGZLP_0.G VSS VSS sg13_lv_nmos ad=2.071p pd=11.28u as=0 ps=0 w=10.9u l=1.38u
X8633 cml_tlatch_56.xmux.xp.S1 A2_2_P A2_2_N VSS sg13_lv_nmos ad=0.1019p pd=1.34u as=56.9f ps=0.74u w=0.17u l=0.17u
X8634 cml_tlatch_61.OUTN cml_tlatch_61.OUTP cml_tlatch_61.xmux.xp.S1 VSS sg13_lv_nmos ad=56.9f pd=0.74u as=0.1019p ps=1.34u w=0.17u l=0.17u
X8635 cml_tlatch_53.xmux.xn.S1 cml_tlatch_54.OUTP A3_2_N VSS sg13_lv_nmos ad=63.19999f pd=0.74u as=63.19999f ps=0.74u w=0.26u l=0.38u
X8636 MOT30_N A3_2_P cml_tlatch_59.xmux.xn.S1 VSS sg13_lv_nmos ad=63.19999f pd=0.74u as=63.19999f ps=0.74u w=0.26u l=0.38u
X8637 cml_tlatch_80.xmux.xn.S1 stub_bi_55.BOTP stub_bi_49.BOTN VSS sg13_lv_nmos ad=63.19999f pd=0.74u as=63.19999f ps=0.74u w=0.26u l=0.38u
X8638 J1_N J4_N cml_tlatch_93.xmux.xn.S1 VSS sg13_lv_nmos ad=63.19999f pd=0.74u as=63.19999f ps=0.74u w=0.26u l=0.38u
X8639 cml_tlatch_2.xtail.S1 CKA0_P cml_tlatch_2.xmux.xp.S1 VSS sg13_lv_nmos ad=89.3f pd=0.85u as=89.3f ps=0.85u w=0.47u l=0.16u
X8640 VSS cml_drvb_1.xrtail.R1 VSS rppd l=2.72u w=1u
X8641 stub_bi_19.BOTN stub_bi_19.BOTP cml_tlatch_15.xmux.xp.S1 VSS sg13_lv_nmos ad=56.9f pd=0.74u as=56.9f ps=0.74u w=0.17u l=0.17u
X8642 cml_tlatch_84.xmux.xp.S1 CKB3_P cml_tlatch_84.xtail.S1 VSS sg13_lv_nmos ad=89.3f pd=0.85u as=89.3f ps=0.85u w=0.47u l=0.16u
X8643 ENB1_N ENB_P cml_drv_0.xrtail.R1 VSS sg13_lv_nmos ad=56.2f pd=0.74u as=56.2f ps=0.74u w=0.16u l=0.19u
X8644 cml_tlatch_91.xmux.xp.S1 CLK_W_P CLK_W_N VSS sg13_lv_nmos ad=56.9f pd=0.74u as=56.9f ps=0.74u w=0.17u l=0.17u
X8645 cml_tlatch_16.OUTP VDD VSS rppd l=5.17u w=1u
X8646 A2_2_P A2_2_N cml_tlatch_56.xmux.xp.S1 VSS sg13_lv_nmos ad=56.9f pd=0.74u as=56.9f ps=0.74u w=0.17u l=0.17u
X8647 VSS hs_to_clk_5.sg13_lv_nmos_2HGZLP_0.G VSS VSS sg13_lv_nmos ad=3.706p pd=22.48u as=0 ps=0 w=10.9u l=1.38u
X8648 cml_tlatch_44.xmux.xp.S1 B2_2_N B2_2_P VSS sg13_lv_nmos ad=56.9f pd=0.74u as=56.9f ps=0.74u w=0.17u l=0.17u
X8649 cml_tlatch_43.xmux.xn.S1 CKB2_P cml_tlatch_43.xtail.S1 VSS sg13_lv_nmos ad=89.3f pd=0.85u as=89.3f ps=0.85u w=0.47u l=0.16u
X8650 cml_tlatch_75.xmux.xp.S1 MOT21_P MOT21_N VSS sg13_lv_nmos ad=56.9f pd=0.74u as=56.9f ps=0.74u w=0.17u l=0.17u
X8651 cml_tlatch_2.xmux.xp.S1 A0_8_P A0_8_N VSS sg13_lv_nmos ad=56.9f pd=0.74u as=56.9f ps=0.74u w=0.17u l=0.17u
X8652 cml_tlatch_19.xmux.xp.S1 CKHB0_N cml_tlatch_19.xtail.S1 VSS sg13_lv_nmos ad=89.3f pd=0.85u as=89.3f ps=0.85u w=0.47u l=0.16u
X8653 cml_tlatch_5.INN cml_tlatch_5.INP cml_tlatch_14.xmux.xp.S1 VSS sg13_lv_nmos ad=56.9f pd=0.74u as=56.9f ps=0.74u w=0.17u l=0.17u
X8654 stub_bi_49.BOTP stub_bi_55.BOTN cml_tlatch_80.xmux.xn.S1 VSS sg13_lv_nmos ad=63.19999f pd=0.74u as=63.19999f ps=0.74u w=0.26u l=0.38u
X8655 cml_tlatch_8.OUTN cml_tlatch_8.OUTP cml_tlatch_8.xmux.xp.S1 VSS sg13_lv_nmos ad=56.9f pd=0.74u as=56.9f ps=0.74u w=0.17u l=0.17u
X8656 cml_tlatch_40.xmux.xp.S1 MOT12_P MOT12_N VSS sg13_lv_nmos ad=56.9f pd=0.74u as=56.9f ps=0.74u w=0.17u l=0.17u
X8657 cml_tlatch_35.xmux.xp.S1 CKA0_N cml_tlatch_35.xtail.S1 VSS sg13_lv_nmos ad=89.3f pd=0.85u as=89.3f ps=0.85u w=0.47u l=0.16u
X8658 cml_tlatch_96.xmux.xn.S1 CKHA1_P cml_tlatch_96.xtail.S1 VSS sg13_lv_nmos ad=89.3f pd=0.85u as=89.3f ps=0.85u w=0.47u l=0.16u
X8659 VDD cml_tlatch_57.INP VSS rppd l=5.17u w=1u
X8660 cml_tlatch_9.xmux.xn.S1 CKA0_P cml_tlatch_9.xtail.S1 VSS sg13_lv_nmos ad=89.3f pd=0.85u as=89.3f ps=0.85u w=0.47u l=0.16u
X8661 GB0_P CKA0_N cml_gate2_1.xrtail.R1 VSS sg13_lv_nmos ad=0.1007p pd=0.91u as=0.1007p ps=0.91u w=0.53u l=0.13u
X8662 stub_bi_55.BOTP stub_bi_55.BOTN cml_tlatch_88.xmux.xp.S1 VSS sg13_lv_nmos ad=56.9f pd=0.74u as=0.1019p ps=1.34u w=0.17u l=0.17u
X8663 cml_tlatch_10.xmux.xn.S1 cml_tlatch_11.OUTN B0_8_P VSS sg13_lv_nmos ad=63.19999f pd=0.74u as=63.19999f ps=0.74u w=0.26u l=0.38u
X8664 MOT22_P MOT22_N cml_tlatch_51.xmux.xp.S1 VSS sg13_lv_nmos ad=56.9f pd=0.74u as=56.9f ps=0.74u w=0.17u l=0.17u
X8665 MOT19_P stub_bi_63.BOTP cml_tlatch_74.xmux.xn.S1 VSS sg13_lv_nmos ad=63.19999f pd=0.74u as=63.19999f ps=0.74u w=0.26u l=0.38u
X8666 cml_tlatch_21.xmux.xn.S1 CKA1_N cml_tlatch_21.xtail.S1 VSS sg13_lv_nmos ad=89.3f pd=0.85u as=89.3f ps=0.85u w=0.47u l=0.16u
X8667 cml_tlatch_36.xmux.xp.S1 cml_tlatch_95.INP cml_tlatch_95.INN VSS sg13_lv_nmos ad=56.9f pd=0.74u as=56.9f ps=0.74u w=0.17u l=0.17u
X8668 cml_tlatch_10.xmux.xn.S1 cml_tlatch_11.OUTN B0_8_P VSS sg13_lv_nmos ad=63.19999f pd=0.74u as=63.19999f ps=0.74u w=0.26u l=0.38u
X8669 cml_gate2_0.xrtail.R1 CKA1_P cml_gate2_0.sg13_lv_nmos_FTPY57_0.D0 VSS sg13_lv_nmos ad=0.1007p pd=0.91u as=0.1007p ps=0.91u w=0.53u l=0.13u
X8670 cml_tlatch_17.xmux.xp.S1 CKHB0_N cml_tlatch_17.xtail.S1 VSS sg13_lv_nmos ad=0.1598p pd=1.62u as=89.3f ps=0.85u w=0.47u l=0.16u
X8671 cml_tlatch_26.xmux.xp.S1 CKHA0_N cml_tlatch_26.xtail.S1 VSS sg13_lv_nmos ad=89.3f pd=0.85u as=89.3f ps=0.85u w=0.47u l=0.16u
X8672 cml_tlatch_25.xmux.xp.S1 MOT4_N MOT4_P VSS sg13_lv_nmos ad=56.9f pd=0.74u as=56.9f ps=0.74u w=0.17u l=0.17u
X8673 cml_tlatch_92.xmux.xn.S1 J1_P J2_N VSS sg13_lv_nmos ad=63.19999f pd=0.74u as=63.19999f ps=0.74u w=0.26u l=0.38u
X8674 cml_tlatch_58.xmux.xp.S1 MOT28_P MOT28_N VSS sg13_lv_nmos ad=56.9f pd=0.74u as=56.9f ps=0.74u w=0.17u l=0.17u
X8675 cml_tlatch_28.xmux.xp.S1 CKB0_P cml_tlatch_28.xtail.S1 VSS sg13_lv_nmos ad=89.3f pd=0.85u as=89.3f ps=0.85u w=0.47u l=0.16u
X8676 VSS POLN cml_tlatch_31.xtail.S1 VSS sg13_lv_nmos ad=2.7982p pd=17.14u as=1.5637p ps=8.61u w=8.23u l=0.13u
X8677 cml_tlatch_89.xmux.xp.S1 cml_tlatch_89.OUTN cml_tlatch_89.OUTP VSS sg13_lv_nmos ad=56.9f pd=0.74u as=56.9f ps=0.74u w=0.17u l=0.17u
X8678 cml_tlatch_70.INP cml_tlatch_70.INN cml_tlatch_84.xmux.xp.S1 VSS sg13_lv_nmos ad=56.9f pd=0.74u as=56.9f ps=0.74u w=0.17u l=0.17u
X8679 cml_tlatch_71.xmux.xn.S1 B3_2_P MOT31_N VSS sg13_lv_nmos ad=63.19999f pd=0.74u as=0.1082p ps=1.34u w=0.26u l=0.38u
X8680 cml_gate2_0.sg13_lv_nmos_FTPY57_0.D0 ENB1_P GB1_N VSS sg13_lv_nmos ad=0.1007p pd=0.91u as=0.1007p ps=0.91u w=0.53u l=0.13u
X8681 cml_tlatch_39.xtail.S1 CKHA1_P cml_tlatch_39.xmux.xn.S1 VSS sg13_lv_nmos ad=0.1598p pd=1.62u as=89.3f ps=0.85u w=0.47u l=0.16u
X8682 cml_tlatch_67.xmux.xp.S1 CKA3_N cml_tlatch_67.xtail.S1 VSS sg13_lv_nmos ad=89.3f pd=0.85u as=89.3f ps=0.85u w=0.47u l=0.16u
X8683 cml_tlatch_36.xmux.xp.S1 cml_tlatch_95.INP cml_tlatch_95.INN VSS sg13_lv_nmos ad=56.9f pd=0.74u as=56.9f ps=0.74u w=0.17u l=0.17u
X8684 cml_gate2_7.sg13_lv_nmos_FTPY57_0.D0 CKA2_P cml_gate2_7.xrtail.R1 VSS sg13_lv_nmos ad=0.1007p pd=0.91u as=0.1007p ps=0.91u w=0.53u l=0.13u
X8685 cml_tlatch_12.xmux.xp.S1 B1_8_N B1_8_P VSS sg13_lv_nmos ad=56.9f pd=0.74u as=56.9f ps=0.74u w=0.17u l=0.17u
X8686 cml_tlatch_99.xmux.xp.S1 cml_tlatch_99.OUTN cml_tlatch_99.OUTP VSS sg13_lv_nmos ad=56.9f pd=0.74u as=56.9f ps=0.74u w=0.17u l=0.17u
X8687 cml_tlatch_41.xtail.S1 CKHA1_P cml_tlatch_41.xmux.xn.S1 VSS sg13_lv_nmos ad=89.3f pd=0.85u as=89.3f ps=0.85u w=0.47u l=0.16u
X8688 J4_N CLK_W_N cml_tlatch_90.xmux.xn.S1 VSS sg13_lv_nmos ad=63.19999f pd=0.74u as=63.19999f ps=0.74u w=0.26u l=0.38u
X8689 cml_tlatch_61.xmux.xp.S1 cml_tlatch_61.OUTN cml_tlatch_61.OUTP VSS sg13_lv_nmos ad=56.9f pd=0.74u as=56.9f ps=0.74u w=0.17u l=0.17u
X8690 cml_tlatch_70.xmux.xp.S1 MOT29_P MOT29_N VSS sg13_lv_nmos ad=56.9f pd=0.74u as=56.9f ps=0.74u w=0.17u l=0.17u
X8691 cml_tlatch_48.xmux.xp.S1 stub_bi_32.BOTN stub_bi_32.BOTP VSS sg13_lv_nmos ad=56.9f pd=0.74u as=56.9f ps=0.74u w=0.17u l=0.17u
X8692 cml_tlatch_20.xmux.xp.S1 MOT7_P MOT7_N VSS sg13_lv_nmos ad=56.9f pd=0.74u as=56.9f ps=0.74u w=0.17u l=0.17u
X8693 VSS POLN cml_tlatch_37.xtail.S1 VSS sg13_lv_nmos ad=2.7982p pd=17.14u as=1.5637p ps=8.61u w=8.23u l=0.13u
X8694 VDD MOT0_N VSS rppd l=5.17u w=1u
X8695 cml_tlatch_29.xmux.xp.S1 cml_tlatch_29.OUTP cml_tlatch_29.OUTN VSS sg13_lv_nmos ad=56.9f pd=0.74u as=56.9f ps=0.74u w=0.17u l=0.17u
X8696 cml_gate2_8.xrtail.R1 NS1_P cml_gate2_8.sg13_lv_nmos_FTPY57_0.D0 VSS sg13_lv_nmos ad=0.1007p pd=0.91u as=0.1007p ps=0.91u w=0.53u l=0.13u
X8697 cml_tlatch_32.xmux.xp.S1 CKB1_N cml_tlatch_32.xtail.S1 VSS sg13_lv_nmos ad=89.3f pd=0.85u as=89.3f ps=0.85u w=0.47u l=0.16u
X8698 cml_tlatch_82.xmux.xp.S1 cml_tlatch_82.OUTP cml_tlatch_82.OUTN VSS sg13_lv_nmos ad=56.9f pd=0.74u as=56.9f ps=0.74u w=0.17u l=0.17u
X8699 cml_tlatch_48.xtail.S1 CKB2_P cml_tlatch_48.xmux.xn.S1 VSS sg13_lv_nmos ad=89.3f pd=0.85u as=89.3f ps=0.85u w=0.47u l=0.16u
X8700 CKA1_P CK_P hs_to_clk_3.D2 VSS sg13_lv_nmos ad=0.228p pd=1.58u as=0.408p ps=3.08u w=1.2u l=0.2u
X8701 cml_tlatch_83.xmux.xp.S1 cml_tlatch_83.OUTP cml_tlatch_83.OUTN VSS sg13_lv_nmos ad=56.9f pd=0.74u as=56.9f ps=0.74u w=0.17u l=0.17u
X8702 cml_tlatch_72.xtail.S1 POLN VSS VSS sg13_lv_nmos ad=1.5637p pd=8.61u as=1.5637p ps=8.61u w=8.23u l=0.13u
X8703 stub_bi_63.BOTN stub_bi_63.BOTP cml_tlatch_79.xmux.xp.S1 VSS sg13_lv_nmos ad=56.9f pd=0.74u as=56.9f ps=0.74u w=0.17u l=0.17u
X8704 B0_8_N B0_8_P cml_tlatch_10.xmux.xp.S1 VSS sg13_lv_nmos ad=56.9f pd=0.74u as=56.9f ps=0.74u w=0.17u l=0.17u
X8705 cml_tlatch_30.xmux.xn.S1 A0_2_N cml_tlatch_30.OUTP VSS sg13_lv_nmos ad=63.19999f pd=0.74u as=63.19999f ps=0.74u w=0.26u l=0.38u
X8706 cml_tlatch_55.xmux.xp.S1 CKA2_N cml_tlatch_55.xtail.S1 VSS sg13_lv_nmos ad=89.3f pd=0.85u as=89.3f ps=0.85u w=0.47u l=0.16u
X8707 cml_tlatch_14.xtail.S1 CKB1_P cml_tlatch_14.xmux.xp.S1 VSS sg13_lv_nmos ad=89.3f pd=0.85u as=89.3f ps=0.85u w=0.47u l=0.16u
X8708 cml_tlatch_20.xmux.xp.S1 MOT7_N MOT7_P VSS sg13_lv_nmos ad=56.9f pd=0.74u as=56.9f ps=0.74u w=0.17u l=0.17u
X8709 B3_8_N cml_tlatch_61.OUTP cml_tlatch_60.xmux.xn.S1 VSS sg13_lv_nmos ad=63.19999f pd=0.74u as=63.19999f ps=0.74u w=0.26u l=0.38u
X8710 MOT30_P MOT30_N cml_tlatch_59.xmux.xp.S1 VSS sg13_lv_nmos ad=56.9f pd=0.74u as=56.9f ps=0.74u w=0.17u l=0.17u
X8711 cml_tlatch_87.xmux.xp.S1 MOT16_P MOT16_N VSS sg13_lv_nmos ad=56.9f pd=0.74u as=56.9f ps=0.74u w=0.17u l=0.17u
X8712 cml_tlatch_1.xmux.xp.S1 CKB0_N cml_tlatch_1.xtail.S1 VSS sg13_lv_nmos ad=89.3f pd=0.85u as=89.3f ps=0.85u w=0.47u l=0.16u
X8713 MOT5_P cml_tlatch_98.OUTN cml_tlatch_19.xmux.xn.S1 VSS sg13_lv_nmos ad=63.19999f pd=0.74u as=63.19999f ps=0.74u w=0.26u l=0.38u
X8714 cml_tlatch_37.xmux.xn.S1 CKA1_N cml_tlatch_37.xtail.S1 VSS sg13_lv_nmos ad=89.3f pd=0.85u as=89.3f ps=0.85u w=0.47u l=0.16u
X8715 cml_tlatch_76.xmux.xp.S1 MOT23_P MOT23_N VSS sg13_lv_nmos ad=56.9f pd=0.74u as=56.9f ps=0.74u w=0.17u l=0.17u
X8716 cml_tlatch_15.xmux.xp.S1 CKB1_N cml_tlatch_15.xtail.S1 VSS sg13_lv_nmos ad=89.3f pd=0.85u as=89.3f ps=0.85u w=0.47u l=0.16u
X8717 A3_8_P cml_tlatch_65.OUTN cml_tlatch_64.xmux.xn.S1 VSS sg13_lv_nmos ad=63.19999f pd=0.74u as=63.19999f ps=0.74u w=0.26u l=0.38u
X8718 cml_tlatch_79.xmux.xn.S1 stub_bi_49.BOTP stub_bi_63.BOTN VSS sg13_lv_nmos ad=0.1082p pd=1.34u as=63.19999f ps=0.74u w=0.26u l=0.38u
X8719 cml_tlatch_62.xmux.xn.S1 CKB3_N cml_tlatch_62.xtail.S1 VSS sg13_lv_nmos ad=89.3f pd=0.85u as=89.3f ps=0.85u w=0.47u l=0.16u
X8720 cml_tlatch_71.xtail.S1 CKHB3_N cml_tlatch_71.xmux.xp.S1 VSS sg13_lv_nmos ad=89.3f pd=0.85u as=89.3f ps=0.85u w=0.47u l=0.16u
X8721 cml_tlatch_81.xmux.xp.S1 A2_8_P A2_8_N VSS sg13_lv_nmos ad=56.9f pd=0.74u as=56.9f ps=0.74u w=0.17u l=0.17u
X8722 cml_tlatch_11.OUTN cml_tlatch_11.OUTP cml_tlatch_11.xmux.xp.S1 VSS sg13_lv_nmos ad=56.9f pd=0.74u as=56.9f ps=0.74u w=0.17u l=0.17u
X8723 cml_tlatch_25.xmux.xp.S1 CKHA0_N cml_tlatch_25.xtail.S1 VSS sg13_lv_nmos ad=89.3f pd=0.85u as=89.3f ps=0.85u w=0.47u l=0.16u
X8724 cml_tlatch_41.xmux.xp.S1 MOT14_N MOT14_P VSS sg13_lv_nmos ad=56.9f pd=0.74u as=56.9f ps=0.74u w=0.17u l=0.17u
X8725 cml_tlatch_96.xmux.xp.S1 MOT8_P MOT8_N VSS sg13_lv_nmos ad=56.9f pd=0.74u as=56.9f ps=0.74u w=0.17u l=0.17u
X8726 cml_tlatch_37.xmux.xp.S1 A1_2_N A1_2_P VSS sg13_lv_nmos ad=56.9f pd=0.74u as=56.9f ps=0.74u w=0.17u l=0.17u
X8727 cml_tlatch_67.OUTN cml_tlatch_67.OUTP cml_tlatch_67.xmux.xp.S1 VSS sg13_lv_nmos ad=56.9f pd=0.74u as=56.9f ps=0.74u w=0.17u l=0.17u
X8728 cml_tlatch_51.xtail.S1 CKHA2_P cml_tlatch_51.xmux.xn.S1 VSS sg13_lv_nmos ad=89.3f pd=0.85u as=89.3f ps=0.85u w=0.47u l=0.16u
X8729 cml_tlatch_93.xmux.xn.S1 CKJ_P cml_tlatch_93.xtail.S1 VSS sg13_lv_nmos ad=89.3f pd=0.85u as=0.1598p ps=1.62u w=0.47u l=0.16u
X8730 cml_tlatch_57.xmux.xn.S1 cml_tlatch_57.INN MOT26_P VSS sg13_lv_nmos ad=0.1082p pd=1.34u as=63.19999f ps=0.74u w=0.26u l=0.38u
X8731 MOT12_P MOT12_N cml_tlatch_40.xmux.xp.S1 VSS sg13_lv_nmos ad=56.9f pd=0.74u as=56.9f ps=0.74u w=0.17u l=0.17u
X8732 stub_bi_49.BOTN stub_bi_49.BOTP cml_tlatch_80.xmux.xp.S1 VSS sg13_lv_nmos ad=56.9f pd=0.74u as=56.9f ps=0.74u w=0.17u l=0.17u
X8733 cml_tlatch_8.xmux.xp.S1 cml_tlatch_8.OUTN cml_tlatch_8.OUTP VSS sg13_lv_nmos ad=56.9f pd=0.74u as=56.9f ps=0.74u w=0.17u l=0.17u
X8734 cml_tlatch_5.INN stub_bi_19.BOTN cml_tlatch_14.xmux.xn.S1 VSS sg13_lv_nmos ad=63.19999f pd=0.74u as=63.19999f ps=0.74u w=0.26u l=0.38u
X8735 VSS POLN hs_to_clk_1.D2 VSS sg13_lv_nmos ad=1.9p pd=10.38u as=3.4p ps=20.68u w=10u l=0.13u
X8736 A1_2_N A1_2_P cml_tlatch_37.xmux.xp.S1 VSS sg13_lv_nmos ad=56.9f pd=0.74u as=56.9f ps=0.74u w=0.17u l=0.17u
X8737 cml_tlatch_85.xmux.xn.S1 cml_tlatch_52.OUTN cml_tlatch_58.INP VSS sg13_lv_nmos ad=63.19999f pd=0.74u as=63.19999f ps=0.74u w=0.26u l=0.38u
X8738 cml_tlatch_55.xmux.xp.S1 cml_tlatch_89.INN cml_tlatch_89.INP VSS sg13_lv_nmos ad=56.9f pd=0.74u as=56.9f ps=0.74u w=0.17u l=0.17u
X8739 cml_tlatch_33.xmux.xp.S1 B1_2_P B1_2_N VSS sg13_lv_nmos ad=56.9f pd=0.74u as=56.9f ps=0.74u w=0.17u l=0.17u
X8740 MOT9_N MOT9_P cml_tlatch_4.xmux.xp.S1 VSS sg13_lv_nmos ad=56.9f pd=0.74u as=56.9f ps=0.74u w=0.17u l=0.17u
X8741 cml_tlatch_40.xmux.xn.S1 cml_tlatch_40.INN MOT12_P VSS sg13_lv_nmos ad=63.19999f pd=0.74u as=0.1082p ps=1.34u w=0.26u l=0.38u
X8742 cml_tlatch_61.xtail.S1 CKB3_N cml_tlatch_61.xmux.xp.S1 VSS sg13_lv_nmos ad=89.3f pd=0.85u as=0.1598p ps=1.62u w=0.47u l=0.16u
X8743 cml_tlatch_46.xmux.xn.S1 cml_tlatch_47.OUTN B3_2_P VSS sg13_lv_nmos ad=0.1082p pd=1.34u as=63.19999f ps=0.74u w=0.26u l=0.38u
X8744 cml_gate2_2.sg13_lv_nmos_FTPY57_0.D0 CKB0_P cml_gate2_2.xrtail.R1 VSS sg13_lv_nmos ad=0.1007p pd=0.91u as=0.1802p ps=1.74u w=0.53u l=0.13u
X8745 cml_tlatch_47.xmux.xp.S1 cml_tlatch_47.OUTN cml_tlatch_47.OUTP VSS sg13_lv_nmos ad=56.9f pd=0.74u as=56.9f ps=0.74u w=0.17u l=0.17u
X8746 cml_tlatch_5.xmux.xp.S1 MOT11_N MOT11_P VSS sg13_lv_nmos ad=56.9f pd=0.74u as=56.9f ps=0.74u w=0.17u l=0.17u
X8747 cml_drvb_0.xrtail.R1 GB1_N CKHB1_P VSS sg13_lv_nmos ad=0.1463p pd=1.15u as=0.2618p ps=2.22u w=0.77u l=0.21u
X8748 cml_tlatch_46.xmux.xn.S1 cml_tlatch_47.OUTN B3_2_P VSS sg13_lv_nmos ad=63.19999f pd=0.74u as=63.19999f ps=0.74u w=0.26u l=0.38u
X8749 cml_tlatch_49.xmux.xn.S1 CKHA2_P cml_tlatch_49.xtail.S1 VSS sg13_lv_nmos ad=89.3f pd=0.85u as=89.3f ps=0.85u w=0.47u l=0.16u
X8750 cml_tlatch_5.xtail.S1 CKHB1_P cml_tlatch_5.xmux.xn.S1 VSS sg13_lv_nmos ad=89.3f pd=0.85u as=89.3f ps=0.85u w=0.47u l=0.16u
X8751 cml_tlatch_89.xmux.xp.S1 cml_tlatch_89.OUTN cml_tlatch_89.OUTP VSS sg13_lv_nmos ad=56.9f pd=0.74u as=56.9f ps=0.74u w=0.17u l=0.17u
X8752 cml_tlatch_0.xmux.xp.S1 interco_bi_19.INP interco_bi_19.INN VSS sg13_lv_nmos ad=56.9f pd=0.74u as=56.9f ps=0.74u w=0.17u l=0.17u
X8753 cml_tlatch_10.xmux.xn.S1 cml_tlatch_11.OUTP B0_8_N VSS sg13_lv_nmos ad=63.19999f pd=0.74u as=63.19999f ps=0.74u w=0.26u l=0.38u
X8754 cml_tlatch_54.OUTN cml_tlatch_54.OUTP cml_tlatch_54.xmux.xp.S1 VSS sg13_lv_nmos ad=56.9f pd=0.74u as=56.9f ps=0.74u w=0.17u l=0.17u
X8755 cml_tlatch_3.xmux.xp.S1 cml_tlatch_3.OUTN cml_tlatch_3.OUTP VSS sg13_lv_nmos ad=56.9f pd=0.74u as=56.9f ps=0.74u w=0.17u l=0.17u
X8756 cml_tlatch_37.xmux.xn.S1 cml_tlatch_38.OUTN A1_2_P VSS sg13_lv_nmos ad=63.19999f pd=0.74u as=63.19999f ps=0.74u w=0.26u l=0.38u
X8757 cml_tlatch_3.xtail.S1 CKA0_P cml_tlatch_3.xmux.xn.S1 VSS sg13_lv_nmos ad=89.3f pd=0.85u as=89.3f ps=0.85u w=0.47u l=0.16u
X8758 cml_tlatch_28.xmux.xp.S1 B0_2_P B0_2_N VSS sg13_lv_nmos ad=56.9f pd=0.74u as=56.9f ps=0.74u w=0.17u l=0.17u
X8759 VDD CKHA0_P VSS rppd l=13.09u w=1u
X8760 cml_tlatch_33.xmux.xp.S1 CKB1_P cml_tlatch_33.xtail.S1 VSS sg13_lv_nmos ad=89.3f pd=0.85u as=89.3f ps=0.85u w=0.47u l=0.16u
X8761 MOT18_N MOT18_P cml_tlatch_49.xmux.xp.S1 VSS sg13_lv_nmos ad=56.9f pd=0.74u as=56.9f ps=0.74u w=0.17u l=0.17u
X8762 MOT25_N MOT25_P cml_tlatch_68.xmux.xp.S1 VSS sg13_lv_nmos ad=56.9f pd=0.74u as=56.9f ps=0.74u w=0.17u l=0.17u
X8763 cml_tlatch_99.OUTN cml_tlatch_99.OUTP cml_tlatch_99.xmux.xp.S1 VSS sg13_lv_nmos ad=56.9f pd=0.74u as=56.9f ps=0.74u w=0.17u l=0.17u
X8764 cml_tlatch_98.OUTP cml_tlatch_98.OUTN cml_tlatch_98.xmux.xp.S1 VSS sg13_lv_nmos ad=56.9f pd=0.74u as=0.1019p ps=1.34u w=0.17u l=0.17u
X8765 cml_tlatch_31.xmux.xp.S1 CKA0_P cml_tlatch_31.xtail.S1 VSS sg13_lv_nmos ad=89.3f pd=0.85u as=0.1598p ps=1.62u w=0.47u l=0.16u
X8766 cml_tlatch_95.xtail.S1 CKA1_N cml_tlatch_95.xmux.xn.S1 VSS sg13_lv_nmos ad=89.3f pd=0.85u as=89.3f ps=0.85u w=0.47u l=0.16u
X8767 cml_tlatch_11.OUTP cml_tlatch_16.OUTN cml_tlatch_11.xmux.xn.S1 VSS sg13_lv_nmos ad=63.19999f pd=0.74u as=63.19999f ps=0.74u w=0.26u l=0.38u
X8768 MOT2_N cml_tlatch_8.OUTP cml_tlatch_24.xmux.xn.S1 VSS sg13_lv_nmos ad=63.19999f pd=0.74u as=63.19999f ps=0.74u w=0.26u l=0.38u
X8769 cml_tlatch_82.xtail.S1 CKA2_N cml_tlatch_82.xmux.xp.S1 VSS sg13_lv_nmos ad=89.3f pd=0.85u as=89.3f ps=0.85u w=0.47u l=0.16u
X8770 MOT10_N MOT10_P cml_tlatch_39.xmux.xp.S1 VSS sg13_lv_nmos ad=56.9f pd=0.74u as=56.9f ps=0.74u w=0.17u l=0.17u
X8771 A1_8_N A1_8_P cml_tlatch_21.xmux.xp.S1 VSS sg13_lv_nmos ad=56.9f pd=0.74u as=56.9f ps=0.74u w=0.17u l=0.17u
X8772 GA2_N ENA1_P cml_gate2_4.sg13_lv_nmos_FTPY57_0.D0 VSS sg13_lv_nmos ad=0.1007p pd=0.91u as=0.1007p ps=0.91u w=0.53u l=0.13u
X8773 MOT15_P MOT15_N cml_tlatch_7.xmux.xp.S1 VSS sg13_lv_nmos ad=56.9f pd=0.74u as=56.9f ps=0.74u w=0.17u l=0.17u
X8774 cml_tlatch_42.xtail.S1 CKA2_N cml_tlatch_42.xmux.xp.S1 VSS sg13_lv_nmos ad=89.3f pd=0.85u as=89.3f ps=0.85u w=0.47u l=0.16u
X8775 MOT30_P MOT30_N cml_tlatch_59.xmux.xp.S1 VSS sg13_lv_nmos ad=56.9f pd=0.74u as=0.1019p ps=1.34u w=0.17u l=0.17u
X8776 cml_tlatch_17.xmux.xp.S1 MOT1_N MOT1_P VSS sg13_lv_nmos ad=56.9f pd=0.74u as=56.9f ps=0.74u w=0.17u l=0.17u
X8777 cml_tlatch_36.xmux.xn.S1 CKA1_P cml_tlatch_36.xtail.S1 VSS sg13_lv_nmos ad=89.3f pd=0.85u as=89.3f ps=0.85u w=0.47u l=0.16u
X8778 A3_2_P A3_2_N cml_tlatch_53.xmux.xp.S1 VSS sg13_lv_nmos ad=56.9f pd=0.74u as=56.9f ps=0.74u w=0.17u l=0.17u
X8779 MOT30_P A3_2_N cml_tlatch_59.xmux.xn.S1 VSS sg13_lv_nmos ad=63.19999f pd=0.74u as=63.19999f ps=0.74u w=0.26u l=0.38u
X8780 cml_tlatch_55.xmux.xn.S1 CKA2_P cml_tlatch_55.xtail.S1 VSS sg13_lv_nmos ad=0.1598p pd=1.62u as=89.3f ps=0.85u w=0.47u l=0.16u
X8781 cml_tlatch_6.INN stub_bi_29.BOTN cml_tlatch_94.xmux.xn.S1 VSS sg13_lv_nmos ad=63.19999f pd=0.74u as=63.19999f ps=0.74u w=0.26u l=0.38u
X8782 cml_tlatch_66.xmux.xp.S1 CKA3_P cml_tlatch_66.xtail.S1 VSS sg13_lv_nmos ad=89.3f pd=0.85u as=89.3f ps=0.85u w=0.47u l=0.16u
X8783 cml_tlatch_83.xmux.xp.S1 cml_tlatch_83.OUTP cml_tlatch_83.OUTN VSS sg13_lv_nmos ad=56.9f pd=0.74u as=56.9f ps=0.74u w=0.17u l=0.17u
X8784 cml_tlatch_98.xmux.xn.S1 CKB0_N cml_tlatch_98.xtail.S1 VSS sg13_lv_nmos ad=89.3f pd=0.85u as=89.3f ps=0.85u w=0.47u l=0.16u
X8785 stub_bi_63.BOTN stub_bi_63.BOTP cml_tlatch_79.xmux.xp.S1 VSS sg13_lv_nmos ad=56.9f pd=0.74u as=56.9f ps=0.74u w=0.17u l=0.17u
X8786 stub_bi_63.BOTP stub_bi_63.BOTN cml_tlatch_79.xmux.xp.S1 VSS sg13_lv_nmos ad=56.9f pd=0.74u as=56.9f ps=0.74u w=0.17u l=0.17u
X8787 cml_tlatch_23.xmux.xp.S1 cml_tlatch_39.INN cml_tlatch_39.INP VSS sg13_lv_nmos ad=56.9f pd=0.74u as=56.9f ps=0.74u w=0.17u l=0.17u
X8788 VDD cml_tlatch_52.OUTN VSS rppd l=5.17u w=1u
X8789 cml_tlatch_75.xtail.S1 CKHB2_N cml_tlatch_75.xmux.xp.S1 VSS sg13_lv_nmos ad=89.3f pd=0.85u as=89.3f ps=0.85u w=0.47u l=0.16u
X8790 cml_tlatch_18.xmux.xp.S1 MOT3_P MOT3_N VSS sg13_lv_nmos ad=56.9f pd=0.74u as=56.9f ps=0.74u w=0.17u l=0.17u
X8791 cml_tlatch_39.xmux.xn.S1 CKHA1_P cml_tlatch_39.xtail.S1 VSS sg13_lv_nmos ad=89.3f pd=0.85u as=89.3f ps=0.85u w=0.47u l=0.16u
X8792 cml_tlatch_95.INP cml_tlatch_95.INN cml_tlatch_36.xmux.xp.S1 VSS sg13_lv_nmos ad=56.9f pd=0.74u as=56.9f ps=0.74u w=0.17u l=0.17u
X8793 cml_tlatch_48.xtail.S1 CKB2_N cml_tlatch_48.xmux.xp.S1 VSS sg13_lv_nmos ad=0.1598p pd=1.62u as=89.3f ps=0.85u w=0.47u l=0.16u
X8794 cml_tlatch_1.xmux.xn.S1 cml_tlatch_98.OUTN cml_tlatch_1.OUTP VSS sg13_lv_nmos ad=63.19999f pd=0.74u as=0.1082p ps=1.34u w=0.26u l=0.38u
X8795 MOT24_N MOT24_P cml_tlatch_86.xmux.xp.S1 VSS sg13_lv_nmos ad=56.9f pd=0.74u as=56.9f ps=0.74u w=0.17u l=0.17u
X8796 cml_tlatch_22.OUTN cml_tlatch_22.OUTP cml_tlatch_22.xmux.xp.S1 VSS sg13_lv_nmos ad=56.9f pd=0.74u as=56.9f ps=0.74u w=0.17u l=0.17u
X8797 cml_tlatch_67.xmux.xp.S1 cml_tlatch_67.OUTN cml_tlatch_67.OUTP VSS sg13_lv_nmos ad=56.9f pd=0.74u as=56.9f ps=0.74u w=0.17u l=0.17u
X8798 MOT31_N MOT31_P cml_tlatch_71.xmux.xp.S1 VSS sg13_lv_nmos ad=56.9f pd=0.74u as=56.9f ps=0.74u w=0.17u l=0.17u
X8799 cml_tlatch_56.INP D2_N cml_tlatch_42.xmux.xn.S1 VSS sg13_lv_nmos ad=63.19999f pd=0.74u as=63.19999f ps=0.74u w=0.26u l=0.38u
X8800 cml_tlatch_95.xmux.xp.S1 CKA1_P cml_tlatch_95.xtail.S1 VSS sg13_lv_nmos ad=89.3f pd=0.85u as=0.1598p ps=1.62u w=0.47u l=0.16u
X8801 cml_tlatch_58.xtail.S1 CKHA3_P cml_tlatch_58.xmux.xn.S1 VSS sg13_lv_nmos ad=89.3f pd=0.85u as=89.3f ps=0.85u w=0.47u l=0.16u
X8802 cml_tlatch_10.xtail.S1 CKB0_N cml_tlatch_10.xmux.xn.S1 VSS sg13_lv_nmos ad=0.1598p pd=1.62u as=89.3f ps=0.85u w=0.47u l=0.16u
X8803 cml_tlatch_85.xmux.xp.S1 cml_tlatch_58.INP cml_tlatch_58.INN VSS sg13_lv_nmos ad=56.9f pd=0.74u as=56.9f ps=0.74u w=0.17u l=0.17u
X8804 CKB1_P CK_N hs_to_clk_2.D2 VSS sg13_lv_nmos ad=0.228p pd=1.58u as=0.228p ps=1.58u w=1.2u l=0.2u
X8805 cml_tlatch_62.xmux.xp.S1 CKB3_P cml_tlatch_62.xtail.S1 VSS sg13_lv_nmos ad=89.3f pd=0.85u as=89.3f ps=0.85u w=0.47u l=0.16u
X8806 cml_tlatch_35.xmux.xp.S1 cml_tlatch_35.OUTN cml_tlatch_35.OUTP VSS sg13_lv_nmos ad=56.9f pd=0.74u as=56.9f ps=0.74u w=0.17u l=0.17u
X8807 MOT3_N cml_tlatch_16.OUTP cml_tlatch_18.xmux.xn.S1 VSS sg13_lv_nmos ad=63.19999f pd=0.74u as=0.1082p ps=1.34u w=0.26u l=0.38u
X8808 cml_tlatch_96.xmux.xp.S1 MOT8_P MOT8_N VSS sg13_lv_nmos ad=56.9f pd=0.74u as=56.9f ps=0.74u w=0.17u l=0.17u
X8809 cml_tlatch_98.OUTP cml_tlatch_98.OUTN cml_tlatch_98.xmux.xp.S1 VSS sg13_lv_nmos ad=56.9f pd=0.74u as=56.9f ps=0.74u w=0.17u l=0.17u
X8810 interco_bi_19.INP interco_bi_19.INN cml_tlatch_0.xmux.xp.S1 VSS sg13_lv_nmos ad=56.9f pd=0.74u as=56.9f ps=0.74u w=0.17u l=0.17u
X8811 stub_bi_62.BOTN stub_bi_62.BOTP cml_tlatch_78.xmux.xp.S1 VSS sg13_lv_nmos ad=56.9f pd=0.74u as=56.9f ps=0.74u w=0.17u l=0.17u
X8812 MOT15_N B1_2_P cml_tlatch_7.xmux.xn.S1 VSS sg13_lv_nmos ad=63.19999f pd=0.74u as=63.19999f ps=0.74u w=0.26u l=0.38u
X8813 cml_tlatch_94.xmux.xp.S1 cml_tlatch_6.INP cml_tlatch_6.INN VSS sg13_lv_nmos ad=56.9f pd=0.74u as=56.9f ps=0.74u w=0.17u l=0.17u
X8814 cml_tlatch_74.xmux.xp.S1 MOT19_P MOT19_N VSS sg13_lv_nmos ad=56.9f pd=0.74u as=56.9f ps=0.74u w=0.17u l=0.17u
X8815 cml_tlatch_9.xmux.xn.S1 CKA0_P cml_tlatch_9.xtail.S1 VSS sg13_lv_nmos ad=89.3f pd=0.85u as=89.3f ps=0.85u w=0.47u l=0.16u
X8816 cml_tlatch_51.xtail.S1 CKHA2_N cml_tlatch_51.xmux.xp.S1 VSS sg13_lv_nmos ad=89.3f pd=0.85u as=89.3f ps=0.85u w=0.47u l=0.16u
X8817 MOT15_N B1_2_P cml_tlatch_7.xmux.xn.S1 VSS sg13_lv_nmos ad=63.19999f pd=0.74u as=63.19999f ps=0.74u w=0.26u l=0.38u
X8818 cml_tlatch_0.xmux.xn.S1 cml_tlatch_40.INN interco_bi_19.INP VSS sg13_lv_nmos ad=63.19999f pd=0.74u as=63.19999f ps=0.74u w=0.26u l=0.38u
X8819 cml_tlatch_29.OUTN D0_P cml_tlatch_29.xmux.xn.S1 VSS sg13_lv_nmos ad=63.19999f pd=0.74u as=63.19999f ps=0.74u w=0.26u l=0.38u
X8820 cml_tlatch_33.xmux.xp.S1 B1_2_P B1_2_N VSS sg13_lv_nmos ad=56.9f pd=0.74u as=56.9f ps=0.74u w=0.17u l=0.17u
X8821 cml_tlatch_93.xmux.xp.S1 CKJ_N cml_tlatch_93.xtail.S1 VSS sg13_lv_nmos ad=89.3f pd=0.85u as=89.3f ps=0.85u w=0.47u l=0.16u
X8822 cml_tlatch_92.xmux.xp.S1 J2_N J2_P VSS sg13_lv_nmos ad=56.9f pd=0.74u as=56.9f ps=0.74u w=0.17u l=0.17u
X8823 NM1_P CLK_W_N cml_drvb_9.xrtail.R1 VSS sg13_lv_nmos ad=0.2618p pd=2.22u as=0.1463p ps=1.15u w=0.77u l=0.21u
X8824 cml_tlatch_39.xmux.xp.S1 MOT10_N MOT10_P VSS sg13_lv_nmos ad=56.9f pd=0.74u as=56.9f ps=0.74u w=0.17u l=0.17u
X8825 VSS POLN cml_tlatch_6.xtail.S1 VSS sg13_lv_nmos ad=2.7982p pd=17.14u as=1.5637p ps=8.61u w=8.23u l=0.13u
X8826 interco_bi_19.INP interco_bi_19.INN cml_tlatch_0.xmux.xp.S1 VSS sg13_lv_nmos ad=56.9f pd=0.74u as=56.9f ps=0.74u w=0.17u l=0.17u
X8827 cml_tlatch_64.xmux.xp.S1 A3_8_P A3_8_N VSS sg13_lv_nmos ad=56.9f pd=0.74u as=56.9f ps=0.74u w=0.17u l=0.17u
X8828 cml_tlatch_43.xmux.xn.S1 B2_2_N stub_bi_42.BOTN VSS sg13_lv_nmos ad=63.19999f pd=0.74u as=63.19999f ps=0.74u w=0.26u l=0.38u
X8829 cml_tlatch_27.xmux.xp.S1 cml_tlatch_27.OUTP cml_tlatch_27.OUTN VSS sg13_lv_nmos ad=56.9f pd=0.74u as=56.9f ps=0.74u w=0.17u l=0.17u
X8830 cml_tlatch_5.xmux.xn.S1 cml_tlatch_5.INP MOT11_N VSS sg13_lv_nmos ad=0.1082p pd=1.34u as=63.19999f ps=0.74u w=0.26u l=0.38u
X8831 interco_bi_19.INN cml_tlatch_40.INP cml_tlatch_0.xmux.xn.S1 VSS sg13_lv_nmos ad=63.19999f pd=0.74u as=63.19999f ps=0.74u w=0.26u l=0.38u
X8832 cml_tlatch_9.OUTN cml_tlatch_9.OUTP cml_tlatch_9.xmux.xp.S1 VSS sg13_lv_nmos ad=56.9f pd=0.74u as=56.9f ps=0.74u w=0.17u l=0.17u
X8833 cml_tlatch_17.xmux.xp.S1 CKHB0_N cml_tlatch_17.xtail.S1 VSS sg13_lv_nmos ad=89.3f pd=0.85u as=89.3f ps=0.85u w=0.47u l=0.16u
X8834 cml_tlatch_75.xmux.xn.S1 stub_bi_55.BOTN MOT21_N VSS sg13_lv_nmos ad=63.19999f pd=0.74u as=63.19999f ps=0.74u w=0.26u l=0.38u
X8835 cml_tlatch_54.OUTN cml_tlatch_54.OUTP cml_tlatch_54.xmux.xp.S1 VSS sg13_lv_nmos ad=56.9f pd=0.74u as=56.9f ps=0.74u w=0.17u l=0.17u
X8836 cml_tlatch_28.xmux.xp.S1 CKB0_P cml_tlatch_28.xtail.S1 VSS sg13_lv_nmos ad=89.3f pd=0.85u as=89.3f ps=0.85u w=0.47u l=0.16u
X8837 cml_tlatch_3.xmux.xp.S1 cml_tlatch_3.OUTN cml_tlatch_3.OUTP VSS sg13_lv_nmos ad=56.9f pd=0.74u as=56.9f ps=0.74u w=0.17u l=0.17u
X8838 cml_tlatch_47.xmux.xp.S1 cml_tlatch_47.OUTP cml_tlatch_47.OUTN VSS sg13_lv_nmos ad=56.9f pd=0.74u as=56.9f ps=0.74u w=0.17u l=0.17u
X8839 cml_tlatch_12.xmux.xp.S1 B1_8_P B1_8_N VSS sg13_lv_nmos ad=56.9f pd=0.74u as=56.9f ps=0.74u w=0.17u l=0.17u
X8840 cml_tlatch_15.xtail.S1 CKB1_P cml_tlatch_15.xmux.xn.S1 VSS sg13_lv_nmos ad=0.1598p pd=1.62u as=89.3f ps=0.85u w=0.47u l=0.16u
X8841 cml_tlatch_25.xtail.S1 CKHA0_N cml_tlatch_25.xmux.xp.S1 VSS sg13_lv_nmos ad=89.3f pd=0.85u as=89.3f ps=0.85u w=0.47u l=0.16u
X8842 MOT9_P MOT9_N cml_tlatch_4.xmux.xp.S1 VSS sg13_lv_nmos ad=56.9f pd=0.74u as=56.9f ps=0.74u w=0.17u l=0.17u
X8843 cml_tlatch_28.xmux.xp.S1 B0_2_P B0_2_N VSS sg13_lv_nmos ad=56.9f pd=0.74u as=56.9f ps=0.74u w=0.17u l=0.17u
X8844 cml_tlatch_52.xmux.xp.S1 cml_tlatch_52.OUTN cml_tlatch_52.OUTP VSS sg13_lv_nmos ad=56.9f pd=0.74u as=56.9f ps=0.74u w=0.17u l=0.17u
X8845 B1_8_P stub_bi_17.BOTP cml_tlatch_12.xmux.xn.S1 VSS sg13_lv_nmos ad=63.19999f pd=0.74u as=63.19999f ps=0.74u w=0.26u l=0.38u
X8846 stub_bi_31.BOTP stub_bi_31.BOTN cml_tlatch_34.xmux.xp.S1 VSS sg13_lv_nmos ad=56.9f pd=0.74u as=56.9f ps=0.74u w=0.17u l=0.17u
X8847 cml_tlatch_65.xmux.xp.S1 cml_tlatch_65.OUTP cml_tlatch_65.OUTN VSS sg13_lv_nmos ad=56.9f pd=0.74u as=56.9f ps=0.74u w=0.17u l=0.17u
X8848 cml_tlatch_16.xmux.xp.S1 cml_tlatch_16.OUTN cml_tlatch_16.OUTP VSS sg13_lv_nmos ad=56.9f pd=0.74u as=56.9f ps=0.74u w=0.17u l=0.17u
X8849 J1_N J1_P cml_tlatch_93.xmux.xp.S1 VSS sg13_lv_nmos ad=56.9f pd=0.74u as=56.9f ps=0.74u w=0.17u l=0.17u
X8850 MOT10_N MOT10_P cml_tlatch_39.xmux.xp.S1 VSS sg13_lv_nmos ad=56.9f pd=0.74u as=56.9f ps=0.74u w=0.17u l=0.17u
X8851 cml_tlatch_46.xtail.S1 CKB3_P cml_tlatch_46.xmux.xp.S1 VSS sg13_lv_nmos ad=89.3f pd=0.85u as=89.3f ps=0.85u w=0.47u l=0.16u
X8852 cml_tlatch_32.xmux.xp.S1 stub_bi_29.BOTP stub_bi_29.BOTN VSS sg13_lv_nmos ad=56.9f pd=0.74u as=56.9f ps=0.74u w=0.17u l=0.17u
X8853 cml_tlatch_89.xtail.S1 CKA2_P cml_tlatch_89.xmux.xp.S1 VSS sg13_lv_nmos ad=89.3f pd=0.85u as=89.3f ps=0.85u w=0.47u l=0.16u
X8854 cml_tlatch_89.INN cml_tlatch_89.INP cml_tlatch_55.xmux.xp.S1 VSS sg13_lv_nmos ad=56.9f pd=0.74u as=56.9f ps=0.74u w=0.17u l=0.17u
X8855 cml_tlatch_63.xmux.xp.S1 CKB3_N cml_tlatch_63.xtail.S1 VSS sg13_lv_nmos ad=89.3f pd=0.85u as=89.3f ps=0.85u w=0.47u l=0.16u
X8856 cml_tlatch_43.xmux.xp.S1 stub_bi_42.BOTN stub_bi_42.BOTP VSS sg13_lv_nmos ad=56.9f pd=0.74u as=56.9f ps=0.74u w=0.17u l=0.17u
X8857 cml_tlatch_39.xtail.S1 CKHA1_N cml_tlatch_39.xmux.xp.S1 VSS sg13_lv_nmos ad=89.3f pd=0.85u as=0.1598p ps=1.62u w=0.47u l=0.16u
X8858 cml_gate2_9.sg13_lv_nmos_FTPY57_0.D0 NM1_P cml_gate2_9.xrtail.R1 VSS sg13_lv_nmos ad=0.1007p pd=0.91u as=0.1007p ps=0.91u w=0.53u l=0.13u
X8859 cml_tlatch_81.xmux.xn.S1 CKA2_N cml_tlatch_81.xtail.S1 VSS sg13_lv_nmos ad=89.3f pd=0.85u as=0.1598p ps=1.62u w=0.47u l=0.16u
X8860 stub_bi_32.BOTN stub_bi_32.BOTP cml_tlatch_48.xmux.xp.S1 VSS sg13_lv_nmos ad=56.9f pd=0.74u as=56.9f ps=0.74u w=0.17u l=0.17u
X8861 cml_tlatch_6.xmux.xp.S1 CKHB1_N cml_tlatch_6.xtail.S1 VSS sg13_lv_nmos ad=89.3f pd=0.85u as=89.3f ps=0.85u w=0.47u l=0.16u
X8862 cml_tlatch_90.xmux.xp.S1 J4_P J4_N VSS sg13_lv_nmos ad=56.9f pd=0.74u as=56.9f ps=0.74u w=0.17u l=0.17u
X8863 cml_tlatch_68.xmux.xn.S1 CKHB3_P cml_tlatch_68.xtail.S1 VSS sg13_lv_nmos ad=89.3f pd=0.85u as=89.3f ps=0.85u w=0.47u l=0.16u
X8864 cml_tlatch_74.xmux.xn.S1 stub_bi_63.BOTP MOT19_P VSS sg13_lv_nmos ad=63.19999f pd=0.74u as=63.19999f ps=0.74u w=0.26u l=0.38u
X8865 cml_tlatch_58.xtail.S1 POLN VSS VSS sg13_lv_nmos ad=1.5637p pd=8.61u as=2.7982p ps=17.14u w=8.23u l=0.13u
X8866 cml_tlatch_50.xtail.S1 CKHA2_N cml_tlatch_50.xmux.xp.S1 VSS sg13_lv_nmos ad=89.3f pd=0.85u as=89.3f ps=0.85u w=0.47u l=0.16u
X8867 cml_tlatch_1.OUTP cml_tlatch_1.OUTN cml_tlatch_1.xmux.xp.S1 VSS sg13_lv_nmos ad=56.9f pd=0.74u as=56.9f ps=0.74u w=0.17u l=0.17u
X8868 GA2_P ENA1_N cml_gate2_4.sg13_lv_nmos_FTPY57_0.D0 VSS sg13_lv_nmos ad=0.1007p pd=0.91u as=0.1007p ps=0.91u w=0.53u l=0.13u
X8869 VSS hs_to_clk_2.sg13_lv_nmos_2HGZLP_0.G VSS VSS sg13_lv_nmos ad=2.071p pd=11.28u as=0 ps=0 w=10.9u l=1.38u
X8870 cml_tlatch_35.xtail.S1 CKA0_P cml_tlatch_35.xmux.xn.S1 VSS sg13_lv_nmos ad=89.3f pd=0.85u as=89.3f ps=0.85u w=0.47u l=0.16u
X8871 cml_tlatch_33.xtail.S1 CKB1_P cml_tlatch_33.xmux.xp.S1 VSS sg13_lv_nmos ad=89.3f pd=0.85u as=0.1598p ps=1.62u w=0.47u l=0.16u
X8872 cml_tlatch_67.xmux.xp.S1 cml_tlatch_67.OUTN cml_tlatch_67.OUTP VSS sg13_lv_nmos ad=56.9f pd=0.74u as=56.9f ps=0.74u w=0.17u l=0.17u
X8873 hs_to_clk_7.sg13_lv_nmos_2HGZLP_0.G CKA3_P VSS rppd l=4.25u w=1u
X8874 cml_tlatch_63.OUTP cml_tlatch_63.OUTN cml_tlatch_63.xmux.xp.S1 VSS sg13_lv_nmos ad=56.9f pd=0.74u as=56.9f ps=0.74u w=0.17u l=0.17u
X8875 cml_tlatch_61.xtail.S1 CKB3_P cml_tlatch_61.xmux.xn.S1 VSS sg13_lv_nmos ad=89.3f pd=0.85u as=89.3f ps=0.85u w=0.47u l=0.16u
X8876 VDD cml_tlatch_56.INN VSS rppd l=5.17u w=1u
X8877 A2_2_N A2_2_P cml_tlatch_56.xmux.xp.S1 VSS sg13_lv_nmos ad=56.9f pd=0.74u as=56.9f ps=0.74u w=0.17u l=0.17u
X8878 cml_tlatch_70.INN cml_tlatch_70.INP cml_tlatch_84.xmux.xp.S1 VSS sg13_lv_nmos ad=56.9f pd=0.74u as=56.9f ps=0.74u w=0.17u l=0.17u
X8879 cml_tlatch_27.OUTP cml_tlatch_27.OUTN cml_tlatch_27.xmux.xp.S1 VSS sg13_lv_nmos ad=56.9f pd=0.74u as=56.9f ps=0.74u w=0.17u l=0.17u
X8880 cml_tlatch_95.INN A1_2_P cml_tlatch_36.xmux.xn.S1 VSS sg13_lv_nmos ad=63.19999f pd=0.74u as=0.1082p ps=1.34u w=0.26u l=0.38u
X8881 cml_tlatch_8.xmux.xp.S1 CKA0_P cml_tlatch_8.xtail.S1 VSS sg13_lv_nmos ad=89.3f pd=0.85u as=89.3f ps=0.85u w=0.47u l=0.16u
X8882 cml_tlatch_15.xmux.xp.S1 stub_bi_19.BOTP stub_bi_19.BOTN VSS sg13_lv_nmos ad=56.9f pd=0.74u as=56.9f ps=0.74u w=0.17u l=0.17u
X8883 VSS hs_to_clk_5.sg13_lv_nmos_2HGZLP_0.G VSS VSS sg13_lv_nmos ad=2.071p pd=11.28u as=0 ps=0 w=10.9u l=1.38u
X8884 cml_tlatch_43.xmux.xp.S1 CKB2_N cml_tlatch_43.xtail.S1 VSS sg13_lv_nmos ad=89.3f pd=0.85u as=89.3f ps=0.85u w=0.47u l=0.16u
X8885 cml_tlatch_23.xmux.xn.S1 CKA1_N cml_tlatch_23.xtail.S1 VSS sg13_lv_nmos ad=89.3f pd=0.85u as=0.1598p ps=1.62u w=0.47u l=0.16u
X8886 cml_gate2_5.xrtail.R1 CKB3_P cml_gate2_5.sg13_lv_nmos_FTPY57_0.D0 VSS sg13_lv_nmos ad=0.1802p pd=1.74u as=0.1007p ps=0.91u w=0.53u l=0.13u
X8887 cml_tlatch_94.xmux.xp.S1 cml_tlatch_6.INP cml_tlatch_6.INN VSS sg13_lv_nmos ad=56.9f pd=0.74u as=56.9f ps=0.74u w=0.17u l=0.17u
X8888 B3_2_P B3_2_N cml_tlatch_46.xmux.xp.S1 VSS sg13_lv_nmos ad=56.9f pd=0.74u as=56.9f ps=0.74u w=0.17u l=0.17u
X8889 cml_tlatch_31.xmux.xn.S1 cml_tlatch_35.OUTN A0_2_P VSS sg13_lv_nmos ad=63.19999f pd=0.74u as=63.19999f ps=0.74u w=0.26u l=0.38u
X8890 cml_tlatch_19.xtail.S1 CKHB0_P cml_tlatch_19.xmux.xn.S1 VSS sg13_lv_nmos ad=89.3f pd=0.85u as=89.3f ps=0.85u w=0.47u l=0.16u
X8891 cml_tlatch_69.xtail.S1 CKHB3_P cml_tlatch_69.xmux.xn.S1 VSS sg13_lv_nmos ad=0.1598p pd=1.62u as=89.3f ps=0.85u w=0.47u l=0.16u
X8892 MOT27_N MOT27_P cml_tlatch_69.xmux.xp.S1 VSS sg13_lv_nmos ad=56.9f pd=0.74u as=56.9f ps=0.74u w=0.17u l=0.17u
X8893 MOT20_P cml_tlatch_89.OUTN cml_tlatch_50.xmux.xn.S1 VSS sg13_lv_nmos ad=0.1082p pd=1.34u as=63.19999f ps=0.74u w=0.26u l=0.38u
X8894 cml_tlatch_85.xmux.xp.S1 cml_tlatch_58.INN cml_tlatch_58.INP VSS sg13_lv_nmos ad=0.1019p pd=1.34u as=56.9f ps=0.74u w=0.17u l=0.17u
X8895 MOT21_N MOT21_P cml_tlatch_75.xmux.xp.S1 VSS sg13_lv_nmos ad=56.9f pd=0.74u as=56.9f ps=0.74u w=0.17u l=0.17u
X8896 cml_gate2_0.xrtail.R1 CKA1_N GB1_P VSS sg13_lv_nmos ad=0.1007p pd=0.91u as=0.1007p ps=0.91u w=0.53u l=0.13u
X8897 cml_tlatch_3.OUTN cml_tlatch_8.OUTP cml_tlatch_3.xmux.xn.S1 VSS sg13_lv_nmos ad=63.19999f pd=0.74u as=63.19999f ps=0.74u w=0.26u l=0.38u
X8898 A0_8_N A0_8_P cml_tlatch_2.xmux.xp.S1 VSS sg13_lv_nmos ad=56.9f pd=0.74u as=56.9f ps=0.74u w=0.17u l=0.17u
X8899 A2_8_N cml_tlatch_82.OUTP cml_tlatch_81.xmux.xn.S1 VSS sg13_lv_nmos ad=63.19999f pd=0.74u as=0.1082p ps=1.34u w=0.26u l=0.38u
X8900 cml_tlatch_86.xtail.S1 CKHA3_P cml_tlatch_86.xmux.xn.S1 VSS sg13_lv_nmos ad=89.3f pd=0.85u as=0.1598p ps=1.62u w=0.47u l=0.16u
X8901 cml_tlatch_75.xmux.xp.S1 CKHB2_N cml_tlatch_75.xtail.S1 VSS sg13_lv_nmos ad=89.3f pd=0.85u as=89.3f ps=0.85u w=0.47u l=0.16u
X8902 cml_tlatch_8.xmux.xp.S1 cml_tlatch_8.OUTP cml_tlatch_8.OUTN VSS sg13_lv_nmos ad=56.9f pd=0.74u as=56.9f ps=0.74u w=0.17u l=0.17u
X8903 cml_tlatch_7.xtail.S1 CKHB1_N cml_tlatch_7.xmux.xp.S1 VSS sg13_lv_nmos ad=0.1598p pd=1.62u as=89.3f ps=0.85u w=0.47u l=0.16u
X8904 cml_tlatch_40.xtail.S1 CKHA1_N cml_tlatch_40.xmux.xp.S1 VSS sg13_lv_nmos ad=89.3f pd=0.85u as=89.3f ps=0.85u w=0.47u l=0.16u
X8905 VSS hs_to_clk_4.sg13_lv_nmos_2HGZLP_0.G VSS VSS sg13_lv_nmos ad=2.071p pd=11.28u as=0 ps=0 w=10.9u l=1.38u
X8906 cml_tlatch_23.xmux.xn.S1 interco_bi_19.INN cml_tlatch_39.INP VSS sg13_lv_nmos ad=63.19999f pd=0.74u as=63.19999f ps=0.74u w=0.26u l=0.38u
X8907 stub_bi_17.BOTP stub_bi_17.BOTN cml_tlatch_13.xmux.xp.S1 VSS sg13_lv_nmos ad=56.9f pd=0.74u as=56.9f ps=0.74u w=0.17u l=0.17u
X8908 VSS POLN cml_tlatch_62.xtail.S1 VSS sg13_lv_nmos ad=1.5637p pd=8.61u as=1.5637p ps=8.61u w=8.23u l=0.13u
X8909 B3_8_P VDD VSS rppd l=5.17u w=1u
X8910 A0_2_P A0_2_N cml_tlatch_31.xmux.xp.S1 VSS sg13_lv_nmos ad=56.9f pd=0.74u as=56.9f ps=0.74u w=0.17u l=0.17u
X8911 cml_tlatch_96.xtail.S1 POLN VSS VSS sg13_lv_nmos ad=1.5637p pd=8.61u as=1.5637p ps=8.61u w=8.23u l=0.13u
X8912 cml_tlatch_13.xmux.xn.S1 cml_tlatch_5.INN stub_bi_17.BOTN VSS sg13_lv_nmos ad=63.19999f pd=0.74u as=63.19999f ps=0.74u w=0.26u l=0.38u
X8913 cml_tlatch_56.xmux.xn.S1 CKA2_N cml_tlatch_56.xtail.S1 VSS sg13_lv_nmos ad=89.3f pd=0.85u as=0.1598p ps=1.62u w=0.47u l=0.16u
X8914 MOT17_P B2_8_N cml_tlatch_73.xmux.xn.S1 VSS sg13_lv_nmos ad=63.19999f pd=0.74u as=63.19999f ps=0.74u w=0.26u l=0.38u
X8915 cml_tlatch_3.OUTN cml_tlatch_3.OUTP cml_tlatch_3.xmux.xp.S1 VSS sg13_lv_nmos ad=56.9f pd=0.74u as=56.9f ps=0.74u w=0.17u l=0.17u
X8916 cml_tlatch_5.xtail.S1 CKHB1_P cml_tlatch_5.xmux.xn.S1 VSS sg13_lv_nmos ad=89.3f pd=0.85u as=89.3f ps=0.85u w=0.47u l=0.16u
X8917 cml_tlatch_64.xtail.S1 CKA3_N cml_tlatch_64.xmux.xn.S1 VSS sg13_lv_nmos ad=89.3f pd=0.85u as=89.3f ps=0.85u w=0.47u l=0.16u
X8918 cml_tlatch_70.xmux.xp.S1 CKHB3_N cml_tlatch_70.xtail.S1 VSS sg13_lv_nmos ad=89.3f pd=0.85u as=89.3f ps=0.85u w=0.47u l=0.16u
X8919 cml_tlatch_13.xmux.xn.S1 cml_tlatch_5.INN stub_bi_17.BOTN VSS sg13_lv_nmos ad=63.19999f pd=0.74u as=63.19999f ps=0.74u w=0.26u l=0.38u
X8920 cml_tlatch_90.xmux.xp.S1 CKJ_P cml_tlatch_90.xtail.S1 VSS sg13_lv_nmos ad=89.3f pd=0.85u as=89.3f ps=0.85u w=0.47u l=0.16u
X8921 MOT5_N cml_tlatch_98.OUTP cml_tlatch_19.xmux.xn.S1 VSS sg13_lv_nmos ad=0.1082p pd=1.34u as=63.19999f ps=0.74u w=0.26u l=0.38u
X8922 MOT4_P MOT4_N cml_tlatch_25.xmux.xp.S1 VSS sg13_lv_nmos ad=56.9f pd=0.74u as=56.9f ps=0.74u w=0.17u l=0.17u
X8923 cml_tlatch_66.xmux.xp.S1 cml_tlatch_57.INP cml_tlatch_57.INN VSS sg13_lv_nmos ad=56.9f pd=0.74u as=56.9f ps=0.74u w=0.17u l=0.17u
X8924 cml_tlatch_38.xmux.xn.S1 CKA1_P cml_tlatch_38.xtail.S1 VSS sg13_lv_nmos ad=89.3f pd=0.85u as=89.3f ps=0.85u w=0.47u l=0.16u
X8925 cml_tlatch_69.INP cml_tlatch_69.INN cml_tlatch_62.xmux.xp.S1 VSS sg13_lv_nmos ad=56.9f pd=0.74u as=56.9f ps=0.74u w=0.17u l=0.17u
X8926 cml_tlatch_44.xmux.xn.S1 stub_bi_32.BOTN B2_2_N VSS sg13_lv_nmos ad=63.19999f pd=0.74u as=63.19999f ps=0.74u w=0.26u l=0.38u
X8927 cml_tlatch_84.xmux.xp.S1 cml_tlatch_70.INN cml_tlatch_70.INP VSS sg13_lv_nmos ad=56.9f pd=0.74u as=56.9f ps=0.74u w=0.17u l=0.17u
X8928 cml_tlatch_82.xtail.S1 CKA2_N cml_tlatch_82.xmux.xp.S1 VSS sg13_lv_nmos ad=89.3f pd=0.85u as=89.3f ps=0.85u w=0.47u l=0.16u
X8929 cml_tlatch_56.xmux.xn.S1 cml_tlatch_56.INN A2_2_P VSS sg13_lv_nmos ad=63.19999f pd=0.74u as=63.19999f ps=0.74u w=0.26u l=0.38u
X8930 cml_tlatch_99.OUTP cml_tlatch_30.OUTN cml_tlatch_99.xmux.xn.S1 VSS sg13_lv_nmos ad=63.19999f pd=0.74u as=63.19999f ps=0.74u w=0.26u l=0.38u
X8931 cml_tlatch_43.xmux.xp.S1 stub_bi_42.BOTN stub_bi_42.BOTP VSS sg13_lv_nmos ad=56.9f pd=0.74u as=56.9f ps=0.74u w=0.17u l=0.17u
X8932 cml_tlatch_14.xmux.xp.S1 cml_tlatch_5.INN cml_tlatch_5.INP VSS sg13_lv_nmos ad=56.9f pd=0.74u as=56.9f ps=0.74u w=0.17u l=0.17u
X8933 VSS POLN cml_tlatch_15.xtail.S1 VSS sg13_lv_nmos ad=2.7982p pd=17.14u as=1.5637p ps=8.61u w=8.23u l=0.13u
X8934 cml_tlatch_59.xmux.xn.S1 CKHA3_P cml_tlatch_59.xtail.S1 VSS sg13_lv_nmos ad=89.3f pd=0.85u as=89.3f ps=0.85u w=0.47u l=0.16u
X8935 cml_tlatch_11.xmux.xn.S1 CKB0_P cml_tlatch_11.xtail.S1 VSS sg13_lv_nmos ad=89.3f pd=0.85u as=89.3f ps=0.85u w=0.47u l=0.16u
X8936 cml_tlatch_99.OUTP cml_tlatch_99.OUTN cml_tlatch_99.xmux.xp.S1 VSS sg13_lv_nmos ad=56.9f pd=0.74u as=0.1019p ps=1.34u w=0.17u l=0.17u
X8937 B1_8_P B1_8_N cml_tlatch_12.xmux.xp.S1 VSS sg13_lv_nmos ad=56.9f pd=0.74u as=0.1019p ps=1.34u w=0.17u l=0.17u
X8938 VSS POLN cml_tlatch_85.xtail.S1 VSS sg13_lv_nmos ad=1.5637p pd=8.61u as=1.5637p ps=8.61u w=8.23u l=0.13u
X8939 cml_tlatch_17.xtail.S1 CKHB0_N cml_tlatch_17.xmux.xp.S1 VSS sg13_lv_nmos ad=89.3f pd=0.85u as=89.3f ps=0.85u w=0.47u l=0.16u
X8940 ENB_P NS1_N cml_gate2_8.xrtail.R1 VSS sg13_lv_nmos ad=0.1007p pd=0.91u as=0.1007p ps=0.91u w=0.53u l=0.13u
X8941 MOT6_P MOT6_N cml_tlatch_26.xmux.xp.S1 VSS sg13_lv_nmos ad=56.9f pd=0.74u as=56.9f ps=0.74u w=0.17u l=0.17u
X8942 cml_tlatch_83.xtail.S1 CKA2_N cml_tlatch_83.xmux.xn.S1 VSS sg13_lv_nmos ad=89.3f pd=0.85u as=89.3f ps=0.85u w=0.47u l=0.16u
X8943 stub_bi_49.BOTN VDD VSS rppd l=5.17u w=1u
X8944 cml_tlatch_65.xmux.xp.S1 cml_tlatch_65.OUTN cml_tlatch_65.OUTP VSS sg13_lv_nmos ad=56.9f pd=0.74u as=56.9f ps=0.74u w=0.17u l=0.17u
X8945 cml_tlatch_61.OUTP cml_tlatch_61.OUTN cml_tlatch_61.xmux.xp.S1 VSS sg13_lv_nmos ad=56.9f pd=0.74u as=56.9f ps=0.74u w=0.17u l=0.17u
X8946 MOT29_N MOT29_P cml_tlatch_70.xmux.xp.S1 VSS sg13_lv_nmos ad=56.9f pd=0.74u as=56.9f ps=0.74u w=0.17u l=0.17u
X8947 cml_tlatch_78.xtail.S1 CKB2_N cml_tlatch_78.xmux.xp.S1 VSS sg13_lv_nmos ad=0.1598p pd=1.62u as=89.3f ps=0.85u w=0.47u l=0.16u
X8948 cml_tlatch_28.xtail.S1 CKB0_P cml_tlatch_28.xmux.xp.S1 VSS sg13_lv_nmos ad=89.3f pd=0.85u as=0.1598p ps=1.62u w=0.47u l=0.16u
X8949 MOT7_N MOT7_P cml_tlatch_20.xmux.xp.S1 VSS sg13_lv_nmos ad=56.9f pd=0.74u as=56.9f ps=0.74u w=0.17u l=0.17u
X8950 cml_tlatch_39.xmux.xn.S1 CKHA1_P cml_tlatch_39.xtail.S1 VSS sg13_lv_nmos ad=89.3f pd=0.85u as=89.3f ps=0.85u w=0.47u l=0.16u
X8951 cml_tlatch_70.xmux.xn.S1 cml_tlatch_70.INN MOT29_P VSS sg13_lv_nmos ad=63.19999f pd=0.74u as=63.19999f ps=0.74u w=0.26u l=0.38u
X8952 cml_tlatch_47.xmux.xn.S1 D3_N cml_tlatch_47.OUTP VSS sg13_lv_nmos ad=0.1082p pd=1.34u as=63.19999f ps=0.74u w=0.26u l=0.38u
X8953 cml_tlatch_44.xmux.xp.S1 B2_2_P B2_2_N VSS sg13_lv_nmos ad=0.1019p pd=1.34u as=56.9f ps=0.74u w=0.17u l=0.17u
X8954 cml_tlatch_6.xmux.xp.S1 MOT13_P MOT13_N VSS sg13_lv_nmos ad=56.9f pd=0.74u as=56.9f ps=0.74u w=0.17u l=0.17u
X8955 cml_tlatch_70.xmux.xn.S1 cml_tlatch_70.INN MOT29_P VSS sg13_lv_nmos ad=63.19999f pd=0.74u as=63.19999f ps=0.74u w=0.26u l=0.38u
X8956 cml_tlatch_29.OUTN D0_P cml_tlatch_29.xmux.xn.S1 VSS sg13_lv_nmos ad=63.19999f pd=0.74u as=63.19999f ps=0.74u w=0.26u l=0.38u
X8957 ENB0_P ENB_N cml_drv_2.xrtail.R1 VSS sg13_lv_nmos ad=56.2f pd=0.74u as=56.2f ps=0.74u w=0.16u l=0.19u
X8958 cml_tlatch_47.xmux.xn.S1 D3_N cml_tlatch_47.OUTP VSS sg13_lv_nmos ad=63.19999f pd=0.74u as=63.19999f ps=0.74u w=0.26u l=0.38u
X8959 cml_tlatch_10.xmux.xp.S1 B0_8_P B0_8_N VSS sg13_lv_nmos ad=56.9f pd=0.74u as=56.9f ps=0.74u w=0.17u l=0.17u
X8960 MOT14_N A1_2_P cml_tlatch_41.xmux.xn.S1 VSS sg13_lv_nmos ad=63.19999f pd=0.74u as=63.19999f ps=0.74u w=0.26u l=0.38u
X8961 cml_gate2_3.xrtail.R1 CKB1_N GA1_P VSS sg13_lv_nmos ad=0.1007p pd=0.91u as=0.1007p ps=0.91u w=0.53u l=0.13u
X8962 B3_2_P VDD VSS rppd l=5.17u w=1u
X8963 MOT7_P MOT7_N cml_tlatch_20.xmux.xp.S1 VSS sg13_lv_nmos ad=56.9f pd=0.74u as=56.9f ps=0.74u w=0.17u l=0.17u
X8964 cml_tlatch_38.xmux.xn.S1 D1_N cml_tlatch_38.OUTP VSS sg13_lv_nmos ad=63.19999f pd=0.74u as=63.19999f ps=0.74u w=0.26u l=0.38u
X8965 cml_tlatch_53.xtail.S1 CKA3_N cml_tlatch_53.xmux.xn.S1 VSS sg13_lv_nmos ad=89.3f pd=0.85u as=89.3f ps=0.85u w=0.47u l=0.16u
X8966 cml_tlatch_20.xtail.S1 CKHB0_P cml_tlatch_20.xmux.xn.S1 VSS sg13_lv_nmos ad=89.3f pd=0.85u as=89.3f ps=0.85u w=0.47u l=0.16u
X8967 cml_tlatch_63.xtail.S1 CKB3_N cml_tlatch_63.xmux.xp.S1 VSS sg13_lv_nmos ad=89.3f pd=0.85u as=89.3f ps=0.85u w=0.47u l=0.16u
X8968 cml_tlatch_21.xtail.S1 CKA1_P cml_tlatch_21.xmux.xp.S1 VSS sg13_lv_nmos ad=89.3f pd=0.85u as=89.3f ps=0.85u w=0.47u l=0.16u
X8969 cml_tlatch_73.xtail.S1 CKHB2_N cml_tlatch_73.xmux.xp.S1 VSS sg13_lv_nmos ad=89.3f pd=0.85u as=89.3f ps=0.85u w=0.47u l=0.16u
X8970 A3_2_N cml_tlatch_54.OUTP cml_tlatch_53.xmux.xn.S1 VSS sg13_lv_nmos ad=63.19999f pd=0.74u as=63.19999f ps=0.74u w=0.26u l=0.38u
X8971 cml_tlatch_93.xmux.xn.S1 J4_N J1_N VSS sg13_lv_nmos ad=63.19999f pd=0.74u as=63.19999f ps=0.74u w=0.26u l=0.38u
X8972 cml_tlatch_61.OUTN cml_tlatch_69.INP cml_tlatch_61.xmux.xn.S1 VSS sg13_lv_nmos ad=63.19999f pd=0.74u as=63.19999f ps=0.74u w=0.26u l=0.38u
X8973 cml_tlatch_11.xmux.xp.S1 cml_tlatch_11.OUTP cml_tlatch_11.OUTN VSS sg13_lv_nmos ad=56.9f pd=0.74u as=56.9f ps=0.74u w=0.17u l=0.17u
X8974 A2_8_N A2_8_P cml_tlatch_81.xmux.xp.S1 VSS sg13_lv_nmos ad=56.9f pd=0.74u as=56.9f ps=0.74u w=0.17u l=0.17u
X8975 B1_8_P B1_8_N cml_tlatch_12.xmux.xp.S1 VSS sg13_lv_nmos ad=56.9f pd=0.74u as=56.9f ps=0.74u w=0.17u l=0.17u
X8976 cml_tlatch_76.xmux.xp.S1 CKHB2_N cml_tlatch_76.xtail.S1 VSS sg13_lv_nmos ad=89.3f pd=0.85u as=89.3f ps=0.85u w=0.47u l=0.16u
X8977 stub_bi_49.BOTN stub_bi_55.BOTP cml_tlatch_80.xmux.xn.S1 VSS sg13_lv_nmos ad=63.19999f pd=0.74u as=63.19999f ps=0.74u w=0.26u l=0.38u
X8978 VSS hs_to_clk_2.sg13_lv_nmos_2HGZLP_0.G VSS VSS sg13_lv_nmos ad=3.706p pd=22.48u as=0 ps=0 w=10.9u l=1.38u
X8979 cml_tlatch_50.xmux.xp.S1 CKHA2_N cml_tlatch_50.xtail.S1 VSS sg13_lv_nmos ad=89.3f pd=0.85u as=89.3f ps=0.85u w=0.47u l=0.16u
X8980 cml_tlatch_79.xtail.S1 POLN VSS VSS sg13_lv_nmos ad=1.5637p pd=8.61u as=1.5637p ps=8.61u w=8.23u l=0.13u
X8981 cml_tlatch_40.xtail.S1 CKHA1_P cml_tlatch_40.xmux.xn.S1 VSS sg13_lv_nmos ad=0.1598p pd=1.62u as=89.3f ps=0.85u w=0.47u l=0.16u
X8982 cml_tlatch_16.OUTN cml_tlatch_16.OUTP cml_tlatch_16.xmux.xp.S1 VSS sg13_lv_nmos ad=56.9f pd=0.74u as=0.1019p ps=1.34u w=0.17u l=0.17u
X8983 VDD cml_tlatch_3.OUTN VSS rppd l=5.17u w=1u
X8984 cml_gate2_5.xrtail.R1 CKB3_N GA3_P VSS sg13_lv_nmos ad=0.1007p pd=0.91u as=0.1007p ps=0.91u w=0.53u l=0.13u
X8985 cml_tlatch_94.xtail.S1 CKB1_N cml_tlatch_94.xmux.xn.S1 VSS sg13_lv_nmos ad=0.1598p pd=1.62u as=89.3f ps=0.85u w=0.47u l=0.16u
X8986 cml_tlatch_42.xmux.xp.S1 cml_tlatch_56.INP cml_tlatch_56.INN VSS sg13_lv_nmos ad=56.9f pd=0.74u as=56.9f ps=0.74u w=0.17u l=0.17u
X8987 cml_tlatch_11.xmux.xp.S1 cml_tlatch_11.OUTN cml_tlatch_11.OUTP VSS sg13_lv_nmos ad=0.1019p pd=1.34u as=56.9f ps=0.74u w=0.17u l=0.17u
X8988 cml_tlatch_8.OUTP cml_tlatch_8.OUTN cml_tlatch_8.xmux.xp.S1 VSS sg13_lv_nmos ad=56.9f pd=0.74u as=56.9f ps=0.74u w=0.17u l=0.17u
X8989 cml_tlatch_57.xtail.S1 POLN VSS VSS sg13_lv_nmos ad=1.5637p pd=8.61u as=1.5637p ps=8.61u w=8.23u l=0.13u
X8990 cml_gate2_4.sg13_lv_nmos_FTPY57_0.D0 ENA1_P GA2_N VSS sg13_lv_nmos ad=0.1007p pd=0.91u as=0.1007p ps=0.91u w=0.53u l=0.13u
X8991 cml_tlatch_80.xmux.xn.S1 stub_bi_55.BOTN stub_bi_49.BOTP VSS sg13_lv_nmos ad=63.19999f pd=0.74u as=0.1082p ps=1.34u w=0.26u l=0.38u
X8992 cml_tlatch_89.INP cml_tlatch_89.INN cml_tlatch_55.xmux.xp.S1 VSS sg13_lv_nmos ad=56.9f pd=0.74u as=56.9f ps=0.74u w=0.17u l=0.17u
X8993 cml_tlatch_5.xtail.S1 CKHB1_N cml_tlatch_5.xmux.xp.S1 VSS sg13_lv_nmos ad=89.3f pd=0.85u as=89.3f ps=0.85u w=0.47u l=0.16u
X8994 cml_tlatch_97.xmux.xp.S1 MOT0_P MOT0_N VSS sg13_lv_nmos ad=56.9f pd=0.74u as=56.9f ps=0.74u w=0.17u l=0.17u
X8995 cml_tlatch_4.xmux.xp.S1 MOT9_P MOT9_N VSS sg13_lv_nmos ad=56.9f pd=0.74u as=56.9f ps=0.74u w=0.17u l=0.17u
X8996 cml_tlatch_15.xtail.S1 CKB1_P cml_tlatch_15.xmux.xn.S1 VSS sg13_lv_nmos ad=89.3f pd=0.85u as=89.3f ps=0.85u w=0.47u l=0.16u
X8997 cml_tlatch_58.xmux.xp.S1 CKHA3_N cml_tlatch_58.xtail.S1 VSS sg13_lv_nmos ad=89.3f pd=0.85u as=89.3f ps=0.85u w=0.47u l=0.16u
X8998 GB2_N ENB0_P cml_gate2_7.sg13_lv_nmos_FTPY57_0.D0 VSS sg13_lv_nmos ad=0.1007p pd=0.91u as=0.1007p ps=0.91u w=0.53u l=0.13u
X8999 cml_tlatch_52.OUTN cml_tlatch_52.OUTP cml_tlatch_52.xmux.xp.S1 VSS sg13_lv_nmos ad=56.9f pd=0.74u as=56.9f ps=0.74u w=0.17u l=0.17u
X9000 cml_tlatch_43.xtail.S1 CKB2_N cml_tlatch_43.xmux.xp.S1 VSS sg13_lv_nmos ad=89.3f pd=0.85u as=89.3f ps=0.85u w=0.47u l=0.16u
X9001 cml_tlatch_54.xmux.xp.S1 cml_tlatch_54.OUTN cml_tlatch_54.OUTP VSS sg13_lv_nmos ad=56.9f pd=0.74u as=56.9f ps=0.74u w=0.17u l=0.17u
X9002 B3_8_P B3_8_N cml_tlatch_60.xmux.xp.S1 VSS sg13_lv_nmos ad=56.9f pd=0.74u as=56.9f ps=0.74u w=0.17u l=0.17u
X9003 cml_tlatch_47.OUTP cml_tlatch_47.OUTN cml_tlatch_47.xmux.xp.S1 VSS sg13_lv_nmos ad=56.9f pd=0.74u as=56.9f ps=0.74u w=0.17u l=0.17u
X9004 cml_gate2_3.sg13_lv_nmos_FTPY57_0.D0 ENA0_P GA1_N VSS sg13_lv_nmos ad=0.1802p pd=1.74u as=0.1007p ps=0.91u w=0.53u l=0.13u
X9005 stub_bi_17.BOTN stub_bi_17.BOTP cml_tlatch_13.xmux.xp.S1 VSS sg13_lv_nmos ad=56.9f pd=0.74u as=56.9f ps=0.74u w=0.17u l=0.17u
X9006 VDD GB2_N VSS rppd l=7.42u w=1u
X9007 interco_bi_19.INN interco_bi_19.INP cml_tlatch_0.xmux.xp.S1 VSS sg13_lv_nmos ad=56.9f pd=0.74u as=56.9f ps=0.74u w=0.17u l=0.17u
X9008 MOT29_N MOT29_P cml_tlatch_70.xmux.xp.S1 VSS sg13_lv_nmos ad=56.9f pd=0.74u as=0.1019p ps=1.34u w=0.17u l=0.17u
X9009 cml_tlatch_80.xmux.xp.S1 stub_bi_49.BOTN stub_bi_49.BOTP VSS sg13_lv_nmos ad=56.9f pd=0.74u as=56.9f ps=0.74u w=0.17u l=0.17u
X9010 cml_tlatch_4.xtail.S1 CKHB1_N cml_tlatch_4.xmux.xp.S1 VSS sg13_lv_nmos ad=89.3f pd=0.85u as=89.3f ps=0.85u w=0.47u l=0.16u
X9011 B0_8_P cml_tlatch_11.OUTN cml_tlatch_10.xmux.xn.S1 VSS sg13_lv_nmos ad=63.19999f pd=0.74u as=63.19999f ps=0.74u w=0.26u l=0.38u
X9012 B0_2_N cml_tlatch_29.OUTP cml_tlatch_28.xmux.xn.S1 VSS sg13_lv_nmos ad=63.19999f pd=0.74u as=63.19999f ps=0.74u w=0.26u l=0.38u
X9013 cml_tlatch_50.xmux.xp.S1 MOT20_N MOT20_P VSS sg13_lv_nmos ad=56.9f pd=0.74u as=56.9f ps=0.74u w=0.17u l=0.17u
X9014 cml_tlatch_49.xmux.xp.S1 MOT18_P MOT18_N VSS sg13_lv_nmos ad=56.9f pd=0.74u as=56.9f ps=0.74u w=0.17u l=0.17u
X9015 cml_tlatch_68.xmux.xp.S1 MOT25_P MOT25_N VSS sg13_lv_nmos ad=56.9f pd=0.74u as=56.9f ps=0.74u w=0.17u l=0.17u
X9016 cml_tlatch_30.xmux.xp.S1 cml_tlatch_30.OUTP cml_tlatch_30.OUTN VSS sg13_lv_nmos ad=56.9f pd=0.74u as=56.9f ps=0.74u w=0.17u l=0.17u
X9017 cml_tlatch_7.xmux.xp.S1 CKHB1_N cml_tlatch_7.xtail.S1 VSS sg13_lv_nmos ad=89.3f pd=0.85u as=89.3f ps=0.85u w=0.47u l=0.16u
X9018 B2_8_P stub_bi_62.BOTP cml_tlatch_77.xmux.xn.S1 VSS sg13_lv_nmos ad=63.19999f pd=0.74u as=63.19999f ps=0.74u w=0.26u l=0.38u
X9019 cml_tlatch_16.OUTN cml_tlatch_16.OUTP cml_tlatch_16.xmux.xp.S1 VSS sg13_lv_nmos ad=56.9f pd=0.74u as=56.9f ps=0.74u w=0.17u l=0.17u
X9020 VSS hs_to_clk_1.sg13_lv_nmos_2HGZLP_0.G VSS VSS sg13_lv_nmos ad=2.071p pd=11.28u as=0 ps=0 w=10.9u l=1.38u
X9021 cml_tlatch_21.xtail.S1 CKA1_P cml_tlatch_21.xmux.xp.S1 VSS sg13_lv_nmos ad=89.3f pd=0.85u as=89.3f ps=0.85u w=0.47u l=0.16u
X9022 cml_tlatch_83.INP cml_tlatch_83.INN cml_tlatch_72.xmux.xp.S1 VSS sg13_lv_nmos ad=56.9f pd=0.74u as=56.9f ps=0.74u w=0.17u l=0.17u
X9023 B2_8_N VDD VSS rppd l=5.17u w=1u
X9024 cml_tlatch_39.xmux.xp.S1 MOT10_P MOT10_N VSS sg13_lv_nmos ad=56.9f pd=0.74u as=56.9f ps=0.74u w=0.17u l=0.17u
X9025 MOT1_P MOT1_N cml_tlatch_17.xmux.xp.S1 VSS sg13_lv_nmos ad=56.9f pd=0.74u as=56.9f ps=0.74u w=0.17u l=0.17u
X9026 cml_tlatch_88.xmux.xp.S1 stub_bi_55.BOTN stub_bi_55.BOTP VSS sg13_lv_nmos ad=56.9f pd=0.74u as=56.9f ps=0.74u w=0.17u l=0.17u
X9027 cml_tlatch_99.OUTN cml_tlatch_30.OUTP cml_tlatch_99.xmux.xn.S1 VSS sg13_lv_nmos ad=63.19999f pd=0.74u as=0.1082p ps=1.34u w=0.26u l=0.38u
X9028 cml_tlatch_53.xmux.xp.S1 A3_2_N A3_2_P VSS sg13_lv_nmos ad=56.9f pd=0.74u as=56.9f ps=0.74u w=0.17u l=0.17u
X9029 cml_tlatch_67.xtail.S1 CKA3_P cml_tlatch_67.xmux.xn.S1 VSS sg13_lv_nmos ad=89.3f pd=0.85u as=89.3f ps=0.85u w=0.47u l=0.16u
X9030 cml_tlatch_75.xmux.xn.S1 CKHB2_P cml_tlatch_75.xtail.S1 VSS sg13_lv_nmos ad=89.3f pd=0.85u as=89.3f ps=0.85u w=0.47u l=0.16u
X9031 cml_tlatch_29.OUTN cml_tlatch_29.OUTP cml_tlatch_29.xmux.xp.S1 VSS sg13_lv_nmos ad=56.9f pd=0.74u as=56.9f ps=0.74u w=0.17u l=0.17u
X9032 cml_tlatch_90.xmux.xn.S1 CLK_W_N J4_N VSS sg13_lv_nmos ad=63.19999f pd=0.74u as=63.19999f ps=0.74u w=0.26u l=0.38u
X9033 cml_tlatch_88.xmux.xn.S1 stub_bi_42.BOTP stub_bi_55.BOTN VSS sg13_lv_nmos ad=63.19999f pd=0.74u as=63.19999f ps=0.74u w=0.26u l=0.38u
X9034 cml_tlatch_38.OUTN cml_tlatch_38.OUTP cml_tlatch_38.xmux.xp.S1 VSS sg13_lv_nmos ad=56.9f pd=0.74u as=56.9f ps=0.74u w=0.17u l=0.17u
X9035 cml_tlatch_83.OUTN cml_tlatch_83.OUTP cml_tlatch_83.xmux.xp.S1 VSS sg13_lv_nmos ad=56.9f pd=0.74u as=56.9f ps=0.74u w=0.17u l=0.17u
X9036 cml_tlatch_79.xmux.xp.S1 stub_bi_63.BOTN stub_bi_63.BOTP VSS sg13_lv_nmos ad=56.9f pd=0.74u as=56.9f ps=0.74u w=0.17u l=0.17u
X9037 cml_tlatch_79.xmux.xp.S1 stub_bi_63.BOTP stub_bi_63.BOTN VSS sg13_lv_nmos ad=56.9f pd=0.74u as=56.9f ps=0.74u w=0.17u l=0.17u
X9038 MOT3_N MOT3_P cml_tlatch_18.xmux.xp.S1 VSS sg13_lv_nmos ad=56.9f pd=0.74u as=56.9f ps=0.74u w=0.17u l=0.17u
X9039 cml_tlatch_22.xtail.S1 CKA1_P cml_tlatch_22.xmux.xn.S1 VSS sg13_lv_nmos ad=89.3f pd=0.85u as=89.3f ps=0.85u w=0.47u l=0.16u
X9040 cml_tlatch_69.xmux.xn.S1 cml_tlatch_69.INP MOT27_N VSS sg13_lv_nmos ad=63.19999f pd=0.74u as=0.1082p ps=1.34u w=0.26u l=0.38u
X9041 ENA_P J1_N cml_gate2_9.sg13_lv_nmos_FTPY57_0.D0 VSS sg13_lv_nmos ad=0.1007p pd=0.91u as=0.1802p ps=1.74u w=0.53u l=0.13u
X9042 cml_tlatch_16.OUTN cml_tlatch_1.OUTP cml_tlatch_16.xmux.xn.S1 VSS sg13_lv_nmos ad=63.19999f pd=0.74u as=63.19999f ps=0.74u w=0.26u l=0.38u
X9043 cml_tlatch_41.xmux.xp.S1 CKHA1_N cml_tlatch_41.xtail.S1 VSS sg13_lv_nmos ad=89.3f pd=0.85u as=89.3f ps=0.85u w=0.47u l=0.16u
X9044 cml_tlatch_30.OUTN A0_2_P cml_tlatch_30.xmux.xn.S1 VSS sg13_lv_nmos ad=63.19999f pd=0.74u as=63.19999f ps=0.74u w=0.26u l=0.38u
X9045 cml_tlatch_22.xmux.xp.S1 cml_tlatch_22.OUTP cml_tlatch_22.OUTN VSS sg13_lv_nmos ad=56.9f pd=0.74u as=56.9f ps=0.74u w=0.17u l=0.17u
X9046 stub_bi_62.BOTP stub_bi_62.BOTN cml_tlatch_78.xmux.xp.S1 VSS sg13_lv_nmos ad=56.9f pd=0.74u as=56.9f ps=0.74u w=0.17u l=0.17u
X9047 B1_8_N stub_bi_17.BOTN cml_tlatch_12.xmux.xn.S1 VSS sg13_lv_nmos ad=63.19999f pd=0.74u as=63.19999f ps=0.74u w=0.26u l=0.38u
X9048 cml_tlatch_58.INN cml_tlatch_58.INP cml_tlatch_85.xmux.xp.S1 VSS sg13_lv_nmos ad=56.9f pd=0.74u as=0.1019p ps=1.34u w=0.17u l=0.17u
X9049 cml_tlatch_6.xmux.xp.S1 MOT13_N MOT13_P VSS sg13_lv_nmos ad=56.9f pd=0.74u as=56.9f ps=0.74u w=0.17u l=0.17u
X9050 cml_tlatch_50.xmux.xn.S1 CKHA2_P cml_tlatch_50.xtail.S1 VSS sg13_lv_nmos ad=89.3f pd=0.85u as=89.3f ps=0.85u w=0.47u l=0.16u
X9051 cml_tlatch_76.xmux.xp.S1 MOT23_N MOT23_P VSS sg13_lv_nmos ad=56.9f pd=0.74u as=56.9f ps=0.74u w=0.17u l=0.17u
X9052 MOT14_P MOT14_N cml_tlatch_41.xmux.xp.S1 VSS sg13_lv_nmos ad=56.9f pd=0.74u as=56.9f ps=0.74u w=0.17u l=0.17u
X9053 MOT8_N MOT8_P cml_tlatch_96.xmux.xp.S1 VSS sg13_lv_nmos ad=56.9f pd=0.74u as=56.9f ps=0.74u w=0.17u l=0.17u
X9054 A1_2_P A1_2_N cml_tlatch_37.xmux.xp.S1 VSS sg13_lv_nmos ad=56.9f pd=0.74u as=56.9f ps=0.74u w=0.17u l=0.17u
X9055 stub_bi_31.BOTN stub_bi_31.BOTP cml_tlatch_34.xmux.xp.S1 VSS sg13_lv_nmos ad=56.9f pd=0.74u as=56.9f ps=0.74u w=0.17u l=0.17u
X9056 cml_tlatch_55.xtail.S1 CKA2_P cml_tlatch_55.xmux.xn.S1 VSS sg13_lv_nmos ad=89.3f pd=0.85u as=89.3f ps=0.85u w=0.47u l=0.16u
X9057 cml_tlatch_60.xmux.xn.S1 cml_tlatch_61.OUTP B3_8_N VSS sg13_lv_nmos ad=63.19999f pd=0.74u as=63.19999f ps=0.74u w=0.26u l=0.38u
X9058 cml_tlatch_98.xmux.xp.S1 cml_tlatch_98.OUTN cml_tlatch_98.OUTP VSS sg13_lv_nmos ad=56.9f pd=0.74u as=56.9f ps=0.74u w=0.17u l=0.17u
X9059 GA0_N ENA0_P cml_gate2_2.sg13_lv_nmos_FTPY57_0.D0 VSS sg13_lv_nmos ad=0.1007p pd=0.91u as=0.1007p ps=0.91u w=0.53u l=0.13u
X9060 cml_tlatch_9.OUTP cml_tlatch_9.OUTN cml_tlatch_9.xmux.xp.S1 VSS sg13_lv_nmos ad=56.9f pd=0.74u as=56.9f ps=0.74u w=0.17u l=0.17u
X9061 cml_tlatch_13.xtail.S1 CKB1_P cml_tlatch_13.xmux.xn.S1 VSS sg13_lv_nmos ad=89.3f pd=0.85u as=89.3f ps=0.85u w=0.47u l=0.16u
X9062 cml_tlatch_45.xmux.xp.S1 cml_tlatch_45.OUTP cml_tlatch_45.OUTN VSS sg13_lv_nmos ad=56.9f pd=0.74u as=56.9f ps=0.74u w=0.17u l=0.17u
X9063 cml_tlatch_30.xtail.S1 CKA0_P cml_tlatch_30.xmux.xn.S1 VSS sg13_lv_nmos ad=89.3f pd=0.85u as=89.3f ps=0.85u w=0.47u l=0.16u
X9064 cml_tlatch_1.OUTN cml_tlatch_98.OUTP cml_tlatch_1.xmux.xn.S1 VSS sg13_lv_nmos ad=63.19999f pd=0.74u as=63.19999f ps=0.74u w=0.26u l=0.38u
X9065 cml_tlatch_82.xtail.S1 CKA2_P cml_tlatch_82.xmux.xn.S1 VSS sg13_lv_nmos ad=89.3f pd=0.85u as=89.3f ps=0.85u w=0.47u l=0.16u
X9066 cml_tlatch_58.xmux.xp.S1 MOT28_N MOT28_P VSS sg13_lv_nmos ad=56.9f pd=0.74u as=56.9f ps=0.74u w=0.17u l=0.17u
X9067 cml_tlatch_8.OUTP cml_tlatch_8.OUTN cml_tlatch_8.xmux.xp.S1 VSS sg13_lv_nmos ad=56.9f pd=0.74u as=56.9f ps=0.74u w=0.17u l=0.17u
X9068 ENB1_P ENB_N cml_drv_0.xrtail.R1 VSS sg13_lv_nmos ad=56.2f pd=0.74u as=56.2f ps=0.74u w=0.16u l=0.19u
X9069 cml_tlatch_10.xmux.xn.S1 CKB0_N cml_tlatch_10.xtail.S1 VSS sg13_lv_nmos ad=89.3f pd=0.85u as=89.3f ps=0.85u w=0.47u l=0.16u
X9070 MOT4_N cml_tlatch_99.OUTP cml_tlatch_25.xmux.xn.S1 VSS sg13_lv_nmos ad=63.19999f pd=0.74u as=63.19999f ps=0.74u w=0.26u l=0.38u
X9071 cml_tlatch_4.xmux.xp.S1 MOT9_P MOT9_N VSS sg13_lv_nmos ad=0.1019p pd=1.34u as=56.9f ps=0.74u w=0.17u l=0.17u
X9072 stub_bi_63.BOTN stub_bi_49.BOTP cml_tlatch_79.xmux.xn.S1 VSS sg13_lv_nmos ad=63.19999f pd=0.74u as=63.19999f ps=0.74u w=0.26u l=0.38u
X9073 cml_tlatch_43.xtail.S1 CKB2_P cml_tlatch_43.xmux.xn.S1 VSS sg13_lv_nmos ad=89.3f pd=0.85u as=89.3f ps=0.85u w=0.47u l=0.16u
X9074 cml_tlatch_0.xmux.xp.S1 interco_bi_19.INN interco_bi_19.INP VSS sg13_lv_nmos ad=56.9f pd=0.74u as=56.9f ps=0.74u w=0.17u l=0.17u
X9075 cml_tlatch_45.xmux.xp.S1 cml_tlatch_45.OUTP cml_tlatch_45.OUTN VSS sg13_lv_nmos ad=0.1019p pd=1.34u as=56.9f ps=0.74u w=0.17u l=0.17u
X9076 cml_tlatch_81.xmux.xp.S1 A2_8_N A2_8_P VSS sg13_lv_nmos ad=56.9f pd=0.74u as=56.9f ps=0.74u w=0.17u l=0.17u
X9077 CKHB2_P GB2_N cml_drvb_7.xrtail.R1 VSS sg13_lv_nmos ad=0.2618p pd=2.22u as=0.1463p ps=1.15u w=0.77u l=0.21u
X9078 MOT26_P cml_tlatch_57.INN cml_tlatch_57.xmux.xn.S1 VSS sg13_lv_nmos ad=63.19999f pd=0.74u as=63.19999f ps=0.74u w=0.26u l=0.38u
X9079 cml_tlatch_35.xtail.S1 CKA0_N cml_tlatch_35.xmux.xp.S1 VSS sg13_lv_nmos ad=89.3f pd=0.85u as=89.3f ps=0.85u w=0.47u l=0.16u
X9080 cml_tlatch_58.INP cml_tlatch_52.OUTN cml_tlatch_85.xmux.xn.S1 VSS sg13_lv_nmos ad=63.19999f pd=0.74u as=63.19999f ps=0.74u w=0.26u l=0.38u
X9081 cml_tlatch_73.xmux.xp.S1 CKHB2_N cml_tlatch_73.xtail.S1 VSS sg13_lv_nmos ad=89.3f pd=0.85u as=89.3f ps=0.85u w=0.47u l=0.16u
X9082 cml_tlatch_9.xmux.xp.S1 cml_tlatch_9.OUTP cml_tlatch_9.OUTN VSS sg13_lv_nmos ad=56.9f pd=0.74u as=56.9f ps=0.74u w=0.17u l=0.17u
X9083 cml_tlatch_3.xtail.S1 CKA0_N cml_tlatch_3.xmux.xp.S1 VSS sg13_lv_nmos ad=89.3f pd=0.85u as=89.3f ps=0.85u w=0.47u l=0.16u
X9084 cml_tlatch_85.xmux.xn.S1 cml_tlatch_52.OUTP cml_tlatch_58.INN VSS sg13_lv_nmos ad=63.19999f pd=0.74u as=63.19999f ps=0.74u w=0.26u l=0.38u
X9085 cml_tlatch_54.xmux.xp.S1 cml_tlatch_54.OUTP cml_tlatch_54.OUTN VSS sg13_lv_nmos ad=56.9f pd=0.74u as=56.9f ps=0.74u w=0.17u l=0.17u
X9086 MOT23_N MOT23_P cml_tlatch_76.xmux.xp.S1 VSS sg13_lv_nmos ad=56.9f pd=0.74u as=56.9f ps=0.74u w=0.17u l=0.17u
X9087 stub_bi_29.BOTP stub_bi_29.BOTN cml_tlatch_32.xmux.xp.S1 VSS sg13_lv_nmos ad=56.9f pd=0.74u as=56.9f ps=0.74u w=0.17u l=0.17u
X9088 cml_tlatch_47.OUTN D3_P cml_tlatch_47.xmux.xn.S1 VSS sg13_lv_nmos ad=63.19999f pd=0.74u as=63.19999f ps=0.74u w=0.26u l=0.38u
X9089 cml_tlatch_71.xmux.xp.S1 MOT31_P MOT31_N VSS sg13_lv_nmos ad=56.9f pd=0.74u as=56.9f ps=0.74u w=0.17u l=0.17u
X9090 cml_gate2_0.xrtail.R1 CKA1_P cml_gate2_0.sg13_lv_nmos_FTPY57_0.D0 VSS sg13_lv_nmos ad=0.1007p pd=0.91u as=0.1007p ps=0.91u w=0.53u l=0.13u
X9091 cml_tlatch_60.xtail.S1 CKB3_N cml_tlatch_60.xmux.xn.S1 VSS sg13_lv_nmos ad=89.3f pd=0.85u as=89.3f ps=0.85u w=0.47u l=0.16u
X9092 B0_2_N B0_2_P cml_tlatch_28.xmux.xp.S1 VSS sg13_lv_nmos ad=56.9f pd=0.74u as=56.9f ps=0.74u w=0.17u l=0.17u
X9093 cml_tlatch_40.xmux.xn.S1 CKHA1_P cml_tlatch_40.xtail.S1 VSS sg13_lv_nmos ad=89.3f pd=0.85u as=89.3f ps=0.85u w=0.47u l=0.16u
X9094 cml_tlatch_35.OUTP cml_tlatch_35.OUTN cml_tlatch_35.xmux.xp.S1 VSS sg13_lv_nmos ad=56.9f pd=0.74u as=56.9f ps=0.74u w=0.17u l=0.17u
X9095 cml_tlatch_20.xtail.S1 POLN VSS VSS sg13_lv_nmos ad=1.5637p pd=8.61u as=1.5637p ps=8.61u w=8.23u l=0.13u
X9096 cml_tlatch_36.xtail.S1 POLN VSS VSS sg13_lv_nmos ad=1.5637p pd=8.61u as=2.7982p ps=17.14u w=8.23u l=0.13u
X9097 MOT26_N MOT26_P cml_tlatch_57.xmux.xp.S1 VSS sg13_lv_nmos ad=56.9f pd=0.74u as=56.9f ps=0.74u w=0.17u l=0.17u
X9098 cml_tlatch_99.xmux.xp.S1 cml_tlatch_99.OUTP cml_tlatch_99.OUTN VSS sg13_lv_nmos ad=56.9f pd=0.74u as=56.9f ps=0.74u w=0.17u l=0.17u
X9099 B3_2_P cml_tlatch_47.OUTN cml_tlatch_46.xmux.xn.S1 VSS sg13_lv_nmos ad=63.19999f pd=0.74u as=63.19999f ps=0.74u w=0.26u l=0.38u
X9100 cml_tlatch_61.xtail.S1 POLN VSS VSS sg13_lv_nmos ad=1.5637p pd=8.61u as=1.5637p ps=8.61u w=8.23u l=0.13u
X9101 cml_tlatch_34.xmux.xp.S1 stub_bi_31.BOTN stub_bi_31.BOTP VSS sg13_lv_nmos ad=56.9f pd=0.74u as=56.9f ps=0.74u w=0.17u l=0.17u
X9102 cml_tlatch_68.xmux.xp.S1 CKHB3_N cml_tlatch_68.xtail.S1 VSS sg13_lv_nmos ad=89.3f pd=0.85u as=89.3f ps=0.85u w=0.47u l=0.16u
X9103 cml_tlatch_93.xmux.xp.S1 J1_P J1_N VSS sg13_lv_nmos ad=56.9f pd=0.74u as=56.9f ps=0.74u w=0.17u l=0.17u
X9104 cml_tlatch_81.xmux.xn.S1 cml_tlatch_82.OUTP A2_8_N VSS sg13_lv_nmos ad=63.19999f pd=0.74u as=63.19999f ps=0.74u w=0.26u l=0.38u
X9105 cml_tlatch_57.INP cml_tlatch_57.INN cml_tlatch_66.xmux.xp.S1 VSS sg13_lv_nmos ad=56.9f pd=0.74u as=56.9f ps=0.74u w=0.17u l=0.17u
X9106 cml_gate2_5.sg13_lv_nmos_FTPY57_0.D0 CKB3_P cml_gate2_5.xrtail.R1 VSS sg13_lv_nmos ad=0.1007p pd=0.91u as=0.1007p ps=0.91u w=0.53u l=0.13u
X9107 cml_tlatch_2.xmux.xp.S1 A0_8_N A0_8_P VSS sg13_lv_nmos ad=56.9f pd=0.74u as=56.9f ps=0.74u w=0.17u l=0.17u
X9108 cml_tlatch_39.xmux.xp.S1 MOT10_P MOT10_N VSS sg13_lv_nmos ad=56.9f pd=0.74u as=56.9f ps=0.74u w=0.17u l=0.17u
X9109 cml_tlatch_21.xmux.xp.S1 A1_8_P A1_8_N VSS sg13_lv_nmos ad=56.9f pd=0.74u as=56.9f ps=0.74u w=0.17u l=0.17u
X9110 cml_tlatch_71.xmux.xp.S1 MOT31_N MOT31_P VSS sg13_lv_nmos ad=56.9f pd=0.74u as=56.9f ps=0.74u w=0.17u l=0.17u
X9111 cml_tlatch_15.xmux.xn.S1 CKB1_P cml_tlatch_15.xtail.S1 VSS sg13_lv_nmos ad=89.3f pd=0.85u as=89.3f ps=0.85u w=0.47u l=0.16u
X9112 cml_gate2_6.xrtail.R1 CKA3_P cml_gate2_6.sg13_lv_nmos_FTPY57_0.D0 VSS sg13_lv_nmos ad=0.1007p pd=0.91u as=0.1007p ps=0.91u w=0.53u l=0.13u
X9113 cml_tlatch_22.xmux.xp.S1 cml_tlatch_22.OUTP cml_tlatch_22.OUTN VSS sg13_lv_nmos ad=56.9f pd=0.74u as=56.9f ps=0.74u w=0.17u l=0.17u
X9114 cml_tlatch_64.xmux.xp.S1 CKA3_P cml_tlatch_64.xtail.S1 VSS sg13_lv_nmos ad=0.1598p pd=1.62u as=89.3f ps=0.85u w=0.47u l=0.16u
X9115 cml_tlatch_11.xmux.xn.S1 cml_tlatch_16.OUTN cml_tlatch_11.OUTP VSS sg13_lv_nmos ad=63.19999f pd=0.74u as=63.19999f ps=0.74u w=0.26u l=0.38u
X9116 GB1_P CKA1_N cml_gate2_0.xrtail.R1 VSS sg13_lv_nmos ad=0.1007p pd=0.91u as=0.1802p ps=1.74u w=0.53u l=0.13u
X9117 MOT8_P MOT8_N cml_tlatch_96.xmux.xp.S1 VSS sg13_lv_nmos ad=56.9f pd=0.74u as=56.9f ps=0.74u w=0.17u l=0.17u
X9118 GA3_N ENA1_P cml_gate2_5.sg13_lv_nmos_FTPY57_0.D0 VSS sg13_lv_nmos ad=0.1007p pd=0.91u as=0.1007p ps=0.91u w=0.53u l=0.13u
X9119 cml_tlatch_73.xmux.xp.S1 MOT17_N MOT17_P VSS sg13_lv_nmos ad=56.9f pd=0.74u as=56.9f ps=0.74u w=0.17u l=0.17u
X9120 cml_tlatch_11.xmux.xn.S1 cml_tlatch_16.OUTN cml_tlatch_11.OUTP VSS sg13_lv_nmos ad=63.19999f pd=0.74u as=63.19999f ps=0.74u w=0.26u l=0.38u
X9121 cml_tlatch_41.xmux.xn.S1 CKHA1_P cml_tlatch_41.xtail.S1 VSS sg13_lv_nmos ad=89.3f pd=0.85u as=89.3f ps=0.85u w=0.47u l=0.16u
X9122 cml_tlatch_1.xmux.xp.S1 cml_tlatch_1.OUTN cml_tlatch_1.OUTP VSS sg13_lv_nmos ad=56.9f pd=0.74u as=56.9f ps=0.74u w=0.17u l=0.17u
X9123 cml_tlatch_36.xmux.xp.S1 cml_tlatch_95.INN cml_tlatch_95.INP VSS sg13_lv_nmos ad=56.9f pd=0.74u as=56.9f ps=0.74u w=0.17u l=0.17u
X9124 cml_tlatch_42.xmux.xn.S1 CKA2_P cml_tlatch_42.xtail.S1 VSS sg13_lv_nmos ad=89.3f pd=0.85u as=0.1598p ps=1.62u w=0.47u l=0.16u
X9125 VSS POLN cml_tlatch_7.xtail.S1 VSS sg13_lv_nmos ad=2.7982p pd=17.14u as=1.5637p ps=8.61u w=8.23u l=0.13u
X9126 GB1_P ENB1_N cml_gate2_0.sg13_lv_nmos_FTPY57_0.D0 VSS sg13_lv_nmos ad=0.1007p pd=0.91u as=0.1007p ps=0.91u w=0.53u l=0.13u
X9127 cml_tlatch_22.xmux.xp.S1 cml_tlatch_22.OUTP cml_tlatch_22.OUTN VSS sg13_lv_nmos ad=56.9f pd=0.74u as=56.9f ps=0.74u w=0.17u l=0.17u
X9128 cml_tlatch_67.OUTP cml_tlatch_67.OUTN cml_tlatch_67.xmux.xp.S1 VSS sg13_lv_nmos ad=56.9f pd=0.74u as=56.9f ps=0.74u w=0.17u l=0.17u
X9129 cml_tlatch_23.xmux.xp.S1 cml_tlatch_39.INP cml_tlatch_39.INN VSS sg13_lv_nmos ad=56.9f pd=0.74u as=56.9f ps=0.74u w=0.17u l=0.17u
X9130 cml_tlatch_20.xtail.S1 CKHB0_P cml_tlatch_20.xmux.xn.S1 VSS sg13_lv_nmos ad=89.3f pd=0.85u as=89.3f ps=0.85u w=0.47u l=0.16u
X9131 VDD GB0_P VSS rppd l=7.42u w=1u
X9132 B3_2_N B3_2_P cml_tlatch_46.xmux.xp.S1 VSS sg13_lv_nmos ad=56.9f pd=0.74u as=56.9f ps=0.74u w=0.17u l=0.17u
X9133 CKHB3_N VDD VSS rppd l=13.09u w=1u
X9134 cml_tlatch_56.xmux.xp.S1 A2_2_P A2_2_N VSS sg13_lv_nmos ad=56.9f pd=0.74u as=56.9f ps=0.74u w=0.17u l=0.17u
X9135 MOT24_P MOT24_N cml_tlatch_86.xmux.xp.S1 VSS sg13_lv_nmos ad=56.9f pd=0.74u as=56.9f ps=0.74u w=0.17u l=0.17u
X9136 cml_tlatch_0.xtail.S1 CKA1_N cml_tlatch_0.xmux.xp.S1 VSS sg13_lv_nmos ad=89.3f pd=0.85u as=89.3f ps=0.85u w=0.47u l=0.16u
X9137 cml_tlatch_94.xmux.xn.S1 stub_bi_29.BOTN cml_tlatch_6.INN VSS sg13_lv_nmos ad=63.19999f pd=0.74u as=0.1082p ps=1.34u w=0.26u l=0.38u
X9138 ENA1_P ENA_N cml_drv_1.xrtail.R1 VSS sg13_lv_nmos ad=0.1012p pd=1.34u as=56.2f ps=0.74u w=0.16u l=0.19u
X9139 cml_tlatch_98.xmux.xp.S1 cml_tlatch_98.OUTN cml_tlatch_98.OUTP VSS sg13_lv_nmos ad=56.9f pd=0.74u as=56.9f ps=0.74u w=0.17u l=0.17u
X9140 cml_tlatch_0.xmux.xp.S1 interco_bi_19.INN interco_bi_19.INP VSS sg13_lv_nmos ad=56.9f pd=0.74u as=56.9f ps=0.74u w=0.17u l=0.17u
X9141 cml_tlatch_65.OUTP cml_tlatch_57.INN cml_tlatch_65.xmux.xn.S1 VSS sg13_lv_nmos ad=63.19999f pd=0.74u as=63.19999f ps=0.74u w=0.26u l=0.38u
X9142 stub_bi_19.BOTN stub_bi_19.BOTP cml_tlatch_15.xmux.xp.S1 VSS sg13_lv_nmos ad=56.9f pd=0.74u as=56.9f ps=0.74u w=0.17u l=0.17u
X9143 cml_tlatch_42.xmux.xn.S1 D2_N cml_tlatch_56.INP VSS sg13_lv_nmos ad=63.19999f pd=0.74u as=63.19999f ps=0.74u w=0.26u l=0.38u
X9144 cml_tlatch_6.INN cml_tlatch_6.INP cml_tlatch_94.xmux.xp.S1 VSS sg13_lv_nmos ad=56.9f pd=0.74u as=56.9f ps=0.74u w=0.17u l=0.17u
X9145 cml_tlatch_88.xmux.xp.S1 CKB2_P cml_tlatch_88.xtail.S1 VSS sg13_lv_nmos ad=89.3f pd=0.85u as=89.3f ps=0.85u w=0.47u l=0.16u
X9146 cml_tlatch_94.xtail.S1 CKB1_N cml_tlatch_94.xmux.xn.S1 VSS sg13_lv_nmos ad=89.3f pd=0.85u as=89.3f ps=0.85u w=0.47u l=0.16u
X9147 cml_tlatch_46.xtail.S1 CKB3_N cml_tlatch_46.xmux.xn.S1 VSS sg13_lv_nmos ad=89.3f pd=0.85u as=89.3f ps=0.85u w=0.47u l=0.16u
X9148 cml_tlatch_63.xmux.xp.S1 cml_tlatch_63.OUTP cml_tlatch_63.OUTN VSS sg13_lv_nmos ad=56.9f pd=0.74u as=56.9f ps=0.74u w=0.17u l=0.17u
X9149 cml_tlatch_56.xmux.xp.S1 CKA2_P cml_tlatch_56.xtail.S1 VSS sg13_lv_nmos ad=89.3f pd=0.85u as=89.3f ps=0.85u w=0.47u l=0.16u
X9150 MOT22_N MOT22_P cml_tlatch_51.xmux.xp.S1 VSS sg13_lv_nmos ad=56.9f pd=0.74u as=56.9f ps=0.74u w=0.17u l=0.17u
X9151 cml_tlatch_15.xtail.S1 CKB1_N cml_tlatch_15.xmux.xp.S1 VSS sg13_lv_nmos ad=89.3f pd=0.85u as=89.3f ps=0.85u w=0.47u l=0.16u
X9152 cml_tlatch_2.xmux.xp.S1 A0_8_P A0_8_N VSS sg13_lv_nmos ad=56.9f pd=0.74u as=56.9f ps=0.74u w=0.17u l=0.17u
X9153 cml_tlatch_8.OUTN cml_tlatch_8.OUTP cml_tlatch_8.xmux.xp.S1 VSS sg13_lv_nmos ad=56.9f pd=0.74u as=0.1019p ps=1.34u w=0.17u l=0.17u
X9154 VSS hs_to_clk_1.sg13_lv_nmos_2HGZLP_0.G VSS VSS sg13_lv_nmos ad=2.071p pd=11.28u as=0 ps=0 w=10.9u l=1.38u
X9155 cml_tlatch_58.xmux.xp.S1 CKHA3_N cml_tlatch_58.xtail.S1 VSS sg13_lv_nmos ad=89.3f pd=0.85u as=89.3f ps=0.85u w=0.47u l=0.16u
X9156 cml_gate2_8.xrtail.R1 NS1_N ENB_P VSS sg13_lv_nmos ad=0.1007p pd=0.91u as=0.1007p ps=0.91u w=0.53u l=0.13u
X9157 B2_8_P B2_8_N cml_tlatch_77.xmux.xp.S1 VSS sg13_lv_nmos ad=56.9f pd=0.74u as=56.9f ps=0.74u w=0.17u l=0.17u
X9158 cml_tlatch_29.xmux.xn.S1 D0_P cml_tlatch_29.OUTN VSS sg13_lv_nmos ad=63.19999f pd=0.74u as=63.19999f ps=0.74u w=0.26u l=0.38u
X9159 cml_tlatch_7.xmux.xn.S1 B1_2_P MOT15_N VSS sg13_lv_nmos ad=63.19999f pd=0.74u as=63.19999f ps=0.74u w=0.26u l=0.38u
X9160 interco_bi_19.INP cml_tlatch_40.INN cml_tlatch_0.xmux.xn.S1 VSS sg13_lv_nmos ad=63.19999f pd=0.74u as=63.19999f ps=0.74u w=0.26u l=0.38u
X9161 VSS POLN cml_tlatch_44.xtail.S1 VSS sg13_lv_nmos ad=1.5637p pd=8.61u as=1.5637p ps=8.61u w=8.23u l=0.13u
X9162 cml_tlatch_91.xmux.xp.S1 CKJ_N cml_tlatch_91.xtail.S1 VSS sg13_lv_nmos ad=89.3f pd=0.85u as=89.3f ps=0.85u w=0.47u l=0.16u
X9163 cml_tlatch_82.OUTN cml_tlatch_83.OUTP cml_tlatch_82.xmux.xn.S1 VSS sg13_lv_nmos ad=63.19999f pd=0.74u as=63.19999f ps=0.74u w=0.26u l=0.38u
X9164 cml_tlatch_11.OUTP cml_tlatch_11.OUTN cml_tlatch_11.xmux.xp.S1 VSS sg13_lv_nmos ad=56.9f pd=0.74u as=56.9f ps=0.74u w=0.17u l=0.17u
X9165 VDD hs_to_clk_8.sg13_lv_nmos_2HGZLP_0.G VSS rppd l=0.68u w=1u
X9166 cml_tlatch_1.OUTN cml_tlatch_1.OUTP cml_tlatch_1.xmux.xp.S1 VSS sg13_lv_nmos ad=56.9f pd=0.74u as=0.1019p ps=1.34u w=0.17u l=0.17u
X9167 cml_tlatch_69.xmux.xn.S1 CKHB3_P cml_tlatch_69.xtail.S1 VSS sg13_lv_nmos ad=89.3f pd=0.85u as=89.3f ps=0.85u w=0.47u l=0.16u
X9168 CKA1_N CK_N hs_to_clk_3.D2 VSS sg13_lv_nmos ad=0.408p pd=3.08u as=0.228p ps=1.58u w=1.2u l=0.2u
X9169 VSS POLN cml_tlatch_78.xtail.S1 VSS sg13_lv_nmos ad=2.7982p pd=17.14u as=1.5637p ps=8.61u w=8.23u l=0.13u
X9170 cml_tlatch_3.xmux.xp.S1 cml_tlatch_3.OUTP cml_tlatch_3.OUTN VSS sg13_lv_nmos ad=56.9f pd=0.74u as=56.9f ps=0.74u w=0.17u l=0.17u
X9171 cml_gate2_8.sg13_lv_nmos_FTPY57_0.D0 J2_N ENB_P VSS sg13_lv_nmos ad=0.1007p pd=0.91u as=0.1007p ps=0.91u w=0.53u l=0.13u
X9172 cml_tlatch_68.xmux.xp.S1 MOT25_N MOT25_P VSS sg13_lv_nmos ad=56.9f pd=0.74u as=56.9f ps=0.74u w=0.17u l=0.17u
X9173 MOT11_N cml_tlatch_5.INP cml_tlatch_5.xmux.xn.S1 VSS sg13_lv_nmos ad=63.19999f pd=0.74u as=63.19999f ps=0.74u w=0.26u l=0.38u
X9174 cml_tlatch_27.xmux.xp.S1 cml_tlatch_27.OUTN cml_tlatch_27.OUTP VSS sg13_lv_nmos ad=56.9f pd=0.74u as=56.9f ps=0.74u w=0.17u l=0.17u
X9175 cml_tlatch_17.xtail.S1 POLN VSS VSS sg13_lv_nmos ad=1.5637p pd=8.61u as=2.7982p ps=17.14u w=8.23u l=0.13u
X9176 cml_tlatch_47.OUTP VDD VSS rppd l=5.17u w=1u
X9177 MOT5_N MOT5_P cml_tlatch_19.xmux.xp.S1 VSS sg13_lv_nmos ad=56.9f pd=0.74u as=56.9f ps=0.74u w=0.17u l=0.17u
X9178 cml_tlatch_7.xmux.xp.S1 CKHB1_N cml_tlatch_7.xtail.S1 VSS sg13_lv_nmos ad=89.3f pd=0.85u as=89.3f ps=0.85u w=0.47u l=0.16u
X9179 cml_tlatch_22.OUTP cml_tlatch_22.OUTN cml_tlatch_22.xmux.xp.S1 VSS sg13_lv_nmos ad=56.9f pd=0.74u as=56.9f ps=0.74u w=0.17u l=0.17u
X9180 cml_tlatch_54.xtail.S1 CKA3_P cml_tlatch_54.xmux.xn.S1 VSS sg13_lv_nmos ad=89.3f pd=0.85u as=89.3f ps=0.85u w=0.47u l=0.16u
X9181 MOT11_N cml_tlatch_5.INP cml_tlatch_5.xmux.xn.S1 VSS sg13_lv_nmos ad=63.19999f pd=0.74u as=63.19999f ps=0.74u w=0.26u l=0.38u
X9182 cml_tlatch_57.INP cml_tlatch_57.INN cml_tlatch_66.xmux.xp.S1 VSS sg13_lv_nmos ad=56.9f pd=0.74u as=56.9f ps=0.74u w=0.17u l=0.17u
X9183 cml_tlatch_57.INN cml_tlatch_57.INP cml_tlatch_66.xmux.xp.S1 VSS sg13_lv_nmos ad=56.9f pd=0.74u as=56.9f ps=0.74u w=0.17u l=0.17u
X9184 cml_tlatch_93.xmux.xp.S1 J1_P J1_N VSS sg13_lv_nmos ad=56.9f pd=0.74u as=56.9f ps=0.74u w=0.17u l=0.17u
X9185 cml_tlatch_90.xmux.xp.S1 J4_N J4_P VSS sg13_lv_nmos ad=56.9f pd=0.74u as=56.9f ps=0.74u w=0.17u l=0.17u
X9186 cml_tlatch_62.xmux.xp.S1 cml_tlatch_69.INN cml_tlatch_69.INP VSS sg13_lv_nmos ad=56.9f pd=0.74u as=56.9f ps=0.74u w=0.17u l=0.17u
X9187 cml_tlatch_85.xtail.S1 CKA3_N cml_tlatch_85.xmux.xn.S1 VSS sg13_lv_nmos ad=89.3f pd=0.85u as=89.3f ps=0.85u w=0.47u l=0.16u
X9188 MOT19_N MOT19_P cml_tlatch_74.xmux.xp.S1 VSS sg13_lv_nmos ad=56.9f pd=0.74u as=56.9f ps=0.74u w=0.17u l=0.17u
X9189 MOT14_P A1_2_N cml_tlatch_41.xmux.xn.S1 VSS sg13_lv_nmos ad=63.19999f pd=0.74u as=63.19999f ps=0.74u w=0.26u l=0.38u
X9190 cml_gate2_3.xrtail.R1 VSS VSS rppd l=4.86u w=1u
X9191 cml_tlatch_69.xmux.xp.S1 MOT27_P MOT27_N VSS sg13_lv_nmos ad=56.9f pd=0.74u as=56.9f ps=0.74u w=0.17u l=0.17u
X9192 cml_tlatch_2.xmux.xp.S1 A0_8_N A0_8_P VSS sg13_lv_nmos ad=0.1019p pd=1.34u as=56.9f ps=0.74u w=0.17u l=0.17u
X9193 VSS POLN cml_tlatch_4.xtail.S1 VSS sg13_lv_nmos ad=2.7982p pd=17.14u as=1.5637p ps=8.61u w=8.23u l=0.13u
X9194 stub_bi_42.BOTP stub_bi_42.BOTN cml_tlatch_43.xmux.xp.S1 VSS sg13_lv_nmos ad=56.9f pd=0.74u as=56.9f ps=0.74u w=0.17u l=0.17u
X9195 cml_tlatch_16.OUTN cml_tlatch_1.OUTP cml_tlatch_16.xmux.xn.S1 VSS sg13_lv_nmos ad=63.19999f pd=0.74u as=63.19999f ps=0.74u w=0.26u l=0.38u
X9196 cml_tlatch_5.INP cml_tlatch_5.INN cml_tlatch_14.xmux.xp.S1 VSS sg13_lv_nmos ad=56.9f pd=0.74u as=56.9f ps=0.74u w=0.17u l=0.17u
X9197 cml_tlatch_72.xmux.xp.S1 CKA2_N cml_tlatch_72.xtail.S1 VSS sg13_lv_nmos ad=89.3f pd=0.85u as=89.3f ps=0.85u w=0.47u l=0.16u
X9198 J4_N J4_P cml_tlatch_90.xmux.xp.S1 VSS sg13_lv_nmos ad=56.9f pd=0.74u as=56.9f ps=0.74u w=0.17u l=0.17u
X9199 ENB0_P ENB_N cml_drv_2.xrtail.R1 VSS sg13_lv_nmos ad=56.2f pd=0.74u as=0.1012p ps=1.34u w=0.16u l=0.19u
X9200 cml_tlatch_65.OUTP cml_tlatch_65.OUTN cml_tlatch_65.xmux.xp.S1 VSS sg13_lv_nmos ad=56.9f pd=0.74u as=56.9f ps=0.74u w=0.17u l=0.17u
X9201 ENA0_N ENA_P cml_drv_3.xrtail.R1 VSS sg13_lv_nmos ad=56.2f pd=0.74u as=56.2f ps=0.74u w=0.16u l=0.19u
X9202 cml_tlatch_57.xtail.S1 CKHA3_P cml_tlatch_57.xmux.xn.S1 VSS sg13_lv_nmos ad=89.3f pd=0.85u as=0.1598p ps=1.62u w=0.47u l=0.16u
X9203 cml_tlatch_1.OUTN cml_tlatch_1.OUTP cml_tlatch_1.xmux.xp.S1 VSS sg13_lv_nmos ad=56.9f pd=0.74u as=56.9f ps=0.74u w=0.17u l=0.17u
X9204 cml_tlatch_35.xmux.xn.S1 D0_N cml_tlatch_35.OUTP VSS sg13_lv_nmos ad=63.19999f pd=0.74u as=63.19999f ps=0.74u w=0.26u l=0.38u
X9205 J1_P J1_N cml_tlatch_93.xmux.xp.S1 VSS sg13_lv_nmos ad=56.9f pd=0.74u as=56.9f ps=0.74u w=0.17u l=0.17u
X9206 cml_tlatch_89.xmux.xp.S1 cml_tlatch_89.OUTP cml_tlatch_89.OUTN VSS sg13_lv_nmos ad=56.9f pd=0.74u as=56.9f ps=0.74u w=0.17u l=0.17u
X9207 cml_tlatch_60.xmux.xn.S1 CKB3_N cml_tlatch_60.xtail.S1 VSS sg13_lv_nmos ad=89.3f pd=0.85u as=89.3f ps=0.85u w=0.47u l=0.16u
X9208 cml_tlatch_39.INP interco_bi_19.INN cml_tlatch_23.xmux.xn.S1 VSS sg13_lv_nmos ad=0.1082p pd=1.34u as=63.19999f ps=0.74u w=0.26u l=0.38u
X9209 cml_tlatch_56.xmux.xp.S1 A2_2_P A2_2_N VSS sg13_lv_nmos ad=56.9f pd=0.74u as=56.9f ps=0.74u w=0.17u l=0.17u
X9210 cml_tlatch_94.xmux.xp.S1 cml_tlatch_6.INN cml_tlatch_6.INP VSS sg13_lv_nmos ad=56.9f pd=0.74u as=56.9f ps=0.74u w=0.17u l=0.17u
X9211 cml_tlatch_95.INP A1_2_N cml_tlatch_36.xmux.xn.S1 VSS sg13_lv_nmos ad=63.19999f pd=0.74u as=0.1082p ps=1.34u w=0.26u l=0.38u
X9212 cml_tlatch_41.xmux.xp.S1 MOT14_P MOT14_N VSS sg13_lv_nmos ad=56.9f pd=0.74u as=56.9f ps=0.74u w=0.17u l=0.17u
X9213 MOT19_P stub_bi_63.BOTP cml_tlatch_74.xmux.xn.S1 VSS sg13_lv_nmos ad=63.19999f pd=0.74u as=63.19999f ps=0.74u w=0.26u l=0.38u
X9214 cml_tlatch_89.xtail.S1 POLN VSS VSS sg13_lv_nmos ad=1.5637p pd=8.61u as=2.7982p ps=17.14u w=8.23u l=0.13u
X9215 cml_tlatch_98.xtail.S1 CKB0_N cml_tlatch_98.xmux.xn.S1 VSS sg13_lv_nmos ad=89.3f pd=0.85u as=89.3f ps=0.85u w=0.47u l=0.16u
X9216 GA1_N ENA0_P cml_gate2_3.sg13_lv_nmos_FTPY57_0.D0 VSS sg13_lv_nmos ad=0.1007p pd=0.91u as=0.1007p ps=0.91u w=0.53u l=0.13u
X9217 cml_tlatch_77.xmux.xn.S1 stub_bi_62.BOTP B2_8_P VSS sg13_lv_nmos ad=63.19999f pd=0.74u as=63.19999f ps=0.74u w=0.26u l=0.38u
X9218 cml_tlatch_36.xmux.xp.S1 CKA1_N cml_tlatch_36.xtail.S1 VSS sg13_lv_nmos ad=89.3f pd=0.85u as=89.3f ps=0.85u w=0.47u l=0.16u
X9219 cml_tlatch_13.xtail.S1 CKB1_P cml_tlatch_13.xmux.xn.S1 VSS sg13_lv_nmos ad=89.3f pd=0.85u as=89.3f ps=0.85u w=0.47u l=0.16u
X9220 cml_tlatch_35.OUTN cml_tlatch_35.OUTP cml_tlatch_35.xmux.xp.S1 VSS sg13_lv_nmos ad=56.9f pd=0.74u as=56.9f ps=0.74u w=0.17u l=0.17u
X9221 cml_tlatch_22.xmux.xp.S1 cml_tlatch_22.OUTN cml_tlatch_22.OUTP VSS sg13_lv_nmos ad=0.1019p pd=1.34u as=56.9f ps=0.74u w=0.17u l=0.17u
X9222 cml_tlatch_33.xtail.S1 POLN VSS VSS sg13_lv_nmos ad=1.5637p pd=8.61u as=1.5637p ps=8.61u w=8.23u l=0.13u
X9223 VSS hs_to_clk_2.sg13_lv_nmos_2HGZLP_0.G VSS VSS sg13_lv_nmos ad=2.071p pd=11.28u as=0 ps=0 w=10.9u l=1.38u
X9224 cml_tlatch_81.xmux.xp.S1 A2_8_P A2_8_N VSS sg13_lv_nmos ad=56.9f pd=0.74u as=56.9f ps=0.74u w=0.17u l=0.17u
X9225 cml_tlatch_38.OUTP cml_tlatch_38.OUTN cml_tlatch_38.xmux.xp.S1 VSS sg13_lv_nmos ad=56.9f pd=0.74u as=56.9f ps=0.74u w=0.17u l=0.17u
X9226 cml_tlatch_2.xmux.xp.S1 A0_8_P A0_8_N VSS sg13_lv_nmos ad=56.9f pd=0.74u as=56.9f ps=0.74u w=0.17u l=0.17u
X9227 cml_tlatch_79.xmux.xn.S1 CKB2_N cml_tlatch_79.xtail.S1 VSS sg13_lv_nmos ad=89.3f pd=0.85u as=89.3f ps=0.85u w=0.47u l=0.16u
X9228 MOT31_N VDD VSS rppd l=5.17u w=1u
X9229 B2_2_P B2_2_N cml_tlatch_44.xmux.xp.S1 VSS sg13_lv_nmos ad=56.9f pd=0.74u as=56.9f ps=0.74u w=0.17u l=0.17u
X9230 VDD MOT5_N VSS rppd l=5.17u w=1u
X9231 cml_tlatch_38.xtail.S1 CKA1_N cml_tlatch_38.xmux.xp.S1 VSS sg13_lv_nmos ad=89.3f pd=0.85u as=89.3f ps=0.85u w=0.47u l=0.16u
X9232 cml_tlatch_56.INN cml_tlatch_56.INP cml_tlatch_42.xmux.xp.S1 VSS sg13_lv_nmos ad=56.9f pd=0.74u as=56.9f ps=0.74u w=0.17u l=0.17u
X9233 cml_tlatch_11.OUTP cml_tlatch_11.OUTN cml_tlatch_11.xmux.xp.S1 VSS sg13_lv_nmos ad=56.9f pd=0.74u as=56.9f ps=0.74u w=0.17u l=0.17u
X9234 cml_tlatch_57.INN cml_tlatch_67.OUTP cml_tlatch_66.xmux.xn.S1 VSS sg13_lv_nmos ad=63.19999f pd=0.74u as=63.19999f ps=0.74u w=0.26u l=0.38u
X9235 cml_tlatch_20.xmux.xn.S1 CKHB0_P cml_tlatch_20.xtail.S1 VSS sg13_lv_nmos ad=89.3f pd=0.85u as=0.1598p ps=1.62u w=0.47u l=0.16u
X9236 cml_tlatch_31.xmux.xp.S1 A0_2_N A0_2_P VSS sg13_lv_nmos ad=56.9f pd=0.74u as=56.9f ps=0.74u w=0.17u l=0.17u
X9237 VSS hs_to_clk_4.sg13_lv_nmos_2HGZLP_0.G VSS VSS sg13_lv_nmos ad=2.071p pd=11.28u as=0 ps=0 w=10.9u l=1.38u
X9238 cml_tlatch_31.xtail.S1 CKA0_N cml_tlatch_31.xmux.xn.S1 VSS sg13_lv_nmos ad=89.3f pd=0.85u as=89.3f ps=0.85u w=0.47u l=0.16u
X9239 cml_tlatch_70.xtail.S1 CKHB3_P cml_tlatch_70.xmux.xn.S1 VSS sg13_lv_nmos ad=89.3f pd=0.85u as=89.3f ps=0.85u w=0.47u l=0.16u
X9240 cml_tlatch_55.xmux.xp.S1 cml_tlatch_89.INN cml_tlatch_89.INP VSS sg13_lv_nmos ad=56.9f pd=0.74u as=56.9f ps=0.74u w=0.17u l=0.17u
X9241 MOT0_N MOT0_P cml_tlatch_97.xmux.xp.S1 VSS sg13_lv_nmos ad=56.9f pd=0.74u as=56.9f ps=0.74u w=0.17u l=0.17u
X9242 MOT9_N MOT9_P cml_tlatch_4.xmux.xp.S1 VSS sg13_lv_nmos ad=56.9f pd=0.74u as=56.9f ps=0.74u w=0.17u l=0.17u
X9243 cml_tlatch_3.xmux.xn.S1 cml_tlatch_8.OUTP cml_tlatch_3.OUTN VSS sg13_lv_nmos ad=63.19999f pd=0.74u as=63.19999f ps=0.74u w=0.26u l=0.38u
X9244 VSS POLN cml_tlatch_24.xtail.S1 VSS sg13_lv_nmos ad=2.7982p pd=17.14u as=1.5637p ps=8.61u w=8.23u l=0.13u
X9245 cml_tlatch_52.xmux.xp.S1 cml_tlatch_52.OUTP cml_tlatch_52.OUTN VSS sg13_lv_nmos ad=56.9f pd=0.74u as=56.9f ps=0.74u w=0.17u l=0.17u
X9246 NS1_P J4_P cml_drvb_8.xrtail.R1 VSS sg13_lv_nmos ad=0.2618p pd=2.22u as=0.1463p ps=1.15u w=0.77u l=0.21u
X9247 cml_tlatch_40.xmux.xn.S1 CKHA1_P cml_tlatch_40.xtail.S1 VSS sg13_lv_nmos ad=89.3f pd=0.85u as=89.3f ps=0.85u w=0.47u l=0.16u
X9248 cml_tlatch_60.xmux.xp.S1 B3_8_N B3_8_P VSS sg13_lv_nmos ad=56.9f pd=0.74u as=56.9f ps=0.74u w=0.17u l=0.17u
X9249 cml_tlatch_54.OUTP cml_tlatch_54.OUTN cml_tlatch_54.xmux.xp.S1 VSS sg13_lv_nmos ad=56.9f pd=0.74u as=56.9f ps=0.74u w=0.17u l=0.17u
X9250 cml_tlatch_94.xmux.xn.S1 CKB1_N cml_tlatch_94.xtail.S1 VSS sg13_lv_nmos ad=89.3f pd=0.85u as=89.3f ps=0.85u w=0.47u l=0.16u
X9251 cml_tlatch_46.xmux.xn.S1 CKB3_N cml_tlatch_46.xtail.S1 VSS sg13_lv_nmos ad=89.3f pd=0.85u as=89.3f ps=0.85u w=0.47u l=0.16u
X9252 cml_gate2_4.xrtail.R1 CKB2_P cml_gate2_4.sg13_lv_nmos_FTPY57_0.D0 VSS sg13_lv_nmos ad=0.1007p pd=0.91u as=0.1007p ps=0.91u w=0.53u l=0.13u
X9253 cml_tlatch_73.xmux.xn.S1 B2_8_N MOT17_P VSS sg13_lv_nmos ad=63.19999f pd=0.74u as=63.19999f ps=0.74u w=0.26u l=0.38u
X9254 cml_tlatch_51.xmux.xp.S1 MOT22_N MOT22_P VSS sg13_lv_nmos ad=56.9f pd=0.74u as=56.9f ps=0.74u w=0.17u l=0.17u
X9255 cml_tlatch_68.xmux.xp.S1 CKHB3_N cml_tlatch_68.xtail.S1 VSS sg13_lv_nmos ad=89.3f pd=0.85u as=89.3f ps=0.85u w=0.47u l=0.16u
X9256 cml_tlatch_95.INN cml_tlatch_95.INP cml_tlatch_36.xmux.xp.S1 VSS sg13_lv_nmos ad=56.9f pd=0.74u as=56.9f ps=0.74u w=0.17u l=0.17u
X9257 MOT17_N B2_8_P cml_tlatch_73.xmux.xn.S1 VSS sg13_lv_nmos ad=63.19999f pd=0.74u as=63.19999f ps=0.74u w=0.26u l=0.38u
X9258 stub_bi_49.BOTP stub_bi_49.BOTN cml_tlatch_80.xmux.xp.S1 VSS sg13_lv_nmos ad=56.9f pd=0.74u as=56.9f ps=0.74u w=0.17u l=0.17u
X9259 stub_bi_17.BOTN cml_tlatch_5.INN cml_tlatch_13.xmux.xn.S1 VSS sg13_lv_nmos ad=63.19999f pd=0.74u as=63.19999f ps=0.74u w=0.26u l=0.38u
X9260 hs_to_clk_7.D2 CK_N CKA3_N VSS sg13_lv_nmos ad=0.228p pd=1.58u as=0.228p ps=1.58u w=1.2u l=0.2u
X9261 cml_tlatch_29.xmux.xp.S1 CKB0_N cml_tlatch_29.xtail.S1 VSS sg13_lv_nmos ad=89.3f pd=0.85u as=89.3f ps=0.85u w=0.47u l=0.16u
X9262 VSS cml_drvb_0.xrtail.R1 VSS rppd l=2.72u w=1u
X9263 GA0_P CKB0_N cml_gate2_2.xrtail.R1 VSS sg13_lv_nmos ad=0.1007p pd=0.91u as=0.1802p ps=1.74u w=0.53u l=0.13u
X9264 cml_tlatch_19.xmux.xn.S1 cml_tlatch_98.OUTP MOT5_N VSS sg13_lv_nmos ad=63.19999f pd=0.74u as=63.19999f ps=0.74u w=0.26u l=0.38u
X9265 MOT20_P MOT20_N cml_tlatch_50.xmux.xp.S1 VSS sg13_lv_nmos ad=56.9f pd=0.74u as=56.9f ps=0.74u w=0.17u l=0.17u
X9266 CKHB2_N GB2_P cml_drvb_7.xrtail.R1 VSS sg13_lv_nmos ad=0.2618p pd=2.22u as=0.1463p ps=1.15u w=0.77u l=0.21u
X9267 MOT25_N MOT25_P cml_tlatch_68.xmux.xp.S1 VSS sg13_lv_nmos ad=56.9f pd=0.74u as=56.9f ps=0.74u w=0.17u l=0.17u
X9268 cml_tlatch_76.xmux.xn.S1 CKHB2_P cml_tlatch_76.xtail.S1 VSS sg13_lv_nmos ad=89.3f pd=0.85u as=89.3f ps=0.85u w=0.47u l=0.16u
X9269 cml_tlatch_98.xmux.xp.S1 CKB0_P cml_tlatch_98.xtail.S1 VSS sg13_lv_nmos ad=89.3f pd=0.85u as=89.3f ps=0.85u w=0.47u l=0.16u
X9270 cml_tlatch_28.xtail.S1 POLN VSS VSS sg13_lv_nmos ad=1.5637p pd=8.61u as=2.7982p ps=17.14u w=8.23u l=0.13u
X9271 cml_tlatch_40.xmux.xp.S1 MOT12_P MOT12_N VSS sg13_lv_nmos ad=56.9f pd=0.74u as=56.9f ps=0.74u w=0.17u l=0.17u
X9272 cml_tlatch_91.xtail.S1 CKJ_N cml_tlatch_91.xmux.xp.S1 VSS sg13_lv_nmos ad=89.3f pd=0.85u as=89.3f ps=0.85u w=0.47u l=0.16u
X9273 cml_tlatch_64.xmux.xp.S1 CKA3_P cml_tlatch_64.xtail.S1 VSS sg13_lv_nmos ad=89.3f pd=0.85u as=89.3f ps=0.85u w=0.47u l=0.16u
X9274 cml_tlatch_16.xmux.xp.S1 cml_tlatch_16.OUTP cml_tlatch_16.OUTN VSS sg13_lv_nmos ad=56.9f pd=0.74u as=56.9f ps=0.74u w=0.17u l=0.17u
X9275 cml_tlatch_19.xmux.xn.S1 cml_tlatch_98.OUTP MOT5_N VSS sg13_lv_nmos ad=63.19999f pd=0.74u as=63.19999f ps=0.74u w=0.26u l=0.38u
X9276 cml_tlatch_56.INN D2_P cml_tlatch_42.xmux.xn.S1 VSS sg13_lv_nmos ad=63.19999f pd=0.74u as=63.19999f ps=0.74u w=0.26u l=0.38u
X9277 cml_tlatch_72.xmux.xp.S1 cml_tlatch_83.INN cml_tlatch_83.INP VSS sg13_lv_nmos ad=56.9f pd=0.74u as=56.9f ps=0.74u w=0.17u l=0.17u
X9278 cml_tlatch_95.xmux.xp.S1 CKA1_P cml_tlatch_95.xtail.S1 VSS sg13_lv_nmos ad=89.3f pd=0.85u as=89.3f ps=0.85u w=0.47u l=0.16u
X9279 cml_tlatch_95.INN cml_tlatch_95.INP cml_tlatch_36.xmux.xp.S1 VSS sg13_lv_nmos ad=56.9f pd=0.74u as=56.9f ps=0.74u w=0.17u l=0.17u
X9280 cml_tlatch_38.xmux.xp.S1 cml_tlatch_38.OUTN cml_tlatch_38.OUTP VSS sg13_lv_nmos ad=0.1019p pd=1.34u as=56.9f ps=0.74u w=0.17u l=0.17u
X9281 B3_8_P B3_8_N cml_tlatch_60.xmux.xp.S1 VSS sg13_lv_nmos ad=56.9f pd=0.74u as=56.9f ps=0.74u w=0.17u l=0.17u
X9282 cml_tlatch_89.xmux.xp.S1 cml_tlatch_89.OUTP cml_tlatch_89.OUTN VSS sg13_lv_nmos ad=56.9f pd=0.74u as=56.9f ps=0.74u w=0.17u l=0.17u
X9283 VSS POLN cml_tlatch_95.xtail.S1 VSS sg13_lv_nmos ad=1.5637p pd=8.61u as=1.5637p ps=8.61u w=8.23u l=0.13u
X9284 stub_bi_55.BOTP stub_bi_55.BOTN cml_tlatch_88.xmux.xp.S1 VSS sg13_lv_nmos ad=56.9f pd=0.74u as=56.9f ps=0.74u w=0.17u l=0.17u
X9285 A2_2_P cml_tlatch_56.INN cml_tlatch_56.xmux.xn.S1 VSS sg13_lv_nmos ad=63.19999f pd=0.74u as=0.1082p ps=1.34u w=0.26u l=0.38u
X9286 cml_tlatch_27.OUTP B0_2_N cml_tlatch_27.xmux.xn.S1 VSS sg13_lv_nmos ad=63.19999f pd=0.74u as=63.19999f ps=0.74u w=0.26u l=0.38u
X9287 cml_tlatch_38.xtail.S1 CKA1_N cml_tlatch_38.xmux.xp.S1 VSS sg13_lv_nmos ad=89.3f pd=0.85u as=89.3f ps=0.85u w=0.47u l=0.16u
X9288 cml_tlatch_58.INN cml_tlatch_52.OUTP cml_tlatch_85.xmux.xn.S1 VSS sg13_lv_nmos ad=0.1082p pd=1.34u as=63.19999f ps=0.74u w=0.26u l=0.38u
X9289 cml_tlatch_89.xmux.xp.S1 CKA2_P cml_tlatch_89.xtail.S1 VSS sg13_lv_nmos ad=0.1598p pd=1.62u as=89.3f ps=0.85u w=0.47u l=0.16u
X9290 cml_tlatch_29.xmux.xp.S1 cml_tlatch_29.OUTP cml_tlatch_29.OUTN VSS sg13_lv_nmos ad=56.9f pd=0.74u as=56.9f ps=0.74u w=0.17u l=0.17u
X9291 MOT13_N MOT13_P cml_tlatch_6.xmux.xp.S1 VSS sg13_lv_nmos ad=56.9f pd=0.74u as=56.9f ps=0.74u w=0.17u l=0.17u
X9292 cml_tlatch_58.xtail.S1 POLN VSS VSS sg13_lv_nmos ad=1.5637p pd=8.61u as=1.5637p ps=8.61u w=8.23u l=0.13u
X9293 stub_bi_32.BOTP VDD VSS rppd l=5.17u w=1u
X9294 cml_tlatch_69.INN cml_tlatch_69.INP cml_tlatch_62.xmux.xp.S1 VSS sg13_lv_nmos ad=56.9f pd=0.74u as=56.9f ps=0.74u w=0.17u l=0.17u
X9295 cml_tlatch_6.xmux.xn.S1 cml_tlatch_6.INN MOT13_P VSS sg13_lv_nmos ad=63.19999f pd=0.74u as=63.19999f ps=0.74u w=0.26u l=0.38u
X9296 cml_tlatch_65.xmux.xn.S1 CKA3_P cml_tlatch_65.xtail.S1 VSS sg13_lv_nmos ad=89.3f pd=0.85u as=89.3f ps=0.85u w=0.47u l=0.16u
X9297 GA2_P ENA1_N cml_gate2_4.sg13_lv_nmos_FTPY57_0.D0 VSS sg13_lv_nmos ad=0.1007p pd=0.91u as=0.1007p ps=0.91u w=0.53u l=0.13u
X9298 cml_tlatch_6.xtail.S1 CKHB1_N cml_tlatch_6.xmux.xp.S1 VSS sg13_lv_nmos ad=89.3f pd=0.85u as=89.3f ps=0.85u w=0.47u l=0.16u
X9299 MOT25_N VDD VSS rppd l=5.17u w=1u
X9300 cml_tlatch_24.xmux.xp.S1 MOT2_P MOT2_N VSS sg13_lv_nmos ad=56.9f pd=0.74u as=56.9f ps=0.74u w=0.17u l=0.17u
X9301 cml_tlatch_59.xtail.S1 CKHA3_N cml_tlatch_59.xmux.xp.S1 VSS sg13_lv_nmos ad=89.3f pd=0.85u as=89.3f ps=0.85u w=0.47u l=0.16u
X9302 cml_tlatch_82.OUTN cml_tlatch_82.OUTP cml_tlatch_82.xmux.xp.S1 VSS sg13_lv_nmos ad=56.9f pd=0.74u as=56.9f ps=0.74u w=0.17u l=0.17u
X9303 cml_tlatch_78.xmux.xp.S1 stub_bi_62.BOTN stub_bi_62.BOTP VSS sg13_lv_nmos ad=56.9f pd=0.74u as=56.9f ps=0.74u w=0.17u l=0.17u
X9304 MOT29_P cml_tlatch_70.INN cml_tlatch_70.xmux.xn.S1 VSS sg13_lv_nmos ad=63.19999f pd=0.74u as=63.19999f ps=0.74u w=0.26u l=0.38u
X9305 ENB1_P ENB_N cml_drv_0.xrtail.R1 VSS sg13_lv_nmos ad=56.2f pd=0.74u as=0.1012p ps=1.34u w=0.16u l=0.19u
X9306 cml_tlatch_47.OUTP D3_N cml_tlatch_47.xmux.xn.S1 VSS sg13_lv_nmos ad=63.19999f pd=0.74u as=63.19999f ps=0.74u w=0.26u l=0.38u
X9307 MOT23_P MOT23_N cml_tlatch_76.xmux.xp.S1 VSS sg13_lv_nmos ad=56.9f pd=0.74u as=56.9f ps=0.74u w=0.17u l=0.17u
X9308 cml_tlatch_30.OUTN cml_tlatch_30.OUTP cml_tlatch_30.xmux.xp.S1 VSS sg13_lv_nmos ad=56.9f pd=0.74u as=56.9f ps=0.74u w=0.17u l=0.17u
X9309 cml_tlatch_12.xmux.xp.S1 B1_8_N B1_8_P VSS sg13_lv_nmos ad=56.9f pd=0.74u as=56.9f ps=0.74u w=0.17u l=0.17u
X9310 cml_tlatch_56.xmux.xp.S1 CKA2_P cml_tlatch_56.xtail.S1 VSS sg13_lv_nmos ad=89.3f pd=0.85u as=89.3f ps=0.85u w=0.47u l=0.16u
X9311 cml_tlatch_61.xmux.xn.S1 CKB3_P cml_tlatch_61.xtail.S1 VSS sg13_lv_nmos ad=89.3f pd=0.85u as=89.3f ps=0.85u w=0.47u l=0.16u
X9312 B2_2_P B2_2_N cml_tlatch_44.xmux.xp.S1 VSS sg13_lv_nmos ad=56.9f pd=0.74u as=56.9f ps=0.74u w=0.17u l=0.17u
X9313 cml_tlatch_37.xmux.xp.S1 A1_2_N A1_2_P VSS sg13_lv_nmos ad=56.9f pd=0.74u as=56.9f ps=0.74u w=0.17u l=0.17u
X9314 cml_tlatch_12.xmux.xp.S1 CKB1_P cml_tlatch_12.xtail.S1 VSS sg13_lv_nmos ad=89.3f pd=0.85u as=89.3f ps=0.85u w=0.47u l=0.16u
X9315 ENA_P NM1_N cml_gate2_9.xrtail.R1 VSS sg13_lv_nmos ad=0.1007p pd=0.91u as=0.1007p ps=0.91u w=0.53u l=0.13u
X9316 cml_tlatch_79.xmux.xp.S1 CKB2_P cml_tlatch_79.xtail.S1 VSS sg13_lv_nmos ad=89.3f pd=0.85u as=89.3f ps=0.85u w=0.47u l=0.16u
X9317 cml_tlatch_9.xmux.xp.S1 cml_tlatch_9.OUTN cml_tlatch_9.OUTP VSS sg13_lv_nmos ad=56.9f pd=0.74u as=56.9f ps=0.74u w=0.17u l=0.17u
X9318 cml_tlatch_8.xtail.S1 CKA0_P cml_tlatch_8.xmux.xp.S1 VSS sg13_lv_nmos ad=89.3f pd=0.85u as=89.3f ps=0.85u w=0.47u l=0.16u
X9319 cml_tlatch_41.xmux.xn.S1 A1_2_P MOT14_N VSS sg13_lv_nmos ad=63.19999f pd=0.74u as=0.1082p ps=1.34u w=0.26u l=0.38u
X9320 cml_tlatch_66.xmux.xp.S1 CKA3_P cml_tlatch_66.xtail.S1 VSS sg13_lv_nmos ad=89.3f pd=0.85u as=89.3f ps=0.85u w=0.47u l=0.16u
X9321 ENA_N J1_P cml_gate2_9.sg13_lv_nmos_FTPY57_0.D0 VSS sg13_lv_nmos ad=0.1007p pd=0.91u as=0.1007p ps=0.91u w=0.53u l=0.13u
X9322 cml_tlatch_98.OUTN VDD VSS rppd l=5.17u w=1u
X9323 MOT28_P MOT28_N cml_tlatch_58.xmux.xp.S1 VSS sg13_lv_nmos ad=56.9f pd=0.74u as=56.9f ps=0.74u w=0.17u l=0.17u
X9324 cml_tlatch_87.xmux.xp.S1 CKHA2_N cml_tlatch_87.xtail.S1 VSS sg13_lv_nmos ad=89.3f pd=0.85u as=0.1598p ps=1.62u w=0.47u l=0.16u
X9325 cml_tlatch_80.xmux.xn.S1 stub_bi_55.BOTP stub_bi_49.BOTN VSS sg13_lv_nmos ad=63.19999f pd=0.74u as=0.1082p ps=1.34u w=0.26u l=0.38u
X9326 cml_tlatch_19.xmux.xn.S1 CKHB0_P cml_tlatch_19.xtail.S1 VSS sg13_lv_nmos ad=89.3f pd=0.85u as=89.3f ps=0.85u w=0.47u l=0.16u
X9327 MOT9_N MOT9_P cml_tlatch_4.xmux.xp.S1 VSS sg13_lv_nmos ad=56.9f pd=0.74u as=56.9f ps=0.74u w=0.17u l=0.17u
X9328 cml_tlatch_52.xmux.xp.S1 cml_tlatch_52.OUTP cml_tlatch_52.OUTN VSS sg13_lv_nmos ad=56.9f pd=0.74u as=56.9f ps=0.74u w=0.17u l=0.17u
X9329 cml_tlatch_80.xmux.xp.S1 stub_bi_49.BOTP stub_bi_49.BOTN VSS sg13_lv_nmos ad=56.9f pd=0.74u as=56.9f ps=0.74u w=0.17u l=0.17u
X9330 cml_tlatch_40.xmux.xp.S1 MOT12_N MOT12_P VSS sg13_lv_nmos ad=56.9f pd=0.74u as=56.9f ps=0.74u w=0.17u l=0.17u
X9331 cml_tlatch_45.OUTN cml_tlatch_45.OUTP cml_tlatch_45.xmux.xp.S1 VSS sg13_lv_nmos ad=56.9f pd=0.74u as=56.9f ps=0.74u w=0.17u l=0.17u
X9332 cml_tlatch_86.xmux.xn.S1 A3_8_P MOT24_N VSS sg13_lv_nmos ad=0.1082p pd=1.34u as=63.19999f ps=0.74u w=0.26u l=0.38u
X9333 cml_tlatch_83.xmux.xp.S1 cml_tlatch_83.OUTN cml_tlatch_83.OUTP VSS sg13_lv_nmos ad=56.9f pd=0.74u as=56.9f ps=0.74u w=0.17u l=0.17u
X9334 cml_drv_3.xrtail.R1 ENA_P ENA0_N VSS sg13_lv_nmos ad=56.2f pd=0.74u as=56.2f ps=0.74u w=0.16u l=0.19u
X9335 A2_8_P A2_8_N cml_tlatch_81.xmux.xp.S1 VSS sg13_lv_nmos ad=56.9f pd=0.74u as=0.1019p ps=1.34u w=0.17u l=0.17u
X9336 cml_tlatch_51.xmux.xp.S1 MOT22_N MOT22_P VSS sg13_lv_nmos ad=0.1019p pd=1.34u as=56.9f ps=0.74u w=0.17u l=0.17u
X9337 cml_tlatch_9.OUTN cml_tlatch_9.OUTP cml_tlatch_9.xmux.xp.S1 VSS sg13_lv_nmos ad=56.9f pd=0.74u as=0.1019p ps=1.34u w=0.17u l=0.17u
X9338 MOT30_P MOT30_N cml_tlatch_59.xmux.xp.S1 VSS sg13_lv_nmos ad=56.9f pd=0.74u as=56.9f ps=0.74u w=0.17u l=0.17u
X9339 cml_tlatch_87.xmux.xp.S1 MOT16_P MOT16_N VSS sg13_lv_nmos ad=56.9f pd=0.74u as=56.9f ps=0.74u w=0.17u l=0.17u
X9340 cml_tlatch_40.xmux.xp.S1 CKHA1_N cml_tlatch_40.xtail.S1 VSS sg13_lv_nmos ad=89.3f pd=0.85u as=89.3f ps=0.85u w=0.47u l=0.16u
X9341 cml_tlatch_86.xmux.xp.S1 CKHA3_N cml_tlatch_86.xtail.S1 VSS sg13_lv_nmos ad=89.3f pd=0.85u as=89.3f ps=0.85u w=0.47u l=0.16u
X9342 cml_tlatch_51.xmux.xn.S1 A2_2_N MOT22_P VSS sg13_lv_nmos ad=63.19999f pd=0.74u as=63.19999f ps=0.74u w=0.26u l=0.38u
X9343 cml_tlatch_9.xmux.xp.S1 CKA0_N cml_tlatch_9.xtail.S1 VSS sg13_lv_nmos ad=89.3f pd=0.85u as=89.3f ps=0.85u w=0.47u l=0.16u
X9344 cml_tlatch_32.xmux.xp.S1 stub_bi_29.BOTN stub_bi_29.BOTP VSS sg13_lv_nmos ad=56.9f pd=0.74u as=56.9f ps=0.74u w=0.17u l=0.17u
X9345 cml_tlatch_76.xmux.xp.S1 MOT23_P MOT23_N VSS sg13_lv_nmos ad=56.9f pd=0.74u as=56.9f ps=0.74u w=0.17u l=0.17u
X9346 MOT1_P B0_8_N cml_tlatch_17.xmux.xn.S1 VSS sg13_lv_nmos ad=0.1082p pd=1.34u as=63.19999f ps=0.74u w=0.26u l=0.38u
X9347 MOT11_P MOT11_N cml_tlatch_5.xmux.xp.S1 VSS sg13_lv_nmos ad=56.9f pd=0.74u as=56.9f ps=0.74u w=0.17u l=0.17u
X9348 VDD MOT7_P VSS rppd l=5.17u w=1u
X9349 cml_tlatch_41.xmux.xp.S1 MOT14_N MOT14_P VSS sg13_lv_nmos ad=56.9f pd=0.74u as=56.9f ps=0.74u w=0.17u l=0.17u
X9350 cml_tlatch_99.OUTN cml_tlatch_99.OUTP cml_tlatch_99.xmux.xp.S1 VSS sg13_lv_nmos ad=56.9f pd=0.74u as=56.9f ps=0.74u w=0.17u l=0.17u
X9351 cml_tlatch_53.xmux.xp.S1 A3_2_P A3_2_N VSS sg13_lv_nmos ad=0.1019p pd=1.34u as=56.9f ps=0.74u w=0.17u l=0.17u
X9352 cml_tlatch_16.xmux.xp.S1 cml_tlatch_16.OUTP cml_tlatch_16.OUTN VSS sg13_lv_nmos ad=56.9f pd=0.74u as=56.9f ps=0.74u w=0.17u l=0.17u
X9353 cml_tlatch_90.xtail.S1 CKJ_P cml_tlatch_90.xmux.xp.S1 VSS sg13_lv_nmos ad=89.3f pd=0.85u as=89.3f ps=0.85u w=0.47u l=0.16u
X9354 cml_tlatch_47.xtail.S1 CKB3_P cml_tlatch_47.xmux.xn.S1 VSS sg13_lv_nmos ad=89.3f pd=0.85u as=89.3f ps=0.85u w=0.47u l=0.16u
X9355 cml_tlatch_28.xmux.xn.S1 cml_tlatch_29.OUTP B0_2_N VSS sg13_lv_nmos ad=63.19999f pd=0.74u as=63.19999f ps=0.74u w=0.26u l=0.38u
X9356 VDD hs_to_clk_7.sg13_lv_nmos_2HGZLP_0.G VSS rppd l=0.68u w=1u
X9357 hs_to_clk_5.D2 CK_P CKB3_N VSS sg13_lv_nmos ad=0.408p pd=3.08u as=0.228p ps=1.58u w=1.2u l=0.2u
X9358 cml_tlatch_63.xtail.S1 CKB3_P cml_tlatch_63.xmux.xn.S1 VSS sg13_lv_nmos ad=89.3f pd=0.85u as=0.1598p ps=1.62u w=0.47u l=0.16u
X9359 A0_8_P A0_8_N cml_tlatch_2.xmux.xp.S1 VSS sg13_lv_nmos ad=56.9f pd=0.74u as=56.9f ps=0.74u w=0.17u l=0.17u
X9360 MOT10_N MOT10_P cml_tlatch_39.xmux.xp.S1 VSS sg13_lv_nmos ad=56.9f pd=0.74u as=56.9f ps=0.74u w=0.17u l=0.17u
X9361 MOT31_P MOT31_N cml_tlatch_71.xmux.xp.S1 VSS sg13_lv_nmos ad=56.9f pd=0.74u as=56.9f ps=0.74u w=0.17u l=0.17u
X9362 cml_tlatch_28.xmux.xn.S1 cml_tlatch_29.OUTP B0_2_N VSS sg13_lv_nmos ad=63.19999f pd=0.74u as=63.19999f ps=0.74u w=0.26u l=0.38u
X9363 cml_tlatch_99.xmux.xp.S1 CKA0_P cml_tlatch_99.xtail.S1 VSS sg13_lv_nmos ad=89.3f pd=0.85u as=0.1598p ps=1.62u w=0.47u l=0.16u
X9364 cml_tlatch_96.xmux.xp.S1 MOT8_N MOT8_P VSS sg13_lv_nmos ad=56.9f pd=0.74u as=56.9f ps=0.74u w=0.17u l=0.17u
X9365 cml_tlatch_23.xmux.xn.S1 CKA1_N cml_tlatch_23.xtail.S1 VSS sg13_lv_nmos ad=89.3f pd=0.85u as=89.3f ps=0.85u w=0.47u l=0.16u
X9366 cml_tlatch_21.xmux.xn.S1 CKA1_N cml_tlatch_21.xtail.S1 VSS sg13_lv_nmos ad=89.3f pd=0.85u as=89.3f ps=0.85u w=0.47u l=0.16u
X9367 cml_tlatch_38.xmux.xp.S1 cml_tlatch_38.OUTP cml_tlatch_38.OUTN VSS sg13_lv_nmos ad=56.9f pd=0.74u as=56.9f ps=0.74u w=0.17u l=0.17u
X9368 MOT27_P MOT27_N cml_tlatch_69.xmux.xp.S1 VSS sg13_lv_nmos ad=56.9f pd=0.74u as=56.9f ps=0.74u w=0.17u l=0.17u
X9369 A2_8_P A2_8_N cml_tlatch_81.xmux.xp.S1 VSS sg13_lv_nmos ad=56.9f pd=0.74u as=56.9f ps=0.74u w=0.17u l=0.17u
X9370 cml_tlatch_7.xmux.xp.S1 MOT15_N MOT15_P VSS sg13_lv_nmos ad=56.9f pd=0.74u as=56.9f ps=0.74u w=0.17u l=0.17u
X9371 MOT17_P MOT17_N cml_tlatch_73.xmux.xp.S1 VSS sg13_lv_nmos ad=56.9f pd=0.74u as=56.9f ps=0.74u w=0.17u l=0.17u
X9372 cml_tlatch_54.xmux.xp.S1 CKA3_N cml_tlatch_54.xtail.S1 VSS sg13_lv_nmos ad=0.1598p pd=1.62u as=89.3f ps=0.85u w=0.47u l=0.16u
X9373 cml_tlatch_83.xmux.xn.S1 CKA2_N cml_tlatch_83.xtail.S1 VSS sg13_lv_nmos ad=0.1598p pd=1.62u as=89.3f ps=0.85u w=0.47u l=0.16u
X9374 stub_bi_17.BOTP cml_tlatch_5.INP cml_tlatch_13.xmux.xn.S1 VSS sg13_lv_nmos ad=63.19999f pd=0.74u as=63.19999f ps=0.74u w=0.26u l=0.38u
X9375 MOT28_P MOT28_N cml_tlatch_58.xmux.xp.S1 VSS sg13_lv_nmos ad=56.9f pd=0.74u as=0.1019p ps=1.34u w=0.17u l=0.17u
X9376 cml_tlatch_78.xmux.xp.S1 stub_bi_62.BOTN stub_bi_62.BOTP VSS sg13_lv_nmos ad=56.9f pd=0.74u as=56.9f ps=0.74u w=0.17u l=0.17u
X9377 cml_tlatch_10.xmux.xp.S1 B0_8_P B0_8_N VSS sg13_lv_nmos ad=0.1019p pd=1.34u as=56.9f ps=0.74u w=0.17u l=0.17u
X9378 cml_tlatch_39.INP cml_tlatch_39.INN cml_tlatch_23.xmux.xp.S1 VSS sg13_lv_nmos ad=56.9f pd=0.74u as=56.9f ps=0.74u w=0.17u l=0.17u
X9379 VSS POLN cml_tlatch_64.xtail.S1 VSS sg13_lv_nmos ad=1.5637p pd=8.61u as=1.5637p ps=8.61u w=8.23u l=0.13u
X9380 cml_tlatch_76.xtail.S1 CKHB2_P cml_tlatch_76.xmux.xn.S1 VSS sg13_lv_nmos ad=89.3f pd=0.85u as=89.3f ps=0.85u w=0.47u l=0.16u
X9381 MOT23_N B2_2_P cml_tlatch_76.xmux.xn.S1 VSS sg13_lv_nmos ad=63.19999f pd=0.74u as=0.1082p ps=1.34u w=0.26u l=0.38u
X9382 cml_tlatch_72.xtail.S1 CKA2_P cml_tlatch_72.xmux.xn.S1 VSS sg13_lv_nmos ad=89.3f pd=0.85u as=89.3f ps=0.85u w=0.47u l=0.16u
X9383 cml_tlatch_46.xmux.xp.S1 B3_2_P B3_2_N VSS sg13_lv_nmos ad=56.9f pd=0.74u as=56.9f ps=0.74u w=0.17u l=0.17u
X9384 cml_tlatch_12.xmux.xn.S1 CKB1_N cml_tlatch_12.xtail.S1 VSS sg13_lv_nmos ad=89.3f pd=0.85u as=89.3f ps=0.85u w=0.47u l=0.16u
X9385 cml_tlatch_86.xmux.xp.S1 MOT24_P MOT24_N VSS sg13_lv_nmos ad=56.9f pd=0.74u as=56.9f ps=0.74u w=0.17u l=0.17u
X9386 cml_tlatch_86.xmux.xp.S1 MOT24_N MOT24_P VSS sg13_lv_nmos ad=56.9f pd=0.74u as=56.9f ps=0.74u w=0.17u l=0.17u
X9387 cml_tlatch_22.xtail.S1 CKA1_N cml_tlatch_22.xmux.xp.S1 VSS sg13_lv_nmos ad=89.3f pd=0.85u as=89.3f ps=0.85u w=0.47u l=0.16u
X9388 cml_tlatch_16.xmux.xn.S1 cml_tlatch_1.OUTP cml_tlatch_16.OUTN VSS sg13_lv_nmos ad=63.19999f pd=0.74u as=63.19999f ps=0.74u w=0.26u l=0.38u
X9389 cml_gate2_1.sg13_lv_nmos_FTPY57_0.D0 CKA0_P cml_gate2_1.xrtail.R1 VSS sg13_lv_nmos ad=0.1007p pd=0.91u as=0.1802p ps=1.74u w=0.53u l=0.13u
X9390 cml_tlatch_12.xmux.xn.S1 stub_bi_17.BOTN B1_8_N VSS sg13_lv_nmos ad=63.19999f pd=0.74u as=63.19999f ps=0.74u w=0.26u l=0.38u
X9391 cml_tlatch_82.OUTP cml_tlatch_82.OUTN cml_tlatch_82.xmux.xp.S1 VSS sg13_lv_nmos ad=56.9f pd=0.74u as=56.9f ps=0.74u w=0.17u l=0.17u
X9392 cml_tlatch_12.xmux.xn.S1 stub_bi_17.BOTN B1_8_N VSS sg13_lv_nmos ad=63.19999f pd=0.74u as=63.19999f ps=0.74u w=0.26u l=0.38u
X9393 cml_tlatch_71.xtail.S1 CKHB3_P cml_tlatch_71.xmux.xn.S1 VSS sg13_lv_nmos ad=89.3f pd=0.85u as=89.3f ps=0.85u w=0.47u l=0.16u
X9394 cml_tlatch_67.xmux.xp.S1 cml_tlatch_67.OUTP cml_tlatch_67.OUTN VSS sg13_lv_nmos ad=56.9f pd=0.74u as=56.9f ps=0.74u w=0.17u l=0.17u
X9395 MOT4_P cml_tlatch_99.OUTN cml_tlatch_25.xmux.xn.S1 VSS sg13_lv_nmos ad=63.19999f pd=0.74u as=63.19999f ps=0.74u w=0.26u l=0.38u
X9396 cml_tlatch_45.xtail.S1 CKB3_P cml_tlatch_45.xmux.xn.S1 VSS sg13_lv_nmos ad=89.3f pd=0.85u as=89.3f ps=0.85u w=0.47u l=0.16u
X9397 cml_tlatch_63.OUTN cml_tlatch_63.OUTP cml_tlatch_63.xmux.xp.S1 VSS sg13_lv_nmos ad=56.9f pd=0.74u as=56.9f ps=0.74u w=0.17u l=0.17u
X9398 cml_tlatch_21.xmux.xn.S1 cml_tlatch_22.OUTN A1_8_P VSS sg13_lv_nmos ad=63.19999f pd=0.74u as=63.19999f ps=0.74u w=0.26u l=0.38u
X9399 cml_gate2_5.xrtail.R1 CKB3_N GA3_P VSS sg13_lv_nmos ad=0.1802p pd=1.74u as=0.1007p ps=0.91u w=0.53u l=0.13u
X9400 interco_bi_19.INP interco_bi_19.INN cml_tlatch_0.xmux.xp.S1 VSS sg13_lv_nmos ad=56.9f pd=0.74u as=56.9f ps=0.74u w=0.17u l=0.17u
X9401 cml_tlatch_1.xmux.xn.S1 cml_tlatch_98.OUTP cml_tlatch_1.OUTN VSS sg13_lv_nmos ad=63.19999f pd=0.74u as=63.19999f ps=0.74u w=0.26u l=0.38u
X9402 cml_tlatch_1.xmux.xn.S1 cml_tlatch_98.OUTP cml_tlatch_1.OUTN VSS sg13_lv_nmos ad=63.19999f pd=0.74u as=63.19999f ps=0.74u w=0.26u l=0.38u
X9403 MOT10_P MOT10_N cml_tlatch_39.xmux.xp.S1 VSS sg13_lv_nmos ad=56.9f pd=0.74u as=56.9f ps=0.74u w=0.17u l=0.17u
X9404 ENB_N VDD VSS rppd l=7.42u w=1u
X9405 cml_tlatch_55.xmux.xp.S1 CKA2_N cml_tlatch_55.xtail.S1 VSS sg13_lv_nmos ad=89.3f pd=0.85u as=0.1598p ps=1.62u w=0.47u l=0.16u
X9406 cml_tlatch_79.xmux.xn.S1 stub_bi_49.BOTP stub_bi_63.BOTN VSS sg13_lv_nmos ad=63.19999f pd=0.74u as=63.19999f ps=0.74u w=0.26u l=0.38u
X9407 GB2_N ENB0_P cml_gate2_7.sg13_lv_nmos_FTPY57_0.D0 VSS sg13_lv_nmos ad=0.1007p pd=0.91u as=0.1007p ps=0.91u w=0.53u l=0.13u
X9408 cml_tlatch_3.OUTN cml_tlatch_3.OUTP cml_tlatch_3.xmux.xp.S1 VSS sg13_lv_nmos ad=56.9f pd=0.74u as=56.9f ps=0.74u w=0.17u l=0.17u
X9409 VSS POLN cml_tlatch_56.xtail.S1 VSS sg13_lv_nmos ad=2.7982p pd=17.14u as=1.5637p ps=8.61u w=8.23u l=0.13u
X9410 MOT31_P MOT31_N cml_tlatch_71.xmux.xp.S1 VSS sg13_lv_nmos ad=56.9f pd=0.74u as=0.1019p ps=1.34u w=0.17u l=0.17u
X9411 cml_tlatch_37.xmux.xn.S1 CKA1_N cml_tlatch_37.xtail.S1 VSS sg13_lv_nmos ad=89.3f pd=0.85u as=89.3f ps=0.85u w=0.47u l=0.16u
X9412 cml_tlatch_85.xmux.xp.S1 cml_tlatch_58.INP cml_tlatch_58.INN VSS sg13_lv_nmos ad=56.9f pd=0.74u as=56.9f ps=0.74u w=0.17u l=0.17u
X9413 MOT25_P MOT25_N cml_tlatch_68.xmux.xp.S1 VSS sg13_lv_nmos ad=56.9f pd=0.74u as=56.9f ps=0.74u w=0.17u l=0.17u
X9414 cml_tlatch_35.xmux.xp.S1 cml_tlatch_35.OUTN cml_tlatch_35.OUTP VSS sg13_lv_nmos ad=56.9f pd=0.74u as=56.9f ps=0.74u w=0.17u l=0.17u
X9415 VSS POLN hs_to_clk_5.D2 VSS sg13_lv_nmos ad=1.9p pd=10.38u as=3.4p ps=20.68u w=10u l=0.13u
X9416 cml_tlatch_71.xtail.S1 CKHB3_N cml_tlatch_71.xmux.xp.S1 VSS sg13_lv_nmos ad=89.3f pd=0.85u as=0.1598p ps=1.62u w=0.47u l=0.16u
X9417 cml_tlatch_27.OUTP B0_2_N cml_tlatch_27.xmux.xn.S1 VSS sg13_lv_nmos ad=63.19999f pd=0.74u as=63.19999f ps=0.74u w=0.26u l=0.38u
X9418 cml_tlatch_8.xmux.xn.S1 CKA0_N cml_tlatch_8.xtail.S1 VSS sg13_lv_nmos ad=89.3f pd=0.85u as=89.3f ps=0.85u w=0.47u l=0.16u
X9419 cml_tlatch_98.xmux.xp.S1 CKB0_P cml_tlatch_98.xtail.S1 VSS sg13_lv_nmos ad=89.3f pd=0.85u as=89.3f ps=0.85u w=0.47u l=0.16u
X9420 cml_tlatch_66.xmux.xp.S1 cml_tlatch_57.INP cml_tlatch_57.INN VSS sg13_lv_nmos ad=56.9f pd=0.74u as=56.9f ps=0.74u w=0.17u l=0.17u
X9421 B1_2_P stub_bi_31.BOTP cml_tlatch_33.xmux.xn.S1 VSS sg13_lv_nmos ad=63.19999f pd=0.74u as=63.19999f ps=0.74u w=0.26u l=0.38u
X9422 J1_N J1_P cml_tlatch_93.xmux.xp.S1 VSS sg13_lv_nmos ad=56.9f pd=0.74u as=56.9f ps=0.74u w=0.17u l=0.17u
X9423 cml_tlatch_66.xmux.xp.S1 cml_tlatch_57.INN cml_tlatch_57.INP VSS sg13_lv_nmos ad=56.9f pd=0.74u as=56.9f ps=0.74u w=0.17u l=0.17u
X9424 cml_tlatch_4.xmux.xp.S1 MOT9_N MOT9_P VSS sg13_lv_nmos ad=56.9f pd=0.74u as=56.9f ps=0.74u w=0.17u l=0.17u
X9425 cml_tlatch_74.xmux.xp.S1 MOT19_P MOT19_N VSS sg13_lv_nmos ad=56.9f pd=0.74u as=56.9f ps=0.74u w=0.17u l=0.17u
X9426 A0_8_P A0_8_N cml_tlatch_2.xmux.xp.S1 VSS sg13_lv_nmos ad=56.9f pd=0.74u as=56.9f ps=0.74u w=0.17u l=0.17u
X9427 MOT26_P MOT26_N cml_tlatch_57.xmux.xp.S1 VSS sg13_lv_nmos ad=56.9f pd=0.74u as=56.9f ps=0.74u w=0.17u l=0.17u
X9428 stub_bi_62.BOTN stub_bi_63.BOTP cml_tlatch_78.xmux.xn.S1 VSS sg13_lv_nmos ad=63.19999f pd=0.74u as=63.19999f ps=0.74u w=0.26u l=0.38u
X9429 cml_tlatch_33.xmux.xn.S1 CKB1_N cml_tlatch_33.xtail.S1 VSS sg13_lv_nmos ad=89.3f pd=0.85u as=89.3f ps=0.85u w=0.47u l=0.16u
X9430 cml_tlatch_10.xmux.xp.S1 CKB0_P cml_tlatch_10.xtail.S1 VSS sg13_lv_nmos ad=89.3f pd=0.85u as=89.3f ps=0.85u w=0.47u l=0.16u
X9431 cml_tlatch_22.xtail.S1 CKA1_N cml_tlatch_22.xmux.xp.S1 VSS sg13_lv_nmos ad=89.3f pd=0.85u as=89.3f ps=0.85u w=0.47u l=0.16u
X9432 cml_tlatch_92.xmux.xp.S1 J2_N J2_P VSS sg13_lv_nmos ad=56.9f pd=0.74u as=56.9f ps=0.74u w=0.17u l=0.17u
X9433 cml_tlatch_46.xmux.xn.S1 cml_tlatch_47.OUTN B3_2_P VSS sg13_lv_nmos ad=63.19999f pd=0.74u as=63.19999f ps=0.74u w=0.26u l=0.38u
X9434 cml_tlatch_65.OUTN cml_tlatch_65.OUTP cml_tlatch_65.xmux.xp.S1 VSS sg13_lv_nmos ad=56.9f pd=0.74u as=56.9f ps=0.74u w=0.17u l=0.17u
X9435 cml_tlatch_97.xtail.S1 POLN VSS VSS sg13_lv_nmos ad=1.5637p pd=8.61u as=2.7982p ps=17.14u w=8.23u l=0.13u
X9436 cml_tlatch_4.xmux.xp.S1 CKHB1_N cml_tlatch_4.xtail.S1 VSS sg13_lv_nmos ad=89.3f pd=0.85u as=89.3f ps=0.85u w=0.47u l=0.16u
X9437 cml_gate2_7.sg13_lv_nmos_FTPY57_0.D0 ENB0_N GB2_P VSS sg13_lv_nmos ad=0.1007p pd=0.91u as=0.1007p ps=0.91u w=0.53u l=0.13u
X9438 cml_tlatch_96.xmux.xp.S1 MOT8_N MOT8_P VSS sg13_lv_nmos ad=0.1019p pd=1.34u as=56.9f ps=0.74u w=0.17u l=0.17u
X9439 cml_tlatch_14.xmux.xp.S1 cml_tlatch_5.INN cml_tlatch_5.INP VSS sg13_lv_nmos ad=56.9f pd=0.74u as=56.9f ps=0.74u w=0.17u l=0.17u
X9440 cml_tlatch_25.xtail.S1 POLN VSS VSS sg13_lv_nmos ad=1.5637p pd=8.61u as=2.7982p ps=17.14u w=8.23u l=0.13u
X9441 cml_tlatch_60.xmux.xp.S1 CKB3_P cml_tlatch_60.xtail.S1 VSS sg13_lv_nmos ad=89.3f pd=0.85u as=89.3f ps=0.85u w=0.47u l=0.16u
X9442 cml_tlatch_56.INP cml_tlatch_56.INN cml_tlatch_42.xmux.xp.S1 VSS sg13_lv_nmos ad=56.9f pd=0.74u as=56.9f ps=0.74u w=0.17u l=0.17u
X9443 B3_2_P B3_2_N cml_tlatch_46.xmux.xp.S1 VSS sg13_lv_nmos ad=56.9f pd=0.74u as=56.9f ps=0.74u w=0.17u l=0.17u
X9444 cml_tlatch_27.xmux.xp.S1 CKB0_N cml_tlatch_27.xtail.S1 VSS sg13_lv_nmos ad=89.3f pd=0.85u as=89.3f ps=0.85u w=0.47u l=0.16u
X9445 cml_tlatch_1.xmux.xp.S1 cml_tlatch_1.OUTP cml_tlatch_1.OUTN VSS sg13_lv_nmos ad=56.9f pd=0.74u as=56.9f ps=0.74u w=0.17u l=0.17u
X9446 stub_bi_19.BOTP stub_bi_19.BOTN cml_tlatch_15.xmux.xp.S1 VSS sg13_lv_nmos ad=56.9f pd=0.74u as=56.9f ps=0.74u w=0.17u l=0.17u
X9447 cml_tlatch_39.INN cml_tlatch_39.INP cml_tlatch_23.xmux.xp.S1 VSS sg13_lv_nmos ad=56.9f pd=0.74u as=56.9f ps=0.74u w=0.17u l=0.17u
X9448 cml_tlatch_1.xtail.S1 CKB0_P cml_tlatch_1.xmux.xn.S1 VSS sg13_lv_nmos ad=89.3f pd=0.85u as=89.3f ps=0.85u w=0.47u l=0.16u
X9449 VSS POLN hs_to_clk_0.D2 VSS sg13_lv_nmos ad=1.9p pd=10.38u as=3.4p ps=20.68u w=10u l=0.13u
X9450 cml_tlatch_73.xmux.xn.S1 B2_8_P MOT17_N VSS sg13_lv_nmos ad=63.19999f pd=0.74u as=63.19999f ps=0.74u w=0.26u l=0.38u
X9451 MOT7_P B0_2_N cml_tlatch_20.xmux.xn.S1 VSS sg13_lv_nmos ad=63.19999f pd=0.74u as=63.19999f ps=0.74u w=0.26u l=0.38u
X9452 cml_tlatch_33.xmux.xp.S1 B1_2_N B1_2_P VSS sg13_lv_nmos ad=56.9f pd=0.74u as=56.9f ps=0.74u w=0.17u l=0.17u
X9453 cml_tlatch_11.OUTP cml_tlatch_16.OUTN cml_tlatch_11.xmux.xn.S1 VSS sg13_lv_nmos ad=63.19999f pd=0.74u as=63.19999f ps=0.74u w=0.26u l=0.38u
X9454 cml_tlatch_6.INP cml_tlatch_6.INN cml_tlatch_94.xmux.xp.S1 VSS sg13_lv_nmos ad=56.9f pd=0.74u as=0.1019p ps=1.34u w=0.17u l=0.17u
X9455 MOT14_N MOT14_P cml_tlatch_41.xmux.xp.S1 VSS sg13_lv_nmos ad=56.9f pd=0.74u as=56.9f ps=0.74u w=0.17u l=0.17u
X9456 MOT22_N A2_2_P cml_tlatch_51.xmux.xn.S1 VSS sg13_lv_nmos ad=0.1082p pd=1.34u as=63.19999f ps=0.74u w=0.26u l=0.38u
X9457 cml_tlatch_75.xtail.S1 CKHB2_P cml_tlatch_75.xmux.xn.S1 VSS sg13_lv_nmos ad=89.3f pd=0.85u as=89.3f ps=0.85u w=0.47u l=0.16u
X9458 B0_2_P cml_tlatch_29.OUTN cml_tlatch_28.xmux.xn.S1 VSS sg13_lv_nmos ad=63.19999f pd=0.74u as=63.19999f ps=0.74u w=0.26u l=0.38u
X9459 cml_tlatch_47.xmux.xn.S1 CKB3_P cml_tlatch_47.xtail.S1 VSS sg13_lv_nmos ad=89.3f pd=0.85u as=89.3f ps=0.85u w=0.47u l=0.16u
X9460 cml_tlatch_63.xmux.xp.S1 cml_tlatch_63.OUTN cml_tlatch_63.OUTP VSS sg13_lv_nmos ad=56.9f pd=0.74u as=56.9f ps=0.74u w=0.17u l=0.17u
X9461 cml_tlatch_52.xtail.S1 CKA3_N cml_tlatch_52.xmux.xp.S1 VSS sg13_lv_nmos ad=89.3f pd=0.85u as=89.3f ps=0.85u w=0.47u l=0.16u
X9462 cml_tlatch_16.xmux.xp.S1 cml_tlatch_16.OUTN cml_tlatch_16.OUTP VSS sg13_lv_nmos ad=56.9f pd=0.74u as=56.9f ps=0.74u w=0.17u l=0.17u
X9463 cml_tlatch_79.xmux.xp.S1 CKB2_P cml_tlatch_79.xtail.S1 VSS sg13_lv_nmos ad=89.3f pd=0.85u as=89.3f ps=0.85u w=0.47u l=0.16u
X9464 CKHB3_N GB3_P cml_drvb_6.xrtail.R1 VSS sg13_lv_nmos ad=0.2618p pd=2.22u as=0.1463p ps=1.15u w=0.77u l=0.21u
X9465 ENB_N J2_P cml_gate2_8.sg13_lv_nmos_FTPY57_0.D0 VSS sg13_lv_nmos ad=0.1007p pd=0.91u as=0.1007p ps=0.91u w=0.53u l=0.13u
X9466 cml_tlatch_35.xmux.xp.S1 cml_tlatch_35.OUTP cml_tlatch_35.OUTN VSS sg13_lv_nmos ad=56.9f pd=0.74u as=56.9f ps=0.74u w=0.17u l=0.17u
X9467 cml_tlatch_80.xtail.S1 CKB2_N cml_tlatch_80.xmux.xp.S1 VSS sg13_lv_nmos ad=89.3f pd=0.85u as=89.3f ps=0.85u w=0.47u l=0.16u
X9468 cml_tlatch_89.INN cml_tlatch_89.INP cml_tlatch_55.xmux.xp.S1 VSS sg13_lv_nmos ad=56.9f pd=0.74u as=56.9f ps=0.74u w=0.17u l=0.17u
X9469 GA0_N ENA0_P cml_gate2_2.sg13_lv_nmos_FTPY57_0.D0 VSS sg13_lv_nmos ad=0.1007p pd=0.91u as=0.1007p ps=0.91u w=0.53u l=0.13u
X9470 cml_tlatch_22.OUTP cml_tlatch_22.OUTN cml_tlatch_22.xmux.xp.S1 VSS sg13_lv_nmos ad=56.9f pd=0.74u as=56.9f ps=0.74u w=0.17u l=0.17u
X9471 cml_tlatch_21.xmux.xp.S1 A1_8_N A1_8_P VSS sg13_lv_nmos ad=56.9f pd=0.74u as=56.9f ps=0.74u w=0.17u l=0.17u
X9472 cml_tlatch_91.xmux.xp.S1 CLK_W_P CLK_W_N VSS sg13_lv_nmos ad=56.9f pd=0.74u as=56.9f ps=0.74u w=0.17u l=0.17u
X9473 MOT25_P MOT25_N cml_tlatch_68.xmux.xp.S1 VSS sg13_lv_nmos ad=56.9f pd=0.74u as=0.1019p ps=1.34u w=0.17u l=0.17u
X9474 MOT10_P cml_tlatch_39.INN cml_tlatch_39.xmux.xn.S1 VSS sg13_lv_nmos ad=63.19999f pd=0.74u as=63.19999f ps=0.74u w=0.26u l=0.38u
X9475 cml_tlatch_56.xmux.xn.S1 cml_tlatch_56.INN A2_2_P VSS sg13_lv_nmos ad=63.19999f pd=0.74u as=63.19999f ps=0.74u w=0.26u l=0.38u
X9476 A2_2_N cml_tlatch_56.INP cml_tlatch_56.xmux.xn.S1 VSS sg13_lv_nmos ad=63.19999f pd=0.74u as=63.19999f ps=0.74u w=0.26u l=0.38u
X9477 VSS POLN cml_tlatch_5.xtail.S1 VSS sg13_lv_nmos ad=2.7982p pd=17.14u as=1.5637p ps=8.61u w=8.23u l=0.13u
X9478 cml_tlatch_75.xmux.xp.S1 MOT21_P MOT21_N VSS sg13_lv_nmos ad=56.9f pd=0.74u as=56.9f ps=0.74u w=0.17u l=0.17u
X9479 stub_bi_31.BOTP D1_P cml_tlatch_34.xmux.xn.S1 VSS sg13_lv_nmos ad=63.19999f pd=0.74u as=63.19999f ps=0.74u w=0.26u l=0.38u
X9480 cml_tlatch_11.xmux.xp.S1 cml_tlatch_11.OUTN cml_tlatch_11.OUTP VSS sg13_lv_nmos ad=56.9f pd=0.74u as=56.9f ps=0.74u w=0.17u l=0.17u
X9481 cml_tlatch_42.xmux.xp.S1 cml_tlatch_56.INP cml_tlatch_56.INN VSS sg13_lv_nmos ad=56.9f pd=0.74u as=56.9f ps=0.74u w=0.17u l=0.17u
X9482 VSS hs_to_clk_4.sg13_lv_nmos_2HGZLP_0.G VSS VSS sg13_lv_nmos ad=2.071p pd=11.28u as=0 ps=0 w=10.9u l=1.38u
X9483 cml_tlatch_56.INP D2_N cml_tlatch_42.xmux.xn.S1 VSS sg13_lv_nmos ad=63.19999f pd=0.74u as=0.1082p ps=1.34u w=0.26u l=0.38u
X9484 hs_to_clk_6.D2 POLN VSS VSS sg13_lv_nmos ad=1.9p pd=10.38u as=1.9p ps=10.38u w=10u l=0.13u
X9485 cml_tlatch_16.xmux.xp.S1 CKB0_P cml_tlatch_16.xtail.S1 VSS sg13_lv_nmos ad=89.3f pd=0.85u as=89.3f ps=0.85u w=0.47u l=0.16u
X9486 cml_tlatch_45.OUTN B3_2_P cml_tlatch_45.xmux.xn.S1 VSS sg13_lv_nmos ad=63.19999f pd=0.74u as=63.19999f ps=0.74u w=0.26u l=0.38u
X9487 A0_2_P A0_2_N cml_tlatch_31.xmux.xp.S1 VSS sg13_lv_nmos ad=56.9f pd=0.74u as=56.9f ps=0.74u w=0.17u l=0.17u
X9488 cml_tlatch_60.xmux.xp.S1 B3_8_P B3_8_N VSS sg13_lv_nmos ad=56.9f pd=0.74u as=56.9f ps=0.74u w=0.17u l=0.17u
X9489 cml_tlatch_27.OUTN VDD VSS rppd l=5.17u w=1u
X9490 cml_tlatch_6.INP cml_tlatch_6.INN cml_tlatch_94.xmux.xp.S1 VSS sg13_lv_nmos ad=56.9f pd=0.74u as=56.9f ps=0.74u w=0.17u l=0.17u
X9491 cml_tlatch_15.xmux.xn.S1 cml_tlatch_6.INP stub_bi_19.BOTP VSS sg13_lv_nmos ad=0.1082p pd=1.34u as=63.19999f ps=0.74u w=0.26u l=0.38u
X9492 cml_tlatch_10.xtail.S1 CKB0_N cml_tlatch_10.xmux.xn.S1 VSS sg13_lv_nmos ad=89.3f pd=0.85u as=89.3f ps=0.85u w=0.47u l=0.16u
X9493 cml_tlatch_61.xmux.xp.S1 cml_tlatch_61.OUTP cml_tlatch_61.OUTN VSS sg13_lv_nmos ad=56.9f pd=0.74u as=56.9f ps=0.74u w=0.17u l=0.17u
X9494 cml_tlatch_58.xtail.S1 CKHA3_P cml_tlatch_58.xmux.xn.S1 VSS sg13_lv_nmos ad=89.3f pd=0.85u as=0.1598p ps=1.62u w=0.47u l=0.16u
X9495 cml_tlatch_27.OUTP cml_tlatch_27.OUTN cml_tlatch_27.xmux.xp.S1 VSS sg13_lv_nmos ad=56.9f pd=0.74u as=56.9f ps=0.74u w=0.17u l=0.17u
X9496 cml_tlatch_84.xtail.S1 CKB3_N cml_tlatch_84.xmux.xn.S1 VSS sg13_lv_nmos ad=89.3f pd=0.85u as=0.1598p ps=1.62u w=0.47u l=0.16u
X9497 MOT29_N cml_tlatch_70.INP cml_tlatch_70.xmux.xn.S1 VSS sg13_lv_nmos ad=63.19999f pd=0.74u as=63.19999f ps=0.74u w=0.26u l=0.38u
X9498 cml_tlatch_17.xmux.xn.S1 CKHB0_P cml_tlatch_17.xtail.S1 VSS sg13_lv_nmos ad=89.3f pd=0.85u as=89.3f ps=0.85u w=0.47u l=0.16u
X9499 cml_gate2_4.sg13_lv_nmos_FTPY57_0.D0 ENA1_N GA2_P VSS sg13_lv_nmos ad=0.1007p pd=0.91u as=0.1007p ps=0.91u w=0.53u l=0.13u
X9500 MOT22_P MOT22_N cml_tlatch_51.xmux.xp.S1 VSS sg13_lv_nmos ad=56.9f pd=0.74u as=56.9f ps=0.74u w=0.17u l=0.17u
X9501 cml_tlatch_45.xmux.xp.S1 cml_tlatch_45.OUTN cml_tlatch_45.OUTP VSS sg13_lv_nmos ad=56.9f pd=0.74u as=56.9f ps=0.74u w=0.17u l=0.17u
X9502 cml_tlatch_59.xmux.xp.S1 MOT30_P MOT30_N VSS sg13_lv_nmos ad=56.9f pd=0.74u as=56.9f ps=0.74u w=0.17u l=0.17u
X9503 cml_gate2_3.sg13_lv_nmos_FTPY57_0.D0 ENA0_N GA1_P VSS sg13_lv_nmos ad=0.1802p pd=1.74u as=0.1007p ps=0.91u w=0.53u l=0.13u
X9504 cml_tlatch_61.xmux.xp.S1 cml_tlatch_61.OUTP cml_tlatch_61.OUTN VSS sg13_lv_nmos ad=0.1019p pd=1.34u as=56.9f ps=0.74u w=0.17u l=0.17u
X9505 cml_tlatch_29.xmux.xn.S1 CKB0_P cml_tlatch_29.xtail.S1 VSS sg13_lv_nmos ad=89.3f pd=0.85u as=89.3f ps=0.85u w=0.47u l=0.16u
X9506 cml_tlatch_44.xtail.S1 CKB2_P cml_tlatch_44.xmux.xp.S1 VSS sg13_lv_nmos ad=89.3f pd=0.85u as=89.3f ps=0.85u w=0.47u l=0.16u
X9507 cml_tlatch_5.xmux.xn.S1 cml_tlatch_5.INP MOT11_N VSS sg13_lv_nmos ad=63.19999f pd=0.74u as=63.19999f ps=0.74u w=0.26u l=0.38u
X9508 cml_tlatch_70.INP cml_tlatch_70.INN cml_tlatch_84.xmux.xp.S1 VSS sg13_lv_nmos ad=56.9f pd=0.74u as=56.9f ps=0.74u w=0.17u l=0.17u
X9509 CLK_W_P CLK_W_N cml_tlatch_91.xmux.xp.S1 VSS sg13_lv_nmos ad=56.9f pd=0.74u as=56.9f ps=0.74u w=0.17u l=0.17u
X9510 cml_tlatch_36.xmux.xp.S1 cml_tlatch_95.INP cml_tlatch_95.INN VSS sg13_lv_nmos ad=56.9f pd=0.74u as=56.9f ps=0.74u w=0.17u l=0.17u
X9511 stub_bi_17.BOTP stub_bi_17.BOTN cml_tlatch_13.xmux.xp.S1 VSS sg13_lv_nmos ad=56.9f pd=0.74u as=56.9f ps=0.74u w=0.17u l=0.17u
X9512 cml_tlatch_63.xmux.xp.S1 cml_tlatch_63.OUTN cml_tlatch_63.OUTP VSS sg13_lv_nmos ad=56.9f pd=0.74u as=56.9f ps=0.74u w=0.17u l=0.17u
X9513 cml_tlatch_65.xmux.xp.S1 CKA3_N cml_tlatch_65.xtail.S1 VSS sg13_lv_nmos ad=0.1598p pd=1.62u as=89.3f ps=0.85u w=0.47u l=0.16u
X9514 cml_gate2_6.xrtail.R1 CKA3_P cml_gate2_6.sg13_lv_nmos_FTPY57_0.D0 VSS sg13_lv_nmos ad=0.1802p pd=1.74u as=0.1007p ps=0.91u w=0.53u l=0.13u
X9515 cml_tlatch_89.xtail.S1 CKA2_N cml_tlatch_89.xmux.xn.S1 VSS sg13_lv_nmos ad=89.3f pd=0.85u as=89.3f ps=0.85u w=0.47u l=0.16u
X9516 cml_tlatch_83.INP cml_tlatch_83.INN cml_tlatch_72.xmux.xp.S1 VSS sg13_lv_nmos ad=56.9f pd=0.74u as=56.9f ps=0.74u w=0.17u l=0.17u
X9517 cml_tlatch_1.xmux.xp.S1 cml_tlatch_1.OUTP cml_tlatch_1.OUTN VSS sg13_lv_nmos ad=56.9f pd=0.74u as=56.9f ps=0.74u w=0.17u l=0.17u
X9518 cml_tlatch_38.OUTP cml_tlatch_38.OUTN cml_tlatch_38.xmux.xp.S1 VSS sg13_lv_nmos ad=56.9f pd=0.74u as=56.9f ps=0.74u w=0.17u l=0.17u
X9519 cml_tlatch_99.xmux.xp.S1 cml_tlatch_99.OUTN cml_tlatch_99.OUTP VSS sg13_lv_nmos ad=56.9f pd=0.74u as=56.9f ps=0.74u w=0.17u l=0.17u
X9520 cml_tlatch_89.OUTN cml_tlatch_89.OUTP cml_tlatch_89.xmux.xp.S1 VSS sg13_lv_nmos ad=56.9f pd=0.74u as=56.9f ps=0.74u w=0.17u l=0.17u
X9521 cml_tlatch_54.xmux.xp.S1 CKA3_N cml_tlatch_54.xtail.S1 VSS sg13_lv_nmos ad=89.3f pd=0.85u as=89.3f ps=0.85u w=0.47u l=0.16u
X9522 cml_tlatch_88.xmux.xp.S1 stub_bi_55.BOTN stub_bi_55.BOTP VSS sg13_lv_nmos ad=56.9f pd=0.74u as=56.9f ps=0.74u w=0.17u l=0.17u
X9523 cml_tlatch_26.xmux.xp.S1 MOT6_N MOT6_P VSS sg13_lv_nmos ad=56.9f pd=0.74u as=56.9f ps=0.74u w=0.17u l=0.17u
X9524 cml_tlatch_98.xtail.S1 CKB0_P cml_tlatch_98.xmux.xp.S1 VSS sg13_lv_nmos ad=89.3f pd=0.85u as=0.1598p ps=1.62u w=0.47u l=0.16u
X9525 cml_tlatch_20.xmux.xp.S1 MOT7_P MOT7_N VSS sg13_lv_nmos ad=56.9f pd=0.74u as=56.9f ps=0.74u w=0.17u l=0.17u
X9526 cml_tlatch_30.xmux.xp.S1 CKA0_N cml_tlatch_30.xtail.S1 VSS sg13_lv_nmos ad=89.3f pd=0.85u as=0.1598p ps=1.62u w=0.47u l=0.16u
X9527 cml_tlatch_97.xtail.S1 CKHA0_P cml_tlatch_97.xmux.xn.S1 VSS sg13_lv_nmos ad=89.3f pd=0.85u as=89.3f ps=0.85u w=0.47u l=0.16u
X9528 cml_tlatch_72.xtail.S1 CKA2_P cml_tlatch_72.xmux.xn.S1 VSS sg13_lv_nmos ad=89.3f pd=0.85u as=89.3f ps=0.85u w=0.47u l=0.16u
X9529 GB1_P ENB1_N cml_gate2_0.sg13_lv_nmos_FTPY57_0.D0 VSS sg13_lv_nmos ad=0.1007p pd=0.91u as=0.1007p ps=0.91u w=0.53u l=0.13u
X9530 MOT4_P MOT4_N cml_tlatch_25.xmux.xp.S1 VSS sg13_lv_nmos ad=56.9f pd=0.74u as=56.9f ps=0.74u w=0.17u l=0.17u
X9531 MOT2_N MOT2_P cml_tlatch_24.xmux.xp.S1 VSS sg13_lv_nmos ad=56.9f pd=0.74u as=56.9f ps=0.74u w=0.17u l=0.17u
X9532 A3_8_P A3_8_N cml_tlatch_64.xmux.xp.S1 VSS sg13_lv_nmos ad=56.9f pd=0.74u as=56.9f ps=0.74u w=0.17u l=0.17u
X9533 cml_tlatch_92.xtail.S1 CKJ_N cml_tlatch_92.xmux.xn.S1 VSS sg13_lv_nmos ad=89.3f pd=0.85u as=89.3f ps=0.85u w=0.47u l=0.16u
X9534 GB3_P CKA3_N cml_gate2_6.xrtail.R1 VSS sg13_lv_nmos ad=0.1007p pd=0.91u as=0.1007p ps=0.91u w=0.53u l=0.13u
X9535 cml_tlatch_84.xtail.S1 POLN VSS VSS sg13_lv_nmos ad=1.5637p pd=8.61u as=2.7982p ps=17.14u w=8.23u l=0.13u
X9536 B0_8_N B0_8_P cml_tlatch_10.xmux.xp.S1 VSS sg13_lv_nmos ad=56.9f pd=0.74u as=56.9f ps=0.74u w=0.17u l=0.17u
X9537 cml_tlatch_74.xmux.xn.S1 stub_bi_63.BOTP MOT19_P VSS sg13_lv_nmos ad=63.19999f pd=0.74u as=63.19999f ps=0.74u w=0.26u l=0.38u
X9538 cml_tlatch_89.xtail.S1 CKA2_P cml_tlatch_89.xmux.xp.S1 VSS sg13_lv_nmos ad=89.3f pd=0.85u as=89.3f ps=0.85u w=0.47u l=0.16u
X9539 cml_tlatch_71.xtail.S1 CKHB3_P cml_tlatch_71.xmux.xn.S1 VSS sg13_lv_nmos ad=89.3f pd=0.85u as=89.3f ps=0.85u w=0.47u l=0.16u
X9540 cml_tlatch_80.xtail.S1 CKB2_P cml_tlatch_80.xmux.xn.S1 VSS sg13_lv_nmos ad=0.1598p pd=1.62u as=89.3f ps=0.85u w=0.47u l=0.16u
X9541 cml_tlatch_3.xmux.xn.S1 CKA0_P cml_tlatch_3.xtail.S1 VSS sg13_lv_nmos ad=89.3f pd=0.85u as=89.3f ps=0.85u w=0.47u l=0.16u
X9542 cml_tlatch_60.xtail.S1 CKB3_P cml_tlatch_60.xmux.xp.S1 VSS sg13_lv_nmos ad=89.3f pd=0.85u as=89.3f ps=0.85u w=0.47u l=0.16u
X9543 B1_8_P B1_8_N cml_tlatch_12.xmux.xp.S1 VSS sg13_lv_nmos ad=56.9f pd=0.74u as=56.9f ps=0.74u w=0.17u l=0.17u
X9544 cml_tlatch_44.xmux.xp.S1 B2_2_N B2_2_P VSS sg13_lv_nmos ad=56.9f pd=0.74u as=56.9f ps=0.74u w=0.17u l=0.17u
X9545 VDD J1_N VSS rppd l=5.17u w=1u
X9546 cml_tlatch_9.OUTP cml_tlatch_9.OUTN cml_tlatch_9.xmux.xp.S1 VSS sg13_lv_nmos ad=56.9f pd=0.74u as=56.9f ps=0.74u w=0.17u l=0.17u
X9547 cml_tlatch_36.xtail.S1 CKA1_P cml_tlatch_36.xmux.xn.S1 VSS sg13_lv_nmos ad=89.3f pd=0.85u as=89.3f ps=0.85u w=0.47u l=0.16u
X9548 VSS POLN cml_tlatch_86.xtail.S1 VSS sg13_lv_nmos ad=1.5637p pd=8.61u as=1.5637p ps=8.61u w=8.23u l=0.13u
X9549 cml_tlatch_75.xmux.xp.S1 MOT21_P MOT21_N VSS sg13_lv_nmos ad=0.1019p pd=1.34u as=56.9f ps=0.74u w=0.17u l=0.17u
X9550 VSS POLN cml_tlatch_51.xtail.S1 VSS sg13_lv_nmos ad=1.5637p pd=8.61u as=1.5637p ps=8.61u w=8.23u l=0.13u
X9551 B2_8_P stub_bi_62.BOTP cml_tlatch_77.xmux.xn.S1 VSS sg13_lv_nmos ad=63.19999f pd=0.74u as=63.19999f ps=0.74u w=0.26u l=0.38u
X9552 MOT29_N MOT29_P cml_tlatch_70.xmux.xp.S1 VSS sg13_lv_nmos ad=56.9f pd=0.74u as=56.9f ps=0.74u w=0.17u l=0.17u
X9553 cml_tlatch_16.xmux.xn.S1 cml_tlatch_1.OUTN cml_tlatch_16.OUTP VSS sg13_lv_nmos ad=63.19999f pd=0.74u as=0.1082p ps=1.34u w=0.26u l=0.38u
X9554 cml_tlatch_11.OUTN cml_tlatch_11.OUTP cml_tlatch_11.xmux.xp.S1 VSS sg13_lv_nmos ad=56.9f pd=0.74u as=56.9f ps=0.74u w=0.17u l=0.17u
X9555 cml_tlatch_61.OUTP cml_tlatch_61.OUTN cml_tlatch_61.xmux.xp.S1 VSS sg13_lv_nmos ad=56.9f pd=0.74u as=56.9f ps=0.74u w=0.17u l=0.17u
X9556 cml_tlatch_34.xmux.xp.S1 CKB1_N cml_tlatch_34.xtail.S1 VSS sg13_lv_nmos ad=89.3f pd=0.85u as=89.3f ps=0.85u w=0.47u l=0.16u
X9557 cml_tlatch_88.xtail.S1 CKB2_P cml_tlatch_88.xmux.xp.S1 VSS sg13_lv_nmos ad=89.3f pd=0.85u as=89.3f ps=0.85u w=0.47u l=0.16u
X9558 cml_tlatch_31.xmux.xp.S1 A0_2_P A0_2_N VSS sg13_lv_nmos ad=56.9f pd=0.74u as=56.9f ps=0.74u w=0.17u l=0.17u
X9559 GA0_P ENA0_N cml_gate2_2.sg13_lv_nmos_FTPY57_0.D0 VSS sg13_lv_nmos ad=0.1007p pd=0.91u as=0.1007p ps=0.91u w=0.53u l=0.13u
X9560 cml_tlatch_6.xmux.xp.S1 MOT13_P MOT13_N VSS sg13_lv_nmos ad=56.9f pd=0.74u as=56.9f ps=0.74u w=0.17u l=0.17u
X9561 cml_tlatch_52.OUTN cml_tlatch_52.OUTP cml_tlatch_52.xmux.xp.S1 VSS sg13_lv_nmos ad=56.9f pd=0.74u as=56.9f ps=0.74u w=0.17u l=0.17u
X9562 stub_bi_49.BOTN stub_bi_49.BOTP cml_tlatch_80.xmux.xp.S1 VSS sg13_lv_nmos ad=56.9f pd=0.74u as=0.1019p ps=1.34u w=0.17u l=0.17u
X9563 cml_tlatch_66.xmux.xn.S1 cml_tlatch_67.OUTP cml_tlatch_57.INN VSS sg13_lv_nmos ad=63.19999f pd=0.74u as=63.19999f ps=0.74u w=0.26u l=0.38u
X9564 cml_tlatch_26.xmux.xn.S1 CKHA0_P cml_tlatch_26.xtail.S1 VSS sg13_lv_nmos ad=0.1598p pd=1.62u as=89.3f ps=0.85u w=0.47u l=0.16u
X9565 cml_tlatch_32.xtail.S1 CKB1_P cml_tlatch_32.xmux.xn.S1 VSS sg13_lv_nmos ad=89.3f pd=0.85u as=89.3f ps=0.85u w=0.47u l=0.16u
X9566 cml_tlatch_83.OUTP cml_tlatch_83.OUTN cml_tlatch_83.xmux.xp.S1 VSS sg13_lv_nmos ad=56.9f pd=0.74u as=56.9f ps=0.74u w=0.17u l=0.17u
X9567 cml_tlatch_79.xtail.S1 CKB2_P cml_tlatch_79.xmux.xp.S1 VSS sg13_lv_nmos ad=89.3f pd=0.85u as=0.1598p ps=1.62u w=0.47u l=0.16u
X9568 cml_tlatch_55.xtail.S1 CKA2_P cml_tlatch_55.xmux.xn.S1 VSS sg13_lv_nmos ad=89.3f pd=0.85u as=89.3f ps=0.85u w=0.47u l=0.16u
X9569 MOT7_P MOT7_N cml_tlatch_20.xmux.xp.S1 VSS sg13_lv_nmos ad=56.9f pd=0.74u as=56.9f ps=0.74u w=0.17u l=0.17u
X9570 cml_tlatch_8.xmux.xn.S1 CKA0_N cml_tlatch_8.xtail.S1 VSS sg13_lv_nmos ad=89.3f pd=0.85u as=89.3f ps=0.85u w=0.47u l=0.16u
X9571 MOT22_P MOT22_N cml_tlatch_51.xmux.xp.S1 VSS sg13_lv_nmos ad=56.9f pd=0.74u as=56.9f ps=0.74u w=0.17u l=0.17u
X9572 MOT16_N MOT16_P cml_tlatch_87.xmux.xp.S1 VSS sg13_lv_nmos ad=56.9f pd=0.74u as=56.9f ps=0.74u w=0.17u l=0.17u
X9573 cml_tlatch_59.xmux.xp.S1 MOT30_N MOT30_P VSS sg13_lv_nmos ad=56.9f pd=0.74u as=56.9f ps=0.74u w=0.17u l=0.17u
X9574 cml_tlatch_36.xmux.xp.S1 cml_tlatch_95.INP cml_tlatch_95.INN VSS sg13_lv_nmos ad=56.9f pd=0.74u as=56.9f ps=0.74u w=0.17u l=0.17u
X9575 cml_gate2_8.sg13_lv_nmos_FTPY57_0.D0 J2_N ENB_P VSS sg13_lv_nmos ad=0.1802p pd=1.74u as=0.1007p ps=0.91u w=0.53u l=0.13u
X9576 MOT0_P A0_8_N cml_tlatch_97.xmux.xn.S1 VSS sg13_lv_nmos ad=63.19999f pd=0.74u as=63.19999f ps=0.74u w=0.26u l=0.38u
X9577 stub_bi_29.BOTP stub_bi_29.BOTN cml_tlatch_32.xmux.xp.S1 VSS sg13_lv_nmos ad=56.9f pd=0.74u as=56.9f ps=0.74u w=0.17u l=0.17u
X9578 MOT23_N MOT23_P cml_tlatch_76.xmux.xp.S1 VSS sg13_lv_nmos ad=56.9f pd=0.74u as=56.9f ps=0.74u w=0.17u l=0.17u
X9579 cml_tlatch_63.xtail.S1 POLN VSS VSS sg13_lv_nmos ad=1.5637p pd=8.61u as=1.5637p ps=8.61u w=8.23u l=0.13u
X9580 MOT27_N VDD VSS rppd l=5.17u w=1u
X9581 cml_tlatch_13.xmux.xp.S1 stub_bi_17.BOTP stub_bi_17.BOTN VSS sg13_lv_nmos ad=0.1019p pd=1.34u as=56.9f ps=0.74u w=0.17u l=0.17u
X9582 cml_tlatch_89.OUTP cml_tlatch_89.INN cml_tlatch_89.xmux.xn.S1 VSS sg13_lv_nmos ad=63.19999f pd=0.74u as=63.19999f ps=0.74u w=0.26u l=0.38u
X9583 cml_tlatch_5.xmux.xp.S1 MOT11_N MOT11_P VSS sg13_lv_nmos ad=56.9f pd=0.74u as=56.9f ps=0.74u w=0.17u l=0.17u
X9584 cml_drv_3.xrtail.R1 ENA_N ENA0_P VSS sg13_lv_nmos ad=0.1012p pd=1.34u as=56.2f ps=0.74u w=0.16u l=0.19u
X9585 cml_tlatch_89.xmux.xp.S1 cml_tlatch_89.OUTN cml_tlatch_89.OUTP VSS sg13_lv_nmos ad=56.9f pd=0.74u as=56.9f ps=0.74u w=0.17u l=0.17u
X9586 hs_to_clk_8.D2 CK_P CKJ_P VSS sg13_lv_nmos ad=0.228p pd=1.58u as=0.228p ps=1.58u w=1.2u l=0.2u
X9587 cml_tlatch_62.xtail.S1 CKB3_P cml_tlatch_62.xmux.xp.S1 VSS sg13_lv_nmos ad=89.3f pd=0.85u as=89.3f ps=0.85u w=0.47u l=0.16u
X9588 cml_tlatch_23.xmux.xp.S1 CKA1_P cml_tlatch_23.xtail.S1 VSS sg13_lv_nmos ad=0.1598p pd=1.62u as=89.3f ps=0.85u w=0.47u l=0.16u
X9589 cml_drv_2.xrtail.R1 ENB_N ENB0_P VSS sg13_lv_nmos ad=56.2f pd=0.74u as=56.2f ps=0.74u w=0.16u l=0.19u
X9590 B0_2_P cml_tlatch_29.OUTN cml_tlatch_28.xmux.xn.S1 VSS sg13_lv_nmos ad=63.19999f pd=0.74u as=63.19999f ps=0.74u w=0.26u l=0.38u
X9591 cml_tlatch_27.xmux.xp.S1 CKB0_N cml_tlatch_27.xtail.S1 VSS sg13_lv_nmos ad=89.3f pd=0.85u as=89.3f ps=0.85u w=0.47u l=0.16u
X9592 cml_tlatch_18.xtail.S1 CKHB0_N cml_tlatch_18.xmux.xp.S1 VSS sg13_lv_nmos ad=89.3f pd=0.85u as=89.3f ps=0.85u w=0.47u l=0.16u
X9593 MOT5_N cml_tlatch_98.OUTP cml_tlatch_19.xmux.xn.S1 VSS sg13_lv_nmos ad=63.19999f pd=0.74u as=63.19999f ps=0.74u w=0.26u l=0.38u
X9594 A3_8_N cml_tlatch_65.OUTP cml_tlatch_64.xmux.xn.S1 VSS sg13_lv_nmos ad=63.19999f pd=0.74u as=63.19999f ps=0.74u w=0.26u l=0.38u
X9595 cml_tlatch_64.xtail.S1 CKA3_N cml_tlatch_64.xmux.xn.S1 VSS sg13_lv_nmos ad=89.3f pd=0.85u as=89.3f ps=0.85u w=0.47u l=0.16u
X9596 cml_tlatch_1.xtail.S1 CKB0_P cml_tlatch_1.xmux.xn.S1 VSS sg13_lv_nmos ad=89.3f pd=0.85u as=89.3f ps=0.85u w=0.47u l=0.16u
X9597 MOT8_P MOT8_N cml_tlatch_96.xmux.xp.S1 VSS sg13_lv_nmos ad=56.9f pd=0.74u as=56.9f ps=0.74u w=0.17u l=0.17u
X9598 GA3_P CKB3_N cml_gate2_5.xrtail.R1 VSS sg13_lv_nmos ad=0.1007p pd=0.91u as=0.1007p ps=0.91u w=0.53u l=0.13u
X9599 cml_tlatch_20.xmux.xp.S1 MOT7_P MOT7_N VSS sg13_lv_nmos ad=56.9f pd=0.74u as=56.9f ps=0.74u w=0.17u l=0.17u
X9600 cml_tlatch_69.xmux.xp.S1 MOT27_N MOT27_P VSS sg13_lv_nmos ad=56.9f pd=0.74u as=56.9f ps=0.74u w=0.17u l=0.17u
X9601 cml_tlatch_49.xmux.xp.S1 CKHA2_N cml_tlatch_49.xtail.S1 VSS sg13_lv_nmos ad=89.3f pd=0.85u as=0.1598p ps=1.62u w=0.47u l=0.16u
X9602 cml_tlatch_47.OUTP cml_tlatch_47.OUTN cml_tlatch_47.xmux.xp.S1 VSS sg13_lv_nmos ad=56.9f pd=0.74u as=56.9f ps=0.74u w=0.17u l=0.17u
X9603 cml_tlatch_95.xmux.xp.S1 cml_tlatch_40.INP cml_tlatch_40.INN VSS sg13_lv_nmos ad=56.9f pd=0.74u as=56.9f ps=0.74u w=0.17u l=0.17u
X9604 A3_2_P A3_2_N cml_tlatch_53.xmux.xp.S1 VSS sg13_lv_nmos ad=56.9f pd=0.74u as=56.9f ps=0.74u w=0.17u l=0.17u
X9605 cml_tlatch_27.xmux.xn.S1 B0_2_N cml_tlatch_27.OUTP VSS sg13_lv_nmos ad=63.19999f pd=0.74u as=63.19999f ps=0.74u w=0.26u l=0.38u
X9606 cml_tlatch_57.xmux.xn.S1 cml_tlatch_57.INP MOT26_N VSS sg13_lv_nmos ad=0.1082p pd=1.34u as=63.19999f ps=0.74u w=0.26u l=0.38u
X9607 interco_bi_19.INN interco_bi_19.INP cml_tlatch_0.xmux.xp.S1 VSS sg13_lv_nmos ad=56.9f pd=0.74u as=56.9f ps=0.74u w=0.17u l=0.17u
X9608 cml_tlatch_38.xmux.xn.S1 CKA1_P cml_tlatch_38.xtail.S1 VSS sg13_lv_nmos ad=89.3f pd=0.85u as=89.3f ps=0.85u w=0.47u l=0.16u
X9609 GA3_P ENA1_N cml_gate2_5.sg13_lv_nmos_FTPY57_0.D0 VSS sg13_lv_nmos ad=0.1007p pd=0.91u as=0.1007p ps=0.91u w=0.53u l=0.13u
X9610 stub_bi_62.BOTP stub_bi_62.BOTN cml_tlatch_78.xmux.xp.S1 VSS sg13_lv_nmos ad=56.9f pd=0.74u as=56.9f ps=0.74u w=0.17u l=0.17u
X9611 cml_tlatch_96.xtail.S1 CKHA1_N cml_tlatch_96.xmux.xp.S1 VSS sg13_lv_nmos ad=89.3f pd=0.85u as=89.3f ps=0.85u w=0.47u l=0.16u
X9612 cml_tlatch_44.xmux.xp.S1 CKB2_P cml_tlatch_44.xtail.S1 VSS sg13_lv_nmos ad=89.3f pd=0.85u as=89.3f ps=0.85u w=0.47u l=0.16u
X9613 stub_bi_63.BOTP stub_bi_63.BOTN cml_tlatch_79.xmux.xp.S1 VSS sg13_lv_nmos ad=56.9f pd=0.74u as=56.9f ps=0.74u w=0.17u l=0.17u
X9614 cml_gate2_7.sg13_lv_nmos_FTPY57_0.D0 ENB0_P GB2_N VSS sg13_lv_nmos ad=0.1007p pd=0.91u as=0.1007p ps=0.91u w=0.53u l=0.13u
X9615 B0_8_N B0_8_P cml_tlatch_10.xmux.xp.S1 VSS sg13_lv_nmos ad=56.9f pd=0.74u as=56.9f ps=0.74u w=0.17u l=0.17u
X9616 cml_tlatch_78.xmux.xn.S1 stub_bi_63.BOTP stub_bi_62.BOTN VSS sg13_lv_nmos ad=63.19999f pd=0.74u as=63.19999f ps=0.74u w=0.26u l=0.38u
X9617 cml_tlatch_18.xmux.xp.S1 MOT3_P MOT3_N VSS sg13_lv_nmos ad=56.9f pd=0.74u as=56.9f ps=0.74u w=0.17u l=0.17u
X9618 MOT13_P cml_tlatch_6.INN cml_tlatch_6.xmux.xn.S1 VSS sg13_lv_nmos ad=63.19999f pd=0.74u as=63.19999f ps=0.74u w=0.26u l=0.38u
X9619 cml_tlatch_85.xmux.xn.S1 cml_tlatch_52.OUTP cml_tlatch_58.INN VSS sg13_lv_nmos ad=63.19999f pd=0.74u as=63.19999f ps=0.74u w=0.26u l=0.38u
X9620 cml_tlatch_53.xmux.xp.S1 CKA3_P cml_tlatch_53.xtail.S1 VSS sg13_lv_nmos ad=89.3f pd=0.85u as=0.1598p ps=1.62u w=0.47u l=0.16u
X9621 cml_tlatch_49.xmux.xp.S1 MOT18_P MOT18_N VSS sg13_lv_nmos ad=56.9f pd=0.74u as=56.9f ps=0.74u w=0.17u l=0.17u
X9622 cml_tlatch_30.xmux.xp.S1 cml_tlatch_30.OUTP cml_tlatch_30.OUTN VSS sg13_lv_nmos ad=56.9f pd=0.74u as=56.9f ps=0.74u w=0.17u l=0.17u
X9623 cml_tlatch_57.xmux.xp.S1 CKHA3_N cml_tlatch_57.xtail.S1 VSS sg13_lv_nmos ad=89.3f pd=0.85u as=89.3f ps=0.85u w=0.47u l=0.16u
X9624 stub_bi_31.BOTN D1_N cml_tlatch_34.xmux.xn.S1 VSS sg13_lv_nmos ad=63.19999f pd=0.74u as=63.19999f ps=0.74u w=0.26u l=0.38u
X9625 MOT24_N MOT24_P cml_tlatch_86.xmux.xp.S1 VSS sg13_lv_nmos ad=56.9f pd=0.74u as=56.9f ps=0.74u w=0.17u l=0.17u
X9626 MOT24_P MOT24_N cml_tlatch_86.xmux.xp.S1 VSS sg13_lv_nmos ad=56.9f pd=0.74u as=56.9f ps=0.74u w=0.17u l=0.17u
X9627 CKHB0_P GB0_N cml_drvb_1.xrtail.R1 VSS sg13_lv_nmos ad=0.2618p pd=2.22u as=0.1463p ps=1.15u w=0.77u l=0.21u
X9628 VDD A1_2_N VSS rppd l=5.17u w=1u
X9629 cml_tlatch_49.xmux.xn.S1 cml_tlatch_83.OUTN MOT18_P VSS sg13_lv_nmos ad=63.19999f pd=0.74u as=63.19999f ps=0.74u w=0.26u l=0.38u
X9630 cml_tlatch_46.xmux.xn.S1 cml_tlatch_47.OUTP B3_2_N VSS sg13_lv_nmos ad=0.1082p pd=1.34u as=63.19999f ps=0.74u w=0.26u l=0.38u
X9631 cml_tlatch_90.xtail.S1 CKJ_N cml_tlatch_90.xmux.xn.S1 VSS sg13_lv_nmos ad=89.3f pd=0.85u as=89.3f ps=0.85u w=0.47u l=0.16u
X9632 cml_tlatch_45.xtail.S1 CKB3_N cml_tlatch_45.xmux.xp.S1 VSS sg13_lv_nmos ad=89.3f pd=0.85u as=89.3f ps=0.85u w=0.47u l=0.16u
X9633 VSS POLN cml_tlatch_54.xtail.S1 VSS sg13_lv_nmos ad=1.5637p pd=8.61u as=1.5637p ps=8.61u w=8.23u l=0.13u
X9634 MOT3_P cml_tlatch_16.OUTN cml_tlatch_18.xmux.xn.S1 VSS sg13_lv_nmos ad=0.1082p pd=1.34u as=63.19999f ps=0.74u w=0.26u l=0.38u
X9635 MOT13_P MOT13_N cml_tlatch_6.xmux.xp.S1 VSS sg13_lv_nmos ad=56.9f pd=0.74u as=56.9f ps=0.74u w=0.17u l=0.17u
X9636 cml_gate2_0.sg13_lv_nmos_FTPY57_0.D0 ENB1_P GB1_N VSS sg13_lv_nmos ad=0.1802p pd=1.74u as=0.1007p ps=0.91u w=0.53u l=0.13u
X9637 cml_tlatch_83.xtail.S1 CKA2_N cml_tlatch_83.xmux.xn.S1 VSS sg13_lv_nmos ad=89.3f pd=0.85u as=89.3f ps=0.85u w=0.47u l=0.16u
X9638 cml_tlatch_34.xmux.xn.S1 CKB1_P cml_tlatch_34.xtail.S1 VSS sg13_lv_nmos ad=89.3f pd=0.85u as=89.3f ps=0.85u w=0.47u l=0.16u
X9639 B2_8_N B2_8_P cml_tlatch_77.xmux.xp.S1 VSS sg13_lv_nmos ad=56.9f pd=0.74u as=56.9f ps=0.74u w=0.17u l=0.17u
X9640 cml_tlatch_47.xmux.xn.S1 D3_N cml_tlatch_47.OUTP VSS sg13_lv_nmos ad=63.19999f pd=0.74u as=63.19999f ps=0.74u w=0.26u l=0.38u
X9641 MOT1_P MOT1_N cml_tlatch_17.xmux.xp.S1 VSS sg13_lv_nmos ad=56.9f pd=0.74u as=56.9f ps=0.74u w=0.17u l=0.17u
X9642 cml_tlatch_96.xmux.xp.S1 MOT8_P MOT8_N VSS sg13_lv_nmos ad=56.9f pd=0.74u as=56.9f ps=0.74u w=0.17u l=0.17u
X9643 cml_tlatch_34.xmux.xp.S1 stub_bi_31.BOTP stub_bi_31.BOTN VSS sg13_lv_nmos ad=0.1019p pd=1.34u as=56.9f ps=0.74u w=0.17u l=0.17u
X9644 cml_tlatch_46.xmux.xn.S1 cml_tlatch_47.OUTP B3_2_N VSS sg13_lv_nmos ad=63.19999f pd=0.74u as=63.19999f ps=0.74u w=0.26u l=0.38u
X9645 cml_tlatch_67.OUTN cml_tlatch_67.OUTP cml_tlatch_67.xmux.xp.S1 VSS sg13_lv_nmos ad=56.9f pd=0.74u as=56.9f ps=0.74u w=0.17u l=0.17u
X9646 VSS cml_drvb_7.xrtail.R1 VSS rppd l=2.72u w=1u
X9647 cml_tlatch_81.xtail.S1 POLN VSS VSS sg13_lv_nmos ad=1.5637p pd=8.61u as=2.7982p ps=17.14u w=8.23u l=0.13u
X9648 cml_tlatch_37.xmux.xn.S1 cml_tlatch_38.OUTP A1_2_N VSS sg13_lv_nmos ad=63.19999f pd=0.74u as=63.19999f ps=0.74u w=0.26u l=0.38u
X9649 MOT12_P MOT12_N cml_tlatch_40.xmux.xp.S1 VSS sg13_lv_nmos ad=56.9f pd=0.74u as=56.9f ps=0.74u w=0.17u l=0.17u
X9650 cml_tlatch_8.xmux.xp.S1 cml_tlatch_8.OUTN cml_tlatch_8.OUTP VSS sg13_lv_nmos ad=56.9f pd=0.74u as=56.9f ps=0.74u w=0.17u l=0.17u
X9651 VSS POLN cml_tlatch_80.xtail.S1 VSS sg13_lv_nmos ad=2.7982p pd=17.14u as=1.5637p ps=8.61u w=8.23u l=0.13u
X9652 cml_tlatch_79.xtail.S1 CKB2_N cml_tlatch_79.xmux.xn.S1 VSS sg13_lv_nmos ad=89.3f pd=0.85u as=89.3f ps=0.85u w=0.47u l=0.16u
X9653 cml_tlatch_33.xmux.xp.S1 B1_2_P B1_2_N VSS sg13_lv_nmos ad=56.9f pd=0.74u as=56.9f ps=0.74u w=0.17u l=0.17u
X9654 cml_tlatch_92.xmux.xn.S1 CKJ_N cml_tlatch_92.xtail.S1 VSS sg13_lv_nmos ad=89.3f pd=0.85u as=89.3f ps=0.85u w=0.47u l=0.16u
X9655 stub_bi_42.BOTN stub_bi_42.BOTP cml_tlatch_43.xmux.xp.S1 VSS sg13_lv_nmos ad=56.9f pd=0.74u as=56.9f ps=0.74u w=0.17u l=0.17u
X9656 cml_tlatch_17.xmux.xn.S1 CKHB0_P cml_tlatch_17.xtail.S1 VSS sg13_lv_nmos ad=89.3f pd=0.85u as=89.3f ps=0.85u w=0.47u l=0.16u
X9657 GB1_P VDD VSS rppd l=7.42u w=1u
X9658 cml_tlatch_39.xmux.xp.S1 MOT10_N MOT10_P VSS sg13_lv_nmos ad=56.9f pd=0.74u as=56.9f ps=0.74u w=0.17u l=0.17u
X9659 MOT29_P MOT29_N cml_tlatch_70.xmux.xp.S1 VSS sg13_lv_nmos ad=56.9f pd=0.74u as=56.9f ps=0.74u w=0.17u l=0.17u
X9660 cml_tlatch_2.xmux.xn.S1 cml_tlatch_3.OUTN A0_8_P VSS sg13_lv_nmos ad=63.19999f pd=0.74u as=63.19999f ps=0.74u w=0.26u l=0.38u
X9661 cml_tlatch_53.xtail.S1 CKA3_N cml_tlatch_53.xmux.xn.S1 VSS sg13_lv_nmos ad=89.3f pd=0.85u as=89.3f ps=0.85u w=0.47u l=0.16u
X9662 cml_tlatch_58.INN cml_tlatch_58.INP cml_tlatch_85.xmux.xp.S1 VSS sg13_lv_nmos ad=56.9f pd=0.74u as=56.9f ps=0.74u w=0.17u l=0.17u
X9663 cml_tlatch_5.xmux.xp.S1 MOT11_N MOT11_P VSS sg13_lv_nmos ad=0.1019p pd=1.34u as=56.9f ps=0.74u w=0.17u l=0.17u
X9664 CLK_W_N J2_N cml_tlatch_91.xmux.xn.S1 VSS sg13_lv_nmos ad=0.1082p pd=1.34u as=63.19999f ps=0.74u w=0.26u l=0.38u
X9665 cml_tlatch_65.xmux.xn.S1 cml_tlatch_57.INP cml_tlatch_65.OUTN VSS sg13_lv_nmos ad=63.19999f pd=0.74u as=63.19999f ps=0.74u w=0.26u l=0.38u
X9666 cml_tlatch_35.OUTP cml_tlatch_35.OUTN cml_tlatch_35.xmux.xp.S1 VSS sg13_lv_nmos ad=56.9f pd=0.74u as=56.9f ps=0.74u w=0.17u l=0.17u
X9667 stub_bi_17.BOTN VDD VSS rppd l=5.17u w=1u
X9668 MOT24_N A3_8_P cml_tlatch_86.xmux.xn.S1 VSS sg13_lv_nmos ad=63.19999f pd=0.74u as=63.19999f ps=0.74u w=0.26u l=0.38u
X9669 cml_gate2_4.xrtail.R1 CKB2_P cml_gate2_4.sg13_lv_nmos_FTPY57_0.D0 VSS sg13_lv_nmos ad=0.1007p pd=0.91u as=0.1007p ps=0.91u w=0.53u l=0.13u
X9670 cml_tlatch_98.xmux.xn.S1 cml_tlatch_27.OUTP cml_tlatch_98.OUTN VSS sg13_lv_nmos ad=0.1082p pd=1.34u as=63.19999f ps=0.74u w=0.26u l=0.38u
X9671 cml_tlatch_0.xmux.xp.S1 interco_bi_19.INP interco_bi_19.INN VSS sg13_lv_nmos ad=0.1019p pd=1.34u as=56.9f ps=0.74u w=0.17u l=0.17u
X9672 stub_bi_55.BOTN stub_bi_55.BOTP cml_tlatch_88.xmux.xp.S1 VSS sg13_lv_nmos ad=56.9f pd=0.74u as=56.9f ps=0.74u w=0.17u l=0.17u
X9673 cml_tlatch_3.xmux.xp.S1 cml_tlatch_3.OUTN cml_tlatch_3.OUTP VSS sg13_lv_nmos ad=56.9f pd=0.74u as=56.9f ps=0.74u w=0.17u l=0.17u
X9674 cml_tlatch_89.INN A2_2_P cml_tlatch_55.xmux.xn.S1 VSS sg13_lv_nmos ad=63.19999f pd=0.74u as=63.19999f ps=0.74u w=0.26u l=0.38u
X9675 MOT22_P A2_2_N cml_tlatch_51.xmux.xn.S1 VSS sg13_lv_nmos ad=63.19999f pd=0.74u as=63.19999f ps=0.74u w=0.26u l=0.38u
X9676 cml_tlatch_87.xmux.xn.S1 CKHA2_P cml_tlatch_87.xtail.S1 VSS sg13_lv_nmos ad=0.1598p pd=1.62u as=89.3f ps=0.85u w=0.47u l=0.16u
X9677 cml_tlatch_28.xmux.xp.S1 B0_2_P B0_2_N VSS sg13_lv_nmos ad=56.9f pd=0.74u as=56.9f ps=0.74u w=0.17u l=0.17u
X9678 MOT19_N MOT19_P cml_tlatch_74.xmux.xp.S1 VSS sg13_lv_nmos ad=56.9f pd=0.74u as=56.9f ps=0.74u w=0.17u l=0.17u
X9679 cml_tlatch_57.xmux.xp.S1 MOT26_P MOT26_N VSS sg13_lv_nmos ad=56.9f pd=0.74u as=56.9f ps=0.74u w=0.17u l=0.17u
X9680 cml_tlatch_57.xmux.xp.S1 MOT26_N MOT26_P VSS sg13_lv_nmos ad=56.9f pd=0.74u as=56.9f ps=0.74u w=0.17u l=0.17u
X9681 cml_tlatch_2.xmux.xp.S1 A0_8_N A0_8_P VSS sg13_lv_nmos ad=56.9f pd=0.74u as=56.9f ps=0.74u w=0.17u l=0.17u
X9682 cml_tlatch_17.xmux.xn.S1 B0_8_N MOT1_P VSS sg13_lv_nmos ad=63.19999f pd=0.74u as=63.19999f ps=0.74u w=0.26u l=0.38u
X9683 cml_tlatch_65.xmux.xp.S1 CKA3_N cml_tlatch_65.xtail.S1 VSS sg13_lv_nmos ad=89.3f pd=0.85u as=89.3f ps=0.85u w=0.47u l=0.16u
X9684 cml_tlatch_89.xtail.S1 CKA2_N cml_tlatch_89.xmux.xn.S1 VSS sg13_lv_nmos ad=89.3f pd=0.85u as=89.3f ps=0.85u w=0.47u l=0.16u
X9685 J2_P J2_N cml_tlatch_92.xmux.xp.S1 VSS sg13_lv_nmos ad=56.9f pd=0.74u as=56.9f ps=0.74u w=0.17u l=0.17u
X9686 cml_tlatch_42.xmux.xn.S1 D2_N cml_tlatch_56.INP VSS sg13_lv_nmos ad=63.19999f pd=0.74u as=63.19999f ps=0.74u w=0.26u l=0.38u
X9687 cml_tlatch_65.xmux.xp.S1 cml_tlatch_65.OUTP cml_tlatch_65.OUTN VSS sg13_lv_nmos ad=56.9f pd=0.74u as=56.9f ps=0.74u w=0.17u l=0.17u
X9688 cml_tlatch_30.OUTP cml_tlatch_30.OUTN cml_tlatch_30.xmux.xp.S1 VSS sg13_lv_nmos ad=56.9f pd=0.74u as=56.9f ps=0.74u w=0.17u l=0.17u
X9689 cml_tlatch_28.xtail.S1 POLN VSS VSS sg13_lv_nmos ad=1.5637p pd=8.61u as=1.5637p ps=8.61u w=8.23u l=0.13u
X9690 cml_tlatch_17.xmux.xn.S1 B0_8_N MOT1_P VSS sg13_lv_nmos ad=63.19999f pd=0.74u as=63.19999f ps=0.74u w=0.26u l=0.38u
X9691 MOT8_P MOT8_N cml_tlatch_96.xmux.xp.S1 VSS sg13_lv_nmos ad=56.9f pd=0.74u as=56.9f ps=0.74u w=0.17u l=0.17u
X9692 cml_tlatch_6.xmux.xn.S1 CKHB1_P cml_tlatch_6.xtail.S1 VSS sg13_lv_nmos ad=89.3f pd=0.85u as=89.3f ps=0.85u w=0.47u l=0.16u
X9693 cml_tlatch_81.xmux.xp.S1 A2_8_N A2_8_P VSS sg13_lv_nmos ad=56.9f pd=0.74u as=56.9f ps=0.74u w=0.17u l=0.17u
X9694 MOT15_P MOT15_N cml_tlatch_7.xmux.xp.S1 VSS sg13_lv_nmos ad=56.9f pd=0.74u as=56.9f ps=0.74u w=0.17u l=0.17u
X9695 GB0_N ENB1_P cml_gate2_1.sg13_lv_nmos_FTPY57_0.D0 VSS sg13_lv_nmos ad=0.1007p pd=0.91u as=0.1007p ps=0.91u w=0.53u l=0.13u
X9696 A3_2_P A3_2_N cml_tlatch_53.xmux.xp.S1 VSS sg13_lv_nmos ad=56.9f pd=0.74u as=56.9f ps=0.74u w=0.17u l=0.17u
X9697 MOT24_N MOT24_P cml_tlatch_86.xmux.xp.S1 VSS sg13_lv_nmos ad=56.9f pd=0.74u as=0.1019p ps=1.34u w=0.17u l=0.17u
X9698 cml_tlatch_22.OUTN cml_tlatch_22.OUTP cml_tlatch_22.xmux.xp.S1 VSS sg13_lv_nmos ad=56.9f pd=0.74u as=56.9f ps=0.74u w=0.17u l=0.17u
X9699 cml_tlatch_46.xmux.xp.S1 B3_2_N B3_2_P VSS sg13_lv_nmos ad=56.9f pd=0.74u as=56.9f ps=0.74u w=0.17u l=0.17u
X9700 VSS POLN hs_to_clk_1.D2 VSS sg13_lv_nmos ad=1.9p pd=10.38u as=1.9p ps=10.38u w=10u l=0.13u
X9701 VSS POLN cml_tlatch_95.xtail.S1 VSS sg13_lv_nmos ad=2.7982p pd=17.14u as=1.5637p ps=8.61u w=8.23u l=0.13u
X9702 B0_2_N cml_tlatch_29.OUTP cml_tlatch_28.xmux.xn.S1 VSS sg13_lv_nmos ad=63.19999f pd=0.74u as=63.19999f ps=0.74u w=0.26u l=0.38u
X9703 cml_gate2_7.xrtail.R1 CKA2_N GB2_P VSS sg13_lv_nmos ad=0.1802p pd=1.74u as=0.1007p ps=0.91u w=0.53u l=0.13u
X9704 cml_tlatch_88.xtail.S1 CKB2_N cml_tlatch_88.xmux.xn.S1 VSS sg13_lv_nmos ad=0.1598p pd=1.62u as=89.3f ps=0.85u w=0.47u l=0.16u
X9705 MOT29_P VDD VSS rppd l=5.17u w=1u
X9706 cml_tlatch_47.xmux.xp.S1 CKB3_N cml_tlatch_47.xtail.S1 VSS sg13_lv_nmos ad=89.3f pd=0.85u as=89.3f ps=0.85u w=0.47u l=0.16u
X9707 stub_bi_63.BOTP stub_bi_63.BOTN cml_tlatch_79.xmux.xp.S1 VSS sg13_lv_nmos ad=56.9f pd=0.74u as=56.9f ps=0.74u w=0.17u l=0.17u
X9708 cml_tlatch_23.xmux.xp.S1 cml_tlatch_39.INP cml_tlatch_39.INN VSS sg13_lv_nmos ad=56.9f pd=0.74u as=56.9f ps=0.74u w=0.17u l=0.17u
X9709 cml_tlatch_23.xmux.xp.S1 cml_tlatch_39.INN cml_tlatch_39.INP VSS sg13_lv_nmos ad=56.9f pd=0.74u as=56.9f ps=0.74u w=0.17u l=0.17u
X9710 cml_tlatch_18.xmux.xp.S1 MOT3_P MOT3_N VSS sg13_lv_nmos ad=56.9f pd=0.74u as=56.9f ps=0.74u w=0.17u l=0.17u
X9711 B1_2_P B1_2_N cml_tlatch_33.xmux.xp.S1 VSS sg13_lv_nmos ad=56.9f pd=0.74u as=56.9f ps=0.74u w=0.17u l=0.17u
X9712 cml_drv_0.xrtail.R1 ENB_N ENB1_P VSS sg13_lv_nmos ad=56.2f pd=0.74u as=56.2f ps=0.74u w=0.16u l=0.19u
X9713 cml_tlatch_1.OUTP cml_tlatch_1.OUTN cml_tlatch_1.xmux.xp.S1 VSS sg13_lv_nmos ad=56.9f pd=0.74u as=56.9f ps=0.74u w=0.17u l=0.17u
X9714 VSS POLN hs_to_clk_7.D2 VSS sg13_lv_nmos ad=1.9p pd=10.38u as=3.4p ps=20.68u w=10u l=0.13u
X9715 cml_tlatch_22.OUTN cml_tlatch_22.OUTP cml_tlatch_22.xmux.xp.S1 VSS sg13_lv_nmos ad=56.9f pd=0.74u as=56.9f ps=0.74u w=0.17u l=0.17u
X9716 cml_tlatch_67.xmux.xp.S1 cml_tlatch_67.OUTN cml_tlatch_67.OUTP VSS sg13_lv_nmos ad=56.9f pd=0.74u as=56.9f ps=0.74u w=0.17u l=0.17u
X9717 cml_tlatch_27.xtail.S1 CKB0_N cml_tlatch_27.xmux.xp.S1 VSS sg13_lv_nmos ad=89.3f pd=0.85u as=0.1598p ps=1.62u w=0.47u l=0.16u
X9718 cml_tlatch_16.OUTP cml_tlatch_16.OUTN cml_tlatch_16.xmux.xp.S1 VSS sg13_lv_nmos ad=56.9f pd=0.74u as=56.9f ps=0.74u w=0.17u l=0.17u
X9719 VSS POLN cml_tlatch_21.xtail.S1 VSS sg13_lv_nmos ad=1.5637p pd=8.61u as=1.5637p ps=8.61u w=8.23u l=0.13u
X9720 cml_tlatch_21.xtail.S1 CKA1_P cml_tlatch_21.xmux.xp.S1 VSS sg13_lv_nmos ad=89.3f pd=0.85u as=89.3f ps=0.85u w=0.47u l=0.16u
X9721 cml_tlatch_13.xmux.xn.S1 cml_tlatch_5.INP stub_bi_17.BOTP VSS sg13_lv_nmos ad=63.19999f pd=0.74u as=0.1082p ps=1.34u w=0.26u l=0.38u
X9722 cml_tlatch_18.xmux.xp.S1 CKHB0_N cml_tlatch_18.xtail.S1 VSS sg13_lv_nmos ad=89.3f pd=0.85u as=89.3f ps=0.85u w=0.47u l=0.16u
X9723 cml_tlatch_13.xmux.xp.S1 CKB1_N cml_tlatch_13.xtail.S1 VSS sg13_lv_nmos ad=89.3f pd=0.85u as=89.3f ps=0.85u w=0.47u l=0.16u
X9724 cml_tlatch_98.OUTP cml_tlatch_98.OUTN cml_tlatch_98.xmux.xp.S1 VSS sg13_lv_nmos ad=56.9f pd=0.74u as=56.9f ps=0.74u w=0.17u l=0.17u
X9725 cml_tlatch_35.OUTN cml_tlatch_35.OUTP cml_tlatch_35.xmux.xp.S1 VSS sg13_lv_nmos ad=56.9f pd=0.74u as=56.9f ps=0.74u w=0.17u l=0.17u
X9726 cml_tlatch_55.xmux.xp.S1 cml_tlatch_89.INP cml_tlatch_89.INN VSS sg13_lv_nmos ad=56.9f pd=0.74u as=56.9f ps=0.74u w=0.17u l=0.17u
X9727 cml_tlatch_15.xmux.xp.S1 stub_bi_19.BOTP stub_bi_19.BOTN VSS sg13_lv_nmos ad=56.9f pd=0.74u as=56.9f ps=0.74u w=0.17u l=0.17u
X9728 ENA_P NM1_N cml_gate2_9.xrtail.R1 VSS sg13_lv_nmos ad=0.1007p pd=0.91u as=0.1007p ps=0.91u w=0.53u l=0.13u
X9729 GA1_P ENA0_N cml_gate2_3.sg13_lv_nmos_FTPY57_0.D0 VSS sg13_lv_nmos ad=0.1007p pd=0.91u as=0.1007p ps=0.91u w=0.53u l=0.13u
X9730 ENA_N J1_P cml_gate2_9.sg13_lv_nmos_FTPY57_0.D0 VSS sg13_lv_nmos ad=0.1007p pd=0.91u as=0.1007p ps=0.91u w=0.53u l=0.13u
X9731 cml_tlatch_92.xmux.xp.S1 J2_N J2_P VSS sg13_lv_nmos ad=56.9f pd=0.74u as=56.9f ps=0.74u w=0.17u l=0.17u
X9732 MOT21_N MOT21_P cml_tlatch_75.xmux.xp.S1 VSS sg13_lv_nmos ad=56.9f pd=0.74u as=56.9f ps=0.74u w=0.17u l=0.17u
X9733 cml_tlatch_26.xmux.xn.S1 CKHA0_P cml_tlatch_26.xtail.S1 VSS sg13_lv_nmos ad=89.3f pd=0.85u as=89.3f ps=0.85u w=0.47u l=0.16u
X9734 B1_8_N stub_bi_17.BOTN cml_tlatch_12.xmux.xn.S1 VSS sg13_lv_nmos ad=63.19999f pd=0.74u as=63.19999f ps=0.74u w=0.26u l=0.38u
X9735 cml_tlatch_32.xtail.S1 CKB1_P cml_tlatch_32.xmux.xn.S1 VSS sg13_lv_nmos ad=89.3f pd=0.85u as=89.3f ps=0.85u w=0.47u l=0.16u
X9736 cml_tlatch_12.xtail.S1 CKB1_P cml_tlatch_12.xmux.xp.S1 VSS sg13_lv_nmos ad=89.3f pd=0.85u as=89.3f ps=0.85u w=0.47u l=0.16u
X9737 cml_tlatch_39.xmux.xp.S1 MOT10_N MOT10_P VSS sg13_lv_nmos ad=0.1019p pd=1.34u as=56.9f ps=0.74u w=0.17u l=0.17u
X9738 cml_tlatch_51.xmux.xp.S1 MOT22_P MOT22_N VSS sg13_lv_nmos ad=56.9f pd=0.74u as=56.9f ps=0.74u w=0.17u l=0.17u
X9739 cml_gate2_6.sg13_lv_nmos_FTPY57_0.D0 CKA3_P cml_gate2_6.xrtail.R1 VSS sg13_lv_nmos ad=0.1007p pd=0.91u as=0.1007p ps=0.91u w=0.53u l=0.13u
X9740 MOT19_N stub_bi_63.BOTN cml_tlatch_74.xmux.xn.S1 VSS sg13_lv_nmos ad=63.19999f pd=0.74u as=0.1082p ps=1.34u w=0.26u l=0.38u
X9741 cml_tlatch_8.xmux.xp.S1 cml_tlatch_8.OUTP cml_tlatch_8.OUTN VSS sg13_lv_nmos ad=56.9f pd=0.74u as=56.9f ps=0.74u w=0.17u l=0.17u
X9742 A1_8_P cml_tlatch_22.OUTN cml_tlatch_21.xmux.xn.S1 VSS sg13_lv_nmos ad=63.19999f pd=0.74u as=63.19999f ps=0.74u w=0.26u l=0.38u
X9743 cml_tlatch_92.xmux.xp.S1 CKJ_P cml_tlatch_92.xtail.S1 VSS sg13_lv_nmos ad=0.1598p pd=1.62u as=89.3f ps=0.85u w=0.47u l=0.16u
X9744 cml_tlatch_84.xmux.xn.S1 cml_tlatch_45.OUTN cml_tlatch_70.INP VSS sg13_lv_nmos ad=0.1082p pd=1.34u as=63.19999f ps=0.74u w=0.26u l=0.38u
X9745 cml_tlatch_27.xmux.xp.S1 cml_tlatch_27.OUTN cml_tlatch_27.OUTP VSS sg13_lv_nmos ad=56.9f pd=0.74u as=56.9f ps=0.74u w=0.17u l=0.17u
X9746 cml_tlatch_45.xmux.xp.S1 CKB3_N cml_tlatch_45.xtail.S1 VSS sg13_lv_nmos ad=89.3f pd=0.85u as=89.3f ps=0.85u w=0.47u l=0.16u
X9747 GB3_N ENB0_P cml_gate2_6.sg13_lv_nmos_FTPY57_0.D0 VSS sg13_lv_nmos ad=0.1007p pd=0.91u as=0.1007p ps=0.91u w=0.53u l=0.13u
X9748 cml_tlatch_1.OUTN cml_tlatch_98.OUTP cml_tlatch_1.xmux.xn.S1 VSS sg13_lv_nmos ad=63.19999f pd=0.74u as=63.19999f ps=0.74u w=0.26u l=0.38u
X9749 cml_tlatch_90.xmux.xn.S1 CKJ_N cml_tlatch_90.xtail.S1 VSS sg13_lv_nmos ad=89.3f pd=0.85u as=89.3f ps=0.85u w=0.47u l=0.16u
X9750 cml_tlatch_47.xmux.xp.S1 cml_tlatch_47.OUTP cml_tlatch_47.OUTN VSS sg13_lv_nmos ad=56.9f pd=0.74u as=56.9f ps=0.74u w=0.17u l=0.17u
X9751 cml_tlatch_84.xmux.xn.S1 cml_tlatch_45.OUTN cml_tlatch_70.INP VSS sg13_lv_nmos ad=63.19999f pd=0.74u as=63.19999f ps=0.74u w=0.26u l=0.38u
X9752 MOT9_P MOT9_N cml_tlatch_4.xmux.xp.S1 VSS sg13_lv_nmos ad=56.9f pd=0.74u as=56.9f ps=0.74u w=0.17u l=0.17u
X9753 cml_tlatch_95.xmux.xn.S1 cml_tlatch_95.INN cml_tlatch_40.INP VSS sg13_lv_nmos ad=63.19999f pd=0.74u as=63.19999f ps=0.74u w=0.26u l=0.38u
X9754 cml_tlatch_19.xmux.xp.S1 MOT5_P MOT5_N VSS sg13_lv_nmos ad=56.9f pd=0.74u as=56.9f ps=0.74u w=0.17u l=0.17u
X9755 cml_tlatch_23.xtail.S1 CKA1_P cml_tlatch_23.xmux.xp.S1 VSS sg13_lv_nmos ad=89.3f pd=0.85u as=89.3f ps=0.85u w=0.47u l=0.16u
X9756 cml_tlatch_86.xtail.S1 CKHA3_N cml_tlatch_86.xmux.xp.S1 VSS sg13_lv_nmos ad=0.1598p pd=1.62u as=89.3f ps=0.85u w=0.47u l=0.16u
X9757 J2_P J2_N cml_tlatch_92.xmux.xp.S1 VSS sg13_lv_nmos ad=56.9f pd=0.74u as=56.9f ps=0.74u w=0.17u l=0.17u
X9758 cml_tlatch_65.xmux.xp.S1 cml_tlatch_65.OUTP cml_tlatch_65.OUTN VSS sg13_lv_nmos ad=56.9f pd=0.74u as=56.9f ps=0.74u w=0.17u l=0.17u
X9759 cml_tlatch_9.xtail.S1 CKA0_N cml_tlatch_9.xmux.xp.S1 VSS sg13_lv_nmos ad=89.3f pd=0.85u as=89.3f ps=0.85u w=0.47u l=0.16u
X9760 cml_tlatch_61.OUTN cml_tlatch_61.OUTP cml_tlatch_61.xmux.xp.S1 VSS sg13_lv_nmos ad=56.9f pd=0.74u as=56.9f ps=0.74u w=0.17u l=0.17u
X9761 cml_gate2_4.xrtail.R1 CKB2_N GA2_P VSS sg13_lv_nmos ad=0.1007p pd=0.91u as=0.1007p ps=0.91u w=0.53u l=0.13u
X9762 cml_tlatch_33.xmux.xn.S1 stub_bi_31.BOTP B1_2_P VSS sg13_lv_nmos ad=63.19999f pd=0.74u as=63.19999f ps=0.74u w=0.26u l=0.38u
X9763 cml_tlatch_84.xmux.xp.S1 cml_tlatch_70.INN cml_tlatch_70.INP VSS sg13_lv_nmos ad=56.9f pd=0.74u as=56.9f ps=0.74u w=0.17u l=0.17u
X9764 cml_tlatch_33.xmux.xn.S1 stub_bi_31.BOTP B1_2_P VSS sg13_lv_nmos ad=63.19999f pd=0.74u as=63.19999f ps=0.74u w=0.26u l=0.38u
X9765 cml_tlatch_81.xmux.xp.S1 CKA2_P cml_tlatch_81.xtail.S1 VSS sg13_lv_nmos ad=89.3f pd=0.85u as=89.3f ps=0.85u w=0.47u l=0.16u
X9766 cml_tlatch_13.xmux.xp.S1 stub_bi_17.BOTN stub_bi_17.BOTP VSS sg13_lv_nmos ad=56.9f pd=0.74u as=56.9f ps=0.74u w=0.17u l=0.17u
X9767 cml_tlatch_43.xmux.xp.S1 stub_bi_42.BOTN stub_bi_42.BOTP VSS sg13_lv_nmos ad=56.9f pd=0.74u as=56.9f ps=0.74u w=0.17u l=0.17u
X9768 hs_to_clk_4.D2 POLN VSS VSS sg13_lv_nmos ad=1.9p pd=10.38u as=1.9p ps=10.38u w=10u l=0.13u
X9769 cml_tlatch_70.INN cml_tlatch_70.INP cml_tlatch_84.xmux.xp.S1 VSS sg13_lv_nmos ad=56.9f pd=0.74u as=56.9f ps=0.74u w=0.17u l=0.17u
X9770 MOT6_P MOT6_N cml_tlatch_26.xmux.xp.S1 VSS sg13_lv_nmos ad=56.9f pd=0.74u as=56.9f ps=0.74u w=0.17u l=0.17u
X9771 cml_tlatch_54.xmux.xn.S1 D3_P cml_tlatch_54.OUTN VSS sg13_lv_nmos ad=63.19999f pd=0.74u as=63.19999f ps=0.74u w=0.26u l=0.38u
X9772 cml_tlatch_96.xtail.S1 CKHA1_N cml_tlatch_96.xmux.xp.S1 VSS sg13_lv_nmos ad=89.3f pd=0.85u as=89.3f ps=0.85u w=0.47u l=0.16u
X9773 MOT7_N MOT7_P cml_tlatch_20.xmux.xp.S1 VSS sg13_lv_nmos ad=56.9f pd=0.74u as=0.1019p ps=1.34u w=0.17u l=0.17u
X9774 cml_tlatch_63.OUTP cml_tlatch_63.OUTN cml_tlatch_63.xmux.xp.S1 VSS sg13_lv_nmos ad=56.9f pd=0.74u as=56.9f ps=0.74u w=0.17u l=0.17u
X9775 cml_tlatch_39.INP interco_bi_19.INN cml_tlatch_23.xmux.xn.S1 VSS sg13_lv_nmos ad=63.19999f pd=0.74u as=0.1082p ps=1.34u w=0.26u l=0.38u
X9776 VSS cml_drv_2.xrtail.R1 VSS rppd l=5.65u w=1u
X9777 MOT25_P VDD VSS rppd l=5.17u w=1u
X9778 cml_tlatch_90.xmux.xp.S1 J4_N J4_P VSS sg13_lv_nmos ad=56.9f pd=0.74u as=56.9f ps=0.74u w=0.17u l=0.17u
X9779 cml_tlatch_70.INP cml_tlatch_70.INN cml_tlatch_84.xmux.xp.S1 VSS sg13_lv_nmos ad=56.9f pd=0.74u as=56.9f ps=0.74u w=0.17u l=0.17u
X9780 cml_tlatch_18.xmux.xn.S1 CKHB0_P cml_tlatch_18.xtail.S1 VSS sg13_lv_nmos ad=89.3f pd=0.85u as=89.3f ps=0.85u w=0.47u l=0.16u
X9781 cml_tlatch_73.xtail.S1 CKHB2_P cml_tlatch_73.xmux.xn.S1 VSS sg13_lv_nmos ad=89.3f pd=0.85u as=89.3f ps=0.85u w=0.47u l=0.16u
X9782 cml_tlatch_28.xmux.xn.S1 cml_tlatch_29.OUTN B0_2_P VSS sg13_lv_nmos ad=63.19999f pd=0.74u as=63.19999f ps=0.74u w=0.26u l=0.38u
X9783 cml_tlatch_15.xmux.xp.S1 stub_bi_19.BOTP stub_bi_19.BOTN VSS sg13_lv_nmos ad=56.9f pd=0.74u as=56.9f ps=0.74u w=0.17u l=0.17u
X9784 MOT17_N B2_8_P cml_tlatch_73.xmux.xn.S1 VSS sg13_lv_nmos ad=63.19999f pd=0.74u as=63.19999f ps=0.74u w=0.26u l=0.38u
X9785 cml_tlatch_20.xmux.xn.S1 B0_2_N MOT7_P VSS sg13_lv_nmos ad=63.19999f pd=0.74u as=63.19999f ps=0.74u w=0.26u l=0.38u
X9786 A1_8_P A1_8_N cml_tlatch_21.xmux.xp.S1 VSS sg13_lv_nmos ad=56.9f pd=0.74u as=56.9f ps=0.74u w=0.17u l=0.17u
X9787 cml_tlatch_52.xmux.xn.S1 CKA3_P cml_tlatch_52.xtail.S1 VSS sg13_lv_nmos ad=89.3f pd=0.85u as=89.3f ps=0.85u w=0.47u l=0.16u
X9788 cml_tlatch_37.xmux.xp.S1 CKA1_P cml_tlatch_37.xtail.S1 VSS sg13_lv_nmos ad=89.3f pd=0.85u as=89.3f ps=0.85u w=0.47u l=0.16u
X9789 cml_tlatch_78.xmux.xn.S1 CKB2_P cml_tlatch_78.xtail.S1 VSS sg13_lv_nmos ad=89.3f pd=0.85u as=89.3f ps=0.85u w=0.47u l=0.16u
X9790 MOT21_N MOT21_P cml_tlatch_75.xmux.xp.S1 VSS sg13_lv_nmos ad=56.9f pd=0.74u as=56.9f ps=0.74u w=0.17u l=0.17u
X9791 cml_tlatch_70.xmux.xp.S1 MOT29_P MOT29_N VSS sg13_lv_nmos ad=56.9f pd=0.74u as=56.9f ps=0.74u w=0.17u l=0.17u
X9792 cml_tlatch_11.OUTN cml_tlatch_16.OUTP cml_tlatch_11.xmux.xn.S1 VSS sg13_lv_nmos ad=63.19999f pd=0.74u as=63.19999f ps=0.74u w=0.26u l=0.38u
X9793 cml_tlatch_22.xmux.xn.S1 cml_tlatch_39.INN cml_tlatch_22.OUTP VSS sg13_lv_nmos ad=63.19999f pd=0.74u as=63.19999f ps=0.74u w=0.26u l=0.38u
X9794 cml_tlatch_47.xtail.S1 CKB3_N cml_tlatch_47.xmux.xp.S1 VSS sg13_lv_nmos ad=89.3f pd=0.85u as=89.3f ps=0.85u w=0.47u l=0.16u
X9795 cml_tlatch_65.xmux.xn.S1 CKA3_P cml_tlatch_65.xtail.S1 VSS sg13_lv_nmos ad=89.3f pd=0.85u as=89.3f ps=0.85u w=0.47u l=0.16u
X9796 cml_tlatch_11.xmux.xp.S1 cml_tlatch_11.OUTP cml_tlatch_11.OUTN VSS sg13_lv_nmos ad=56.9f pd=0.74u as=56.9f ps=0.74u w=0.17u l=0.17u
X9797 cml_tlatch_45.OUTP B3_2_N cml_tlatch_45.xmux.xn.S1 VSS sg13_lv_nmos ad=63.19999f pd=0.74u as=63.19999f ps=0.74u w=0.26u l=0.38u
X9798 J2_N J2_P cml_tlatch_92.xmux.xp.S1 VSS sg13_lv_nmos ad=56.9f pd=0.74u as=56.9f ps=0.74u w=0.17u l=0.17u
X9799 A0_2_N A0_2_P cml_tlatch_31.xmux.xp.S1 VSS sg13_lv_nmos ad=56.9f pd=0.74u as=56.9f ps=0.74u w=0.17u l=0.17u
X9800 VSS hs_to_clk_4.sg13_lv_nmos_2HGZLP_0.G VSS VSS sg13_lv_nmos ad=2.071p pd=11.28u as=0 ps=0 w=10.9u l=1.38u
X9801 cml_tlatch_15.xmux.xn.S1 cml_tlatch_6.INN stub_bi_19.BOTN VSS sg13_lv_nmos ad=0.1082p pd=1.34u as=63.19999f ps=0.74u w=0.26u l=0.38u
X9802 cml_tlatch_56.xmux.xn.S1 cml_tlatch_56.INP A2_2_N VSS sg13_lv_nmos ad=63.19999f pd=0.74u as=63.19999f ps=0.74u w=0.26u l=0.38u
X9803 cml_tlatch_94.xmux.xp.S1 cml_tlatch_6.INN cml_tlatch_6.INP VSS sg13_lv_nmos ad=56.9f pd=0.74u as=56.9f ps=0.74u w=0.17u l=0.17u
X9804 cml_tlatch_45.xmux.xn.S1 CKB3_P cml_tlatch_45.xtail.S1 VSS sg13_lv_nmos ad=89.3f pd=0.85u as=89.3f ps=0.85u w=0.47u l=0.16u
X9805 cml_tlatch_91.xmux.xn.S1 CKJ_P cml_tlatch_91.xtail.S1 VSS sg13_lv_nmos ad=89.3f pd=0.85u as=89.3f ps=0.85u w=0.47u l=0.16u
X9806 cml_tlatch_83.xmux.xp.S1 cml_tlatch_83.OUTN cml_tlatch_83.OUTP VSS sg13_lv_nmos ad=56.9f pd=0.74u as=56.9f ps=0.74u w=0.17u l=0.17u
X9807 cml_tlatch_99.xtail.S1 CKA0_N cml_tlatch_99.xmux.xn.S1 VSS sg13_lv_nmos ad=89.3f pd=0.85u as=89.3f ps=0.85u w=0.47u l=0.16u
X9808 cml_tlatch_34.xmux.xn.S1 D1_P stub_bi_31.BOTP VSS sg13_lv_nmos ad=63.19999f pd=0.74u as=0.1082p ps=1.34u w=0.26u l=0.38u
X9809 cml_tlatch_31.xmux.xp.S1 CKA0_P cml_tlatch_31.xtail.S1 VSS sg13_lv_nmos ad=89.3f pd=0.85u as=89.3f ps=0.85u w=0.47u l=0.16u
X9810 cml_tlatch_51.xmux.xp.S1 MOT22_N MOT22_P VSS sg13_lv_nmos ad=56.9f pd=0.74u as=56.9f ps=0.74u w=0.17u l=0.17u
X9811 cml_tlatch_24.xtail.S1 CKHA0_P cml_tlatch_24.xmux.xn.S1 VSS sg13_lv_nmos ad=89.3f pd=0.85u as=89.3f ps=0.85u w=0.47u l=0.16u
X9812 cml_tlatch_70.xmux.xn.S1 cml_tlatch_70.INP MOT29_N VSS sg13_lv_nmos ad=63.19999f pd=0.74u as=63.19999f ps=0.74u w=0.26u l=0.38u
X9813 cml_tlatch_83.INN cml_tlatch_83.INP cml_tlatch_72.xmux.xp.S1 VSS sg13_lv_nmos ad=56.9f pd=0.74u as=56.9f ps=0.74u w=0.17u l=0.17u
X9814 stub_bi_17.BOTN stub_bi_17.BOTP cml_tlatch_13.xmux.xp.S1 VSS sg13_lv_nmos ad=56.9f pd=0.74u as=56.9f ps=0.74u w=0.17u l=0.17u
X9815 MOT11_P MOT11_N cml_tlatch_5.xmux.xp.S1 VSS sg13_lv_nmos ad=56.9f pd=0.74u as=56.9f ps=0.74u w=0.17u l=0.17u
X9816 CKHB1_P GB1_N cml_drvb_0.xrtail.R1 VSS sg13_lv_nmos ad=0.2618p pd=2.22u as=0.1463p ps=1.15u w=0.77u l=0.21u
X9817 stub_bi_19.BOTP cml_tlatch_6.INP cml_tlatch_15.xmux.xn.S1 VSS sg13_lv_nmos ad=63.19999f pd=0.74u as=63.19999f ps=0.74u w=0.26u l=0.38u
X9818 cml_tlatch_69.INN cml_tlatch_69.INP cml_tlatch_62.xmux.xp.S1 VSS sg13_lv_nmos ad=56.9f pd=0.74u as=56.9f ps=0.74u w=0.17u l=0.17u
X9819 cml_tlatch_56.xmux.xp.S1 A2_2_N A2_2_P VSS sg13_lv_nmos ad=56.9f pd=0.74u as=56.9f ps=0.74u w=0.17u l=0.17u
X9820 cml_tlatch_93.xtail.S1 CKJ_P cml_tlatch_93.xmux.xn.S1 VSS sg13_lv_nmos ad=89.3f pd=0.85u as=89.3f ps=0.85u w=0.47u l=0.16u
X9821 cml_tlatch_26.xtail.S1 CKHA0_P cml_tlatch_26.xmux.xn.S1 VSS sg13_lv_nmos ad=89.3f pd=0.85u as=89.3f ps=0.85u w=0.47u l=0.16u
X9822 VSS POLN hs_to_clk_3.D2 VSS sg13_lv_nmos ad=1.9p pd=10.38u as=1.9p ps=10.38u w=10u l=0.13u
X9823 cml_tlatch_89.OUTP cml_tlatch_89.OUTN cml_tlatch_89.xmux.xp.S1 VSS sg13_lv_nmos ad=56.9f pd=0.74u as=0.1019p ps=1.34u w=0.17u l=0.17u
X9824 cml_tlatch_70.xmux.xn.S1 cml_tlatch_70.INP MOT29_N VSS sg13_lv_nmos ad=63.19999f pd=0.74u as=63.19999f ps=0.74u w=0.26u l=0.38u
X9825 MOT17_N MOT17_P cml_tlatch_73.xmux.xp.S1 VSS sg13_lv_nmos ad=56.9f pd=0.74u as=56.9f ps=0.74u w=0.17u l=0.17u
X9826 cml_tlatch_95.INN cml_tlatch_95.INP cml_tlatch_36.xmux.xp.S1 VSS sg13_lv_nmos ad=56.9f pd=0.74u as=56.9f ps=0.74u w=0.17u l=0.17u
X9827 cml_tlatch_50.xmux.xp.S1 MOT20_N MOT20_P VSS sg13_lv_nmos ad=56.9f pd=0.74u as=56.9f ps=0.74u w=0.17u l=0.17u
X9828 GB1_N ENB1_P cml_gate2_0.sg13_lv_nmos_FTPY57_0.D0 VSS sg13_lv_nmos ad=0.1007p pd=0.91u as=0.1007p ps=0.91u w=0.53u l=0.13u
X9829 cml_tlatch_14.xmux.xp.S1 cml_tlatch_5.INP cml_tlatch_5.INN VSS sg13_lv_nmos ad=56.9f pd=0.74u as=56.9f ps=0.74u w=0.17u l=0.17u
X9830 MOT12_N MOT12_P cml_tlatch_40.xmux.xp.S1 VSS sg13_lv_nmos ad=56.9f pd=0.74u as=56.9f ps=0.74u w=0.17u l=0.17u
X9831 cml_tlatch_61.xmux.xp.S1 CKB3_N cml_tlatch_61.xtail.S1 VSS sg13_lv_nmos ad=89.3f pd=0.85u as=89.3f ps=0.85u w=0.47u l=0.16u
X9832 cml_tlatch_74.xtail.S1 CKHB2_N cml_tlatch_74.xmux.xp.S1 VSS sg13_lv_nmos ad=89.3f pd=0.85u as=89.3f ps=0.85u w=0.47u l=0.16u
X9833 cml_tlatch_27.xmux.xn.S1 CKB0_P cml_tlatch_27.xtail.S1 VSS sg13_lv_nmos ad=89.3f pd=0.85u as=89.3f ps=0.85u w=0.47u l=0.16u
X9834 MOT0_N MOT0_P cml_tlatch_97.xmux.xp.S1 VSS sg13_lv_nmos ad=56.9f pd=0.74u as=56.9f ps=0.74u w=0.17u l=0.17u
X9835 MOT6_P MOT6_N cml_tlatch_26.xmux.xp.S1 VSS sg13_lv_nmos ad=56.9f pd=0.74u as=56.9f ps=0.74u w=0.17u l=0.17u
X9836 cml_tlatch_61.OUTP cml_tlatch_61.OUTN cml_tlatch_61.xmux.xp.S1 VSS sg13_lv_nmos ad=56.9f pd=0.74u as=56.9f ps=0.74u w=0.17u l=0.17u
X9837 MOT7_N MOT7_P cml_tlatch_20.xmux.xp.S1 VSS sg13_lv_nmos ad=56.9f pd=0.74u as=56.9f ps=0.74u w=0.17u l=0.17u
X9838 MOT27_P MOT27_N cml_tlatch_69.xmux.xp.S1 VSS sg13_lv_nmos ad=56.9f pd=0.74u as=56.9f ps=0.74u w=0.17u l=0.17u
X9839 cml_tlatch_60.xmux.xp.S1 B3_8_N B3_8_P VSS sg13_lv_nmos ad=56.9f pd=0.74u as=56.9f ps=0.74u w=0.17u l=0.17u
X9840 cml_tlatch_65.OUTN cml_tlatch_57.INP cml_tlatch_65.xmux.xn.S1 VSS sg13_lv_nmos ad=0.1082p pd=1.34u as=63.19999f ps=0.74u w=0.26u l=0.38u
X9841 cml_tlatch_29.OUTN cml_tlatch_29.OUTP cml_tlatch_29.xmux.xp.S1 VSS sg13_lv_nmos ad=56.9f pd=0.74u as=56.9f ps=0.74u w=0.17u l=0.17u
X9842 cml_tlatch_4.xmux.xn.S1 CKHB1_P cml_tlatch_4.xtail.S1 VSS sg13_lv_nmos ad=89.3f pd=0.85u as=89.3f ps=0.85u w=0.47u l=0.16u
X9843 cml_tlatch_54.xtail.S1 CKA3_P cml_tlatch_54.xmux.xn.S1 VSS sg13_lv_nmos ad=89.3f pd=0.85u as=89.3f ps=0.85u w=0.47u l=0.16u
X9844 VSS POLN hs_to_clk_0.D2 VSS sg13_lv_nmos ad=1.9p pd=10.38u as=1.9p ps=10.38u w=10u l=0.13u
X9845 cml_tlatch_51.xtail.S1 CKHA2_P cml_tlatch_51.xmux.xn.S1 VSS sg13_lv_nmos ad=89.3f pd=0.85u as=89.3f ps=0.85u w=0.47u l=0.16u
X9846 cml_tlatch_35.xmux.xp.S1 CKA0_N cml_tlatch_35.xtail.S1 VSS sg13_lv_nmos ad=89.3f pd=0.85u as=89.3f ps=0.85u w=0.47u l=0.16u
X9847 cml_tlatch_10.xmux.xp.S1 B0_8_P B0_8_N VSS sg13_lv_nmos ad=56.9f pd=0.74u as=56.9f ps=0.74u w=0.17u l=0.17u
X9848 MOT28_N MOT28_P cml_tlatch_58.xmux.xp.S1 VSS sg13_lv_nmos ad=56.9f pd=0.74u as=56.9f ps=0.74u w=0.17u l=0.17u
X9849 MOT3_N MOT3_P cml_tlatch_18.xmux.xp.S1 VSS sg13_lv_nmos ad=56.9f pd=0.74u as=0.1019p ps=1.34u w=0.17u l=0.17u
X9850 cml_tlatch_11.xmux.xp.S1 CKB0_N cml_tlatch_11.xtail.S1 VSS sg13_lv_nmos ad=89.3f pd=0.85u as=89.3f ps=0.85u w=0.47u l=0.16u
X9851 MOT18_N MOT18_P cml_tlatch_49.xmux.xp.S1 VSS sg13_lv_nmos ad=56.9f pd=0.74u as=56.9f ps=0.74u w=0.17u l=0.17u
X9852 cml_tlatch_30.OUTN cml_tlatch_30.OUTP cml_tlatch_30.xmux.xp.S1 VSS sg13_lv_nmos ad=56.9f pd=0.74u as=56.9f ps=0.74u w=0.17u l=0.17u
X9853 cml_tlatch_89.OUTP cml_tlatch_89.OUTN cml_tlatch_89.xmux.xp.S1 VSS sg13_lv_nmos ad=56.9f pd=0.74u as=56.9f ps=0.74u w=0.17u l=0.17u
X9854 cml_tlatch_72.xmux.xp.S1 CKA2_N cml_tlatch_72.xtail.S1 VSS sg13_lv_nmos ad=89.3f pd=0.85u as=89.3f ps=0.85u w=0.47u l=0.16u
X9855 stub_bi_29.BOTP B1_2_P cml_tlatch_32.xmux.xn.S1 VSS sg13_lv_nmos ad=63.19999f pd=0.74u as=63.19999f ps=0.74u w=0.26u l=0.38u
X9856 ENB_N J2_P cml_gate2_8.sg13_lv_nmos_FTPY57_0.D0 VSS sg13_lv_nmos ad=0.1007p pd=0.91u as=0.1007p ps=0.91u w=0.53u l=0.13u
X9857 cml_tlatch_6.xmux.xp.S1 MOT13_N MOT13_P VSS sg13_lv_nmos ad=56.9f pd=0.74u as=56.9f ps=0.74u w=0.17u l=0.17u
X9858 cml_gate2_7.xrtail.R1 CKA2_P cml_gate2_7.sg13_lv_nmos_FTPY57_0.D0 VSS sg13_lv_nmos ad=0.1007p pd=0.91u as=0.1007p ps=0.91u w=0.53u l=0.13u
X9859 cml_tlatch_11.xmux.xp.S1 cml_tlatch_11.OUTP cml_tlatch_11.OUTN VSS sg13_lv_nmos ad=56.9f pd=0.74u as=56.9f ps=0.74u w=0.17u l=0.17u
X9860 cml_tlatch_61.xmux.xp.S1 cml_tlatch_61.OUTN cml_tlatch_61.OUTP VSS sg13_lv_nmos ad=56.9f pd=0.74u as=56.9f ps=0.74u w=0.17u l=0.17u
X9861 cml_tlatch_76.xmux.xp.S1 MOT23_N MOT23_P VSS sg13_lv_nmos ad=56.9f pd=0.74u as=56.9f ps=0.74u w=0.17u l=0.17u
X9862 cml_tlatch_77.xmux.xp.S1 B2_8_P B2_8_N VSS sg13_lv_nmos ad=56.9f pd=0.74u as=56.9f ps=0.74u w=0.17u l=0.17u
X9863 cml_tlatch_84.xtail.S1 CKB3_P cml_tlatch_84.xmux.xp.S1 VSS sg13_lv_nmos ad=89.3f pd=0.85u as=89.3f ps=0.85u w=0.47u l=0.16u
X9864 MOT14_P MOT14_N cml_tlatch_41.xmux.xp.S1 VSS sg13_lv_nmos ad=56.9f pd=0.74u as=0.1019p ps=1.34u w=0.17u l=0.17u
X9865 stub_bi_31.BOTN stub_bi_31.BOTP cml_tlatch_34.xmux.xp.S1 VSS sg13_lv_nmos ad=56.9f pd=0.74u as=56.9f ps=0.74u w=0.17u l=0.17u
X9866 A1_2_P A1_2_N cml_tlatch_37.xmux.xp.S1 VSS sg13_lv_nmos ad=56.9f pd=0.74u as=56.9f ps=0.74u w=0.17u l=0.17u
X9867 A0_2_N A0_2_P cml_tlatch_31.xmux.xp.S1 VSS sg13_lv_nmos ad=56.9f pd=0.74u as=56.9f ps=0.74u w=0.17u l=0.17u
X9868 VSS cml_drv_0.xrtail.R1 VSS rppd l=5.65u w=1u
X9869 cml_tlatch_53.xtail.S1 CKA3_P cml_tlatch_53.xmux.xp.S1 VSS sg13_lv_nmos ad=89.3f pd=0.85u as=89.3f ps=0.85u w=0.47u l=0.16u
X9870 VSS hs_to_clk_0.sg13_lv_nmos_2HGZLP_0.G VSS VSS sg13_lv_nmos ad=2.071p pd=11.28u as=0 ps=0 w=10.9u l=1.38u
X9871 stub_bi_32.BOTP stub_bi_32.BOTN cml_tlatch_48.xmux.xp.S1 VSS sg13_lv_nmos ad=56.9f pd=0.74u as=56.9f ps=0.74u w=0.17u l=0.17u
X9872 cml_tlatch_80.xmux.xp.S1 CKB2_N cml_tlatch_80.xtail.S1 VSS sg13_lv_nmos ad=89.3f pd=0.85u as=89.3f ps=0.85u w=0.47u l=0.16u
X9873 cml_tlatch_77.xmux.xn.S1 stub_bi_62.BOTP B2_8_P VSS sg13_lv_nmos ad=63.19999f pd=0.74u as=0.1082p ps=1.34u w=0.26u l=0.38u
X9874 cml_tlatch_8.OUTP cml_tlatch_8.OUTN cml_tlatch_8.xmux.xp.S1 VSS sg13_lv_nmos ad=56.9f pd=0.74u as=56.9f ps=0.74u w=0.17u l=0.17u
X9875 cml_tlatch_67.xmux.xp.S1 CKA3_N cml_tlatch_67.xtail.S1 VSS sg13_lv_nmos ad=89.3f pd=0.85u as=89.3f ps=0.85u w=0.47u l=0.16u
X9876 cml_tlatch_19.xtail.S1 CKHB0_N cml_tlatch_19.xmux.xp.S1 VSS sg13_lv_nmos ad=89.3f pd=0.85u as=89.3f ps=0.85u w=0.47u l=0.16u
X9877 B2_8_N stub_bi_62.BOTN cml_tlatch_77.xmux.xn.S1 VSS sg13_lv_nmos ad=63.19999f pd=0.74u as=63.19999f ps=0.74u w=0.26u l=0.38u
X9878 B1_2_N B1_2_P cml_tlatch_33.xmux.xp.S1 VSS sg13_lv_nmos ad=56.9f pd=0.74u as=0.1019p ps=1.34u w=0.17u l=0.17u
X9879 cml_tlatch_73.xmux.xn.S1 CKHB2_P cml_tlatch_73.xtail.S1 VSS sg13_lv_nmos ad=89.3f pd=0.85u as=89.3f ps=0.85u w=0.47u l=0.16u
X9880 cml_tlatch_43.xmux.xp.S1 stub_bi_42.BOTP stub_bi_42.BOTN VSS sg13_lv_nmos ad=56.9f pd=0.74u as=56.9f ps=0.74u w=0.17u l=0.17u
X9881 cml_tlatch_4.xmux.xp.S1 MOT9_P MOT9_N VSS sg13_lv_nmos ad=56.9f pd=0.74u as=56.9f ps=0.74u w=0.17u l=0.17u
X9882 MOT10_P MOT10_N cml_tlatch_39.xmux.xp.S1 VSS sg13_lv_nmos ad=56.9f pd=0.74u as=56.9f ps=0.74u w=0.17u l=0.17u
X9883 cml_tlatch_96.xtail.S1 CKHA1_P cml_tlatch_96.xmux.xn.S1 VSS sg13_lv_nmos ad=89.3f pd=0.85u as=89.3f ps=0.85u w=0.47u l=0.16u
X9884 cml_tlatch_42.xtail.S1 POLN VSS VSS sg13_lv_nmos ad=1.5637p pd=8.61u as=2.7982p ps=17.14u w=8.23u l=0.13u
X9885 cml_tlatch_82.OUTN cml_tlatch_82.OUTP cml_tlatch_82.xmux.xp.S1 VSS sg13_lv_nmos ad=56.9f pd=0.74u as=56.9f ps=0.74u w=0.17u l=0.17u
X9886 cml_tlatch_70.xmux.xp.S1 MOT29_N MOT29_P VSS sg13_lv_nmos ad=56.9f pd=0.74u as=56.9f ps=0.74u w=0.17u l=0.17u
X9887 cml_tlatch_41.xtail.S1 CKHA1_P cml_tlatch_41.xmux.xn.S1 VSS sg13_lv_nmos ad=89.3f pd=0.85u as=89.3f ps=0.85u w=0.47u l=0.16u
X9888 cml_tlatch_36.xmux.xp.S1 CKA1_N cml_tlatch_36.xtail.S1 VSS sg13_lv_nmos ad=89.3f pd=0.85u as=89.3f ps=0.85u w=0.47u l=0.16u
X9889 cml_tlatch_45.xmux.xp.S1 cml_tlatch_45.OUTP cml_tlatch_45.OUTN VSS sg13_lv_nmos ad=56.9f pd=0.74u as=56.9f ps=0.74u w=0.17u l=0.17u
X9890 cml_tlatch_47.OUTP cml_tlatch_47.OUTN cml_tlatch_47.xmux.xp.S1 VSS sg13_lv_nmos ad=56.9f pd=0.74u as=56.9f ps=0.74u w=0.17u l=0.17u
X9891 cml_tlatch_85.xmux.xp.S1 cml_tlatch_58.INP cml_tlatch_58.INN VSS sg13_lv_nmos ad=56.9f pd=0.74u as=56.9f ps=0.74u w=0.17u l=0.17u
X9892 MOT25_P B3_8_N cml_tlatch_68.xmux.xn.S1 VSS sg13_lv_nmos ad=63.19999f pd=0.74u as=63.19999f ps=0.74u w=0.26u l=0.38u
X9893 cml_tlatch_9.xmux.xp.S1 cml_tlatch_9.OUTP cml_tlatch_9.OUTN VSS sg13_lv_nmos ad=56.9f pd=0.74u as=56.9f ps=0.74u w=0.17u l=0.17u
X9894 MOT11_P MOT11_N cml_tlatch_5.xmux.xp.S1 VSS sg13_lv_nmos ad=56.9f pd=0.74u as=56.9f ps=0.74u w=0.17u l=0.17u
X9895 cml_tlatch_58.xmux.xn.S1 cml_tlatch_58.INP MOT28_N VSS sg13_lv_nmos ad=0.1082p pd=1.34u as=63.19999f ps=0.74u w=0.26u l=0.38u
X9896 cml_tlatch_39.xtail.S1 CKHA1_N cml_tlatch_39.xmux.xp.S1 VSS sg13_lv_nmos ad=89.3f pd=0.85u as=89.3f ps=0.85u w=0.47u l=0.16u
X9897 interco_bi_19.INN interco_bi_19.INP cml_tlatch_0.xmux.xp.S1 VSS sg13_lv_nmos ad=56.9f pd=0.74u as=56.9f ps=0.74u w=0.17u l=0.17u
X9898 cml_tlatch_57.INN cml_tlatch_67.OUTP cml_tlatch_66.xmux.xn.S1 VSS sg13_lv_nmos ad=63.19999f pd=0.74u as=0.1082p ps=1.34u w=0.26u l=0.38u
X9899 cml_tlatch_88.xmux.xn.S1 stub_bi_42.BOTN stub_bi_55.BOTP VSS sg13_lv_nmos ad=63.19999f pd=0.74u as=63.19999f ps=0.74u w=0.26u l=0.38u
X9900 cml_tlatch_68.xmux.xn.S1 CKHB3_P cml_tlatch_68.xtail.S1 VSS sg13_lv_nmos ad=89.3f pd=0.85u as=89.3f ps=0.85u w=0.47u l=0.16u
X9901 cml_tlatch_50.xmux.xp.S1 MOT20_N MOT20_P VSS sg13_lv_nmos ad=0.1019p pd=1.34u as=56.9f ps=0.74u w=0.17u l=0.17u
X9902 cml_tlatch_32.xmux.xp.S1 CKB1_N cml_tlatch_32.xtail.S1 VSS sg13_lv_nmos ad=89.3f pd=0.85u as=89.3f ps=0.85u w=0.47u l=0.16u
X9903 cml_tlatch_26.xtail.S1 CKHA0_N cml_tlatch_26.xmux.xp.S1 VSS sg13_lv_nmos ad=89.3f pd=0.85u as=89.3f ps=0.85u w=0.47u l=0.16u
X9904 cml_tlatch_89.xmux.xn.S1 cml_tlatch_89.INN cml_tlatch_89.OUTP VSS sg13_lv_nmos ad=63.19999f pd=0.74u as=63.19999f ps=0.74u w=0.26u l=0.38u
X9905 MOT28_P MOT28_N cml_tlatch_58.xmux.xp.S1 VSS sg13_lv_nmos ad=56.9f pd=0.74u as=56.9f ps=0.74u w=0.17u l=0.17u
X9906 MOT26_N MOT26_P cml_tlatch_57.xmux.xp.S1 VSS sg13_lv_nmos ad=56.9f pd=0.74u as=56.9f ps=0.74u w=0.17u l=0.17u
X9907 MOT26_P MOT26_N cml_tlatch_57.xmux.xp.S1 VSS sg13_lv_nmos ad=56.9f pd=0.74u as=56.9f ps=0.74u w=0.17u l=0.17u
X9908 cml_tlatch_97.xmux.xn.S1 A0_8_N MOT0_P VSS sg13_lv_nmos ad=63.19999f pd=0.74u as=63.19999f ps=0.74u w=0.26u l=0.38u
X9909 cml_tlatch_16.OUTN cml_tlatch_16.OUTP cml_tlatch_16.xmux.xp.S1 VSS sg13_lv_nmos ad=56.9f pd=0.74u as=56.9f ps=0.74u w=0.17u l=0.17u
X9910 cml_tlatch_99.xmux.xp.S1 cml_tlatch_99.OUTP cml_tlatch_99.OUTN VSS sg13_lv_nmos ad=56.9f pd=0.74u as=56.9f ps=0.74u w=0.17u l=0.17u
X9911 cml_tlatch_30.xmux.xp.S1 cml_tlatch_30.OUTN cml_tlatch_30.OUTP VSS sg13_lv_nmos ad=56.9f pd=0.74u as=56.9f ps=0.74u w=0.17u l=0.17u
X9912 cml_tlatch_70.xtail.S1 CKHB3_P cml_tlatch_70.xmux.xn.S1 VSS sg13_lv_nmos ad=89.3f pd=0.85u as=89.3f ps=0.85u w=0.47u l=0.16u
X9913 cml_tlatch_80.xmux.xp.S1 stub_bi_49.BOTP stub_bi_49.BOTN VSS sg13_lv_nmos ad=56.9f pd=0.74u as=56.9f ps=0.74u w=0.17u l=0.17u
X9914 hs_to_clk_0.D2 CK_N CKA0_N VSS sg13_lv_nmos ad=0.228p pd=1.58u as=0.228p ps=1.58u w=1.2u l=0.2u
X9915 cml_tlatch_40.xmux.xp.S1 MOT12_N MOT12_P VSS sg13_lv_nmos ad=56.9f pd=0.74u as=56.9f ps=0.74u w=0.17u l=0.17u
X9916 cml_tlatch_39.xmux.xp.S1 MOT10_P MOT10_N VSS sg13_lv_nmos ad=56.9f pd=0.74u as=56.9f ps=0.74u w=0.17u l=0.17u
X9917 cml_tlatch_40.INN cml_tlatch_40.INP cml_tlatch_95.xmux.xp.S1 VSS sg13_lv_nmos ad=56.9f pd=0.74u as=56.9f ps=0.74u w=0.17u l=0.17u
X9918 A2_8_P A2_8_N cml_tlatch_81.xmux.xp.S1 VSS sg13_lv_nmos ad=56.9f pd=0.74u as=56.9f ps=0.74u w=0.17u l=0.17u
X9919 cml_tlatch_47.xmux.xp.S1 cml_tlatch_47.OUTN cml_tlatch_47.OUTP VSS sg13_lv_nmos ad=56.9f pd=0.74u as=56.9f ps=0.74u w=0.17u l=0.17u
X9920 B1_2_N B1_2_P cml_tlatch_33.xmux.xp.S1 VSS sg13_lv_nmos ad=56.9f pd=0.74u as=56.9f ps=0.74u w=0.17u l=0.17u
X9921 cml_tlatch_53.xmux.xp.S1 A3_2_N A3_2_P VSS sg13_lv_nmos ad=56.9f pd=0.74u as=56.9f ps=0.74u w=0.17u l=0.17u
X9922 cml_tlatch_27.xtail.S1 POLN VSS VSS sg13_lv_nmos ad=1.5637p pd=8.61u as=2.7982p ps=17.14u w=8.23u l=0.13u
X9923 cml_tlatch_87.xtail.S1 CKHA2_P cml_tlatch_87.xmux.xn.S1 VSS sg13_lv_nmos ad=89.3f pd=0.85u as=89.3f ps=0.85u w=0.47u l=0.16u
X9924 cml_gate2_2.xrtail.R1 CKB0_P cml_gate2_2.sg13_lv_nmos_FTPY57_0.D0 VSS sg13_lv_nmos ad=0.1007p pd=0.91u as=0.1007p ps=0.91u w=0.53u l=0.13u
X9925 cml_tlatch_79.xmux.xp.S1 stub_bi_63.BOTN stub_bi_63.BOTP VSS sg13_lv_nmos ad=56.9f pd=0.74u as=56.9f ps=0.74u w=0.17u l=0.17u
X9926 cml_tlatch_93.xmux.xn.S1 CKJ_P cml_tlatch_93.xtail.S1 VSS sg13_lv_nmos ad=89.3f pd=0.85u as=89.3f ps=0.85u w=0.47u l=0.16u
X9927 cml_tlatch_73.xmux.xp.S1 MOT17_N MOT17_P VSS sg13_lv_nmos ad=56.9f pd=0.74u as=56.9f ps=0.74u w=0.17u l=0.17u
X9928 cml_tlatch_11.OUTN cml_tlatch_16.OUTP cml_tlatch_11.xmux.xn.S1 VSS sg13_lv_nmos ad=63.19999f pd=0.74u as=63.19999f ps=0.74u w=0.26u l=0.38u
X9929 cml_tlatch_18.xmux.xn.S1 CKHB0_P cml_tlatch_18.xtail.S1 VSS sg13_lv_nmos ad=89.3f pd=0.85u as=89.3f ps=0.85u w=0.47u l=0.16u
X9930 MOT3_N MOT3_P cml_tlatch_18.xmux.xp.S1 VSS sg13_lv_nmos ad=56.9f pd=0.74u as=56.9f ps=0.74u w=0.17u l=0.17u
X9931 cml_tlatch_33.xmux.xp.S1 B1_2_N B1_2_P VSS sg13_lv_nmos ad=56.9f pd=0.74u as=56.9f ps=0.74u w=0.17u l=0.17u
X9932 VSS POLN cml_tlatch_52.xtail.S1 VSS sg13_lv_nmos ad=2.7982p pd=17.14u as=1.5637p ps=8.61u w=8.23u l=0.13u
X9933 cml_tlatch_1.xmux.xp.S1 cml_tlatch_1.OUTN cml_tlatch_1.OUTP VSS sg13_lv_nmos ad=56.9f pd=0.74u as=56.9f ps=0.74u w=0.17u l=0.17u
X9934 MOT6_N A0_2_P cml_tlatch_26.xmux.xn.S1 VSS sg13_lv_nmos ad=63.19999f pd=0.74u as=63.19999f ps=0.74u w=0.26u l=0.38u
X9935 cml_tlatch_22.xmux.xp.S1 cml_tlatch_22.OUTP cml_tlatch_22.OUTN VSS sg13_lv_nmos ad=56.9f pd=0.74u as=56.9f ps=0.74u w=0.17u l=0.17u
X9936 cml_tlatch_70.INP VDD VSS rppd l=5.17u w=1u
X9937 cml_tlatch_3.OUTP cml_tlatch_3.OUTN cml_tlatch_3.xmux.xp.S1 VSS sg13_lv_nmos ad=56.9f pd=0.74u as=56.9f ps=0.74u w=0.17u l=0.17u
X9938 cml_tlatch_67.OUTP cml_tlatch_67.OUTN cml_tlatch_67.xmux.xp.S1 VSS sg13_lv_nmos ad=56.9f pd=0.74u as=0.1019p ps=1.34u w=0.17u l=0.17u
X9939 GB3_P CKA3_N cml_gate2_6.xrtail.R1 VSS sg13_lv_nmos ad=0.1007p pd=0.91u as=0.1007p ps=0.91u w=0.53u l=0.13u
X9940 cml_tlatch_16.xmux.xp.S1 cml_tlatch_16.OUTN cml_tlatch_16.OUTP VSS sg13_lv_nmos ad=56.9f pd=0.74u as=56.9f ps=0.74u w=0.17u l=0.17u
X9941 J2_P J1_N cml_tlatch_92.xmux.xn.S1 VSS sg13_lv_nmos ad=0.1082p pd=1.34u as=63.19999f ps=0.74u w=0.26u l=0.38u
X9942 B3_2_N B3_2_P cml_tlatch_46.xmux.xp.S1 VSS sg13_lv_nmos ad=56.9f pd=0.74u as=56.9f ps=0.74u w=0.17u l=0.17u
X9943 cml_tlatch_6.xmux.xp.S1 MOT13_N MOT13_P VSS sg13_lv_nmos ad=0.1019p pd=1.34u as=56.9f ps=0.74u w=0.17u l=0.17u
X9944 cml_tlatch_61.xtail.S1 CKB3_N cml_tlatch_61.xmux.xp.S1 VSS sg13_lv_nmos ad=89.3f pd=0.85u as=89.3f ps=0.85u w=0.47u l=0.16u
X9945 cml_tlatch_78.xmux.xn.S1 CKB2_P cml_tlatch_78.xtail.S1 VSS sg13_lv_nmos ad=89.3f pd=0.85u as=89.3f ps=0.85u w=0.47u l=0.16u
X9946 hs_to_clk_0.D2 CK_P CKA0_P VSS sg13_lv_nmos ad=0.228p pd=1.58u as=0.228p ps=1.58u w=1.2u l=0.2u
X9947 MOT26_N cml_tlatch_57.INP cml_tlatch_57.xmux.xn.S1 VSS sg13_lv_nmos ad=63.19999f pd=0.74u as=63.19999f ps=0.74u w=0.26u l=0.38u
X9948 cml_tlatch_76.xmux.xp.S1 MOT23_N MOT23_P VSS sg13_lv_nmos ad=0.1019p pd=1.34u as=56.9f ps=0.74u w=0.17u l=0.17u
X9949 cml_tlatch_43.xtail.S1 POLN VSS VSS sg13_lv_nmos ad=1.5637p pd=8.61u as=2.7982p ps=17.14u w=8.23u l=0.13u
X9950 A1_8_N A1_8_P cml_tlatch_21.xmux.xp.S1 VSS sg13_lv_nmos ad=56.9f pd=0.74u as=0.1019p ps=1.34u w=0.17u l=0.17u
X9951 cml_tlatch_58.INN cml_tlatch_52.OUTP cml_tlatch_85.xmux.xn.S1 VSS sg13_lv_nmos ad=63.19999f pd=0.74u as=63.19999f ps=0.74u w=0.26u l=0.38u
X9952 MOT31_P MOT31_N cml_tlatch_71.xmux.xp.S1 VSS sg13_lv_nmos ad=56.9f pd=0.74u as=56.9f ps=0.74u w=0.17u l=0.17u
X9953 MOT8_N MOT8_P cml_tlatch_96.xmux.xp.S1 VSS sg13_lv_nmos ad=56.9f pd=0.74u as=56.9f ps=0.74u w=0.17u l=0.17u
X9954 cml_tlatch_98.xmux.xp.S1 cml_tlatch_98.OUTN cml_tlatch_98.OUTP VSS sg13_lv_nmos ad=56.9f pd=0.74u as=56.9f ps=0.74u w=0.17u l=0.17u
X9955 cml_tlatch_34.xmux.xn.S1 D1_N stub_bi_31.BOTN VSS sg13_lv_nmos ad=63.19999f pd=0.74u as=63.19999f ps=0.74u w=0.26u l=0.38u
X9956 cml_tlatch_89.INN cml_tlatch_89.INP cml_tlatch_55.xmux.xp.S1 VSS sg13_lv_nmos ad=56.9f pd=0.74u as=56.9f ps=0.74u w=0.17u l=0.17u
X9957 cml_tlatch_45.xmux.xp.S1 cml_tlatch_45.OUTP cml_tlatch_45.OUTN VSS sg13_lv_nmos ad=56.9f pd=0.74u as=56.9f ps=0.74u w=0.17u l=0.17u
X9958 MOT18_P cml_tlatch_83.OUTN cml_tlatch_49.xmux.xn.S1 VSS sg13_lv_nmos ad=63.19999f pd=0.74u as=63.19999f ps=0.74u w=0.26u l=0.38u
X9959 cml_tlatch_6.xmux.xn.S1 cml_tlatch_6.INN MOT13_P VSS sg13_lv_nmos ad=63.19999f pd=0.74u as=0.1082p ps=1.34u w=0.26u l=0.38u
X9960 cml_tlatch_49.xmux.xn.S1 CKHA2_P cml_tlatch_49.xtail.S1 VSS sg13_lv_nmos ad=0.1598p pd=1.62u as=89.3f ps=0.85u w=0.47u l=0.16u
X9961 stub_bi_62.BOTN stub_bi_63.BOTP cml_tlatch_78.xmux.xn.S1 VSS sg13_lv_nmos ad=63.19999f pd=0.74u as=63.19999f ps=0.74u w=0.26u l=0.38u
X9962 cml_tlatch_1.xtail.S1 CKB0_N cml_tlatch_1.xmux.xp.S1 VSS sg13_lv_nmos ad=0.1598p pd=1.62u as=89.3f ps=0.85u w=0.47u l=0.16u
X9963 VSS POLN cml_tlatch_38.xtail.S1 VSS sg13_lv_nmos ad=1.5637p pd=8.61u as=1.5637p ps=8.61u w=8.23u l=0.13u
X9964 cml_tlatch_38.xtail.S1 CKA1_N cml_tlatch_38.xmux.xp.S1 VSS sg13_lv_nmos ad=89.3f pd=0.85u as=89.3f ps=0.85u w=0.47u l=0.16u
X9965 cml_tlatch_82.xmux.xp.S1 cml_tlatch_82.OUTN cml_tlatch_82.OUTP VSS sg13_lv_nmos ad=0.1019p pd=1.34u as=56.9f ps=0.74u w=0.17u l=0.17u
X9966 VSS POLN cml_tlatch_86.xtail.S1 VSS sg13_lv_nmos ad=2.7982p pd=17.14u as=1.5637p ps=8.61u w=8.23u l=0.13u
X9967 VSS POLN cml_tlatch_51.xtail.S1 VSS sg13_lv_nmos ad=2.7982p pd=17.14u as=1.5637p ps=8.61u w=8.23u l=0.13u
X9968 VDD cml_tlatch_82.OUTN VSS rppd l=5.17u w=1u
X9969 cml_tlatch_18.xmux.xn.S1 cml_tlatch_16.OUTN MOT3_P VSS sg13_lv_nmos ad=63.19999f pd=0.74u as=63.19999f ps=0.74u w=0.26u l=0.38u
X9970 cml_tlatch_7.xmux.xp.S1 MOT15_N MOT15_P VSS sg13_lv_nmos ad=56.9f pd=0.74u as=56.9f ps=0.74u w=0.17u l=0.17u
X9971 cml_tlatch_34.xmux.xn.S1 D1_N stub_bi_31.BOTN VSS sg13_lv_nmos ad=63.19999f pd=0.74u as=63.19999f ps=0.74u w=0.26u l=0.38u
X9972 cml_tlatch_62.xtail.S1 CKB3_N cml_tlatch_62.xmux.xn.S1 VSS sg13_lv_nmos ad=89.3f pd=0.85u as=89.3f ps=0.85u w=0.47u l=0.16u
X9973 cml_tlatch_54.OUTN D3_P cml_tlatch_54.xmux.xn.S1 VSS sg13_lv_nmos ad=0.1082p pd=1.34u as=63.19999f ps=0.74u w=0.26u l=0.38u
X9974 cml_tlatch_3.xtail.S1 CKA0_P cml_tlatch_3.xmux.xn.S1 VSS sg13_lv_nmos ad=89.3f pd=0.85u as=89.3f ps=0.85u w=0.47u l=0.16u
X9975 ENB0_N ENB_P cml_drv_2.xrtail.R1 VSS sg13_lv_nmos ad=56.2f pd=0.74u as=56.2f ps=0.74u w=0.16u l=0.19u
X9976 B3_2_N cml_tlatch_47.OUTP cml_tlatch_46.xmux.xn.S1 VSS sg13_lv_nmos ad=63.19999f pd=0.74u as=63.19999f ps=0.74u w=0.26u l=0.38u
X9977 cml_tlatch_18.xmux.xn.S1 cml_tlatch_16.OUTN MOT3_P VSS sg13_lv_nmos ad=63.19999f pd=0.74u as=63.19999f ps=0.74u w=0.26u l=0.38u
X9978 MOT22_N MOT22_P cml_tlatch_51.xmux.xp.S1 VSS sg13_lv_nmos ad=56.9f pd=0.74u as=56.9f ps=0.74u w=0.17u l=0.17u
X9979 cml_tlatch_51.xmux.xn.S1 CKHA2_P cml_tlatch_51.xtail.S1 VSS sg13_lv_nmos ad=89.3f pd=0.85u as=89.3f ps=0.85u w=0.47u l=0.16u
X9980 GA0_P ENA0_N cml_gate2_2.sg13_lv_nmos_FTPY57_0.D0 VSS sg13_lv_nmos ad=0.1007p pd=0.91u as=0.1007p ps=0.91u w=0.53u l=0.13u
X9981 MOT10_P MOT10_N cml_tlatch_39.xmux.xp.S1 VSS sg13_lv_nmos ad=56.9f pd=0.74u as=56.9f ps=0.74u w=0.17u l=0.17u
X9982 cml_tlatch_95.INP cml_tlatch_95.INN cml_tlatch_36.xmux.xp.S1 VSS sg13_lv_nmos ad=56.9f pd=0.74u as=0.1019p ps=1.34u w=0.17u l=0.17u
X9983 cml_tlatch_60.xtail.S1 POLN VSS VSS sg13_lv_nmos ad=1.5637p pd=8.61u as=2.7982p ps=17.14u w=8.23u l=0.13u
X9984 cml_tlatch_31.xmux.xp.S1 CKA0_P cml_tlatch_31.xtail.S1 VSS sg13_lv_nmos ad=89.3f pd=0.85u as=89.3f ps=0.85u w=0.47u l=0.16u
X9985 A3_2_P cml_tlatch_54.OUTN cml_tlatch_53.xmux.xn.S1 VSS sg13_lv_nmos ad=63.19999f pd=0.74u as=63.19999f ps=0.74u w=0.26u l=0.38u
X9986 cml_tlatch_0.xtail.S1 CKA1_P cml_tlatch_0.xmux.xn.S1 VSS sg13_lv_nmos ad=89.3f pd=0.85u as=89.3f ps=0.85u w=0.47u l=0.16u
X9987 MOT26_N MOT26_P cml_tlatch_57.xmux.xp.S1 VSS sg13_lv_nmos ad=56.9f pd=0.74u as=0.1019p ps=1.34u w=0.17u l=0.17u
X9988 cml_tlatch_34.xtail.S1 CKB1_N cml_tlatch_34.xmux.xp.S1 VSS sg13_lv_nmos ad=89.3f pd=0.85u as=89.3f ps=0.85u w=0.47u l=0.16u
X9989 B2_8_P B2_8_N cml_tlatch_77.xmux.xp.S1 VSS sg13_lv_nmos ad=56.9f pd=0.74u as=56.9f ps=0.74u w=0.17u l=0.17u
X9990 cml_tlatch_95.xmux.xp.S1 cml_tlatch_40.INN cml_tlatch_40.INP VSS sg13_lv_nmos ad=56.9f pd=0.74u as=56.9f ps=0.74u w=0.17u l=0.17u
X9991 cml_tlatch_90.xmux.xp.S1 J4_P J4_N VSS sg13_lv_nmos ad=56.9f pd=0.74u as=56.9f ps=0.74u w=0.17u l=0.17u
X9992 cml_tlatch_89.INP A2_2_N cml_tlatch_55.xmux.xn.S1 VSS sg13_lv_nmos ad=63.19999f pd=0.74u as=63.19999f ps=0.74u w=0.26u l=0.38u
X9993 cml_tlatch_59.xmux.xn.S1 CKHA3_P cml_tlatch_59.xtail.S1 VSS sg13_lv_nmos ad=89.3f pd=0.85u as=89.3f ps=0.85u w=0.47u l=0.16u
X9994 cml_tlatch_71.xmux.xp.S1 MOT31_P MOT31_N VSS sg13_lv_nmos ad=0.1019p pd=1.34u as=56.9f ps=0.74u w=0.17u l=0.17u
X9995 cml_tlatch_66.xmux.xp.S1 CKA3_P cml_tlatch_66.xtail.S1 VSS sg13_lv_nmos ad=89.3f pd=0.85u as=89.3f ps=0.85u w=0.47u l=0.16u
X9996 cml_tlatch_99.xmux.xp.S1 cml_tlatch_99.OUTP cml_tlatch_99.OUTN VSS sg13_lv_nmos ad=0.1019p pd=1.34u as=56.9f ps=0.74u w=0.17u l=0.17u
X9997 MOT5_N MOT5_P cml_tlatch_19.xmux.xp.S1 VSS sg13_lv_nmos ad=56.9f pd=0.74u as=56.9f ps=0.74u w=0.17u l=0.17u
X9998 cml_tlatch_65.OUTN cml_tlatch_65.OUTP cml_tlatch_65.xmux.xp.S1 VSS sg13_lv_nmos ad=56.9f pd=0.74u as=56.9f ps=0.74u w=0.17u l=0.17u
X9999 cml_tlatch_63.OUTN cml_tlatch_63.OUTP cml_tlatch_63.xmux.xp.S1 VSS sg13_lv_nmos ad=56.9f pd=0.74u as=56.9f ps=0.74u w=0.17u l=0.17u
X10000 cml_tlatch_57.INN cml_tlatch_57.INP cml_tlatch_66.xmux.xp.S1 VSS sg13_lv_nmos ad=56.9f pd=0.74u as=56.9f ps=0.74u w=0.17u l=0.17u
X10001 cml_tlatch_93.xmux.xp.S1 J1_P J1_N VSS sg13_lv_nmos ad=56.9f pd=0.74u as=56.9f ps=0.74u w=0.17u l=0.17u
X10002 cml_tlatch_19.xmux.xp.S1 CKHB0_N cml_tlatch_19.xtail.S1 VSS sg13_lv_nmos ad=89.3f pd=0.85u as=89.3f ps=0.85u w=0.47u l=0.16u
X10003 cml_tlatch_66.xtail.S1 POLN VSS VSS sg13_lv_nmos ad=1.5637p pd=8.61u as=2.7982p ps=17.14u w=8.23u l=0.13u
X10004 cml_tlatch_51.xmux.xn.S1 A2_2_N MOT22_P VSS sg13_lv_nmos ad=63.19999f pd=0.74u as=63.19999f ps=0.74u w=0.26u l=0.38u
X10005 cml_tlatch_22.xmux.xp.S1 cml_tlatch_22.OUTP cml_tlatch_22.OUTN VSS sg13_lv_nmos ad=56.9f pd=0.74u as=56.9f ps=0.74u w=0.17u l=0.17u
X10006 stub_bi_17.BOTP stub_bi_17.BOTN cml_tlatch_13.xmux.xp.S1 VSS sg13_lv_nmos ad=56.9f pd=0.74u as=56.9f ps=0.74u w=0.17u l=0.17u
X10007 cml_tlatch_62.xmux.xp.S1 CKB3_P cml_tlatch_62.xtail.S1 VSS sg13_lv_nmos ad=89.3f pd=0.85u as=89.3f ps=0.85u w=0.47u l=0.16u
X10008 stub_bi_42.BOTP stub_bi_42.BOTN cml_tlatch_43.xmux.xp.S1 VSS sg13_lv_nmos ad=56.9f pd=0.74u as=0.1019p ps=1.34u w=0.17u l=0.17u
X10009 J4_N J4_P cml_tlatch_90.xmux.xp.S1 VSS sg13_lv_nmos ad=56.9f pd=0.74u as=0.1019p ps=1.34u w=0.17u l=0.17u
X10010 MOT1_P B0_8_N cml_tlatch_17.xmux.xn.S1 VSS sg13_lv_nmos ad=63.19999f pd=0.74u as=63.19999f ps=0.74u w=0.26u l=0.38u
X10011 cml_gate2_9.xrtail.R1 NM1_P cml_gate2_9.sg13_lv_nmos_FTPY57_0.D0 VSS sg13_lv_nmos ad=0.1007p pd=0.91u as=0.1007p ps=0.91u w=0.53u l=0.13u
X10012 A3_8_N A3_8_P cml_tlatch_64.xmux.xp.S1 VSS sg13_lv_nmos ad=56.9f pd=0.74u as=56.9f ps=0.74u w=0.17u l=0.17u
X10013 cml_tlatch_86.xmux.xp.S1 CKHA3_N cml_tlatch_86.xtail.S1 VSS sg13_lv_nmos ad=89.3f pd=0.85u as=89.3f ps=0.85u w=0.47u l=0.16u
X10014 cml_tlatch_73.xmux.xp.S1 MOT17_N MOT17_P VSS sg13_lv_nmos ad=0.1019p pd=1.34u as=56.9f ps=0.74u w=0.17u l=0.17u
X10015 cml_tlatch_42.xmux.xp.S1 cml_tlatch_56.INN cml_tlatch_56.INP VSS sg13_lv_nmos ad=0.1019p pd=1.34u as=56.9f ps=0.74u w=0.17u l=0.17u
X10016 cml_tlatch_26.xmux.xp.S1 MOT6_N MOT6_P VSS sg13_lv_nmos ad=56.9f pd=0.74u as=56.9f ps=0.74u w=0.17u l=0.17u
X10017 cml_tlatch_42.xmux.xp.S1 CKA2_N cml_tlatch_42.xtail.S1 VSS sg13_lv_nmos ad=89.3f pd=0.85u as=89.3f ps=0.85u w=0.47u l=0.16u
X10018 MOT25_P MOT25_N cml_tlatch_68.xmux.xp.S1 VSS sg13_lv_nmos ad=56.9f pd=0.74u as=56.9f ps=0.74u w=0.17u l=0.17u
X10019 cml_tlatch_69.xtail.S1 CKHB3_N cml_tlatch_69.xmux.xp.S1 VSS sg13_lv_nmos ad=89.3f pd=0.85u as=89.3f ps=0.85u w=0.47u l=0.16u
X10020 cml_tlatch_7.xtail.S1 CKHB1_P cml_tlatch_7.xmux.xn.S1 VSS sg13_lv_nmos ad=89.3f pd=0.85u as=0.1598p ps=1.62u w=0.47u l=0.16u
X10021 cml_tlatch_1.xmux.xp.S1 cml_tlatch_1.OUTN cml_tlatch_1.OUTP VSS sg13_lv_nmos ad=56.9f pd=0.74u as=56.9f ps=0.74u w=0.17u l=0.17u
X10022 VSS POLN cml_tlatch_32.xtail.S1 VSS sg13_lv_nmos ad=1.5637p pd=8.61u as=1.5637p ps=8.61u w=8.23u l=0.13u
X10023 cml_tlatch_28.xmux.xn.S1 CKB0_N cml_tlatch_28.xtail.S1 VSS sg13_lv_nmos ad=89.3f pd=0.85u as=89.3f ps=0.85u w=0.47u l=0.16u
X10024 cml_tlatch_93.xmux.xp.S1 CKJ_N cml_tlatch_93.xtail.S1 VSS sg13_lv_nmos ad=0.1598p pd=1.62u as=89.3f ps=0.85u w=0.47u l=0.16u
X10025 cml_tlatch_0.xtail.S1 CKA1_P cml_tlatch_0.xmux.xn.S1 VSS sg13_lv_nmos ad=89.3f pd=0.85u as=89.3f ps=0.85u w=0.47u l=0.16u
X10026 cml_tlatch_15.xmux.xp.S1 stub_bi_19.BOTN stub_bi_19.BOTP VSS sg13_lv_nmos ad=0.1019p pd=1.34u as=56.9f ps=0.74u w=0.17u l=0.17u
X10027 cml_tlatch_4.xmux.xp.S1 MOT9_N MOT9_P VSS sg13_lv_nmos ad=56.9f pd=0.74u as=56.9f ps=0.74u w=0.17u l=0.17u
X10028 cml_tlatch_56.xmux.xp.S1 A2_2_P A2_2_N VSS sg13_lv_nmos ad=56.9f pd=0.74u as=56.9f ps=0.74u w=0.17u l=0.17u
X10029 J4_P J4_N cml_tlatch_90.xmux.xp.S1 VSS sg13_lv_nmos ad=56.9f pd=0.74u as=56.9f ps=0.74u w=0.17u l=0.17u
X10030 cml_tlatch_52.OUTP cml_tlatch_52.OUTN cml_tlatch_52.xmux.xp.S1 VSS sg13_lv_nmos ad=56.9f pd=0.74u as=56.9f ps=0.74u w=0.17u l=0.17u
X10031 stub_bi_19.BOTN stub_bi_19.BOTP cml_tlatch_15.xmux.xp.S1 VSS sg13_lv_nmos ad=56.9f pd=0.74u as=56.9f ps=0.74u w=0.17u l=0.17u
X10032 cml_drv_1.xrtail.R1 ENA_P ENA1_N VSS sg13_lv_nmos ad=56.2f pd=0.74u as=56.2f ps=0.74u w=0.16u l=0.19u
X10033 cml_tlatch_95.xtail.S1 CKA1_P cml_tlatch_95.xmux.xp.S1 VSS sg13_lv_nmos ad=89.3f pd=0.85u as=89.3f ps=0.85u w=0.47u l=0.16u
X10034 cml_tlatch_53.xtail.S1 CKA3_P cml_tlatch_53.xmux.xp.S1 VSS sg13_lv_nmos ad=89.3f pd=0.85u as=89.3f ps=0.85u w=0.47u l=0.16u
X10035 cml_tlatch_20.xtail.S1 CKHB0_N cml_tlatch_20.xmux.xp.S1 VSS sg13_lv_nmos ad=89.3f pd=0.85u as=89.3f ps=0.85u w=0.47u l=0.16u
X10036 cml_tlatch_77.xtail.S1 CKB2_P cml_tlatch_77.xmux.xp.S1 VSS sg13_lv_nmos ad=89.3f pd=0.85u as=89.3f ps=0.85u w=0.47u l=0.16u
X10037 cml_tlatch_25.xtail.S1 CKHA0_N cml_tlatch_25.xmux.xp.S1 VSS sg13_lv_nmos ad=89.3f pd=0.85u as=89.3f ps=0.85u w=0.47u l=0.16u
X10038 VSS POLN cml_tlatch_41.xtail.S1 VSS sg13_lv_nmos ad=1.5637p pd=8.61u as=1.5637p ps=8.61u w=8.23u l=0.13u
X10039 cml_tlatch_57.xtail.S1 CKHA3_N cml_tlatch_57.xmux.xp.S1 VSS sg13_lv_nmos ad=0.1598p pd=1.62u as=89.3f ps=0.85u w=0.47u l=0.16u
X10040 cml_tlatch_9.OUTP cml_tlatch_99.OUTN cml_tlatch_9.xmux.xn.S1 VSS sg13_lv_nmos ad=0.1082p pd=1.34u as=63.19999f ps=0.74u w=0.26u l=0.38u
X10041 cml_tlatch_58.INP cml_tlatch_58.INN cml_tlatch_85.xmux.xp.S1 VSS sg13_lv_nmos ad=56.9f pd=0.74u as=56.9f ps=0.74u w=0.17u l=0.17u
X10042 cml_tlatch_75.xmux.xp.S1 MOT21_P MOT21_N VSS sg13_lv_nmos ad=56.9f pd=0.74u as=56.9f ps=0.74u w=0.17u l=0.17u
X10043 cml_tlatch_59.xmux.xp.S1 MOT30_P MOT30_N VSS sg13_lv_nmos ad=56.9f pd=0.74u as=56.9f ps=0.74u w=0.17u l=0.17u
X10044 VSS hs_to_clk_4.sg13_lv_nmos_2HGZLP_0.G VSS VSS sg13_lv_nmos ad=2.071p pd=11.28u as=0 ps=0 w=10.9u l=1.38u
X10045 cml_tlatch_2.xmux.xp.S1 A0_8_P A0_8_N VSS sg13_lv_nmos ad=56.9f pd=0.74u as=56.9f ps=0.74u w=0.17u l=0.17u
X10046 cml_tlatch_9.OUTP cml_tlatch_99.OUTN cml_tlatch_9.xmux.xn.S1 VSS sg13_lv_nmos ad=63.19999f pd=0.74u as=63.19999f ps=0.74u w=0.26u l=0.38u
X10047 GB2_P ENB0_N cml_gate2_7.sg13_lv_nmos_FTPY57_0.D0 VSS sg13_lv_nmos ad=0.1007p pd=0.91u as=0.1802p ps=1.74u w=0.53u l=0.13u
X10048 cml_tlatch_9.xtail.S1 CKA0_P cml_tlatch_9.xmux.xn.S1 VSS sg13_lv_nmos ad=89.3f pd=0.85u as=89.3f ps=0.85u w=0.47u l=0.16u
X10049 MOT8_N A1_8_P cml_tlatch_96.xmux.xn.S1 VSS sg13_lv_nmos ad=63.19999f pd=0.74u as=63.19999f ps=0.74u w=0.26u l=0.38u
X10050 stub_bi_63.BOTP stub_bi_49.BOTN cml_tlatch_79.xmux.xn.S1 VSS sg13_lv_nmos ad=63.19999f pd=0.74u as=63.19999f ps=0.74u w=0.26u l=0.38u
X10051 cml_tlatch_6.INP cml_tlatch_6.INN cml_tlatch_94.xmux.xp.S1 VSS sg13_lv_nmos ad=56.9f pd=0.74u as=56.9f ps=0.74u w=0.17u l=0.17u
X10052 cml_tlatch_94.xtail.S1 CKB1_P cml_tlatch_94.xmux.xp.S1 VSS sg13_lv_nmos ad=89.3f pd=0.85u as=89.3f ps=0.85u w=0.47u l=0.16u
X10053 cml_tlatch_46.xtail.S1 CKB3_P cml_tlatch_46.xmux.xp.S1 VSS sg13_lv_nmos ad=0.1598p pd=1.62u as=89.3f ps=0.85u w=0.47u l=0.16u
X10054 MOT14_N MOT14_P cml_tlatch_41.xmux.xp.S1 VSS sg13_lv_nmos ad=56.9f pd=0.74u as=56.9f ps=0.74u w=0.17u l=0.17u
X10055 cml_tlatch_89.xtail.S1 CKA2_P cml_tlatch_89.xmux.xp.S1 VSS sg13_lv_nmos ad=89.3f pd=0.85u as=89.3f ps=0.85u w=0.47u l=0.16u
X10056 cml_tlatch_78.xtail.S1 CKB2_P cml_tlatch_78.xmux.xn.S1 VSS sg13_lv_nmos ad=89.3f pd=0.85u as=0.1598p ps=1.62u w=0.47u l=0.16u
X10057 cml_tlatch_31.xmux.xp.S1 A0_2_N A0_2_P VSS sg13_lv_nmos ad=56.9f pd=0.74u as=56.9f ps=0.74u w=0.17u l=0.17u
X10058 cml_gate2_5.sg13_lv_nmos_FTPY57_0.D0 ENA1_P GA3_N VSS sg13_lv_nmos ad=0.1007p pd=0.91u as=0.1007p ps=0.91u w=0.53u l=0.13u
X10059 cml_tlatch_39.xtail.S1 CKHA1_N cml_tlatch_39.xmux.xp.S1 VSS sg13_lv_nmos ad=89.3f pd=0.85u as=89.3f ps=0.85u w=0.47u l=0.16u
X10060 cml_tlatch_14.xtail.S1 CKB1_P cml_tlatch_14.xmux.xp.S1 VSS sg13_lv_nmos ad=89.3f pd=0.85u as=89.3f ps=0.85u w=0.47u l=0.16u
X10061 cml_tlatch_35.OUTP D0_N cml_tlatch_35.xmux.xn.S1 VSS sg13_lv_nmos ad=63.19999f pd=0.74u as=0.1082p ps=1.34u w=0.26u l=0.38u
X10062 MOT5_N MOT5_P cml_tlatch_19.xmux.xp.S1 VSS sg13_lv_nmos ad=56.9f pd=0.74u as=56.9f ps=0.74u w=0.17u l=0.17u
X10063 cml_tlatch_26.xtail.S1 CKHA0_N cml_tlatch_26.xmux.xp.S1 VSS sg13_lv_nmos ad=89.3f pd=0.85u as=89.3f ps=0.85u w=0.47u l=0.16u
X10064 ENB1_N ENB_P cml_drv_0.xrtail.R1 VSS sg13_lv_nmos ad=56.2f pd=0.74u as=56.2f ps=0.74u w=0.16u l=0.19u
X10065 cml_tlatch_22.OUTP cml_tlatch_22.OUTN cml_tlatch_22.xmux.xp.S1 VSS sg13_lv_nmos ad=56.9f pd=0.74u as=56.9f ps=0.74u w=0.17u l=0.17u
X10066 cml_tlatch_13.xmux.xp.S1 stub_bi_17.BOTP stub_bi_17.BOTN VSS sg13_lv_nmos ad=56.9f pd=0.74u as=56.9f ps=0.74u w=0.17u l=0.17u
X10067 cml_tlatch_57.INN cml_tlatch_57.INP cml_tlatch_66.xmux.xp.S1 VSS sg13_lv_nmos ad=56.9f pd=0.74u as=56.9f ps=0.74u w=0.17u l=0.17u
X10068 cml_tlatch_91.xmux.xp.S1 CLK_W_P CLK_W_N VSS sg13_lv_nmos ad=56.9f pd=0.74u as=56.9f ps=0.74u w=0.17u l=0.17u
X10069 cml_tlatch_70.INP cml_tlatch_45.OUTN cml_tlatch_84.xmux.xn.S1 VSS sg13_lv_nmos ad=63.19999f pd=0.74u as=63.19999f ps=0.74u w=0.26u l=0.38u
X10070 cml_tlatch_62.xmux.xp.S1 cml_tlatch_69.INP cml_tlatch_69.INN VSS sg13_lv_nmos ad=56.9f pd=0.74u as=56.9f ps=0.74u w=0.17u l=0.17u
X10071 MOT27_P VDD VSS rppd l=5.17u w=1u
X10072 cml_tlatch_90.xmux.xp.S1 J4_N J4_P VSS sg13_lv_nmos ad=56.9f pd=0.74u as=56.9f ps=0.74u w=0.17u l=0.17u
X10073 cml_tlatch_62.xmux.xp.S1 cml_tlatch_69.INN cml_tlatch_69.INP VSS sg13_lv_nmos ad=56.9f pd=0.74u as=56.9f ps=0.74u w=0.17u l=0.17u
X10074 A2_2_P A2_2_N cml_tlatch_56.xmux.xp.S1 VSS sg13_lv_nmos ad=56.9f pd=0.74u as=56.9f ps=0.74u w=0.17u l=0.17u
X10075 VSS POLN hs_to_clk_2.D2 VSS sg13_lv_nmos ad=1.9p pd=10.38u as=1.9p ps=10.38u w=10u l=0.13u
X10076 cml_tlatch_69.xmux.xp.S1 MOT27_P MOT27_N VSS sg13_lv_nmos ad=0.1019p pd=1.34u as=56.9f ps=0.74u w=0.17u l=0.17u
X10077 cml_tlatch_74.xtail.S1 CKHB2_P cml_tlatch_74.xmux.xn.S1 VSS sg13_lv_nmos ad=89.3f pd=0.85u as=89.3f ps=0.85u w=0.47u l=0.16u
X10078 A0_8_N cml_tlatch_3.OUTP cml_tlatch_2.xmux.xn.S1 VSS sg13_lv_nmos ad=63.19999f pd=0.74u as=63.19999f ps=0.74u w=0.26u l=0.38u
X10079 MOT30_N MOT30_P cml_tlatch_59.xmux.xp.S1 VSS sg13_lv_nmos ad=56.9f pd=0.74u as=56.9f ps=0.74u w=0.17u l=0.17u
X10080 cml_tlatch_61.xtail.S1 CKB3_P cml_tlatch_61.xmux.xn.S1 VSS sg13_lv_nmos ad=89.3f pd=0.85u as=89.3f ps=0.85u w=0.47u l=0.16u
X10081 cml_tlatch_22.xmux.xn.S1 CKA1_P cml_tlatch_22.xtail.S1 VSS sg13_lv_nmos ad=0.1598p pd=1.62u as=89.3f ps=0.85u w=0.47u l=0.16u
X10082 MOT20_P MOT20_N cml_tlatch_50.xmux.xp.S1 VSS sg13_lv_nmos ad=56.9f pd=0.74u as=56.9f ps=0.74u w=0.17u l=0.17u
X10083 cml_tlatch_5.INN cml_tlatch_5.INP cml_tlatch_14.xmux.xp.S1 VSS sg13_lv_nmos ad=56.9f pd=0.74u as=56.9f ps=0.74u w=0.17u l=0.17u
X10084 cml_tlatch_8.xmux.xp.S1 CKA0_P cml_tlatch_8.xtail.S1 VSS sg13_lv_nmos ad=89.3f pd=0.85u as=89.3f ps=0.85u w=0.47u l=0.16u
X10085 cml_tlatch_77.xmux.xn.S1 stub_bi_62.BOTN B2_8_N VSS sg13_lv_nmos ad=63.19999f pd=0.74u as=63.19999f ps=0.74u w=0.26u l=0.38u
X10086 cml_tlatch_40.xmux.xp.S1 MOT12_P MOT12_N VSS sg13_lv_nmos ad=56.9f pd=0.74u as=56.9f ps=0.74u w=0.17u l=0.17u
X10087 cml_tlatch_3.xmux.xn.S1 cml_tlatch_8.OUTN cml_tlatch_3.OUTP VSS sg13_lv_nmos ad=63.19999f pd=0.74u as=63.19999f ps=0.74u w=0.26u l=0.38u
X10088 cml_tlatch_26.xmux.xp.S1 MOT6_N MOT6_P VSS sg13_lv_nmos ad=56.9f pd=0.74u as=56.9f ps=0.74u w=0.17u l=0.17u
X10089 cml_tlatch_2.xtail.S1 CKA0_N cml_tlatch_2.xmux.xn.S1 VSS sg13_lv_nmos ad=89.3f pd=0.85u as=89.3f ps=0.85u w=0.47u l=0.16u
X10090 GB0_N ENB1_P cml_gate2_1.sg13_lv_nmos_FTPY57_0.D0 VSS sg13_lv_nmos ad=0.1007p pd=0.91u as=0.1007p ps=0.91u w=0.53u l=0.13u
X10091 cml_tlatch_20.xmux.xp.S1 MOT7_P MOT7_N VSS sg13_lv_nmos ad=56.9f pd=0.74u as=56.9f ps=0.74u w=0.17u l=0.17u
X10092 B1_2_P stub_bi_31.BOTP cml_tlatch_33.xmux.xn.S1 VSS sg13_lv_nmos ad=63.19999f pd=0.74u as=63.19999f ps=0.74u w=0.26u l=0.38u
X10093 cml_tlatch_72.xmux.xp.S1 cml_tlatch_83.INN cml_tlatch_83.INP VSS sg13_lv_nmos ad=56.9f pd=0.74u as=56.9f ps=0.74u w=0.17u l=0.17u
X10094 cml_tlatch_1.OUTN cml_tlatch_1.OUTP cml_tlatch_1.xmux.xp.S1 VSS sg13_lv_nmos ad=56.9f pd=0.74u as=56.9f ps=0.74u w=0.17u l=0.17u
X10095 J1_P J1_N cml_tlatch_93.xmux.xp.S1 VSS sg13_lv_nmos ad=56.9f pd=0.74u as=56.9f ps=0.74u w=0.17u l=0.17u
X10096 cml_tlatch_81.xtail.S1 CKA2_N cml_tlatch_81.xmux.xn.S1 VSS sg13_lv_nmos ad=89.3f pd=0.85u as=89.3f ps=0.85u w=0.47u l=0.16u
X10097 stub_bi_55.BOTP stub_bi_55.BOTN cml_tlatch_88.xmux.xp.S1 VSS sg13_lv_nmos ad=56.9f pd=0.74u as=56.9f ps=0.74u w=0.17u l=0.17u
X10098 cml_tlatch_29.xmux.xp.S1 cml_tlatch_29.OUTP cml_tlatch_29.OUTN VSS sg13_lv_nmos ad=56.9f pd=0.74u as=56.9f ps=0.74u w=0.17u l=0.17u
X10099 VDD GB0_N VSS rppd l=7.42u w=1u
X10100 MOT13_N MOT13_P cml_tlatch_6.xmux.xp.S1 VSS sg13_lv_nmos ad=56.9f pd=0.74u as=0.1019p ps=1.34u w=0.17u l=0.17u
X10101 J4_P J4_N cml_tlatch_90.xmux.xp.S1 VSS sg13_lv_nmos ad=56.9f pd=0.74u as=56.9f ps=0.74u w=0.17u l=0.17u
X10102 B2_2_N B2_2_P cml_tlatch_44.xmux.xp.S1 VSS sg13_lv_nmos ad=56.9f pd=0.74u as=56.9f ps=0.74u w=0.17u l=0.17u
X10103 MOT21_P stub_bi_55.BOTP cml_tlatch_75.xmux.xn.S1 VSS sg13_lv_nmos ad=0.1082p pd=1.34u as=63.19999f ps=0.74u w=0.26u l=0.38u
X10104 cml_tlatch_58.xmux.xp.S1 MOT28_P MOT28_N VSS sg13_lv_nmos ad=56.9f pd=0.74u as=56.9f ps=0.74u w=0.17u l=0.17u
X10105 cml_tlatch_25.xmux.xp.S1 MOT4_N MOT4_P VSS sg13_lv_nmos ad=56.9f pd=0.74u as=56.9f ps=0.74u w=0.17u l=0.17u
X10106 cml_tlatch_35.xmux.xn.S1 CKA0_P cml_tlatch_35.xtail.S1 VSS sg13_lv_nmos ad=89.3f pd=0.85u as=89.3f ps=0.85u w=0.47u l=0.16u
X10107 cml_tlatch_22.xtail.S1 CKA1_N cml_tlatch_22.xmux.xp.S1 VSS sg13_lv_nmos ad=89.3f pd=0.85u as=89.3f ps=0.85u w=0.47u l=0.16u
X10108 cml_tlatch_67.xmux.xn.S1 CKA3_P cml_tlatch_67.xtail.S1 VSS sg13_lv_nmos ad=0.1598p pd=1.62u as=89.3f ps=0.85u w=0.47u l=0.16u
X10109 cml_tlatch_77.xtail.S1 CKB2_N cml_tlatch_77.xmux.xn.S1 VSS sg13_lv_nmos ad=89.3f pd=0.85u as=89.3f ps=0.85u w=0.47u l=0.16u
X10110 cml_tlatch_25.xtail.S1 CKHA0_P cml_tlatch_25.xmux.xn.S1 VSS sg13_lv_nmos ad=89.3f pd=0.85u as=89.3f ps=0.85u w=0.47u l=0.16u
X10111 cml_gate2_1.sg13_lv_nmos_FTPY57_0.D0 ENB1_N GB0_P VSS sg13_lv_nmos ad=0.1007p pd=0.91u as=0.1007p ps=0.91u w=0.53u l=0.13u
X10112 VSS POLN cml_tlatch_21.xtail.S1 VSS sg13_lv_nmos ad=2.7982p pd=17.14u as=1.5637p ps=8.61u w=8.23u l=0.13u
X10113 cml_tlatch_64.xtail.S1 CKA3_N cml_tlatch_64.xmux.xn.S1 VSS sg13_lv_nmos ad=89.3f pd=0.85u as=89.3f ps=0.85u w=0.47u l=0.16u
X10114 cml_tlatch_95.xtail.S1 CKA1_N cml_tlatch_95.xmux.xn.S1 VSS sg13_lv_nmos ad=89.3f pd=0.85u as=89.3f ps=0.85u w=0.47u l=0.16u
X10115 VDD cml_tlatch_30.OUTP VSS rppd l=5.17u w=1u
X10116 MOT13_P MOT13_N cml_tlatch_6.xmux.xp.S1 VSS sg13_lv_nmos ad=56.9f pd=0.74u as=56.9f ps=0.74u w=0.17u l=0.17u
X10117 B2_8_N B2_8_P cml_tlatch_77.xmux.xp.S1 VSS sg13_lv_nmos ad=56.9f pd=0.74u as=56.9f ps=0.74u w=0.17u l=0.17u
X10118 cml_tlatch_11.OUTN cml_tlatch_11.OUTP cml_tlatch_11.xmux.xp.S1 VSS sg13_lv_nmos ad=56.9f pd=0.74u as=56.9f ps=0.74u w=0.17u l=0.17u
X10119 cml_tlatch_38.OUTP cml_tlatch_38.OUTN cml_tlatch_38.xmux.xp.S1 VSS sg13_lv_nmos ad=56.9f pd=0.74u as=56.9f ps=0.74u w=0.17u l=0.17u
X10120 MOT23_P MOT23_N cml_tlatch_76.xmux.xp.S1 VSS sg13_lv_nmos ad=56.9f pd=0.74u as=56.9f ps=0.74u w=0.17u l=0.17u
X10121 cml_tlatch_73.xmux.xn.S1 B2_8_P MOT17_N VSS sg13_lv_nmos ad=63.19999f pd=0.74u as=63.19999f ps=0.74u w=0.26u l=0.38u
X10122 cml_tlatch_23.xtail.S1 CKA1_N cml_tlatch_23.xmux.xn.S1 VSS sg13_lv_nmos ad=89.3f pd=0.85u as=89.3f ps=0.85u w=0.47u l=0.16u
X10123 cml_tlatch_34.xmux.xp.S1 stub_bi_31.BOTP stub_bi_31.BOTN VSS sg13_lv_nmos ad=56.9f pd=0.74u as=56.9f ps=0.74u w=0.17u l=0.17u
X10124 cml_tlatch_12.xmux.xp.S1 B1_8_N B1_8_P VSS sg13_lv_nmos ad=56.9f pd=0.74u as=56.9f ps=0.74u w=0.17u l=0.17u
X10125 cml_tlatch_13.xtail.S1 CKB1_N cml_tlatch_13.xmux.xp.S1 VSS sg13_lv_nmos ad=89.3f pd=0.85u as=89.3f ps=0.85u w=0.47u l=0.16u
X10126 cml_tlatch_48.xmux.xp.S1 stub_bi_32.BOTN stub_bi_32.BOTP VSS sg13_lv_nmos ad=56.9f pd=0.74u as=56.9f ps=0.74u w=0.17u l=0.17u
X10127 cml_tlatch_11.xmux.xn.S1 cml_tlatch_16.OUTP cml_tlatch_11.OUTN VSS sg13_lv_nmos ad=63.19999f pd=0.74u as=63.19999f ps=0.74u w=0.26u l=0.38u
X10128 cml_tlatch_8.xmux.xp.S1 cml_tlatch_8.OUTN cml_tlatch_8.OUTP VSS sg13_lv_nmos ad=56.9f pd=0.74u as=56.9f ps=0.74u w=0.17u l=0.17u
X10129 cml_tlatch_22.OUTP cml_tlatch_39.INN cml_tlatch_22.xmux.xn.S1 VSS sg13_lv_nmos ad=63.19999f pd=0.74u as=63.19999f ps=0.74u w=0.26u l=0.38u
X10130 VSS POLN cml_tlatch_88.xtail.S1 VSS sg13_lv_nmos ad=1.5637p pd=8.61u as=1.5637p ps=8.61u w=8.23u l=0.13u
X10131 cml_tlatch_31.xmux.xp.S1 A0_2_N A0_2_P VSS sg13_lv_nmos ad=0.1019p pd=1.34u as=56.9f ps=0.74u w=0.17u l=0.17u
X10132 cml_tlatch_86.xmux.xn.S1 CKHA3_P cml_tlatch_86.xtail.S1 VSS sg13_lv_nmos ad=89.3f pd=0.85u as=89.3f ps=0.85u w=0.47u l=0.16u
X10133 cml_tlatch_75.xtail.S1 CKHB2_N cml_tlatch_75.xmux.xp.S1 VSS sg13_lv_nmos ad=89.3f pd=0.85u as=89.3f ps=0.85u w=0.47u l=0.16u
X10134 MOT2_N MOT2_P cml_tlatch_24.xmux.xp.S1 VSS sg13_lv_nmos ad=56.9f pd=0.74u as=56.9f ps=0.74u w=0.17u l=0.17u
X10135 stub_bi_42.BOTN stub_bi_42.BOTP cml_tlatch_43.xmux.xp.S1 VSS sg13_lv_nmos ad=56.9f pd=0.74u as=56.9f ps=0.74u w=0.17u l=0.17u
X10136 MOT9_N MOT9_P cml_tlatch_4.xmux.xp.S1 VSS sg13_lv_nmos ad=56.9f pd=0.74u as=56.9f ps=0.74u w=0.17u l=0.17u
X10137 cml_tlatch_52.xtail.S1 CKA3_N cml_tlatch_52.xmux.xp.S1 VSS sg13_lv_nmos ad=89.3f pd=0.85u as=89.3f ps=0.85u w=0.47u l=0.16u
X10138 cml_tlatch_59.xmux.xn.S1 CKHA3_P cml_tlatch_59.xtail.S1 VSS sg13_lv_nmos ad=89.3f pd=0.85u as=89.3f ps=0.85u w=0.47u l=0.16u
X10139 cml_tlatch_14.xtail.S1 CKB1_N cml_tlatch_14.xmux.xn.S1 VSS sg13_lv_nmos ad=89.3f pd=0.85u as=89.3f ps=0.85u w=0.47u l=0.16u
X10140 cml_tlatch_17.xtail.S1 CKHB0_N cml_tlatch_17.xmux.xp.S1 VSS sg13_lv_nmos ad=89.3f pd=0.85u as=89.3f ps=0.85u w=0.47u l=0.16u
X10141 cml_tlatch_82.xmux.xp.S1 cml_tlatch_82.OUTP cml_tlatch_82.OUTN VSS sg13_lv_nmos ad=56.9f pd=0.74u as=56.9f ps=0.74u w=0.17u l=0.17u
X10142 cml_tlatch_52.xmux.xp.S1 cml_tlatch_52.OUTP cml_tlatch_52.OUTN VSS sg13_lv_nmos ad=56.9f pd=0.74u as=56.9f ps=0.74u w=0.17u l=0.17u
X10143 MOT29_P MOT29_N cml_tlatch_70.xmux.xp.S1 VSS sg13_lv_nmos ad=56.9f pd=0.74u as=56.9f ps=0.74u w=0.17u l=0.17u
X10144 cml_tlatch_83.xtail.S1 CKA2_N cml_tlatch_83.xmux.xn.S1 VSS sg13_lv_nmos ad=89.3f pd=0.85u as=89.3f ps=0.85u w=0.47u l=0.16u
X10145 cml_tlatch_20.xmux.xp.S1 MOT7_N MOT7_P VSS sg13_lv_nmos ad=56.9f pd=0.74u as=56.9f ps=0.74u w=0.17u l=0.17u
X10146 cml_tlatch_5.xmux.xn.S1 CKHB1_P cml_tlatch_5.xtail.S1 VSS sg13_lv_nmos ad=89.3f pd=0.85u as=89.3f ps=0.85u w=0.47u l=0.16u
X10147 cml_tlatch_13.xmux.xp.S1 stub_bi_17.BOTP stub_bi_17.BOTN VSS sg13_lv_nmos ad=56.9f pd=0.74u as=56.9f ps=0.74u w=0.17u l=0.17u
X10148 stub_bi_19.BOTN cml_tlatch_6.INN cml_tlatch_15.xmux.xn.S1 VSS sg13_lv_nmos ad=63.19999f pd=0.74u as=63.19999f ps=0.74u w=0.26u l=0.38u
X10149 A2_2_N cml_tlatch_56.INP cml_tlatch_56.xmux.xn.S1 VSS sg13_lv_nmos ad=63.19999f pd=0.74u as=0.1082p ps=1.34u w=0.26u l=0.38u
X10150 cml_tlatch_56.xtail.S1 CKA2_N cml_tlatch_56.xmux.xn.S1 VSS sg13_lv_nmos ad=89.3f pd=0.85u as=89.3f ps=0.85u w=0.47u l=0.16u
X10151 cml_tlatch_87.xmux.xp.S1 MOT16_P MOT16_N VSS sg13_lv_nmos ad=56.9f pd=0.74u as=56.9f ps=0.74u w=0.17u l=0.17u
X10152 VSS hs_to_clk_4.sg13_lv_nmos_2HGZLP_0.G VSS VSS sg13_lv_nmos ad=3.706p pd=22.48u as=0 ps=0 w=10.9u l=1.38u
X10153 MOT30_P MOT30_N cml_tlatch_59.xmux.xp.S1 VSS sg13_lv_nmos ad=56.9f pd=0.74u as=56.9f ps=0.74u w=0.17u l=0.17u
X10154 cml_tlatch_7.xmux.xn.S1 B1_2_N MOT15_P VSS sg13_lv_nmos ad=63.19999f pd=0.74u as=63.19999f ps=0.74u w=0.26u l=0.38u
X10155 cml_tlatch_32.xmux.xp.S1 stub_bi_29.BOTN stub_bi_29.BOTP VSS sg13_lv_nmos ad=56.9f pd=0.74u as=56.9f ps=0.74u w=0.17u l=0.17u
X10156 cml_tlatch_26.xtail.S1 POLN VSS VSS sg13_lv_nmos ad=1.5637p pd=8.61u as=2.7982p ps=17.14u w=8.23u l=0.13u
X10157 cml_tlatch_6.xmux.xn.S1 cml_tlatch_6.INP MOT13_N VSS sg13_lv_nmos ad=63.19999f pd=0.74u as=63.19999f ps=0.74u w=0.26u l=0.38u
X10158 ENA_P J1_N cml_gate2_9.sg13_lv_nmos_FTPY57_0.D0 VSS sg13_lv_nmos ad=0.1007p pd=0.91u as=0.1007p ps=0.91u w=0.53u l=0.13u
X10159 cml_gate2_6.xrtail.R1 CKA3_N GB3_P VSS sg13_lv_nmos ad=0.1007p pd=0.91u as=0.1007p ps=0.91u w=0.53u l=0.13u
X10160 MOT20_P MOT20_N cml_tlatch_50.xmux.xp.S1 VSS sg13_lv_nmos ad=56.9f pd=0.74u as=56.9f ps=0.74u w=0.17u l=0.17u
X10161 cml_tlatch_58.xmux.xp.S1 MOT28_N MOT28_P VSS sg13_lv_nmos ad=56.9f pd=0.74u as=56.9f ps=0.74u w=0.17u l=0.17u
X10162 cml_tlatch_40.xmux.xp.S1 MOT12_P MOT12_N VSS sg13_lv_nmos ad=0.1019p pd=1.34u as=56.9f ps=0.74u w=0.17u l=0.17u
X10163 cml_gate2_4.xrtail.R1 CKB2_N GA2_P VSS sg13_lv_nmos ad=0.1007p pd=0.91u as=0.1007p ps=0.91u w=0.53u l=0.13u
X10164 cml_tlatch_16.xmux.xp.S1 cml_tlatch_16.OUTP cml_tlatch_16.OUTN VSS sg13_lv_nmos ad=56.9f pd=0.74u as=56.9f ps=0.74u w=0.17u l=0.17u
X10165 cml_tlatch_99.OUTN cml_tlatch_99.OUTP cml_tlatch_99.xmux.xp.S1 VSS sg13_lv_nmos ad=56.9f pd=0.74u as=56.9f ps=0.74u w=0.17u l=0.17u
X10166 cml_tlatch_44.xtail.S1 CKB2_N cml_tlatch_44.xmux.xn.S1 VSS sg13_lv_nmos ad=89.3f pd=0.85u as=89.3f ps=0.85u w=0.47u l=0.16u
X10167 cml_tlatch_30.OUTP cml_tlatch_30.OUTN cml_tlatch_30.xmux.xp.S1 VSS sg13_lv_nmos ad=56.9f pd=0.74u as=56.9f ps=0.74u w=0.17u l=0.17u
X10168 cml_tlatch_95.xtail.S1 CKA1_N cml_tlatch_95.xmux.xn.S1 VSS sg13_lv_nmos ad=89.3f pd=0.85u as=89.3f ps=0.85u w=0.47u l=0.16u
X10169 cml_tlatch_82.xmux.xp.S1 CKA2_N cml_tlatch_82.xtail.S1 VSS sg13_lv_nmos ad=89.3f pd=0.85u as=89.3f ps=0.85u w=0.47u l=0.16u
X10170 cml_tlatch_52.xmux.xn.S1 A3_2_P cml_tlatch_52.OUTN VSS sg13_lv_nmos ad=63.19999f pd=0.74u as=63.19999f ps=0.74u w=0.26u l=0.38u
X10171 MOT29_N cml_tlatch_70.INP cml_tlatch_70.xmux.xn.S1 VSS sg13_lv_nmos ad=63.19999f pd=0.74u as=63.19999f ps=0.74u w=0.26u l=0.38u
X10172 stub_bi_29.BOTN VDD VSS rppd l=5.17u w=1u
X10173 cml_tlatch_53.xtail.S1 CKA3_N cml_tlatch_53.xmux.xn.S1 VSS sg13_lv_nmos ad=89.3f pd=0.85u as=89.3f ps=0.85u w=0.47u l=0.16u
X10174 cml_gate2_6.sg13_lv_nmos_FTPY57_0.D0 ENB0_N GB3_P VSS sg13_lv_nmos ad=0.1007p pd=0.91u as=0.1007p ps=0.91u w=0.53u l=0.13u
X10175 cml_tlatch_72.xmux.xp.S1 cml_tlatch_83.INN cml_tlatch_83.INP VSS sg13_lv_nmos ad=56.9f pd=0.74u as=56.9f ps=0.74u w=0.17u l=0.17u
X10176 cml_tlatch_98.xmux.xn.S1 cml_tlatch_27.OUTN cml_tlatch_98.OUTP VSS sg13_lv_nmos ad=63.19999f pd=0.74u as=0.1082p ps=1.34u w=0.26u l=0.38u
X10177 stub_bi_49.BOTN stub_bi_49.BOTP cml_tlatch_80.xmux.xp.S1 VSS sg13_lv_nmos ad=56.9f pd=0.74u as=56.9f ps=0.74u w=0.17u l=0.17u
X10178 cml_gate2_3.sg13_lv_nmos_FTPY57_0.D0 CKB1_P cml_gate2_3.xrtail.R1 VSS sg13_lv_nmos ad=0.1007p pd=0.91u as=0.1007p ps=0.91u w=0.53u l=0.13u
X10179 B3_8_P B3_8_N cml_tlatch_60.xmux.xp.S1 VSS sg13_lv_nmos ad=56.9f pd=0.74u as=56.9f ps=0.74u w=0.17u l=0.17u
X10180 GA2_N ENA1_P cml_gate2_4.sg13_lv_nmos_FTPY57_0.D0 VSS sg13_lv_nmos ad=0.1007p pd=0.91u as=0.1007p ps=0.91u w=0.53u l=0.13u
X10181 stub_bi_55.BOTP stub_bi_55.BOTN cml_tlatch_88.xmux.xp.S1 VSS sg13_lv_nmos ad=56.9f pd=0.74u as=56.9f ps=0.74u w=0.17u l=0.17u
X10182 cml_tlatch_11.xtail.S1 CKB0_P cml_tlatch_11.xmux.xn.S1 VSS sg13_lv_nmos ad=0.1598p pd=1.62u as=89.3f ps=0.85u w=0.47u l=0.16u
X10183 cml_tlatch_95.xmux.xp.S1 cml_tlatch_40.INP cml_tlatch_40.INN VSS sg13_lv_nmos ad=56.9f pd=0.74u as=56.9f ps=0.74u w=0.17u l=0.17u
X10184 cml_tlatch_54.OUTP D3_N cml_tlatch_54.xmux.xn.S1 VSS sg13_lv_nmos ad=63.19999f pd=0.74u as=63.19999f ps=0.74u w=0.26u l=0.38u
X10185 cml_tlatch_76.xmux.xp.S1 CKHB2_N cml_tlatch_76.xtail.S1 VSS sg13_lv_nmos ad=0.1598p pd=1.62u as=89.3f ps=0.85u w=0.47u l=0.16u
X10186 cml_tlatch_29.xmux.xp.S1 cml_tlatch_29.OUTP cml_tlatch_29.OUTN VSS sg13_lv_nmos ad=56.9f pd=0.74u as=56.9f ps=0.74u w=0.17u l=0.17u
X10187 cml_tlatch_26.xmux.xp.S1 CKHA0_N cml_tlatch_26.xtail.S1 VSS sg13_lv_nmos ad=89.3f pd=0.85u as=0.1598p ps=1.62u w=0.47u l=0.16u
X10188 cml_tlatch_50.xmux.xp.S1 CKHA2_N cml_tlatch_50.xtail.S1 VSS sg13_lv_nmos ad=89.3f pd=0.85u as=89.3f ps=0.85u w=0.47u l=0.16u
X10189 MOT17_P MOT17_N cml_tlatch_73.xmux.xp.S1 VSS sg13_lv_nmos ad=56.9f pd=0.74u as=56.9f ps=0.74u w=0.17u l=0.17u
X10190 cml_tlatch_18.xmux.xp.S1 MOT3_P MOT3_N VSS sg13_lv_nmos ad=56.9f pd=0.74u as=56.9f ps=0.74u w=0.17u l=0.17u
X10191 cml_tlatch_39.xtail.S1 CKHA1_P cml_tlatch_39.xmux.xn.S1 VSS sg13_lv_nmos ad=89.3f pd=0.85u as=89.3f ps=0.85u w=0.47u l=0.16u
X10192 cml_tlatch_74.xmux.xn.S1 CKHB2_P cml_tlatch_74.xtail.S1 VSS sg13_lv_nmos ad=89.3f pd=0.85u as=89.3f ps=0.85u w=0.47u l=0.16u
X10193 cml_tlatch_68.xmux.xp.S1 MOT25_P MOT25_N VSS sg13_lv_nmos ad=56.9f pd=0.74u as=56.9f ps=0.74u w=0.17u l=0.17u
X10194 cml_tlatch_89.xmux.xp.S1 cml_tlatch_89.OUTN cml_tlatch_89.OUTP VSS sg13_lv_nmos ad=56.9f pd=0.74u as=56.9f ps=0.74u w=0.17u l=0.17u
X10195 cml_tlatch_78.xmux.xp.S1 stub_bi_62.BOTN stub_bi_62.BOTP VSS sg13_lv_nmos ad=56.9f pd=0.74u as=56.9f ps=0.74u w=0.17u l=0.17u
X10196 cml_tlatch_5.xtail.S1 CKHB1_N cml_tlatch_5.xmux.xp.S1 VSS sg13_lv_nmos ad=0.1598p pd=1.62u as=89.3f ps=0.85u w=0.47u l=0.16u
X10197 cml_tlatch_65.xmux.xn.S1 cml_tlatch_57.INP cml_tlatch_65.OUTN VSS sg13_lv_nmos ad=63.19999f pd=0.74u as=63.19999f ps=0.74u w=0.26u l=0.38u
X10198 stub_bi_29.BOTN B1_2_N cml_tlatch_32.xmux.xn.S1 VSS sg13_lv_nmos ad=63.19999f pd=0.74u as=63.19999f ps=0.74u w=0.26u l=0.38u
X10199 VSS POLN cml_tlatch_91.xtail.S1 VSS sg13_lv_nmos ad=1.5637p pd=8.61u as=1.5637p ps=8.61u w=8.23u l=0.13u
X10200 MOT16_P MOT16_N cml_tlatch_87.xmux.xp.S1 VSS sg13_lv_nmos ad=56.9f pd=0.74u as=56.9f ps=0.74u w=0.17u l=0.17u
X10201 MOT13_P MOT13_N cml_tlatch_6.xmux.xp.S1 VSS sg13_lv_nmos ad=56.9f pd=0.74u as=56.9f ps=0.74u w=0.17u l=0.17u
X10202 cml_tlatch_46.xmux.xp.S1 B3_2_P B3_2_N VSS sg13_lv_nmos ad=56.9f pd=0.74u as=56.9f ps=0.74u w=0.17u l=0.17u
X10203 MOT27_P cml_tlatch_69.INN cml_tlatch_69.xmux.xn.S1 VSS sg13_lv_nmos ad=63.19999f pd=0.74u as=63.19999f ps=0.74u w=0.26u l=0.38u
X10204 MOT23_P MOT23_N cml_tlatch_76.xmux.xp.S1 VSS sg13_lv_nmos ad=56.9f pd=0.74u as=56.9f ps=0.74u w=0.17u l=0.17u
X10205 cml_tlatch_71.xmux.xp.S1 MOT31_N MOT31_P VSS sg13_lv_nmos ad=56.9f pd=0.74u as=56.9f ps=0.74u w=0.17u l=0.17u
X10206 cml_tlatch_34.xmux.xp.S1 stub_bi_31.BOTP stub_bi_31.BOTN VSS sg13_lv_nmos ad=56.9f pd=0.74u as=56.9f ps=0.74u w=0.17u l=0.17u
X10207 cml_tlatch_37.xmux.xp.S1 A1_2_N A1_2_P VSS sg13_lv_nmos ad=56.9f pd=0.74u as=56.9f ps=0.74u w=0.17u l=0.17u
X10208 cml_tlatch_94.xtail.S1 POLN VSS VSS sg13_lv_nmos ad=1.5637p pd=8.61u as=1.5637p ps=8.61u w=8.23u l=0.13u
X10209 cml_tlatch_16.xtail.S1 CKB0_N cml_tlatch_16.xmux.xn.S1 VSS sg13_lv_nmos ad=89.3f pd=0.85u as=89.3f ps=0.85u w=0.47u l=0.16u
X10210 cml_tlatch_98.OUTP cml_tlatch_98.OUTN cml_tlatch_98.xmux.xp.S1 VSS sg13_lv_nmos ad=56.9f pd=0.74u as=56.9f ps=0.74u w=0.17u l=0.17u
X10211 cml_tlatch_69.xmux.xn.S1 CKHB3_P cml_tlatch_69.xtail.S1 VSS sg13_lv_nmos ad=89.3f pd=0.85u as=89.3f ps=0.85u w=0.47u l=0.16u
X10212 cml_tlatch_63.xmux.xp.S1 CKB3_N cml_tlatch_63.xtail.S1 VSS sg13_lv_nmos ad=89.3f pd=0.85u as=89.3f ps=0.85u w=0.47u l=0.16u
X10213 cml_tlatch_87.xmux.xn.S1 A2_8_P MOT16_N VSS sg13_lv_nmos ad=63.19999f pd=0.74u as=63.19999f ps=0.74u w=0.26u l=0.38u
X10214 cml_tlatch_55.xtail.S1 POLN VSS VSS sg13_lv_nmos ad=1.5637p pd=8.61u as=1.5637p ps=8.61u w=8.23u l=0.13u
X10215 cml_tlatch_51.xmux.xp.S1 CKHA2_N cml_tlatch_51.xtail.S1 VSS sg13_lv_nmos ad=89.3f pd=0.85u as=89.3f ps=0.85u w=0.47u l=0.16u
X10216 cml_tlatch_82.OUTP cml_tlatch_82.OUTN cml_tlatch_82.xmux.xp.S1 VSS sg13_lv_nmos ad=56.9f pd=0.74u as=56.9f ps=0.74u w=0.17u l=0.17u
X10217 MOT1_N B0_8_P cml_tlatch_17.xmux.xn.S1 VSS sg13_lv_nmos ad=0.1082p pd=1.34u as=63.19999f ps=0.74u w=0.26u l=0.38u
X10218 cml_tlatch_38.OUTN cml_tlatch_38.OUTP cml_tlatch_38.xmux.xp.S1 VSS sg13_lv_nmos ad=56.9f pd=0.74u as=0.1019p ps=1.34u w=0.17u l=0.17u
X10219 cml_tlatch_94.xtail.S1 CKB1_P cml_tlatch_94.xmux.xp.S1 VSS sg13_lv_nmos ad=89.3f pd=0.85u as=89.3f ps=0.85u w=0.47u l=0.16u
X10220 cml_tlatch_8.xmux.xp.S1 cml_tlatch_8.OUTN cml_tlatch_8.OUTP VSS sg13_lv_nmos ad=56.9f pd=0.74u as=56.9f ps=0.74u w=0.17u l=0.17u
X10221 cml_tlatch_17.xmux.xp.S1 MOT1_N MOT1_P VSS sg13_lv_nmos ad=56.9f pd=0.74u as=56.9f ps=0.74u w=0.17u l=0.17u
X10222 CKA1_P CK_P hs_to_clk_3.D2 VSS sg13_lv_nmos ad=0.408p pd=3.08u as=0.228p ps=1.58u w=1.2u l=0.2u
X10223 cml_tlatch_32.xmux.xn.S1 B1_2_P stub_bi_29.BOTP VSS sg13_lv_nmos ad=63.19999f pd=0.74u as=0.1082p ps=1.34u w=0.26u l=0.38u
X10224 cml_tlatch_51.xmux.xp.S1 MOT22_P MOT22_N VSS sg13_lv_nmos ad=56.9f pd=0.74u as=56.9f ps=0.74u w=0.17u l=0.17u
X10225 cml_tlatch_83.xmux.xp.S1 cml_tlatch_83.OUTP cml_tlatch_83.OUTN VSS sg13_lv_nmos ad=56.9f pd=0.74u as=56.9f ps=0.74u w=0.17u l=0.17u
X10226 cml_tlatch_45.OUTN cml_tlatch_45.OUTP cml_tlatch_45.xmux.xp.S1 VSS sg13_lv_nmos ad=56.9f pd=0.74u as=56.9f ps=0.74u w=0.17u l=0.17u
X10227 stub_bi_63.BOTN stub_bi_63.BOTP cml_tlatch_79.xmux.xp.S1 VSS sg13_lv_nmos ad=56.9f pd=0.74u as=56.9f ps=0.74u w=0.17u l=0.17u
X10228 cml_tlatch_77.xmux.xp.S1 B2_8_N B2_8_P VSS sg13_lv_nmos ad=56.9f pd=0.74u as=56.9f ps=0.74u w=0.17u l=0.17u
X10229 cml_tlatch_1.xmux.xp.S1 CKB0_N cml_tlatch_1.xtail.S1 VSS sg13_lv_nmos ad=89.3f pd=0.85u as=89.3f ps=0.85u w=0.47u l=0.16u
X10230 B3_2_N B3_2_P cml_tlatch_46.xmux.xp.S1 VSS sg13_lv_nmos ad=56.9f pd=0.74u as=56.9f ps=0.74u w=0.17u l=0.17u
X10231 cml_tlatch_49.xtail.S1 CKHA2_P cml_tlatch_49.xmux.xn.S1 VSS sg13_lv_nmos ad=89.3f pd=0.85u as=89.3f ps=0.85u w=0.47u l=0.16u
X10232 cml_gate2_9.sg13_lv_nmos_FTPY57_0.D0 J1_N ENA_P VSS sg13_lv_nmos ad=0.1007p pd=0.91u as=0.1007p ps=0.91u w=0.53u l=0.13u
X10233 cml_tlatch_47.xtail.S1 POLN VSS VSS sg13_lv_nmos ad=1.5637p pd=8.61u as=2.7982p ps=17.14u w=8.23u l=0.13u
X10234 cml_tlatch_58.xmux.xn.S1 cml_tlatch_58.INN MOT28_P VSS sg13_lv_nmos ad=0.1082p pd=1.34u as=63.19999f ps=0.74u w=0.26u l=0.38u
X10235 cml_tlatch_87.xmux.xp.S1 MOT16_P MOT16_N VSS sg13_lv_nmos ad=0.1019p pd=1.34u as=56.9f ps=0.74u w=0.17u l=0.17u
X10236 MOT24_N MOT24_P cml_tlatch_86.xmux.xp.S1 VSS sg13_lv_nmos ad=56.9f pd=0.74u as=56.9f ps=0.74u w=0.17u l=0.17u
X10237 cml_tlatch_32.xmux.xp.S1 stub_bi_29.BOTN stub_bi_29.BOTP VSS sg13_lv_nmos ad=56.9f pd=0.74u as=56.9f ps=0.74u w=0.17u l=0.17u
X10238 cml_tlatch_76.xmux.xp.S1 MOT23_P MOT23_N VSS sg13_lv_nmos ad=56.9f pd=0.74u as=56.9f ps=0.74u w=0.17u l=0.17u
X10239 MOT31_N MOT31_P cml_tlatch_71.xmux.xp.S1 VSS sg13_lv_nmos ad=56.9f pd=0.74u as=56.9f ps=0.74u w=0.17u l=0.17u
X10240 cml_tlatch_39.INN interco_bi_19.INP cml_tlatch_23.xmux.xn.S1 VSS sg13_lv_nmos ad=63.19999f pd=0.74u as=63.19999f ps=0.74u w=0.26u l=0.38u
X10241 cml_tlatch_35.xmux.xp.S1 cml_tlatch_35.OUTN cml_tlatch_35.OUTP VSS sg13_lv_nmos ad=56.9f pd=0.74u as=56.9f ps=0.74u w=0.17u l=0.17u
X10242 cml_tlatch_41.xmux.xp.S1 MOT14_N MOT14_P VSS sg13_lv_nmos ad=56.9f pd=0.74u as=56.9f ps=0.74u w=0.17u l=0.17u
X10243 cml_tlatch_96.xmux.xp.S1 MOT8_P MOT8_N VSS sg13_lv_nmos ad=56.9f pd=0.74u as=56.9f ps=0.74u w=0.17u l=0.17u
X10244 cml_tlatch_68.xmux.xn.S1 B3_8_N MOT25_P VSS sg13_lv_nmos ad=63.19999f pd=0.74u as=63.19999f ps=0.74u w=0.26u l=0.38u
X10245 cml_tlatch_99.OUTN cml_tlatch_99.OUTP cml_tlatch_99.xmux.xp.S1 VSS sg13_lv_nmos ad=56.9f pd=0.74u as=56.9f ps=0.74u w=0.17u l=0.17u
X10246 cml_tlatch_19.xmux.xp.S1 MOT5_P MOT5_N VSS sg13_lv_nmos ad=56.9f pd=0.74u as=56.9f ps=0.74u w=0.17u l=0.17u
X10247 cml_tlatch_22.xtail.S1 CKA1_P cml_tlatch_22.xmux.xn.S1 VSS sg13_lv_nmos ad=89.3f pd=0.85u as=89.3f ps=0.85u w=0.47u l=0.16u
X10248 cml_tlatch_63.OUTN VDD VSS rppd l=5.17u w=1u
X10249 MOT6_N MOT6_P cml_tlatch_26.xmux.xp.S1 VSS sg13_lv_nmos ad=56.9f pd=0.74u as=56.9f ps=0.74u w=0.17u l=0.17u
X10250 J1_P J4_P cml_tlatch_93.xmux.xn.S1 VSS sg13_lv_nmos ad=0.1082p pd=1.34u as=63.19999f ps=0.74u w=0.26u l=0.38u
X10251 hs_to_clk_8.D2 POLN VSS VSS sg13_lv_nmos ad=1.9p pd=10.38u as=1.9p ps=10.38u w=10u l=0.13u
X10252 cml_tlatch_68.xmux.xn.S1 B3_8_N MOT25_P VSS sg13_lv_nmos ad=63.19999f pd=0.74u as=63.19999f ps=0.74u w=0.26u l=0.38u
X10253 MOT28_N cml_tlatch_58.INP cml_tlatch_58.xmux.xn.S1 VSS sg13_lv_nmos ad=63.19999f pd=0.74u as=63.19999f ps=0.74u w=0.26u l=0.38u
X10254 A0_8_P A0_8_N cml_tlatch_2.xmux.xp.S1 VSS sg13_lv_nmos ad=56.9f pd=0.74u as=56.9f ps=0.74u w=0.17u l=0.17u
X10255 MOT10_N MOT10_P cml_tlatch_39.xmux.xp.S1 VSS sg13_lv_nmos ad=56.9f pd=0.74u as=56.9f ps=0.74u w=0.17u l=0.17u
X10256 cml_tlatch_5.INN VDD VSS rppd l=5.17u w=1u
X10257 cml_tlatch_33.xmux.xp.S1 B1_2_P B1_2_N VSS sg13_lv_nmos ad=56.9f pd=0.74u as=56.9f ps=0.74u w=0.17u l=0.17u
X10258 cml_tlatch_50.xmux.xn.S1 CKHA2_P cml_tlatch_50.xtail.S1 VSS sg13_lv_nmos ad=0.1598p pd=1.62u as=89.3f ps=0.85u w=0.47u l=0.16u
X10259 cml_tlatch_96.xmux.xp.S1 MOT8_N MOT8_P VSS sg13_lv_nmos ad=56.9f pd=0.74u as=56.9f ps=0.74u w=0.17u l=0.17u
X10260 cml_tlatch_85.xmux.xn.S1 CKA3_N cml_tlatch_85.xtail.S1 VSS sg13_lv_nmos ad=0.1598p pd=1.62u as=89.3f ps=0.85u w=0.47u l=0.16u
X10261 cml_tlatch_89.OUTP cml_tlatch_89.INN cml_tlatch_89.xmux.xn.S1 VSS sg13_lv_nmos ad=63.19999f pd=0.74u as=0.1082p ps=1.34u w=0.26u l=0.38u
X10262 cml_tlatch_64.xmux.xp.S1 A3_8_P A3_8_N VSS sg13_lv_nmos ad=56.9f pd=0.74u as=56.9f ps=0.74u w=0.17u l=0.17u
X10263 cml_tlatch_56.INP cml_tlatch_56.INN cml_tlatch_42.xmux.xp.S1 VSS sg13_lv_nmos ad=56.9f pd=0.74u as=56.9f ps=0.74u w=0.17u l=0.17u
X10264 MOT17_P MOT17_N cml_tlatch_73.xmux.xp.S1 VSS sg13_lv_nmos ad=56.9f pd=0.74u as=56.9f ps=0.74u w=0.17u l=0.17u
X10265 cml_tlatch_77.xmux.xp.S1 B2_8_N B2_8_P VSS sg13_lv_nmos ad=56.9f pd=0.74u as=56.9f ps=0.74u w=0.17u l=0.17u
X10266 cml_tlatch_68.xmux.xp.S1 MOT25_N MOT25_P VSS sg13_lv_nmos ad=56.9f pd=0.74u as=56.9f ps=0.74u w=0.17u l=0.17u
X10267 B2_2_P stub_bi_32.BOTP cml_tlatch_44.xmux.xn.S1 VSS sg13_lv_nmos ad=63.19999f pd=0.74u as=63.19999f ps=0.74u w=0.26u l=0.38u
X10268 cml_tlatch_74.xmux.xp.S1 CKHB2_N cml_tlatch_74.xtail.S1 VSS sg13_lv_nmos ad=89.3f pd=0.85u as=89.3f ps=0.85u w=0.47u l=0.16u
X10269 cml_tlatch_1.OUTP cml_tlatch_1.OUTN cml_tlatch_1.xmux.xp.S1 VSS sg13_lv_nmos ad=56.9f pd=0.74u as=56.9f ps=0.74u w=0.17u l=0.17u
X10270 cml_tlatch_21.xmux.xn.S1 cml_tlatch_22.OUTP A1_8_N VSS sg13_lv_nmos ad=63.19999f pd=0.74u as=63.19999f ps=0.74u w=0.26u l=0.38u
X10271 cml_tlatch_67.xmux.xn.S1 CKA3_P cml_tlatch_67.xtail.S1 VSS sg13_lv_nmos ad=89.3f pd=0.85u as=89.3f ps=0.85u w=0.47u l=0.16u
X10272 cml_tlatch_22.OUTN cml_tlatch_22.OUTP cml_tlatch_22.xmux.xp.S1 VSS sg13_lv_nmos ad=56.9f pd=0.74u as=56.9f ps=0.74u w=0.17u l=0.17u
X10273 cml_tlatch_54.OUTN cml_tlatch_54.OUTP cml_tlatch_54.xmux.xp.S1 VSS sg13_lv_nmos ad=56.9f pd=0.74u as=56.9f ps=0.74u w=0.17u l=0.17u
X10274 cml_tlatch_3.xmux.xp.S1 cml_tlatch_3.OUTN cml_tlatch_3.OUTP VSS sg13_lv_nmos ad=56.9f pd=0.74u as=56.9f ps=0.74u w=0.17u l=0.17u
X10275 stub_bi_19.BOTP stub_bi_19.BOTN cml_tlatch_15.xmux.xp.S1 VSS sg13_lv_nmos ad=56.9f pd=0.74u as=56.9f ps=0.74u w=0.17u l=0.17u
X10276 VSS POLN cml_tlatch_46.xtail.S1 VSS sg13_lv_nmos ad=2.7982p pd=17.14u as=1.5637p ps=8.61u w=8.23u l=0.13u
X10277 cml_gate2_0.sg13_lv_nmos_FTPY57_0.D0 ENB1_N GB1_P VSS sg13_lv_nmos ad=0.1007p pd=0.91u as=0.1007p ps=0.91u w=0.53u l=0.13u
X10278 cml_tlatch_39.INN cml_tlatch_39.INP cml_tlatch_23.xmux.xp.S1 VSS sg13_lv_nmos ad=56.9f pd=0.74u as=56.9f ps=0.74u w=0.17u l=0.17u
X10279 cml_tlatch_28.xmux.xp.S1 B0_2_P B0_2_N VSS sg13_lv_nmos ad=56.9f pd=0.74u as=56.9f ps=0.74u w=0.17u l=0.17u
X10280 A2_2_N A2_2_P cml_tlatch_56.xmux.xp.S1 VSS sg13_lv_nmos ad=56.9f pd=0.74u as=0.1019p ps=1.34u w=0.17u l=0.17u
X10281 cml_tlatch_52.xmux.xp.S1 cml_tlatch_52.OUTN cml_tlatch_52.OUTP VSS sg13_lv_nmos ad=56.9f pd=0.74u as=56.9f ps=0.74u w=0.17u l=0.17u
X10282 cml_tlatch_4.xtail.S1 CKHB1_P cml_tlatch_4.xmux.xn.S1 VSS sg13_lv_nmos ad=89.3f pd=0.85u as=89.3f ps=0.85u w=0.47u l=0.16u
X10283 cml_tlatch_98.OUTP cml_tlatch_98.OUTN cml_tlatch_98.xmux.xp.S1 VSS sg13_lv_nmos ad=56.9f pd=0.74u as=56.9f ps=0.74u w=0.17u l=0.17u
X10284 cml_tlatch_73.xmux.xp.S1 CKHB2_N cml_tlatch_73.xtail.S1 VSS sg13_lv_nmos ad=89.3f pd=0.85u as=89.3f ps=0.85u w=0.47u l=0.16u
X10285 cml_tlatch_27.xmux.xn.S1 B0_2_P cml_tlatch_27.OUTN VSS sg13_lv_nmos ad=63.19999f pd=0.74u as=0.1082p ps=1.34u w=0.26u l=0.38u
X10286 cml_tlatch_35.xtail.S1 CKA0_N cml_tlatch_35.xmux.xp.S1 VSS sg13_lv_nmos ad=89.3f pd=0.85u as=89.3f ps=0.85u w=0.47u l=0.16u
X10287 cml_tlatch_96.xmux.xn.S1 A1_8_N MOT8_P VSS sg13_lv_nmos ad=63.19999f pd=0.74u as=63.19999f ps=0.74u w=0.26u l=0.38u
X10288 cml_tlatch_85.xmux.xp.S1 CKA3_P cml_tlatch_85.xtail.S1 VSS sg13_lv_nmos ad=89.3f pd=0.85u as=89.3f ps=0.85u w=0.47u l=0.16u
X10289 cml_tlatch_78.xmux.xp.S1 stub_bi_62.BOTP stub_bi_62.BOTN VSS sg13_lv_nmos ad=0.1019p pd=1.34u as=56.9f ps=0.74u w=0.17u l=0.17u
X10290 cml_gate2_7.xrtail.R1 CKA2_P cml_gate2_7.sg13_lv_nmos_FTPY57_0.D0 VSS sg13_lv_nmos ad=0.1007p pd=0.91u as=0.1007p ps=0.91u w=0.53u l=0.13u
X10291 cml_tlatch_63.OUTN cml_tlatch_63.OUTP cml_tlatch_63.xmux.xp.S1 VSS sg13_lv_nmos ad=56.9f pd=0.74u as=56.9f ps=0.74u w=0.17u l=0.17u
X10292 cml_tlatch_51.xmux.xp.S1 MOT22_P MOT22_N VSS sg13_lv_nmos ad=56.9f pd=0.74u as=56.9f ps=0.74u w=0.17u l=0.17u
X10293 cml_tlatch_49.xmux.xn.S1 cml_tlatch_83.OUTN MOT18_P VSS sg13_lv_nmos ad=63.19999f pd=0.74u as=63.19999f ps=0.74u w=0.26u l=0.38u
X10294 cml_tlatch_78.xmux.xn.S1 stub_bi_63.BOTP stub_bi_62.BOTN VSS sg13_lv_nmos ad=63.19999f pd=0.74u as=0.1082p ps=1.34u w=0.26u l=0.38u
X10295 B1_2_N stub_bi_31.BOTN cml_tlatch_33.xmux.xn.S1 VSS sg13_lv_nmos ad=63.19999f pd=0.74u as=63.19999f ps=0.74u w=0.26u l=0.38u
X10296 cml_tlatch_48.xtail.S1 CKB2_N cml_tlatch_48.xmux.xp.S1 VSS sg13_lv_nmos ad=89.3f pd=0.85u as=89.3f ps=0.85u w=0.47u l=0.16u
X10297 VDD A0_2_P VSS rppd l=5.17u w=1u
X10298 cml_tlatch_14.xtail.S1 CKB1_N cml_tlatch_14.xmux.xn.S1 VSS sg13_lv_nmos ad=89.3f pd=0.85u as=89.3f ps=0.85u w=0.47u l=0.16u
X10299 cml_drvb_9.xrtail.R1 CLK_W_N NM1_P VSS sg13_lv_nmos ad=0.1463p pd=1.15u as=0.2618p ps=2.22u w=0.77u l=0.21u
X10300 cml_tlatch_84.xmux.xp.S1 CKB3_P cml_tlatch_84.xtail.S1 VSS sg13_lv_nmos ad=89.3f pd=0.85u as=89.3f ps=0.85u w=0.47u l=0.16u
X10301 hs_to_clk_1.D2 CK_P CKB0_N VSS sg13_lv_nmos ad=0.228p pd=1.58u as=0.408p ps=3.08u w=1.2u l=0.2u
X10302 stub_bi_31.BOTN D1_N cml_tlatch_34.xmux.xn.S1 VSS sg13_lv_nmos ad=63.19999f pd=0.74u as=63.19999f ps=0.74u w=0.26u l=0.38u
X10303 cml_tlatch_40.INP cml_tlatch_40.INN cml_tlatch_95.xmux.xp.S1 VSS sg13_lv_nmos ad=56.9f pd=0.74u as=56.9f ps=0.74u w=0.17u l=0.17u
X10304 cml_tlatch_5.xmux.xp.S1 CKHB1_N cml_tlatch_5.xtail.S1 VSS sg13_lv_nmos ad=89.3f pd=0.85u as=89.3f ps=0.85u w=0.47u l=0.16u
X10305 cml_tlatch_46.xmux.xn.S1 cml_tlatch_47.OUTP B3_2_N VSS sg13_lv_nmos ad=63.19999f pd=0.74u as=63.19999f ps=0.74u w=0.26u l=0.38u
X10306 cml_tlatch_41.xmux.xp.S1 MOT14_P MOT14_N VSS sg13_lv_nmos ad=56.9f pd=0.74u as=56.9f ps=0.74u w=0.17u l=0.17u
X10307 MOT3_P cml_tlatch_16.OUTN cml_tlatch_18.xmux.xn.S1 VSS sg13_lv_nmos ad=63.19999f pd=0.74u as=63.19999f ps=0.74u w=0.26u l=0.38u
X10308 cml_tlatch_15.xmux.xn.S1 CKB1_P cml_tlatch_15.xtail.S1 VSS sg13_lv_nmos ad=89.3f pd=0.85u as=89.3f ps=0.85u w=0.47u l=0.16u
X10309 J4_P CLK_W_P cml_tlatch_90.xmux.xn.S1 VSS sg13_lv_nmos ad=0.1082p pd=1.34u as=63.19999f ps=0.74u w=0.26u l=0.38u
X10310 cml_tlatch_67.xmux.xp.S1 cml_tlatch_67.OUTN cml_tlatch_67.OUTP VSS sg13_lv_nmos ad=56.9f pd=0.74u as=56.9f ps=0.74u w=0.17u l=0.17u
X10311 cml_tlatch_54.xmux.xn.S1 D3_P cml_tlatch_54.OUTN VSS sg13_lv_nmos ad=63.19999f pd=0.74u as=63.19999f ps=0.74u w=0.26u l=0.38u
X10312 cml_tlatch_57.xmux.xp.S1 CKHA3_N cml_tlatch_57.xtail.S1 VSS sg13_lv_nmos ad=89.3f pd=0.85u as=89.3f ps=0.85u w=0.47u l=0.16u
X10313 cml_tlatch_43.xmux.xn.S1 CKB2_P cml_tlatch_43.xtail.S1 VSS sg13_lv_nmos ad=89.3f pd=0.85u as=89.3f ps=0.85u w=0.47u l=0.16u
X10314 A0_2_P A0_2_N cml_tlatch_31.xmux.xp.S1 VSS sg13_lv_nmos ad=56.9f pd=0.74u as=56.9f ps=0.74u w=0.17u l=0.17u
X10315 hs_to_clk_7.D2 CK_P CKA3_P VSS sg13_lv_nmos ad=0.228p pd=1.58u as=0.228p ps=1.58u w=1.2u l=0.2u
X10316 cml_tlatch_70.xtail.S1 CKHB3_N cml_tlatch_70.xmux.xp.S1 VSS sg13_lv_nmos ad=89.3f pd=0.85u as=89.3f ps=0.85u w=0.47u l=0.16u
X10317 GB2_P CKA2_N cml_gate2_7.xrtail.R1 VSS sg13_lv_nmos ad=0.1007p pd=0.91u as=0.1007p ps=0.91u w=0.53u l=0.13u
X10318 cml_tlatch_52.xmux.xn.S1 CKA3_P cml_tlatch_52.xtail.S1 VSS sg13_lv_nmos ad=89.3f pd=0.85u as=89.3f ps=0.85u w=0.47u l=0.16u
X10319 CKB2_P hs_to_clk_6.sg13_lv_nmos_2HGZLP_0.G VSS rppd l=4.25u w=1u
X10320 A2_2_N A2_2_P cml_tlatch_56.xmux.xp.S1 VSS sg13_lv_nmos ad=56.9f pd=0.74u as=56.9f ps=0.74u w=0.17u l=0.17u
X10321 cml_tlatch_70.INN cml_tlatch_70.INP cml_tlatch_84.xmux.xp.S1 VSS sg13_lv_nmos ad=56.9f pd=0.74u as=56.9f ps=0.74u w=0.17u l=0.17u
X10322 cml_tlatch_27.OUTP cml_tlatch_27.OUTN cml_tlatch_27.xmux.xp.S1 VSS sg13_lv_nmos ad=56.9f pd=0.74u as=56.9f ps=0.74u w=0.17u l=0.17u
X10323 cml_tlatch_35.xmux.xp.S1 cml_tlatch_35.OUTN cml_tlatch_35.OUTP VSS sg13_lv_nmos ad=0.1019p pd=1.34u as=56.9f ps=0.74u w=0.17u l=0.17u
X10324 cml_tlatch_96.xmux.xn.S1 CKHA1_P cml_tlatch_96.xtail.S1 VSS sg13_lv_nmos ad=89.3f pd=0.85u as=89.3f ps=0.85u w=0.47u l=0.16u
X10325 ENB_P J2_N cml_gate2_8.sg13_lv_nmos_FTPY57_0.D0 VSS sg13_lv_nmos ad=0.1007p pd=0.91u as=0.1007p ps=0.91u w=0.53u l=0.13u
X10326 VDD A2_8_P VSS rppd l=5.17u w=1u
X10327 cml_tlatch_67.OUTN cml_tlatch_58.INP cml_tlatch_67.xmux.xn.S1 VSS sg13_lv_nmos ad=63.19999f pd=0.74u as=63.19999f ps=0.74u w=0.26u l=0.38u
X10328 cml_tlatch_51.xtail.S1 CKHA2_N cml_tlatch_51.xmux.xp.S1 VSS sg13_lv_nmos ad=89.3f pd=0.85u as=89.3f ps=0.85u w=0.47u l=0.16u
X10329 cml_tlatch_19.xmux.xp.S1 MOT5_P MOT5_N VSS sg13_lv_nmos ad=56.9f pd=0.74u as=56.9f ps=0.74u w=0.17u l=0.17u
X10330 cml_tlatch_41.xmux.xn.S1 CKHA1_P cml_tlatch_41.xtail.S1 VSS sg13_lv_nmos ad=89.3f pd=0.85u as=89.3f ps=0.85u w=0.47u l=0.16u
X10331 cml_tlatch_63.xmux.xp.S1 cml_tlatch_63.OUTP cml_tlatch_63.OUTN VSS sg13_lv_nmos ad=56.9f pd=0.74u as=56.9f ps=0.74u w=0.17u l=0.17u
X10332 cml_tlatch_66.xmux.xp.S1 cml_tlatch_57.INP cml_tlatch_57.INN VSS sg13_lv_nmos ad=56.9f pd=0.74u as=56.9f ps=0.74u w=0.17u l=0.17u
X10333 J1_N J1_P cml_tlatch_93.xmux.xp.S1 VSS sg13_lv_nmos ad=56.9f pd=0.74u as=56.9f ps=0.74u w=0.17u l=0.17u
X10334 cml_tlatch_46.xmux.xp.S1 CKB3_P cml_tlatch_46.xtail.S1 VSS sg13_lv_nmos ad=89.3f pd=0.85u as=89.3f ps=0.85u w=0.47u l=0.16u
X10335 cml_tlatch_94.xmux.xp.S1 cml_tlatch_6.INP cml_tlatch_6.INN VSS sg13_lv_nmos ad=56.9f pd=0.74u as=56.9f ps=0.74u w=0.17u l=0.17u
X10336 CLK_W_N CLK_W_P cml_tlatch_91.xmux.xp.S1 VSS sg13_lv_nmos ad=56.9f pd=0.74u as=56.9f ps=0.74u w=0.17u l=0.17u
X10337 cml_tlatch_74.xmux.xp.S1 MOT19_P MOT19_N VSS sg13_lv_nmos ad=56.9f pd=0.74u as=56.9f ps=0.74u w=0.17u l=0.17u
X10338 MOT7_N B0_2_P cml_tlatch_20.xmux.xn.S1 VSS sg13_lv_nmos ad=63.19999f pd=0.74u as=63.19999f ps=0.74u w=0.26u l=0.38u
X10339 MOT15_N VDD VSS rppd l=5.17u w=1u
X10340 cml_tlatch_56.xmux.xp.S1 A2_2_N A2_2_P VSS sg13_lv_nmos ad=56.9f pd=0.74u as=56.9f ps=0.74u w=0.17u l=0.17u
X10341 MOT27_N MOT27_P cml_tlatch_69.xmux.xp.S1 VSS sg13_lv_nmos ad=56.9f pd=0.74u as=56.9f ps=0.74u w=0.17u l=0.17u
X10342 hs_to_clk_1.D2 CK_N CKB0_P VSS sg13_lv_nmos ad=0.228p pd=1.58u as=0.408p ps=3.08u w=1.2u l=0.2u
X10343 cml_tlatch_31.xmux.xn.S1 cml_tlatch_35.OUTP A0_2_N VSS sg13_lv_nmos ad=63.19999f pd=0.74u as=63.19999f ps=0.74u w=0.26u l=0.38u
X10344 cml_tlatch_92.xmux.xp.S1 J2_N J2_P VSS sg13_lv_nmos ad=56.9f pd=0.74u as=56.9f ps=0.74u w=0.17u l=0.17u
X10345 cml_tlatch_61.xmux.xp.S1 cml_tlatch_61.OUTP cml_tlatch_61.OUTN VSS sg13_lv_nmos ad=56.9f pd=0.74u as=56.9f ps=0.74u w=0.17u l=0.17u
X10346 A0_8_N A0_8_P cml_tlatch_2.xmux.xp.S1 VSS sg13_lv_nmos ad=56.9f pd=0.74u as=56.9f ps=0.74u w=0.17u l=0.17u
X10347 cml_tlatch_14.xmux.xp.S1 cml_tlatch_5.INP cml_tlatch_5.INN VSS sg13_lv_nmos ad=56.9f pd=0.74u as=56.9f ps=0.74u w=0.17u l=0.17u
X10348 cml_tlatch_59.xtail.S1 CKHA3_N cml_tlatch_59.xmux.xp.S1 VSS sg13_lv_nmos ad=89.3f pd=0.85u as=89.3f ps=0.85u w=0.47u l=0.16u
X10349 MOT12_N MOT12_P cml_tlatch_40.xmux.xp.S1 VSS sg13_lv_nmos ad=56.9f pd=0.74u as=56.9f ps=0.74u w=0.17u l=0.17u
X10350 cml_tlatch_48.xmux.xp.S1 stub_bi_32.BOTP stub_bi_32.BOTN VSS sg13_lv_nmos ad=0.1019p pd=1.34u as=56.9f ps=0.74u w=0.17u l=0.17u
X10351 cml_tlatch_1.xmux.xp.S1 cml_tlatch_1.OUTP cml_tlatch_1.OUTN VSS sg13_lv_nmos ad=56.9f pd=0.74u as=56.9f ps=0.74u w=0.17u l=0.17u
X10352 cml_tlatch_27.xtail.S1 POLN VSS VSS sg13_lv_nmos ad=1.5637p pd=8.61u as=1.5637p ps=8.61u w=8.23u l=0.13u
X10353 MOT10_N cml_tlatch_39.INP cml_tlatch_39.xmux.xn.S1 VSS sg13_lv_nmos ad=63.19999f pd=0.74u as=63.19999f ps=0.74u w=0.26u l=0.38u
X10354 cml_tlatch_56.xmux.xn.S1 cml_tlatch_56.INP A2_2_N VSS sg13_lv_nmos ad=63.19999f pd=0.74u as=63.19999f ps=0.74u w=0.26u l=0.38u
X10355 cml_gate2_2.xrtail.R1 CKB0_P cml_gate2_2.sg13_lv_nmos_FTPY57_0.D0 VSS sg13_lv_nmos ad=0.1007p pd=0.91u as=0.1007p ps=0.91u w=0.53u l=0.13u
X10356 VSS POLN cml_tlatch_17.xtail.S1 VSS sg13_lv_nmos ad=2.7982p pd=17.14u as=1.5637p ps=8.61u w=8.23u l=0.13u
X10357 cml_tlatch_42.xtail.S1 CKA2_P cml_tlatch_42.xmux.xn.S1 VSS sg13_lv_nmos ad=89.3f pd=0.85u as=89.3f ps=0.85u w=0.47u l=0.16u
X10358 cml_tlatch_91.xmux.xp.S1 CKJ_N cml_tlatch_91.xtail.S1 VSS sg13_lv_nmos ad=89.3f pd=0.85u as=89.3f ps=0.85u w=0.47u l=0.16u
X10359 MOT28_N MOT28_P cml_tlatch_58.xmux.xp.S1 VSS sg13_lv_nmos ad=56.9f pd=0.74u as=56.9f ps=0.74u w=0.17u l=0.17u
X10360 MOT4_P MOT4_N cml_tlatch_25.xmux.xp.S1 VSS sg13_lv_nmos ad=56.9f pd=0.74u as=56.9f ps=0.74u w=0.17u l=0.17u
X10361 cml_tlatch_16.xmux.xp.S1 cml_tlatch_16.OUTN cml_tlatch_16.OUTP VSS sg13_lv_nmos ad=0.1019p pd=1.34u as=56.9f ps=0.74u w=0.17u l=0.17u
X10362 cml_tlatch_16.xtail.S1 CKB0_N cml_tlatch_16.xmux.xn.S1 VSS sg13_lv_nmos ad=89.3f pd=0.85u as=89.3f ps=0.85u w=0.47u l=0.16u
X10363 A3_8_P A3_8_N cml_tlatch_64.xmux.xp.S1 VSS sg13_lv_nmos ad=56.9f pd=0.74u as=56.9f ps=0.74u w=0.17u l=0.17u
X10364 cml_tlatch_84.xmux.xp.S1 cml_tlatch_70.INN cml_tlatch_70.INP VSS sg13_lv_nmos ad=56.9f pd=0.74u as=56.9f ps=0.74u w=0.17u l=0.17u
X10365 cml_tlatch_52.OUTN A3_2_P cml_tlatch_52.xmux.xn.S1 VSS sg13_lv_nmos ad=0.1082p pd=1.34u as=63.19999f ps=0.74u w=0.26u l=0.38u
X10366 stub_bi_62.BOTP VDD VSS rppd l=5.17u w=1u
X10367 cml_tlatch_0.xmux.xp.S1 CKA1_N cml_tlatch_0.xtail.S1 VSS sg13_lv_nmos ad=89.3f pd=0.85u as=89.3f ps=0.85u w=0.47u l=0.16u
X10368 VDD A2_2_P VSS rppd l=5.17u w=1u
X10369 cml_tlatch_43.xmux.xp.S1 stub_bi_42.BOTN stub_bi_42.BOTP VSS sg13_lv_nmos ad=56.9f pd=0.74u as=56.9f ps=0.74u w=0.17u l=0.17u
X10370 cml_tlatch_66.xmux.xn.S1 CKA3_N cml_tlatch_66.xtail.S1 VSS sg13_lv_nmos ad=89.3f pd=0.85u as=89.3f ps=0.85u w=0.47u l=0.16u
X10371 cml_tlatch_21.xmux.xp.S1 A1_8_N A1_8_P VSS sg13_lv_nmos ad=56.9f pd=0.74u as=56.9f ps=0.74u w=0.17u l=0.17u
X10372 cml_tlatch_91.xmux.xp.S1 CLK_W_P CLK_W_N VSS sg13_lv_nmos ad=56.9f pd=0.74u as=56.9f ps=0.74u w=0.17u l=0.17u
X10373 cml_tlatch_48.xtail.S1 CKB2_P cml_tlatch_48.xmux.xn.S1 VSS sg13_lv_nmos ad=89.3f pd=0.85u as=89.3f ps=0.85u w=0.47u l=0.16u
X10374 B1_8_P B1_8_N cml_tlatch_12.xmux.xp.S1 VSS sg13_lv_nmos ad=56.9f pd=0.74u as=56.9f ps=0.74u w=0.17u l=0.17u
X10375 VSS POLN cml_tlatch_38.xtail.S1 VSS sg13_lv_nmos ad=2.7982p pd=17.14u as=1.5637p ps=8.61u w=8.23u l=0.13u
X10376 cml_tlatch_54.xtail.S1 CKA3_P cml_tlatch_54.xmux.xn.S1 VSS sg13_lv_nmos ad=89.3f pd=0.85u as=89.3f ps=0.85u w=0.47u l=0.16u
X10377 cml_gate2_1.xrtail.R1 CKA0_N GB0_P VSS sg13_lv_nmos ad=0.1007p pd=0.91u as=0.1007p ps=0.91u w=0.53u l=0.13u
X10378 ENA0_P ENA_N cml_drv_3.xrtail.R1 VSS sg13_lv_nmos ad=56.2f pd=0.74u as=56.2f ps=0.74u w=0.16u l=0.19u
X10379 MOT29_N MOT29_P cml_tlatch_70.xmux.xp.S1 VSS sg13_lv_nmos ad=56.9f pd=0.74u as=56.9f ps=0.74u w=0.17u l=0.17u
X10380 cml_tlatch_9.xmux.xn.S1 cml_tlatch_99.OUTP cml_tlatch_9.OUTN VSS sg13_lv_nmos ad=63.19999f pd=0.74u as=63.19999f ps=0.74u w=0.26u l=0.38u
X10381 cml_tlatch_69.INP cml_tlatch_63.OUTN cml_tlatch_62.xmux.xn.S1 VSS sg13_lv_nmos ad=63.19999f pd=0.74u as=63.19999f ps=0.74u w=0.26u l=0.38u
X10382 stub_bi_32.BOTP stub_bi_32.BOTN cml_tlatch_48.xmux.xp.S1 VSS sg13_lv_nmos ad=56.9f pd=0.74u as=56.9f ps=0.74u w=0.17u l=0.17u
X10383 ENA0_N ENA_P cml_drv_3.xrtail.R1 VSS sg13_lv_nmos ad=56.2f pd=0.74u as=56.2f ps=0.74u w=0.16u l=0.19u
X10384 cml_tlatch_15.xmux.xp.S1 CKB1_N cml_tlatch_15.xtail.S1 VSS sg13_lv_nmos ad=89.3f pd=0.85u as=89.3f ps=0.85u w=0.47u l=0.16u
X10385 A0_2_P A0_2_N cml_tlatch_31.xmux.xp.S1 VSS sg13_lv_nmos ad=56.9f pd=0.74u as=56.9f ps=0.74u w=0.17u l=0.17u
X10386 cml_tlatch_9.xmux.xn.S1 cml_tlatch_99.OUTN cml_tlatch_9.OUTP VSS sg13_lv_nmos ad=63.19999f pd=0.74u as=63.19999f ps=0.74u w=0.26u l=0.38u
X10387 cml_tlatch_12.xmux.xn.S1 stub_bi_17.BOTP B1_8_P VSS sg13_lv_nmos ad=0.1082p pd=1.34u as=63.19999f ps=0.74u w=0.26u l=0.38u
X10388 MOT9_N VDD VSS rppd l=5.17u w=1u
X10389 cml_tlatch_62.xmux.xn.S1 CKB3_N cml_tlatch_62.xtail.S1 VSS sg13_lv_nmos ad=89.3f pd=0.85u as=89.3f ps=0.85u w=0.47u l=0.16u
X10390 cml_tlatch_58.xtail.S1 CKHA3_N cml_tlatch_58.xmux.xp.S1 VSS sg13_lv_nmos ad=89.3f pd=0.85u as=89.3f ps=0.85u w=0.47u l=0.16u
X10391 ENB0_P ENB_N cml_drv_2.xrtail.R1 VSS sg13_lv_nmos ad=56.2f pd=0.74u as=56.2f ps=0.74u w=0.16u l=0.19u
X10392 cml_tlatch_61.xmux.xp.S1 cml_tlatch_61.OUTP cml_tlatch_61.OUTN VSS sg13_lv_nmos ad=56.9f pd=0.74u as=56.9f ps=0.74u w=0.17u l=0.17u
X10393 cml_tlatch_52.OUTN cml_tlatch_52.OUTP cml_tlatch_52.xmux.xp.S1 VSS sg13_lv_nmos ad=56.9f pd=0.74u as=0.1019p ps=1.34u w=0.17u l=0.17u
X10394 VSS POLN cml_tlatch_89.xtail.S1 VSS sg13_lv_nmos ad=2.7982p pd=17.14u as=1.5637p ps=8.61u w=8.23u l=0.13u
X10395 cml_tlatch_82.OUTN cml_tlatch_82.OUTP cml_tlatch_82.xmux.xp.S1 VSS sg13_lv_nmos ad=56.9f pd=0.74u as=56.9f ps=0.74u w=0.17u l=0.17u
X10396 hs_to_clk_5.D2 CK_P CKB3_N VSS sg13_lv_nmos ad=0.228p pd=1.58u as=0.408p ps=3.08u w=1.2u l=0.2u
X10397 VSS hs_to_clk_4.sg13_lv_nmos_2HGZLP_0.G VSS VSS sg13_lv_nmos ad=2.071p pd=11.28u as=0 ps=0 w=10.9u l=1.38u
X10398 MOT7_P MOT7_N cml_tlatch_20.xmux.xp.S1 VSS sg13_lv_nmos ad=56.9f pd=0.74u as=56.9f ps=0.74u w=0.17u l=0.17u
X10399 CLK_W_N CLK_W_P cml_tlatch_91.xmux.xp.S1 VSS sg13_lv_nmos ad=56.9f pd=0.74u as=56.9f ps=0.74u w=0.17u l=0.17u
X10400 MOT22_P MOT22_N cml_tlatch_51.xmux.xp.S1 VSS sg13_lv_nmos ad=56.9f pd=0.74u as=56.9f ps=0.74u w=0.17u l=0.17u
X10401 cml_tlatch_99.xmux.xp.S1 CKA0_P cml_tlatch_99.xtail.S1 VSS sg13_lv_nmos ad=89.3f pd=0.85u as=89.3f ps=0.85u w=0.47u l=0.16u
X10402 cml_tlatch_59.xmux.xp.S1 MOT30_N MOT30_P VSS sg13_lv_nmos ad=56.9f pd=0.74u as=56.9f ps=0.74u w=0.17u l=0.17u
X10403 MOT16_N MOT16_P cml_tlatch_87.xmux.xp.S1 VSS sg13_lv_nmos ad=56.9f pd=0.74u as=56.9f ps=0.74u w=0.17u l=0.17u
X10404 cml_tlatch_21.xtail.S1 CKA1_N cml_tlatch_21.xmux.xn.S1 VSS sg13_lv_nmos ad=89.3f pd=0.85u as=89.3f ps=0.85u w=0.47u l=0.16u
X10405 hs_to_clk_5.D2 CK_N CKB3_P VSS sg13_lv_nmos ad=0.408p pd=3.08u as=0.228p ps=1.58u w=1.2u l=0.2u
X10406 cml_tlatch_6.INP stub_bi_29.BOTP cml_tlatch_94.xmux.xn.S1 VSS sg13_lv_nmos ad=63.19999f pd=0.74u as=63.19999f ps=0.74u w=0.26u l=0.38u
X10407 VSS POLN cml_tlatch_92.xtail.S1 VSS sg13_lv_nmos ad=2.7982p pd=17.14u as=1.5637p ps=8.61u w=8.23u l=0.13u
X10408 cml_tlatch_72.xmux.xp.S1 cml_tlatch_83.INP cml_tlatch_83.INN VSS sg13_lv_nmos ad=0.1019p pd=1.34u as=56.9f ps=0.74u w=0.17u l=0.17u
X10409 cml_tlatch_7.xtail.S1 CKHB1_N cml_tlatch_7.xmux.xp.S1 VSS sg13_lv_nmos ad=89.3f pd=0.85u as=89.3f ps=0.85u w=0.47u l=0.16u
X10410 cml_tlatch_50.xmux.xp.S1 MOT20_N MOT20_P VSS sg13_lv_nmos ad=56.9f pd=0.74u as=56.9f ps=0.74u w=0.17u l=0.17u
X10411 cml_tlatch_84.xmux.xn.S1 cml_tlatch_45.OUTN cml_tlatch_70.INP VSS sg13_lv_nmos ad=63.19999f pd=0.74u as=63.19999f ps=0.74u w=0.26u l=0.38u
X10412 MOT12_N MOT12_P cml_tlatch_40.xmux.xp.S1 VSS sg13_lv_nmos ad=56.9f pd=0.74u as=56.9f ps=0.74u w=0.17u l=0.17u
X10413 VSS hs_to_clk_5.sg13_lv_nmos_2HGZLP_0.G VSS VSS sg13_lv_nmos ad=2.071p pd=11.28u as=0 ps=0 w=10.9u l=1.38u
X10414 cml_tlatch_85.xmux.xn.S1 CKA3_N cml_tlatch_85.xtail.S1 VSS sg13_lv_nmos ad=89.3f pd=0.85u as=89.3f ps=0.85u w=0.47u l=0.16u
X10415 cml_tlatch_16.OUTN cml_tlatch_16.OUTP cml_tlatch_16.xmux.xp.S1 VSS sg13_lv_nmos ad=56.9f pd=0.74u as=56.9f ps=0.74u w=0.17u l=0.17u
X10416 CLK_W_P CLK_W_N cml_tlatch_91.xmux.xp.S1 VSS sg13_lv_nmos ad=56.9f pd=0.74u as=56.9f ps=0.74u w=0.17u l=0.17u
X10417 cml_tlatch_73.xmux.xp.S1 MOT17_P MOT17_N VSS sg13_lv_nmos ad=56.9f pd=0.74u as=56.9f ps=0.74u w=0.17u l=0.17u
X10418 cml_tlatch_83.INP cml_tlatch_83.INN cml_tlatch_72.xmux.xp.S1 VSS sg13_lv_nmos ad=56.9f pd=0.74u as=56.9f ps=0.74u w=0.17u l=0.17u
X10419 cml_tlatch_80.xmux.xp.S1 stub_bi_49.BOTP stub_bi_49.BOTN VSS sg13_lv_nmos ad=56.9f pd=0.74u as=56.9f ps=0.74u w=0.17u l=0.17u
X10420 cml_tlatch_37.xmux.xp.S1 A1_2_P A1_2_N VSS sg13_lv_nmos ad=56.9f pd=0.74u as=56.9f ps=0.74u w=0.17u l=0.17u
X10421 cml_tlatch_88.xmux.xp.S1 stub_bi_55.BOTN stub_bi_55.BOTP VSS sg13_lv_nmos ad=56.9f pd=0.74u as=56.9f ps=0.74u w=0.17u l=0.17u
X10422 MOT19_P MOT19_N cml_tlatch_74.xmux.xp.S1 VSS sg13_lv_nmos ad=56.9f pd=0.74u as=56.9f ps=0.74u w=0.17u l=0.17u
X10423 cml_gate2_8.sg13_lv_nmos_FTPY57_0.D0 NS1_P cml_gate2_8.xrtail.R1 VSS sg13_lv_nmos ad=0.1007p pd=0.91u as=0.1007p ps=0.91u w=0.53u l=0.13u
X10424 cml_tlatch_29.OUTN cml_tlatch_29.OUTP cml_tlatch_29.xmux.xp.S1 VSS sg13_lv_nmos ad=56.9f pd=0.74u as=56.9f ps=0.74u w=0.17u l=0.17u
X10425 cml_tlatch_97.xmux.xp.S1 MOT0_P MOT0_N VSS sg13_lv_nmos ad=56.9f pd=0.74u as=56.9f ps=0.74u w=0.17u l=0.17u
X10426 B2_8_N stub_bi_62.BOTN cml_tlatch_77.xmux.xn.S1 VSS sg13_lv_nmos ad=63.19999f pd=0.74u as=63.19999f ps=0.74u w=0.26u l=0.38u
X10427 cml_tlatch_26.xmux.xn.S1 A0_2_N MOT6_P VSS sg13_lv_nmos ad=63.19999f pd=0.74u as=63.19999f ps=0.74u w=0.26u l=0.38u
X10428 cml_tlatch_57.xmux.xn.S1 CKHA3_P cml_tlatch_57.xtail.S1 VSS sg13_lv_nmos ad=89.3f pd=0.85u as=89.3f ps=0.85u w=0.47u l=0.16u
X10429 VSS POLN cml_tlatch_32.xtail.S1 VSS sg13_lv_nmos ad=2.7982p pd=17.14u as=1.5637p ps=8.61u w=8.23u l=0.13u
X10430 MOT4_P MOT4_N cml_tlatch_25.xmux.xp.S1 VSS sg13_lv_nmos ad=56.9f pd=0.74u as=56.9f ps=0.74u w=0.17u l=0.17u
X10431 cml_tlatch_60.xmux.xp.S1 B3_8_N B3_8_P VSS sg13_lv_nmos ad=56.9f pd=0.74u as=56.9f ps=0.74u w=0.17u l=0.17u
X10432 hs_to_clk_7.sg13_lv_nmos_2HGZLP_0.G CKA3_N VSS rppd l=4.25u w=1u
X10433 cml_tlatch_89.OUTP cml_tlatch_89.OUTN cml_tlatch_89.xmux.xp.S1 VSS sg13_lv_nmos ad=56.9f pd=0.74u as=56.9f ps=0.74u w=0.17u l=0.17u
X10434 cml_gate2_2.xrtail.R1 CKB0_N GA0_P VSS sg13_lv_nmos ad=0.1007p pd=0.91u as=0.1007p ps=0.91u w=0.53u l=0.13u
X10435 cml_tlatch_63.xmux.xn.S1 CKB3_P cml_tlatch_63.xtail.S1 VSS sg13_lv_nmos ad=89.3f pd=0.85u as=89.3f ps=0.85u w=0.47u l=0.16u
X10436 stub_bi_62.BOTP stub_bi_62.BOTN cml_tlatch_78.xmux.xp.S1 VSS sg13_lv_nmos ad=56.9f pd=0.74u as=0.1019p ps=1.34u w=0.17u l=0.17u
X10437 cml_tlatch_11.xmux.xn.S1 CKB0_P cml_tlatch_11.xtail.S1 VSS sg13_lv_nmos ad=89.3f pd=0.85u as=89.3f ps=0.85u w=0.47u l=0.16u
X10438 VSS hs_to_clk_0.sg13_lv_nmos_2HGZLP_0.G VSS VSS sg13_lv_nmos ad=2.071p pd=11.28u as=0 ps=0 w=10.9u l=1.38u
X10439 cml_tlatch_76.xtail.S1 CKHB2_N cml_tlatch_76.xmux.xp.S1 VSS sg13_lv_nmos ad=89.3f pd=0.85u as=89.3f ps=0.85u w=0.47u l=0.16u
X10440 cml_tlatch_49.xmux.xp.S1 MOT18_P MOT18_N VSS sg13_lv_nmos ad=56.9f pd=0.74u as=56.9f ps=0.74u w=0.17u l=0.17u
X10441 cml_tlatch_30.xmux.xp.S1 cml_tlatch_30.OUTP cml_tlatch_30.OUTN VSS sg13_lv_nmos ad=56.9f pd=0.74u as=56.9f ps=0.74u w=0.17u l=0.17u
X10442 cml_tlatch_81.xmux.xp.S1 CKA2_P cml_tlatch_81.xtail.S1 VSS sg13_lv_nmos ad=89.3f pd=0.85u as=89.3f ps=0.85u w=0.47u l=0.16u
X10443 cml_tlatch_76.xmux.xp.S1 MOT23_N MOT23_P VSS sg13_lv_nmos ad=56.9f pd=0.74u as=56.9f ps=0.74u w=0.17u l=0.17u
X10444 B1_8_P B1_8_N cml_tlatch_12.xmux.xp.S1 VSS sg13_lv_nmos ad=56.9f pd=0.74u as=56.9f ps=0.74u w=0.17u l=0.17u
X10445 cml_tlatch_78.xtail.S1 CKB2_N cml_tlatch_78.xmux.xp.S1 VSS sg13_lv_nmos ad=89.3f pd=0.85u as=89.3f ps=0.85u w=0.47u l=0.16u
X10446 cml_tlatch_94.xmux.xn.S1 CKB1_N cml_tlatch_94.xtail.S1 VSS sg13_lv_nmos ad=89.3f pd=0.85u as=89.3f ps=0.85u w=0.47u l=0.16u
X10447 cml_tlatch_37.xtail.S1 CKA1_N cml_tlatch_37.xmux.xn.S1 VSS sg13_lv_nmos ad=89.3f pd=0.85u as=89.3f ps=0.85u w=0.47u l=0.16u
X10448 cml_tlatch_89.xmux.xn.S1 cml_tlatch_89.INN cml_tlatch_89.OUTP VSS sg13_lv_nmos ad=63.19999f pd=0.74u as=63.19999f ps=0.74u w=0.26u l=0.38u
X10449 cml_tlatch_61.OUTP cml_tlatch_61.OUTN cml_tlatch_61.xmux.xp.S1 VSS sg13_lv_nmos ad=56.9f pd=0.74u as=56.9f ps=0.74u w=0.17u l=0.17u
X10450 cml_tlatch_82.xmux.xp.S1 cml_tlatch_82.OUTN cml_tlatch_82.OUTP VSS sg13_lv_nmos ad=56.9f pd=0.74u as=56.9f ps=0.74u w=0.17u l=0.17u
X10451 cml_tlatch_89.OUTN cml_tlatch_89.INP cml_tlatch_89.xmux.xn.S1 VSS sg13_lv_nmos ad=63.19999f pd=0.74u as=63.19999f ps=0.74u w=0.26u l=0.38u
X10452 MOT1_P MOT1_N cml_tlatch_17.xmux.xp.S1 VSS sg13_lv_nmos ad=56.9f pd=0.74u as=56.9f ps=0.74u w=0.17u l=0.17u
X10453 cml_tlatch_5.xmux.xp.S1 CKHB1_N cml_tlatch_5.xtail.S1 VSS sg13_lv_nmos ad=89.3f pd=0.85u as=89.3f ps=0.85u w=0.47u l=0.16u
X10454 cml_tlatch_19.xtail.S1 POLN VSS VSS sg13_lv_nmos ad=1.5637p pd=8.61u as=2.7982p ps=17.14u w=8.23u l=0.13u
X10455 cml_tlatch_44.xmux.xn.S1 stub_bi_32.BOTP B2_2_P VSS sg13_lv_nmos ad=63.19999f pd=0.74u as=63.19999f ps=0.74u w=0.26u l=0.38u
X10456 cml_tlatch_31.xmux.xp.S1 A0_2_P A0_2_N VSS sg13_lv_nmos ad=56.9f pd=0.74u as=56.9f ps=0.74u w=0.17u l=0.17u
X10457 cml_tlatch_43.xmux.xn.S1 CKB2_P cml_tlatch_43.xtail.S1 VSS sg13_lv_nmos ad=89.3f pd=0.85u as=89.3f ps=0.85u w=0.47u l=0.16u
X10458 cml_tlatch_77.xmux.xp.S1 CKB2_P cml_tlatch_77.xtail.S1 VSS sg13_lv_nmos ad=89.3f pd=0.85u as=89.3f ps=0.85u w=0.47u l=0.16u
X10459 cml_tlatch_25.xmux.xp.S1 CKHA0_N cml_tlatch_25.xtail.S1 VSS sg13_lv_nmos ad=89.3f pd=0.85u as=89.3f ps=0.85u w=0.47u l=0.16u
X10460 cml_tlatch_6.xmux.xp.S1 MOT13_P MOT13_N VSS sg13_lv_nmos ad=56.9f pd=0.74u as=56.9f ps=0.74u w=0.17u l=0.17u
X10461 cml_tlatch_91.xtail.S1 CKJ_N cml_tlatch_91.xmux.xp.S1 VSS sg13_lv_nmos ad=89.3f pd=0.85u as=89.3f ps=0.85u w=0.47u l=0.16u
X10462 cml_tlatch_64.xmux.xp.S1 CKA3_P cml_tlatch_64.xtail.S1 VSS sg13_lv_nmos ad=89.3f pd=0.85u as=89.3f ps=0.85u w=0.47u l=0.16u
X10463 MOT12_P MOT12_N cml_tlatch_40.xmux.xp.S1 VSS sg13_lv_nmos ad=56.9f pd=0.74u as=0.1019p ps=1.34u w=0.17u l=0.17u
X10464 cml_tlatch_83.OUTN cml_tlatch_83.OUTP cml_tlatch_83.xmux.xp.S1 VSS sg13_lv_nmos ad=56.9f pd=0.74u as=56.9f ps=0.74u w=0.17u l=0.17u
X10465 stub_bi_32.BOTN D2_N cml_tlatch_48.xmux.xn.S1 VSS sg13_lv_nmos ad=63.19999f pd=0.74u as=63.19999f ps=0.74u w=0.26u l=0.38u
X10466 cml_tlatch_79.xmux.xp.S1 stub_bi_63.BOTP stub_bi_63.BOTN VSS sg13_lv_nmos ad=56.9f pd=0.74u as=56.9f ps=0.74u w=0.17u l=0.17u
X10467 cml_tlatch_35.OUTN D0_P cml_tlatch_35.xmux.xn.S1 VSS sg13_lv_nmos ad=63.19999f pd=0.74u as=63.19999f ps=0.74u w=0.26u l=0.38u
X10468 MOT7_P MOT7_N cml_tlatch_20.xmux.xp.S1 VSS sg13_lv_nmos ad=56.9f pd=0.74u as=56.9f ps=0.74u w=0.17u l=0.17u
X10469 cml_tlatch_10.xmux.xp.S1 CKB0_P cml_tlatch_10.xtail.S1 VSS sg13_lv_nmos ad=89.3f pd=0.85u as=89.3f ps=0.85u w=0.47u l=0.16u
X10470 cml_tlatch_9.xmux.xn.S1 CKA0_P cml_tlatch_9.xtail.S1 VSS sg13_lv_nmos ad=89.3f pd=0.85u as=89.3f ps=0.85u w=0.47u l=0.16u
X10471 MOT16_N MOT16_P cml_tlatch_87.xmux.xp.S1 VSS sg13_lv_nmos ad=56.9f pd=0.74u as=56.9f ps=0.74u w=0.17u l=0.17u
X10472 cml_tlatch_59.xmux.xp.S1 MOT30_N MOT30_P VSS sg13_lv_nmos ad=56.9f pd=0.74u as=56.9f ps=0.74u w=0.17u l=0.17u
X10473 cml_tlatch_86.xmux.xp.S1 MOT24_P MOT24_N VSS sg13_lv_nmos ad=56.9f pd=0.74u as=56.9f ps=0.74u w=0.17u l=0.17u
X10474 stub_bi_29.BOTP stub_bi_29.BOTN cml_tlatch_32.xmux.xp.S1 VSS sg13_lv_nmos ad=56.9f pd=0.74u as=56.9f ps=0.74u w=0.17u l=0.17u
X10475 MOT23_N MOT23_P cml_tlatch_76.xmux.xp.S1 VSS sg13_lv_nmos ad=56.9f pd=0.74u as=56.9f ps=0.74u w=0.17u l=0.17u
X10476 cml_tlatch_71.xmux.xp.S1 MOT31_P MOT31_N VSS sg13_lv_nmos ad=56.9f pd=0.74u as=56.9f ps=0.74u w=0.17u l=0.17u
X10477 cml_tlatch_40.xtail.S1 CKHA1_P cml_tlatch_40.xmux.xn.S1 VSS sg13_lv_nmos ad=89.3f pd=0.85u as=89.3f ps=0.85u w=0.47u l=0.16u
X10478 cml_tlatch_58.INN cml_tlatch_58.INP cml_tlatch_85.xmux.xp.S1 VSS sg13_lv_nmos ad=56.9f pd=0.74u as=56.9f ps=0.74u w=0.17u l=0.17u
X10479 cml_tlatch_37.xmux.xp.S1 CKA1_P cml_tlatch_37.xtail.S1 VSS sg13_lv_nmos ad=89.3f pd=0.85u as=0.1598p ps=1.62u w=0.47u l=0.16u
X10480 cml_tlatch_5.xmux.xp.S1 MOT11_N MOT11_P VSS sg13_lv_nmos ad=56.9f pd=0.74u as=56.9f ps=0.74u w=0.17u l=0.17u
X10481 cml_tlatch_35.OUTP cml_tlatch_35.OUTN cml_tlatch_35.xmux.xp.S1 VSS sg13_lv_nmos ad=56.9f pd=0.74u as=56.9f ps=0.74u w=0.17u l=0.17u
X10482 MOT14_P MOT14_N cml_tlatch_41.xmux.xp.S1 VSS sg13_lv_nmos ad=56.9f pd=0.74u as=56.9f ps=0.74u w=0.17u l=0.17u
X10483 cml_tlatch_14.xmux.xp.S1 CKB1_P cml_tlatch_14.xtail.S1 VSS sg13_lv_nmos ad=89.3f pd=0.85u as=89.3f ps=0.85u w=0.47u l=0.16u
X10484 cml_tlatch_65.xmux.xn.S1 CKA3_P cml_tlatch_65.xtail.S1 VSS sg13_lv_nmos ad=89.3f pd=0.85u as=89.3f ps=0.85u w=0.47u l=0.16u
X10485 cml_tlatch_78.xmux.xn.S1 stub_bi_63.BOTN stub_bi_62.BOTP VSS sg13_lv_nmos ad=63.19999f pd=0.74u as=63.19999f ps=0.74u w=0.26u l=0.38u
X10486 cml_tlatch_6.xtail.S1 CKHB1_N cml_tlatch_6.xmux.xp.S1 VSS sg13_lv_nmos ad=0.1598p pd=1.62u as=89.3f ps=0.85u w=0.47u l=0.16u
X10487 A3_2_N A3_2_P cml_tlatch_53.xmux.xp.S1 VSS sg13_lv_nmos ad=56.9f pd=0.74u as=56.9f ps=0.74u w=0.17u l=0.17u
X10488 stub_bi_55.BOTN stub_bi_55.BOTP cml_tlatch_88.xmux.xp.S1 VSS sg13_lv_nmos ad=56.9f pd=0.74u as=56.9f ps=0.74u w=0.17u l=0.17u
X10489 cml_tlatch_16.OUTN cml_tlatch_16.OUTP cml_tlatch_16.xmux.xp.S1 VSS sg13_lv_nmos ad=56.9f pd=0.74u as=56.9f ps=0.74u w=0.17u l=0.17u
X10490 cml_tlatch_99.xmux.xp.S1 cml_tlatch_99.OUTP cml_tlatch_99.OUTN VSS sg13_lv_nmos ad=56.9f pd=0.74u as=56.9f ps=0.74u w=0.17u l=0.17u
X10491 cml_tlatch_68.xtail.S1 CKHB3_N cml_tlatch_68.xmux.xp.S1 VSS sg13_lv_nmos ad=89.3f pd=0.85u as=89.3f ps=0.85u w=0.47u l=0.16u
X10492 cml_tlatch_83.xmux.xp.S1 CKA2_P cml_tlatch_83.xtail.S1 VSS sg13_lv_nmos ad=89.3f pd=0.85u as=89.3f ps=0.85u w=0.47u l=0.16u
X10493 cml_tlatch_52.xmux.xn.S1 A3_2_N cml_tlatch_52.OUTP VSS sg13_lv_nmos ad=63.19999f pd=0.74u as=63.19999f ps=0.74u w=0.26u l=0.38u
X10494 cml_tlatch_59.xtail.S1 CKHA3_N cml_tlatch_59.xmux.xp.S1 VSS sg13_lv_nmos ad=89.3f pd=0.85u as=89.3f ps=0.85u w=0.47u l=0.16u
X10495 MOT18_P MOT18_N cml_tlatch_49.xmux.xp.S1 VSS sg13_lv_nmos ad=56.9f pd=0.74u as=56.9f ps=0.74u w=0.17u l=0.17u
X10496 cml_tlatch_26.xmux.xp.S1 MOT6_P MOT6_N VSS sg13_lv_nmos ad=56.9f pd=0.74u as=56.9f ps=0.74u w=0.17u l=0.17u
X10497 cml_tlatch_29.xtail.S1 CKB0_N cml_tlatch_29.xmux.xp.S1 VSS sg13_lv_nmos ad=0.1598p pd=1.62u as=89.3f ps=0.85u w=0.47u l=0.16u
X10498 MOT13_N cml_tlatch_6.INP cml_tlatch_6.xmux.xn.S1 VSS sg13_lv_nmos ad=63.19999f pd=0.74u as=63.19999f ps=0.74u w=0.26u l=0.38u
X10499 ENB1_P ENB_N cml_drv_0.xrtail.R1 VSS sg13_lv_nmos ad=56.2f pd=0.74u as=56.2f ps=0.74u w=0.16u l=0.19u
X10500 B1_2_N B1_2_P cml_tlatch_33.xmux.xp.S1 VSS sg13_lv_nmos ad=56.9f pd=0.74u as=56.9f ps=0.74u w=0.17u l=0.17u
X10501 cml_tlatch_49.xmux.xn.S1 cml_tlatch_83.OUTP MOT18_N VSS sg13_lv_nmos ad=63.19999f pd=0.74u as=63.19999f ps=0.74u w=0.26u l=0.38u
X10502 cml_tlatch_61.xmux.xn.S1 CKB3_P cml_tlatch_61.xtail.S1 VSS sg13_lv_nmos ad=89.3f pd=0.85u as=89.3f ps=0.85u w=0.47u l=0.16u
X10503 MOT8_P MOT8_N cml_tlatch_96.xmux.xp.S1 VSS sg13_lv_nmos ad=56.9f pd=0.74u as=56.9f ps=0.74u w=0.17u l=0.17u
X10504 cml_tlatch_0.xmux.xp.S1 interco_bi_19.INN interco_bi_19.INP VSS sg13_lv_nmos ad=56.9f pd=0.74u as=56.9f ps=0.74u w=0.17u l=0.17u
X10505 A3_8_N A3_8_P cml_tlatch_64.xmux.xp.S1 VSS sg13_lv_nmos ad=56.9f pd=0.74u as=56.9f ps=0.74u w=0.17u l=0.17u
X10506 cml_tlatch_81.xmux.xp.S1 A2_8_N A2_8_P VSS sg13_lv_nmos ad=56.9f pd=0.74u as=56.9f ps=0.74u w=0.17u l=0.17u
X10507 cml_tlatch_8.xtail.S1 CKA0_P cml_tlatch_8.xmux.xp.S1 VSS sg13_lv_nmos ad=89.3f pd=0.85u as=89.3f ps=0.85u w=0.47u l=0.16u
X10508 MOT15_P MOT15_N cml_tlatch_7.xmux.xp.S1 VSS sg13_lv_nmos ad=56.9f pd=0.74u as=0.1019p ps=1.34u w=0.17u l=0.17u
X10509 cml_tlatch_47.OUTP cml_tlatch_47.OUTN cml_tlatch_47.xmux.xp.S1 VSS sg13_lv_nmos ad=56.9f pd=0.74u as=56.9f ps=0.74u w=0.17u l=0.17u
X10510 cml_tlatch_73.xmux.xp.S1 MOT17_N MOT17_P VSS sg13_lv_nmos ad=56.9f pd=0.74u as=56.9f ps=0.74u w=0.17u l=0.17u
X10511 cml_tlatch_42.xmux.xp.S1 cml_tlatch_56.INN cml_tlatch_56.INP VSS sg13_lv_nmos ad=56.9f pd=0.74u as=56.9f ps=0.74u w=0.17u l=0.17u
X10512 interco_bi_19.INN interco_bi_19.INP cml_tlatch_0.xmux.xp.S1 VSS sg13_lv_nmos ad=56.9f pd=0.74u as=56.9f ps=0.74u w=0.17u l=0.17u
X10513 cml_tlatch_54.xmux.xp.S1 cml_tlatch_54.OUTP cml_tlatch_54.OUTN VSS sg13_lv_nmos ad=56.9f pd=0.74u as=56.9f ps=0.74u w=0.17u l=0.17u
X10514 cml_tlatch_3.OUTP cml_tlatch_3.OUTN cml_tlatch_3.xmux.xp.S1 VSS sg13_lv_nmos ad=56.9f pd=0.74u as=56.9f ps=0.74u w=0.17u l=0.17u
X10515 cml_tlatch_15.xmux.xp.S1 stub_bi_19.BOTN stub_bi_19.BOTP VSS sg13_lv_nmos ad=56.9f pd=0.74u as=56.9f ps=0.74u w=0.17u l=0.17u
X10516 cml_tlatch_50.xtail.S1 CKHA2_P cml_tlatch_50.xmux.xn.S1 VSS sg13_lv_nmos ad=89.3f pd=0.85u as=89.3f ps=0.85u w=0.47u l=0.16u
X10517 cml_tlatch_49.xmux.xp.S1 MOT18_P MOT18_N VSS sg13_lv_nmos ad=0.1019p pd=1.34u as=56.9f ps=0.74u w=0.17u l=0.17u
X10518 B0_2_N B0_2_P cml_tlatch_28.xmux.xp.S1 VSS sg13_lv_nmos ad=56.9f pd=0.74u as=56.9f ps=0.74u w=0.17u l=0.17u
X10519 cml_tlatch_52.OUTP cml_tlatch_52.OUTN cml_tlatch_52.xmux.xp.S1 VSS sg13_lv_nmos ad=56.9f pd=0.74u as=56.9f ps=0.74u w=0.17u l=0.17u
X10520 cml_tlatch_30.xmux.xp.S1 cml_tlatch_30.OUTP cml_tlatch_30.OUTN VSS sg13_lv_nmos ad=0.1019p pd=1.34u as=56.9f ps=0.74u w=0.17u l=0.17u
X10521 A0_8_P cml_tlatch_3.OUTN cml_tlatch_2.xmux.xn.S1 VSS sg13_lv_nmos ad=63.19999f pd=0.74u as=0.1082p ps=1.34u w=0.26u l=0.38u
X10522 MOT26_N MOT26_P cml_tlatch_57.xmux.xp.S1 VSS sg13_lv_nmos ad=56.9f pd=0.74u as=56.9f ps=0.74u w=0.17u l=0.17u
X10523 cml_tlatch_23.xmux.xn.S1 interco_bi_19.INP cml_tlatch_39.INN VSS sg13_lv_nmos ad=63.19999f pd=0.74u as=63.19999f ps=0.74u w=0.26u l=0.38u
X10524 cml_tlatch_16.OUTP cml_tlatch_16.OUTN cml_tlatch_16.xmux.xp.S1 VSS sg13_lv_nmos ad=56.9f pd=0.74u as=56.9f ps=0.74u w=0.17u l=0.17u
X10525 cml_tlatch_65.OUTN cml_tlatch_57.INP cml_tlatch_65.xmux.xn.S1 VSS sg13_lv_nmos ad=63.19999f pd=0.74u as=63.19999f ps=0.74u w=0.26u l=0.38u
X10526 cml_tlatch_82.xmux.xp.S1 cml_tlatch_82.OUTN cml_tlatch_82.OUTP VSS sg13_lv_nmos ad=56.9f pd=0.74u as=56.9f ps=0.74u w=0.17u l=0.17u
X10527 cml_tlatch_21.xmux.xp.S1 A1_8_P A1_8_N VSS sg13_lv_nmos ad=56.9f pd=0.74u as=56.9f ps=0.74u w=0.17u l=0.17u
X10528 cml_tlatch_69.xmux.xn.S1 cml_tlatch_69.INN MOT27_P VSS sg13_lv_nmos ad=63.19999f pd=0.74u as=63.19999f ps=0.74u w=0.26u l=0.38u
X10529 cml_tlatch_35.xtail.S1 CKA0_P cml_tlatch_35.xmux.xn.S1 VSS sg13_lv_nmos ad=89.3f pd=0.85u as=89.3f ps=0.85u w=0.47u l=0.16u
X10530 cml_tlatch_39.xmux.xp.S1 MOT10_P MOT10_N VSS sg13_lv_nmos ad=56.9f pd=0.74u as=56.9f ps=0.74u w=0.17u l=0.17u
X10531 CLK_W_P J2_P cml_tlatch_91.xmux.xn.S1 VSS sg13_lv_nmos ad=0.1082p pd=1.34u as=63.19999f ps=0.74u w=0.26u l=0.38u
X10532 MOT1_P MOT1_N cml_tlatch_17.xmux.xp.S1 VSS sg13_lv_nmos ad=56.9f pd=0.74u as=56.9f ps=0.74u w=0.17u l=0.17u
X10533 cml_tlatch_32.xmux.xn.S1 B1_2_N stub_bi_29.BOTN VSS sg13_lv_nmos ad=63.19999f pd=0.74u as=0.1082p ps=1.34u w=0.26u l=0.38u
X10534 cml_tlatch_56.xtail.S1 CKA2_P cml_tlatch_56.xmux.xp.S1 VSS sg13_lv_nmos ad=89.3f pd=0.85u as=89.3f ps=0.85u w=0.47u l=0.16u
X10535 cml_tlatch_15.xmux.xp.S1 CKB1_N cml_tlatch_15.xtail.S1 VSS sg13_lv_nmos ad=89.3f pd=0.85u as=89.3f ps=0.85u w=0.47u l=0.16u
X10536 cml_tlatch_55.xmux.xp.S1 cml_tlatch_89.INP cml_tlatch_89.INN VSS sg13_lv_nmos ad=56.9f pd=0.74u as=56.9f ps=0.74u w=0.17u l=0.17u
X10537 cml_tlatch_69.xmux.xn.S1 cml_tlatch_69.INN MOT27_P VSS sg13_lv_nmos ad=63.19999f pd=0.74u as=63.19999f ps=0.74u w=0.26u l=0.38u
X10538 MOT16_N A2_8_P cml_tlatch_87.xmux.xn.S1 VSS sg13_lv_nmos ad=63.19999f pd=0.74u as=63.19999f ps=0.74u w=0.26u l=0.38u
X10539 cml_tlatch_18.xtail.S1 POLN VSS VSS sg13_lv_nmos ad=1.5637p pd=8.61u as=2.7982p ps=17.14u w=8.23u l=0.13u
X10540 cml_tlatch_17.xmux.xn.S1 B0_8_P MOT1_N VSS sg13_lv_nmos ad=63.19999f pd=0.74u as=63.19999f ps=0.74u w=0.26u l=0.38u
X10541 cml_tlatch_39.INP cml_tlatch_39.INN cml_tlatch_23.xmux.xp.S1 VSS sg13_lv_nmos ad=56.9f pd=0.74u as=0.1019p ps=1.34u w=0.17u l=0.17u
X10542 cml_tlatch_36.xmux.xp.S1 cml_tlatch_95.INN cml_tlatch_95.INP VSS sg13_lv_nmos ad=56.9f pd=0.74u as=56.9f ps=0.74u w=0.17u l=0.17u
X10543 cml_tlatch_63.xtail.S1 CKB3_P cml_tlatch_63.xmux.xn.S1 VSS sg13_lv_nmos ad=89.3f pd=0.85u as=89.3f ps=0.85u w=0.47u l=0.16u
X10544 cml_tlatch_19.xtail.S1 CKHB0_P cml_tlatch_19.xmux.xn.S1 VSS sg13_lv_nmos ad=89.3f pd=0.85u as=89.3f ps=0.85u w=0.47u l=0.16u
X10545 cml_tlatch_39.xmux.xp.S1 MOT10_N MOT10_P VSS sg13_lv_nmos ad=56.9f pd=0.74u as=56.9f ps=0.74u w=0.17u l=0.17u
X10546 cml_tlatch_17.xmux.xn.S1 B0_8_P MOT1_N VSS sg13_lv_nmos ad=63.19999f pd=0.74u as=63.19999f ps=0.74u w=0.26u l=0.38u
X10547 cml_tlatch_86.xmux.xp.S1 MOT24_N MOT24_P VSS sg13_lv_nmos ad=56.9f pd=0.74u as=56.9f ps=0.74u w=0.17u l=0.17u
X10548 cml_tlatch_99.xmux.xp.S1 CKA0_P cml_tlatch_99.xtail.S1 VSS sg13_lv_nmos ad=89.3f pd=0.85u as=89.3f ps=0.85u w=0.47u l=0.16u
X10549 cml_tlatch_67.OUTP cml_tlatch_67.OUTN cml_tlatch_67.xmux.xp.S1 VSS sg13_lv_nmos ad=56.9f pd=0.74u as=56.9f ps=0.74u w=0.17u l=0.17u
X10550 cml_tlatch_58.INN cml_tlatch_58.INP cml_tlatch_85.xmux.xp.S1 VSS sg13_lv_nmos ad=56.9f pd=0.74u as=56.9f ps=0.74u w=0.17u l=0.17u
X10551 cml_tlatch_13.xtail.S1 CKB1_P cml_tlatch_13.xmux.xn.S1 VSS sg13_lv_nmos ad=89.3f pd=0.85u as=89.3f ps=0.85u w=0.47u l=0.16u
X10552 J4_N J4_P cml_tlatch_90.xmux.xp.S1 VSS sg13_lv_nmos ad=56.9f pd=0.74u as=56.9f ps=0.74u w=0.17u l=0.17u
X10553 cml_tlatch_84.xmux.xp.S1 cml_tlatch_70.INP cml_tlatch_70.INN VSS sg13_lv_nmos ad=56.9f pd=0.74u as=56.9f ps=0.74u w=0.17u l=0.17u
X10554 cml_tlatch_75.xmux.xp.S1 CKHB2_N cml_tlatch_75.xtail.S1 VSS sg13_lv_nmos ad=89.3f pd=0.85u as=89.3f ps=0.85u w=0.47u l=0.16u
X10555 cml_tlatch_27.xmux.xp.S1 cml_tlatch_27.OUTN cml_tlatch_27.OUTP VSS sg13_lv_nmos ad=56.9f pd=0.74u as=56.9f ps=0.74u w=0.17u l=0.17u
X10556 cml_tlatch_35.OUTP cml_tlatch_35.OUTN cml_tlatch_35.xmux.xp.S1 VSS sg13_lv_nmos ad=56.9f pd=0.74u as=56.9f ps=0.74u w=0.17u l=0.17u
X10557 cml_tlatch_83.OUTP cml_tlatch_83.INN cml_tlatch_83.xmux.xn.S1 VSS sg13_lv_nmos ad=63.19999f pd=0.74u as=63.19999f ps=0.74u w=0.26u l=0.38u
X10558 cml_tlatch_2.xmux.xp.S1 CKA0_P cml_tlatch_2.xtail.S1 VSS sg13_lv_nmos ad=89.3f pd=0.85u as=0.1598p ps=1.62u w=0.47u l=0.16u
X10559 cml_gate2_1.xrtail.R1 CKA0_P cml_gate2_1.sg13_lv_nmos_FTPY57_0.D0 VSS sg13_lv_nmos ad=0.1007p pd=0.91u as=0.1007p ps=0.91u w=0.53u l=0.13u
X10560 cml_tlatch_17.xmux.xp.S1 CKHB0_N cml_tlatch_17.xtail.S1 VSS sg13_lv_nmos ad=89.3f pd=0.85u as=89.3f ps=0.85u w=0.47u l=0.16u
X10561 cml_tlatch_26.xmux.xp.S1 MOT6_P MOT6_N VSS sg13_lv_nmos ad=0.1019p pd=1.34u as=56.9f ps=0.74u w=0.17u l=0.17u
X10562 cml_gate2_5.sg13_lv_nmos_FTPY57_0.D0 ENA1_N GA3_P VSS sg13_lv_nmos ad=0.1007p pd=0.91u as=0.1007p ps=0.91u w=0.53u l=0.13u
X10563 VSS POLN cml_tlatch_77.xtail.S1 VSS sg13_lv_nmos ad=1.5637p pd=8.61u as=1.5637p ps=8.61u w=8.23u l=0.13u
X10564 MOT9_P MOT9_N cml_tlatch_4.xmux.xp.S1 VSS sg13_lv_nmos ad=56.9f pd=0.74u as=0.1019p ps=1.34u w=0.17u l=0.17u
X10565 MOT28_P cml_tlatch_58.INN cml_tlatch_58.xmux.xn.S1 VSS sg13_lv_nmos ad=63.19999f pd=0.74u as=63.19999f ps=0.74u w=0.26u l=0.38u
X10566 cml_tlatch_6.INN cml_tlatch_6.INP cml_tlatch_94.xmux.xp.S1 VSS sg13_lv_nmos ad=56.9f pd=0.74u as=56.9f ps=0.74u w=0.17u l=0.17u
X10567 cml_drv_3.xrtail.R1 VSS VSS rppd l=5.65u w=1u
X10568 MOT19_N MOT19_P cml_tlatch_74.xmux.xp.S1 VSS sg13_lv_nmos ad=56.9f pd=0.74u as=56.9f ps=0.74u w=0.17u l=0.17u
X10569 cml_tlatch_5.xtail.S1 CKHB1_P cml_tlatch_5.xmux.xn.S1 VSS sg13_lv_nmos ad=89.3f pd=0.85u as=89.3f ps=0.85u w=0.47u l=0.16u
X10570 cml_tlatch_69.xmux.xp.S1 MOT27_P MOT27_N VSS sg13_lv_nmos ad=56.9f pd=0.74u as=56.9f ps=0.74u w=0.17u l=0.17u
X10571 cml_tlatch_43.xtail.S1 CKB2_P cml_tlatch_43.xmux.xn.S1 VSS sg13_lv_nmos ad=89.3f pd=0.85u as=0.1598p ps=1.62u w=0.47u l=0.16u
X10572 VDD cml_tlatch_56.INP VSS rppd l=5.17u w=1u
X10573 cml_tlatch_4.xmux.xn.S1 B1_8_N MOT9_P VSS sg13_lv_nmos ad=63.19999f pd=0.74u as=63.19999f ps=0.74u w=0.26u l=0.38u
X10574 VDD CKHA2_N VSS rppd l=13.09u w=1u
X10575 cml_tlatch_30.xmux.xp.S1 CKA0_N cml_tlatch_30.xtail.S1 VSS sg13_lv_nmos ad=89.3f pd=0.85u as=89.3f ps=0.85u w=0.47u l=0.16u
X10576 J2_P J2_N cml_tlatch_92.xmux.xp.S1 VSS sg13_lv_nmos ad=56.9f pd=0.74u as=56.9f ps=0.74u w=0.17u l=0.17u
X10577 cml_tlatch_65.xmux.xp.S1 cml_tlatch_65.OUTP cml_tlatch_65.OUTN VSS sg13_lv_nmos ad=56.9f pd=0.74u as=56.9f ps=0.74u w=0.17u l=0.17u
X10578 MOT25_P B3_8_N cml_tlatch_68.xmux.xn.S1 VSS sg13_lv_nmos ad=63.19999f pd=0.74u as=63.19999f ps=0.74u w=0.26u l=0.38u
X10579 cml_tlatch_42.xmux.xp.S1 cml_tlatch_56.INN cml_tlatch_56.INP VSS sg13_lv_nmos ad=56.9f pd=0.74u as=56.9f ps=0.74u w=0.17u l=0.17u
X10580 cml_tlatch_84.xmux.xn.S1 CKB3_N cml_tlatch_84.xtail.S1 VSS sg13_lv_nmos ad=89.3f pd=0.85u as=89.3f ps=0.85u w=0.47u l=0.16u
X10581 B2_8_P B2_8_N cml_tlatch_77.xmux.xp.S1 VSS sg13_lv_nmos ad=56.9f pd=0.74u as=56.9f ps=0.74u w=0.17u l=0.17u
X10582 cml_gate2_3.sg13_lv_nmos_FTPY57_0.D0 CKB1_P cml_gate2_3.xrtail.R1 VSS sg13_lv_nmos ad=0.1007p pd=0.91u as=0.1007p ps=0.91u w=0.53u l=0.13u
X10583 cml_tlatch_46.xmux.xp.S1 B3_2_N B3_2_P VSS sg13_lv_nmos ad=56.9f pd=0.74u as=56.9f ps=0.74u w=0.17u l=0.17u
X10584 cml_tlatch_13.xmux.xp.S1 stub_bi_17.BOTN stub_bi_17.BOTP VSS sg13_lv_nmos ad=56.9f pd=0.74u as=56.9f ps=0.74u w=0.17u l=0.17u
X10585 cml_tlatch_1.OUTN cml_tlatch_1.OUTP cml_tlatch_1.xmux.xp.S1 VSS sg13_lv_nmos ad=56.9f pd=0.74u as=56.9f ps=0.74u w=0.17u l=0.17u
X10586 VDD CKHB0_P VSS rppd l=13.09u w=1u
X10587 cml_tlatch_45.xtail.S1 CKB3_P cml_tlatch_45.xmux.xn.S1 VSS sg13_lv_nmos ad=89.3f pd=0.85u as=89.3f ps=0.85u w=0.47u l=0.16u
X10588 cml_tlatch_3.xmux.xp.S1 cml_tlatch_3.OUTP cml_tlatch_3.OUTN VSS sg13_lv_nmos ad=56.9f pd=0.74u as=56.9f ps=0.74u w=0.17u l=0.17u
X10589 cml_tlatch_36.xmux.xn.S1 CKA1_P cml_tlatch_36.xtail.S1 VSS sg13_lv_nmos ad=0.1598p pd=1.62u as=89.3f ps=0.85u w=0.47u l=0.16u
X10590 cml_tlatch_15.xmux.xp.S1 stub_bi_19.BOTN stub_bi_19.BOTP VSS sg13_lv_nmos ad=56.9f pd=0.74u as=56.9f ps=0.74u w=0.17u l=0.17u
X10591 cml_tlatch_23.xmux.xp.S1 cml_tlatch_39.INP cml_tlatch_39.INN VSS sg13_lv_nmos ad=56.9f pd=0.74u as=56.9f ps=0.74u w=0.17u l=0.17u
X10592 cml_tlatch_6.xmux.xp.S1 CKHB1_N cml_tlatch_6.xtail.S1 VSS sg13_lv_nmos ad=89.3f pd=0.85u as=89.3f ps=0.85u w=0.47u l=0.16u
X10593 hs_to_clk_5.D2 POLN VSS VSS sg13_lv_nmos ad=3.4p pd=20.68u as=1.9p ps=10.38u w=10u l=0.13u
X10594 cml_tlatch_48.xmux.xn.S1 D2_P stub_bi_32.BOTP VSS sg13_lv_nmos ad=63.19999f pd=0.74u as=63.19999f ps=0.74u w=0.26u l=0.38u
X10595 cml_tlatch_50.xtail.S1 CKHA2_N cml_tlatch_50.xmux.xp.S1 VSS sg13_lv_nmos ad=89.3f pd=0.85u as=89.3f ps=0.85u w=0.47u l=0.16u
X10596 MOT5_P cml_tlatch_98.OUTN cml_tlatch_19.xmux.xn.S1 VSS sg13_lv_nmos ad=63.19999f pd=0.74u as=63.19999f ps=0.74u w=0.26u l=0.38u
X10597 cml_tlatch_98.xmux.xn.S1 CKB0_N cml_tlatch_98.xtail.S1 VSS sg13_lv_nmos ad=89.3f pd=0.85u as=89.3f ps=0.85u w=0.47u l=0.16u
X10598 A1_8_N cml_tlatch_22.OUTP cml_tlatch_21.xmux.xn.S1 VSS sg13_lv_nmos ad=63.19999f pd=0.74u as=63.19999f ps=0.74u w=0.26u l=0.38u
X10599 cml_tlatch_28.xtail.S1 CKB0_P cml_tlatch_28.xmux.xp.S1 VSS sg13_lv_nmos ad=89.3f pd=0.85u as=89.3f ps=0.85u w=0.47u l=0.16u
X10600 VSS hs_to_clk_1.sg13_lv_nmos_2HGZLP_0.G VSS VSS sg13_lv_nmos ad=2.071p pd=11.28u as=0 ps=0 w=10.9u l=1.38u
X10601 cml_tlatch_25.xmux.xp.S1 MOT4_N MOT4_P VSS sg13_lv_nmos ad=56.9f pd=0.74u as=56.9f ps=0.74u w=0.17u l=0.17u
X10602 cml_tlatch_57.INP cml_tlatch_57.INN cml_tlatch_66.xmux.xp.S1 VSS sg13_lv_nmos ad=56.9f pd=0.74u as=56.9f ps=0.74u w=0.17u l=0.17u
X10603 cml_tlatch_16.OUTP cml_tlatch_16.OUTN cml_tlatch_16.xmux.xp.S1 VSS sg13_lv_nmos ad=56.9f pd=0.74u as=56.9f ps=0.74u w=0.17u l=0.17u
X10604 cml_tlatch_64.xmux.xp.S1 A3_8_N A3_8_P VSS sg13_lv_nmos ad=56.9f pd=0.74u as=56.9f ps=0.74u w=0.17u l=0.17u
X10605 VDD cml_tlatch_40.INN VSS rppd l=5.17u w=1u
X10606 cml_tlatch_39.xmux.xn.S1 CKHA1_P cml_tlatch_39.xtail.S1 VSS sg13_lv_nmos ad=89.3f pd=0.85u as=89.3f ps=0.85u w=0.47u l=0.16u
X10607 cml_tlatch_84.xmux.xn.S1 cml_tlatch_45.OUTP cml_tlatch_70.INN VSS sg13_lv_nmos ad=0.1082p pd=1.34u as=63.19999f ps=0.74u w=0.26u l=0.38u
X10608 cml_tlatch_12.xtail.S1 CKB1_N cml_tlatch_12.xmux.xn.S1 VSS sg13_lv_nmos ad=0.1598p pd=1.62u as=89.3f ps=0.85u w=0.47u l=0.16u
X10609 VSS POLN cml_tlatch_97.xtail.S1 VSS sg13_lv_nmos ad=2.7982p pd=17.14u as=1.5637p ps=8.61u w=8.23u l=0.13u
X10610 cml_tlatch_55.xmux.xp.S1 cml_tlatch_89.INP cml_tlatch_89.INN VSS sg13_lv_nmos ad=56.9f pd=0.74u as=56.9f ps=0.74u w=0.17u l=0.17u
X10611 stub_bi_42.BOTP stub_bi_42.BOTN cml_tlatch_43.xmux.xp.S1 VSS sg13_lv_nmos ad=56.9f pd=0.74u as=56.9f ps=0.74u w=0.17u l=0.17u
X10612 cml_tlatch_84.xmux.xn.S1 cml_tlatch_45.OUTP cml_tlatch_70.INN VSS sg13_lv_nmos ad=63.19999f pd=0.74u as=63.19999f ps=0.74u w=0.26u l=0.38u
X10613 J4_N J4_P cml_tlatch_90.xmux.xp.S1 VSS sg13_lv_nmos ad=56.9f pd=0.74u as=56.9f ps=0.74u w=0.17u l=0.17u
X10614 VSS POLN cml_tlatch_25.xtail.S1 VSS sg13_lv_nmos ad=2.7982p pd=17.14u as=1.5637p ps=8.61u w=8.23u l=0.13u
X10615 cml_tlatch_95.xmux.xn.S1 cml_tlatch_95.INP cml_tlatch_40.INN VSS sg13_lv_nmos ad=63.19999f pd=0.74u as=63.19999f ps=0.74u w=0.26u l=0.38u
X10616 MOT21_N MOT21_P cml_tlatch_75.xmux.xp.S1 VSS sg13_lv_nmos ad=56.9f pd=0.74u as=56.9f ps=0.74u w=0.17u l=0.17u
X10617 cml_tlatch_70.xmux.xp.S1 MOT29_P MOT29_N VSS sg13_lv_nmos ad=56.9f pd=0.74u as=56.9f ps=0.74u w=0.17u l=0.17u
X10618 cml_tlatch_63.xtail.S1 CKB3_N cml_tlatch_63.xmux.xp.S1 VSS sg13_lv_nmos ad=89.3f pd=0.85u as=89.3f ps=0.85u w=0.47u l=0.16u
X10619 GB1_N VDD VSS rppd l=7.42u w=1u
X10620 cml_tlatch_10.xmux.xp.S1 CKB0_P cml_tlatch_10.xtail.S1 VSS sg13_lv_nmos ad=89.3f pd=0.85u as=89.3f ps=0.85u w=0.47u l=0.16u
X10621 cml_tlatch_31.xmux.xp.S1 A0_2_N A0_2_P VSS sg13_lv_nmos ad=56.9f pd=0.74u as=56.9f ps=0.74u w=0.17u l=0.17u
X10622 cml_tlatch_33.xmux.xn.S1 stub_bi_31.BOTN B1_2_N VSS sg13_lv_nmos ad=63.19999f pd=0.74u as=63.19999f ps=0.74u w=0.26u l=0.38u
X10623 cml_tlatch_56.xmux.xp.S1 A2_2_P A2_2_N VSS sg13_lv_nmos ad=56.9f pd=0.74u as=56.9f ps=0.74u w=0.17u l=0.17u
X10624 cml_tlatch_12.xtail.S1 POLN VSS VSS sg13_lv_nmos ad=1.5637p pd=8.61u as=1.5637p ps=8.61u w=8.23u l=0.13u
X10625 cml_tlatch_94.xmux.xp.S1 cml_tlatch_6.INN cml_tlatch_6.INP VSS sg13_lv_nmos ad=56.9f pd=0.74u as=56.9f ps=0.74u w=0.17u l=0.17u
X10626 cml_tlatch_33.xmux.xn.S1 stub_bi_31.BOTN B1_2_N VSS sg13_lv_nmos ad=63.19999f pd=0.74u as=63.19999f ps=0.74u w=0.26u l=0.38u
X10627 cml_tlatch_27.xmux.xp.S1 cml_tlatch_27.OUTN cml_tlatch_27.OUTP VSS sg13_lv_nmos ad=56.9f pd=0.74u as=56.9f ps=0.74u w=0.17u l=0.17u
X10628 cml_tlatch_55.xtail.S1 CKA2_N cml_tlatch_55.xmux.xp.S1 VSS sg13_lv_nmos ad=89.3f pd=0.85u as=89.3f ps=0.85u w=0.47u l=0.16u
X10629 cml_tlatch_67.OUTP cml_tlatch_58.INN cml_tlatch_67.xmux.xn.S1 VSS sg13_lv_nmos ad=63.19999f pd=0.74u as=63.19999f ps=0.74u w=0.26u l=0.38u
X10630 MOT12_N cml_tlatch_40.INP cml_tlatch_40.xmux.xn.S1 VSS sg13_lv_nmos ad=63.19999f pd=0.74u as=63.19999f ps=0.74u w=0.26u l=0.38u
X10631 cml_tlatch_97.xmux.xp.S1 CKHA0_N cml_tlatch_97.xtail.S1 VSS sg13_lv_nmos ad=89.3f pd=0.85u as=89.3f ps=0.85u w=0.47u l=0.16u
X10632 cml_tlatch_37.xmux.xn.S1 cml_tlatch_38.OUTN A1_2_P VSS sg13_lv_nmos ad=63.19999f pd=0.74u as=63.19999f ps=0.74u w=0.26u l=0.38u
X10633 cml_tlatch_54.OUTN D3_P cml_tlatch_54.xmux.xn.S1 VSS sg13_lv_nmos ad=63.19999f pd=0.74u as=63.19999f ps=0.74u w=0.26u l=0.38u
X10634 cml_tlatch_20.xmux.xp.S1 MOT7_N MOT7_P VSS sg13_lv_nmos ad=56.9f pd=0.74u as=56.9f ps=0.74u w=0.17u l=0.17u
X10635 cml_tlatch_64.xmux.xp.S1 A3_8_N A3_8_P VSS sg13_lv_nmos ad=56.9f pd=0.74u as=56.9f ps=0.74u w=0.17u l=0.17u
X10636 cml_tlatch_1.xtail.S1 CKB0_N cml_tlatch_1.xmux.xp.S1 VSS sg13_lv_nmos ad=89.3f pd=0.85u as=89.3f ps=0.85u w=0.47u l=0.16u
X10637 cml_tlatch_15.xtail.S1 CKB1_N cml_tlatch_15.xmux.xp.S1 VSS sg13_lv_nmos ad=89.3f pd=0.85u as=0.1598p ps=1.62u w=0.47u l=0.16u
X10638 cml_tlatch_1.xtail.S1 CKB0_P cml_tlatch_1.xmux.xn.S1 VSS sg13_lv_nmos ad=89.3f pd=0.85u as=89.3f ps=0.85u w=0.47u l=0.16u
X10639 cml_gate2_2.sg13_lv_nmos_FTPY57_0.D0 ENA0_P GA0_N VSS sg13_lv_nmos ad=0.1802p pd=1.74u as=0.1007p ps=0.91u w=0.53u l=0.13u
X10640 cml_tlatch_71.xmux.xp.S1 CKHB3_N cml_tlatch_71.xtail.S1 VSS sg13_lv_nmos ad=89.3f pd=0.85u as=89.3f ps=0.85u w=0.47u l=0.16u
X10641 cml_tlatch_67.xmux.xn.S1 cml_tlatch_58.INP cml_tlatch_67.OUTN VSS sg13_lv_nmos ad=63.19999f pd=0.74u as=63.19999f ps=0.74u w=0.26u l=0.38u
X10642 cml_tlatch_83.INN cml_tlatch_83.INP cml_tlatch_72.xmux.xp.S1 VSS sg13_lv_nmos ad=56.9f pd=0.74u as=56.9f ps=0.74u w=0.17u l=0.17u
X10643 cml_tlatch_61.OUTN cml_tlatch_61.OUTP cml_tlatch_61.xmux.xp.S1 VSS sg13_lv_nmos ad=56.9f pd=0.74u as=56.9f ps=0.74u w=0.17u l=0.17u
X10644 VSS hs_to_clk_5.sg13_lv_nmos_2HGZLP_0.G VSS VSS sg13_lv_nmos ad=2.071p pd=11.28u as=0 ps=0 w=10.9u l=1.38u
X10645 cml_tlatch_43.xtail.S1 CKB2_N cml_tlatch_43.xmux.xp.S1 VSS sg13_lv_nmos ad=89.3f pd=0.85u as=89.3f ps=0.85u w=0.47u l=0.16u
X10646 cml_tlatch_2.xmux.xp.S1 A0_8_P A0_8_N VSS sg13_lv_nmos ad=56.9f pd=0.74u as=56.9f ps=0.74u w=0.17u l=0.17u
X10647 cml_tlatch_38.xtail.S1 CKA1_P cml_tlatch_38.xmux.xn.S1 VSS sg13_lv_nmos ad=89.3f pd=0.85u as=89.3f ps=0.85u w=0.47u l=0.16u
X10648 cml_tlatch_52.xtail.S1 CKA3_N cml_tlatch_52.xmux.xp.S1 VSS sg13_lv_nmos ad=89.3f pd=0.85u as=89.3f ps=0.85u w=0.47u l=0.16u
X10649 MOT17_N MOT17_P cml_tlatch_73.xmux.xp.S1 VSS sg13_lv_nmos ad=56.9f pd=0.74u as=56.9f ps=0.74u w=0.17u l=0.17u
X10650 cml_tlatch_79.xmux.xp.S1 CKB2_P cml_tlatch_79.xtail.S1 VSS sg13_lv_nmos ad=89.3f pd=0.85u as=89.3f ps=0.85u w=0.47u l=0.16u
X10651 MOT30_P A3_2_N cml_tlatch_59.xmux.xn.S1 VSS sg13_lv_nmos ad=63.19999f pd=0.74u as=63.19999f ps=0.74u w=0.26u l=0.38u
X10652 cml_tlatch_13.xmux.xp.S1 stub_bi_17.BOTN stub_bi_17.BOTP VSS sg13_lv_nmos ad=56.9f pd=0.74u as=56.9f ps=0.74u w=0.17u l=0.17u
X10653 cml_tlatch_33.xtail.S1 CKB1_N cml_tlatch_33.xmux.xn.S1 VSS sg13_lv_nmos ad=0.1598p pd=1.62u as=89.3f ps=0.85u w=0.47u l=0.16u
X10654 cml_tlatch_63.OUTP cml_tlatch_63.OUTN cml_tlatch_63.xmux.xp.S1 VSS sg13_lv_nmos ad=56.9f pd=0.74u as=56.9f ps=0.74u w=0.17u l=0.17u
X10655 cml_tlatch_48.xmux.xn.S1 D2_N stub_bi_32.BOTN VSS sg13_lv_nmos ad=63.19999f pd=0.74u as=63.19999f ps=0.74u w=0.26u l=0.38u
X10656 cml_tlatch_1.OUTN cml_tlatch_1.OUTP cml_tlatch_1.xmux.xp.S1 VSS sg13_lv_nmos ad=56.9f pd=0.74u as=56.9f ps=0.74u w=0.17u l=0.17u
X10657 cml_tlatch_20.xmux.xn.S1 B0_2_P MOT7_N VSS sg13_lv_nmos ad=63.19999f pd=0.74u as=63.19999f ps=0.74u w=0.26u l=0.38u
X10658 cml_tlatch_65.xmux.xp.S1 cml_tlatch_65.OUTN cml_tlatch_65.OUTP VSS sg13_lv_nmos ad=0.1019p pd=1.34u as=56.9f ps=0.74u w=0.17u l=0.17u
X10659 MOT6_P MOT6_N cml_tlatch_26.xmux.xp.S1 VSS sg13_lv_nmos ad=56.9f pd=0.74u as=56.9f ps=0.74u w=0.17u l=0.17u
X10660 MOT0_N MOT0_P cml_tlatch_97.xmux.xp.S1 VSS sg13_lv_nmos ad=56.9f pd=0.74u as=56.9f ps=0.74u w=0.17u l=0.17u
X10661 MOT7_N MOT7_P cml_tlatch_20.xmux.xp.S1 VSS sg13_lv_nmos ad=56.9f pd=0.74u as=56.9f ps=0.74u w=0.17u l=0.17u
X10662 GA2_P ENA1_N cml_gate2_4.sg13_lv_nmos_FTPY57_0.D0 VSS sg13_lv_nmos ad=0.1007p pd=0.91u as=0.1007p ps=0.91u w=0.53u l=0.13u
X10663 MOT3_N cml_tlatch_16.OUTP cml_tlatch_18.xmux.xn.S1 VSS sg13_lv_nmos ad=63.19999f pd=0.74u as=63.19999f ps=0.74u w=0.26u l=0.38u
X10664 MOT11_N VDD VSS rppd l=5.17u w=1u
X10665 GA1_P CKB1_N cml_gate2_3.xrtail.R1 VSS sg13_lv_nmos ad=0.1007p pd=0.91u as=0.1007p ps=0.91u w=0.53u l=0.13u
X10666 cml_tlatch_25.xmux.xp.S1 MOT4_N MOT4_P VSS sg13_lv_nmos ad=56.9f pd=0.74u as=56.9f ps=0.74u w=0.17u l=0.17u
X10667 cml_tlatch_59.xtail.S1 POLN VSS VSS sg13_lv_nmos ad=1.5637p pd=8.61u as=2.7982p ps=17.14u w=8.23u l=0.13u
X10668 cml_tlatch_90.xmux.xp.S1 J4_N J4_P VSS sg13_lv_nmos ad=56.9f pd=0.74u as=56.9f ps=0.74u w=0.17u l=0.17u
X10669 cml_tlatch_70.INP cml_tlatch_70.INN cml_tlatch_84.xmux.xp.S1 VSS sg13_lv_nmos ad=56.9f pd=0.74u as=56.9f ps=0.74u w=0.17u l=0.17u
X10670 cml_drvb_8.xrtail.R1 J4_N NS1_N VSS sg13_lv_nmos ad=0.1463p pd=1.15u as=0.2618p ps=2.22u w=0.77u l=0.21u
X10671 cml_tlatch_52.OUTP A3_2_N cml_tlatch_52.xmux.xn.S1 VSS sg13_lv_nmos ad=0.1082p pd=1.34u as=63.19999f ps=0.74u w=0.26u l=0.38u
X10672 cml_gate2_6.sg13_lv_nmos_FTPY57_0.D0 ENB0_P GB3_N VSS sg13_lv_nmos ad=0.1007p pd=0.91u as=0.1007p ps=0.91u w=0.53u l=0.13u
X10673 MOT18_N MOT18_P cml_tlatch_49.xmux.xp.S1 VSS sg13_lv_nmos ad=56.9f pd=0.74u as=56.9f ps=0.74u w=0.17u l=0.17u
X10674 cml_tlatch_84.xtail.S1 CKB3_N cml_tlatch_84.xmux.xn.S1 VSS sg13_lv_nmos ad=89.3f pd=0.85u as=89.3f ps=0.85u w=0.47u l=0.16u
X10675 cml_tlatch_30.OUTN cml_tlatch_30.OUTP cml_tlatch_30.xmux.xp.S1 VSS sg13_lv_nmos ad=56.9f pd=0.74u as=56.9f ps=0.74u w=0.17u l=0.17u
X10676 cml_tlatch_12.xmux.xp.S1 B1_8_N B1_8_P VSS sg13_lv_nmos ad=56.9f pd=0.74u as=56.9f ps=0.74u w=0.17u l=0.17u
X10677 cml_gate2_5.xrtail.R1 CKB3_P cml_gate2_5.sg13_lv_nmos_FTPY57_0.D0 VSS sg13_lv_nmos ad=0.1007p pd=0.91u as=0.1007p ps=0.91u w=0.53u l=0.13u
X10678 cml_tlatch_8.OUTN cml_tlatch_9.OUTP cml_tlatch_8.xmux.xn.S1 VSS sg13_lv_nmos ad=63.19999f pd=0.74u as=63.19999f ps=0.74u w=0.26u l=0.38u
X10679 VSS POLN cml_tlatch_93.xtail.S1 VSS sg13_lv_nmos ad=2.7982p pd=17.14u as=1.5637p ps=8.61u w=8.23u l=0.13u
X10680 cml_tlatch_70.xmux.xp.S1 MOT29_P MOT29_N VSS sg13_lv_nmos ad=56.9f pd=0.74u as=56.9f ps=0.74u w=0.17u l=0.17u
X10681 cml_tlatch_42.xmux.xp.S1 CKA2_N cml_tlatch_42.xtail.S1 VSS sg13_lv_nmos ad=89.3f pd=0.85u as=89.3f ps=0.85u w=0.47u l=0.16u
X10682 cml_tlatch_61.xmux.xp.S1 cml_tlatch_61.OUTN cml_tlatch_61.OUTP VSS sg13_lv_nmos ad=56.9f pd=0.74u as=56.9f ps=0.74u w=0.17u l=0.17u
X10683 cml_tlatch_69.xtail.S1 CKHB3_N cml_tlatch_69.xmux.xp.S1 VSS sg13_lv_nmos ad=89.3f pd=0.85u as=0.1598p ps=1.62u w=0.47u l=0.16u
X10684 cml_tlatch_73.xtail.S1 CKHB2_N cml_tlatch_73.xmux.xp.S1 VSS sg13_lv_nmos ad=89.3f pd=0.85u as=89.3f ps=0.85u w=0.47u l=0.16u
X10685 cml_tlatch_11.xmux.xp.S1 cml_tlatch_11.OUTP cml_tlatch_11.OUTN VSS sg13_lv_nmos ad=56.9f pd=0.74u as=56.9f ps=0.74u w=0.17u l=0.17u
X10686 cml_tlatch_29.xmux.xn.S1 D0_N cml_tlatch_29.OUTP VSS sg13_lv_nmos ad=0.1082p pd=1.34u as=63.19999f ps=0.74u w=0.26u l=0.38u
.ends sr16_rx4
