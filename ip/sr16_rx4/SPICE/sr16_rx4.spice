* NGSPICE file created from flatpost.ext - technology: ihp-sg13g2

.subckt sr16_rx4 VSS VDD CK_N CK_P D0_N D0_P D1_N D1_P D2_N D2_P D3_N D3_P POLN MOT0_N
+ MOT0_P MOT1_N MOT1_P MOT2_N MOT2_P MOT3_N MOT3_P MOT4_N MOT4_P MOT5_N MOT5_P MOT6_N
+ MOT6_P MOT7_N MOT7_P MOT8_N MOT8_P MOT9_N MOT9_P MOT10_N MOT10_P MOT11_N MOT11_P
+ MOT12_N MOT12_P MOT13_N MOT13_P MOT14_N MOT14_P MOT15_N MOT15_P MOT16_N MOT16_P
+ MOT17_N MOT17_P MOT18_N MOT18_P MOT19_N MOT19_P MOT20_N MOT20_P MOT21_N MOT21_P
+ MOT22_N MOT22_P MOT23_N MOT23_P MOT24_N MOT24_P MOT25_N MOT25_P MOT26_N MOT26_P
+ MOT27_N MOT27_P MOT28_N MOT28_P MOT29_N MOT29_P MOT30_N MOT30_P MOT31_N MOT31_P
+ CLK_W_N CLK_W_P
X0 cml_tlatch_91.xmux.xp.S1 cml_tlatch_91.OUTP cml_tlatch_91.OUTN VSS sg13_lv_nmos ad=56.9f pd=0.74u as=56.9f ps=0.74u w=0.17u l=0.17u
X1 cml_tlatch_56.xmux.xn.S1 A3_2_P cml_tlatch_56.OUTN VSS sg13_lv_nmos ad=63.19999f pd=0.74u as=63.19999f ps=0.74u w=0.26u l=0.38u
X2 A0_2_N A0_2_P cml_tlatch_34.xmux.xp.S1 VSS sg13_lv_nmos ad=56.9f pd=0.74u as=56.9f ps=0.74u w=0.17u l=0.17u
X3 ENA0_P ENA_N cml_drv_3.xrtail.R1 VSS sg13_lv_nmos ad=56.2f pd=0.74u as=56.2f ps=0.74u w=0.16u l=0.19u
X4 MOT16_P MOT16_N cml_tlatch_52.xmux.xp.S1 VSS sg13_lv_nmos ad=56.9f pd=0.74u as=56.9f ps=0.74u w=0.17u l=0.17u
X5 cml_tlatch_32.xmux.xn.S1 CKB0_P cml_tlatch_32.xtail.S1 VSS sg13_lv_nmos ad=89.3f pd=0.85u as=89.3f ps=0.85u w=0.47u l=0.16u
X6 cml_tlatch_62.xmux.xp.S1 MOT24_N MOT24_P VSS sg13_lv_nmos ad=56.9f pd=0.74u as=56.9f ps=0.74u w=0.17u l=0.17u
X7 cml_tlatch_80.xmux.xp.S1 MOT23_P MOT23_N VSS sg13_lv_nmos ad=56.9f pd=0.74u as=56.9f ps=0.74u w=0.17u l=0.17u
X8 cml_tlatch_22.xtail.S1 CKA1_P cml_tlatch_22.xmux.xn.S1 VSS sg13_lv_nmos ad=89.3f pd=0.85u as=89.3f ps=0.85u w=0.47u l=0.16u
X9 hs_to_clk_8.D2 CK_P CKJ_P VSS sg13_lv_nmos ad=0.228p pd=1.58u as=0.228p ps=1.58u w=1.2u l=0.2u
X10 cml_tlatch_42.xmux.xn.S1 A1_8_P MOT8_N VSS sg13_lv_nmos ad=63.19999f pd=0.74u as=63.19999f ps=0.74u w=0.26u l=0.38u
X11 cml_gate2_7.xrtail.R1 CKA2_P cml_gate2_7.xamp.xn.S1 VSS sg13_lv_nmos ad=0.1007p pd=0.91u as=0.1802p ps=1.74u w=0.53u l=0.13u
X12 cml_tlatch_14.xmux.xp.S1 MOT1_P MOT1_N VSS sg13_lv_nmos ad=56.9f pd=0.74u as=56.9f ps=0.74u w=0.17u l=0.17u
X13 ENA0_N ENA_P cml_drv_3.xrtail.R1 VSS sg13_lv_nmos ad=56.2f pd=0.74u as=56.2f ps=0.74u w=0.16u l=0.19u
X14 VSS POLN cml_tlatch_69.xtail.S1 VSS sg13_lv_nmos ad=1.5637p pd=8.61u as=1.5637p ps=8.61u w=8.23u l=0.13u
X15 cml_tlatch_87.xmux.xp.S1 cml_tlatch_87.OUTP cml_tlatch_87.OUTN VSS sg13_lv_nmos ad=56.9f pd=0.74u as=56.9f ps=0.74u w=0.17u l=0.17u
X16 stub_bi_63.BOTN stub_bi_63.BOTP cml_tlatch_83.xmux.xp.S1 VSS sg13_lv_nmos ad=56.9f pd=0.74u as=56.9f ps=0.74u w=0.17u l=0.17u
X17 B2_8_P VDD VSS rppd l=5.17u w=1u
X18 cml_tlatch_7.xtail.S1 CKB0_P cml_tlatch_7.xmux.xp.S1 VSS sg13_lv_nmos ad=0.1598p pd=1.62u as=89.3f ps=0.85u w=0.47u l=0.16u
X19 cml_tlatch_79.xmux.xp.S1 MOT21_N MOT21_P VSS sg13_lv_nmos ad=56.9f pd=0.74u as=56.9f ps=0.74u w=0.17u l=0.17u
X20 cml_tlatch_48.xmux.xp.S1 CKB2_N cml_tlatch_48.xtail.S1 VSS sg13_lv_nmos ad=89.3f pd=0.85u as=89.3f ps=0.85u w=0.47u l=0.16u
X21 ENB0_P ENB_N cml_drv_2.xrtail.R1 VSS sg13_lv_nmos ad=56.2f pd=0.74u as=56.2f ps=0.74u w=0.16u l=0.19u
X22 cml_tlatch_58.xmux.xp.S1 cml_tlatch_58.OUTN cml_tlatch_58.OUTP VSS sg13_lv_nmos ad=0.1019p pd=1.34u as=56.9f ps=0.74u w=0.17u l=0.17u
X23 cml_tlatch_58.xmux.xp.S1 CKA3_N cml_tlatch_58.xtail.S1 VSS sg13_lv_nmos ad=89.3f pd=0.85u as=89.3f ps=0.85u w=0.47u l=0.16u
X24 B1_8_P stub_bi_15.BOTP cml_tlatch_10.xmux.xn.S1 VSS sg13_lv_nmos ad=63.19999f pd=0.74u as=63.19999f ps=0.74u w=0.26u l=0.38u
X25 cml_tlatch_14.xmux.xp.S1 CKHB0_N cml_tlatch_14.xtail.S1 VSS sg13_lv_nmos ad=89.3f pd=0.85u as=89.3f ps=0.85u w=0.47u l=0.16u
X26 cml_tlatch_24.xmux.xp.S1 MOT12_N MOT12_P VSS sg13_lv_nmos ad=56.9f pd=0.74u as=56.9f ps=0.74u w=0.17u l=0.17u
X27 cml_tlatch_13.xtail.S1 CKB1_P cml_tlatch_13.xmux.xn.S1 VSS sg13_lv_nmos ad=89.3f pd=0.85u as=89.3f ps=0.85u w=0.47u l=0.16u
X28 hs_to_clk_2.D2 CK_P CKB1_N VSS sg13_lv_nmos ad=0.228p pd=1.58u as=0.408p ps=3.08u w=1.2u l=0.2u
X29 cml_tlatch_84.xmux.xp.S1 stub_bi_49.BOTN stub_bi_49.BOTP VSS sg13_lv_nmos ad=0.1019p pd=1.34u as=56.9f ps=0.74u w=0.17u l=0.17u
X30 cml_tlatch_33.xmux.xp.S1 CKA0_N cml_tlatch_33.xtail.S1 VSS sg13_lv_nmos ad=89.3f pd=0.85u as=89.3f ps=0.85u w=0.47u l=0.16u
X31 VDD J4_N VSS rppd l=5.17u w=1u
X32 B2_2_P B2_2_N cml_tlatch_47.xmux.xp.S1 VSS sg13_lv_nmos ad=56.9f pd=0.74u as=56.9f ps=0.74u w=0.17u l=0.17u
X33 cml_tlatch_90.xmux.xp.S1 stub_bi_55.BOTP stub_bi_55.BOTN VSS sg13_lv_nmos ad=56.9f pd=0.74u as=56.9f ps=0.74u w=0.17u l=0.17u
X34 cml_tlatch_0.xmux.xp.S1 cml_tlatch_0.OUTN cml_tlatch_0.OUTP VSS sg13_lv_nmos ad=56.9f pd=0.74u as=56.9f ps=0.74u w=0.17u l=0.17u
X35 MOT7_N MOT7_P cml_tlatch_17.xmux.xp.S1 VSS sg13_lv_nmos ad=56.9f pd=0.74u as=56.9f ps=0.74u w=0.17u l=0.17u
X36 VSS POLN cml_tlatch_75.xtail.S1 VSS sg13_lv_nmos ad=1.5637p pd=8.61u as=1.5637p ps=8.61u w=8.23u l=0.13u
X37 GA3_P ENA1_N cml_gate2_4.xamp.xn.S1 VSS sg13_lv_nmos ad=0.1007p pd=0.91u as=0.1007p ps=0.91u w=0.53u l=0.13u
X38 cml_tlatch_96.xmux.xn.S1 stub_bi_29.BOTP cml_tlatch_5.INP VSS sg13_lv_nmos ad=63.19999f pd=0.74u as=63.19999f ps=0.74u w=0.26u l=0.38u
X39 cml_tlatch_1.xtail.S1 CKB0_P cml_tlatch_1.xmux.xp.S1 VSS sg13_lv_nmos ad=89.3f pd=0.85u as=0.1598p ps=1.62u w=0.47u l=0.16u
X40 cml_tlatch_53.xmux.xn.S1 CKHA2_P cml_tlatch_53.xtail.S1 VSS sg13_lv_nmos ad=89.3f pd=0.85u as=0.1598p ps=1.62u w=0.47u l=0.16u
X41 VDD MOT3_P VSS rppd l=5.17u w=1u
X42 A1_2_N A1_2_P cml_tlatch_40.xmux.xp.S1 VSS sg13_lv_nmos ad=56.9f pd=0.74u as=56.9f ps=0.74u w=0.17u l=0.17u
X43 cml_tlatch_96.xmux.xn.S1 stub_bi_29.BOTP cml_tlatch_5.INP VSS sg13_lv_nmos ad=63.19999f pd=0.74u as=63.19999f ps=0.74u w=0.26u l=0.38u
X44 VSS hs_to_clk_2.sg13_lv_nmos_2HGZLP_0.G VSS VSS sg13_lv_nmos ad=2.071p pd=11.28u as=5.04403n ps=0.0239 w=10.9u l=1.38u
X45 MOT28_N cml_tlatch_44.INP cml_tlatch_44.xmux.xn.S1 VSS sg13_lv_nmos ad=63.19999f pd=0.74u as=63.19999f ps=0.74u w=0.26u l=0.38u
X46 cml_tlatch_42.xtail.S1 CKHA1_P cml_tlatch_42.xmux.xn.S1 VSS sg13_lv_nmos ad=89.3f pd=0.85u as=89.3f ps=0.85u w=0.47u l=0.16u
X47 cml_tlatch_44.xmux.xp.S1 MOT28_N MOT28_P VSS sg13_lv_nmos ad=56.9f pd=0.74u as=56.9f ps=0.74u w=0.17u l=0.17u
X48 cml_tlatch_56.xmux.xp.S1 cml_tlatch_56.OUTP cml_tlatch_56.OUTN VSS sg13_lv_nmos ad=56.9f pd=0.74u as=56.9f ps=0.74u w=0.17u l=0.17u
X49 cml_tlatch_73.xmux.xn.S1 cml_tlatch_73.INP MOT27_N VSS sg13_lv_nmos ad=63.19999f pd=0.74u as=63.19999f ps=0.74u w=0.26u l=0.38u
X50 cml_tlatch_39.xtail.S1 CKA1_P cml_tlatch_39.xmux.xn.S1 VSS sg13_lv_nmos ad=89.3f pd=0.85u as=89.3f ps=0.85u w=0.47u l=0.16u
X51 cml_tlatch_77.xmux.xp.S1 MOT17_N MOT17_P VSS sg13_lv_nmos ad=56.9f pd=0.74u as=56.9f ps=0.74u w=0.17u l=0.17u
X52 A2_8_P A2_8_N cml_tlatch_85.xmux.xp.S1 VSS sg13_lv_nmos ad=56.9f pd=0.74u as=56.9f ps=0.74u w=0.17u l=0.17u
X53 cml_tlatch_51.xmux.xp.S1 cml_tlatch_51.OUTN cml_tlatch_51.OUTP VSS sg13_lv_nmos ad=56.9f pd=0.74u as=56.9f ps=0.74u w=0.17u l=0.17u
X54 cml_tlatch_24.INN cml_tlatch_24.INP cml_tlatch_97.xmux.xp.S1 VSS sg13_lv_nmos ad=56.9f pd=0.74u as=56.9f ps=0.74u w=0.17u l=0.17u
X55 cml_tlatch_63.xmux.xn.S1 CKHA3_P cml_tlatch_63.xtail.S1 VSS sg13_lv_nmos ad=89.3f pd=0.85u as=89.3f ps=0.85u w=0.47u l=0.16u
X56 cml_tlatch_32.xmux.xp.S1 CKB0_N cml_tlatch_32.xtail.S1 VSS sg13_lv_nmos ad=89.3f pd=0.85u as=89.3f ps=0.85u w=0.47u l=0.16u
X57 cml_tlatch_31.xtail.S1 CKB0_P cml_tlatch_31.xmux.xp.S1 VSS sg13_lv_nmos ad=89.3f pd=0.85u as=89.3f ps=0.85u w=0.47u l=0.16u
X58 MOT1_N B0_8_P cml_tlatch_14.xmux.xn.S1 VSS sg13_lv_nmos ad=63.19999f pd=0.74u as=0.1082p ps=1.34u w=0.26u l=0.38u
X59 cml_tlatch_58.OUTN cml_tlatch_58.OUTP cml_tlatch_58.xmux.xp.S1 VSS sg13_lv_nmos ad=56.9f pd=0.74u as=56.9f ps=0.74u w=0.17u l=0.17u
X60 cml_tlatch_81.xmux.xn.S1 stub_bi_62.BOTN B2_8_N VSS sg13_lv_nmos ad=63.19999f pd=0.74u as=0.1082p ps=1.34u w=0.26u l=0.38u
X61 cml_tlatch_28.xmux.xp.S1 MOT4_P MOT4_N VSS sg13_lv_nmos ad=56.9f pd=0.74u as=56.9f ps=0.74u w=0.17u l=0.17u
X62 cml_tlatch_79.xtail.S1 CKHB2_P cml_tlatch_79.xmux.xn.S1 VSS sg13_lv_nmos ad=89.3f pd=0.85u as=89.3f ps=0.85u w=0.47u l=0.16u
X63 cml_tlatch_3.xmux.xp.S1 MOT9_N MOT9_P VSS sg13_lv_nmos ad=56.9f pd=0.74u as=56.9f ps=0.74u w=0.17u l=0.17u
X64 cml_tlatch_76.xmux.xn.S1 CKA2_P cml_tlatch_76.xtail.S1 VSS sg13_lv_nmos ad=89.3f pd=0.85u as=89.3f ps=0.85u w=0.47u l=0.16u
X65 cml_tlatch_10.xtail.S1 CKB1_N cml_tlatch_10.xmux.xn.S1 VSS sg13_lv_nmos ad=89.3f pd=0.85u as=89.3f ps=0.85u w=0.47u l=0.16u
X66 cml_tlatch_31.xmux.xp.S1 B0_2_P B0_2_N VSS sg13_lv_nmos ad=56.9f pd=0.74u as=56.9f ps=0.74u w=0.17u l=0.17u
X67 B2_2_P VDD VSS rppd l=5.17u w=1u
X68 cml_tlatch_33.OUTN cml_tlatch_33.OUTP cml_tlatch_33.xmux.xp.S1 VSS sg13_lv_nmos ad=56.9f pd=0.74u as=56.9f ps=0.74u w=0.17u l=0.17u
X69 MOT15_N MOT15_P cml_tlatch_6.xmux.xp.S1 VSS sg13_lv_nmos ad=56.9f pd=0.74u as=0.1019p ps=1.34u w=0.17u l=0.17u
X70 cml_tlatch_83.xtail.S1 CKB2_P cml_tlatch_83.xmux.xp.S1 VSS sg13_lv_nmos ad=89.3f pd=0.85u as=89.3f ps=0.85u w=0.47u l=0.16u
X71 cml_tlatch_4.INP stub_bi_17.BOTP cml_tlatch_12.xmux.xn.S1 VSS sg13_lv_nmos ad=63.19999f pd=0.74u as=63.19999f ps=0.74u w=0.26u l=0.38u
X72 cml_tlatch_90.xmux.xp.S1 stub_bi_55.BOTP stub_bi_55.BOTN VSS sg13_lv_nmos ad=56.9f pd=0.74u as=56.9f ps=0.74u w=0.17u l=0.17u
X73 cml_tlatch_81.xmux.xp.S1 B2_8_P B2_8_N VSS sg13_lv_nmos ad=56.9f pd=0.74u as=56.9f ps=0.74u w=0.17u l=0.17u
X74 A1_8_N A1_8_P cml_tlatch_19.xmux.xp.S1 VSS sg13_lv_nmos ad=56.9f pd=0.74u as=56.9f ps=0.74u w=0.17u l=0.17u
X75 CLK_W_N J2_N cml_tlatch_93.xmux.xn.S1 VSS sg13_lv_nmos ad=0.1082p pd=1.34u as=63.19999f ps=0.74u w=0.26u l=0.38u
X76 cml_tlatch_53.xtail.S1 CKHA2_N cml_tlatch_53.xmux.xp.S1 VSS sg13_lv_nmos ad=89.3f pd=0.85u as=89.3f ps=0.85u w=0.47u l=0.16u
X77 cml_tlatch_28.xmux.xp.S1 CKHA0_N cml_tlatch_28.xtail.S1 VSS sg13_lv_nmos ad=89.3f pd=0.85u as=89.3f ps=0.85u w=0.47u l=0.16u
X78 cml_tlatch_64.xmux.xp.S1 CKB3_P cml_tlatch_64.xtail.S1 VSS sg13_lv_nmos ad=89.3f pd=0.85u as=89.3f ps=0.85u w=0.47u l=0.16u
X79 cml_tlatch_3.xmux.xn.S1 B1_8_P MOT9_N VSS sg13_lv_nmos ad=0.1082p pd=1.34u as=63.19999f ps=0.74u w=0.26u l=0.38u
X80 MOT19_P MOT19_N cml_tlatch_78.xmux.xp.S1 VSS sg13_lv_nmos ad=56.9f pd=0.74u as=56.9f ps=0.74u w=0.17u l=0.17u
X81 cml_tlatch_62.xmux.xp.S1 MOT24_N MOT24_P VSS sg13_lv_nmos ad=56.9f pd=0.74u as=56.9f ps=0.74u w=0.17u l=0.17u
X82 cml_tlatch_73.xmux.xp.S1 MOT27_N MOT27_P VSS sg13_lv_nmos ad=56.9f pd=0.74u as=56.9f ps=0.74u w=0.17u l=0.17u
X83 MOT15_P MOT15_N cml_tlatch_6.xmux.xp.S1 VSS sg13_lv_nmos ad=56.9f pd=0.74u as=56.9f ps=0.74u w=0.17u l=0.17u
X84 cml_tlatch_41.xmux.xp.S1 cml_tlatch_41.OUTP cml_tlatch_41.OUTN VSS sg13_lv_nmos ad=56.9f pd=0.74u as=56.9f ps=0.74u w=0.17u l=0.17u
X85 cml_tlatch_11.xmux.xn.S1 cml_tlatch_4.INN stub_bi_15.BOTN VSS sg13_lv_nmos ad=0.1082p pd=1.34u as=63.19999f ps=0.74u w=0.26u l=0.38u
X86 cml_tlatch_91.xmux.xn.S1 cml_tlatch_91.INP cml_tlatch_91.OUTN VSS sg13_lv_nmos ad=63.19999f pd=0.74u as=63.19999f ps=0.74u w=0.26u l=0.38u
X87 MOT29_P MOT29_N cml_tlatch_74.xmux.xp.S1 VSS sg13_lv_nmos ad=56.9f pd=0.74u as=56.9f ps=0.74u w=0.17u l=0.17u
X88 MOT8_P MOT8_N cml_tlatch_42.xmux.xp.S1 VSS sg13_lv_nmos ad=56.9f pd=0.74u as=56.9f ps=0.74u w=0.17u l=0.17u
X89 cml_tlatch_97.INP cml_tlatch_97.INN cml_tlatch_39.xmux.xp.S1 VSS sg13_lv_nmos ad=56.9f pd=0.74u as=56.9f ps=0.74u w=0.17u l=0.17u
X90 cml_tlatch_90.xmux.xp.S1 CKB2_P cml_tlatch_90.xtail.S1 VSS sg13_lv_nmos ad=89.3f pd=0.85u as=89.3f ps=0.85u w=0.47u l=0.16u
X91 cml_tlatch_46.xmux.xp.S1 stub_bi_38.BOTP stub_bi_38.BOTN VSS sg13_lv_nmos ad=56.9f pd=0.74u as=56.9f ps=0.74u w=0.17u l=0.17u
X92 VSS POLN cml_tlatch_72.xtail.S1 VSS sg13_lv_nmos ad=1.5637p pd=8.61u as=1.5637p ps=8.61u w=8.23u l=0.13u
X93 cml_tlatch_89.xmux.xp.S1 CKA3_P cml_tlatch_89.xtail.S1 VSS sg13_lv_nmos ad=89.3f pd=0.85u as=89.3f ps=0.85u w=0.47u l=0.16u
X94 cml_tlatch_82.xmux.xp.S1 stub_bi_62.BOTN stub_bi_62.BOTP VSS sg13_lv_nmos ad=56.9f pd=0.74u as=56.9f ps=0.74u w=0.17u l=0.17u
X95 cml_tlatch_23.OUTP cml_tlatch_0.OUTN cml_tlatch_23.xmux.xn.S1 VSS sg13_lv_nmos ad=0.1082p pd=1.34u as=63.19999f ps=0.74u w=0.26u l=0.38u
X96 cml_tlatch_71.xmux.xp.S1 cml_tlatch_71.OUTN cml_tlatch_71.OUTP VSS sg13_lv_nmos ad=56.9f pd=0.74u as=56.9f ps=0.74u w=0.17u l=0.17u
X97 B2_2_P stub_bi_43.BOTP cml_tlatch_47.xmux.xn.S1 VSS sg13_lv_nmos ad=63.19999f pd=0.74u as=63.19999f ps=0.74u w=0.26u l=0.38u
X98 cml_tlatch_80.xtail.S1 CKHB2_N cml_tlatch_80.xmux.xp.S1 VSS sg13_lv_nmos ad=89.3f pd=0.85u as=89.3f ps=0.85u w=0.47u l=0.16u
X99 cml_tlatch_68.xtail.S1 CKA3_N cml_tlatch_68.xmux.xn.S1 VSS sg13_lv_nmos ad=89.3f pd=0.85u as=89.3f ps=0.85u w=0.47u l=0.16u
X100 MOT17_P B2_8_N cml_tlatch_77.xmux.xn.S1 VSS sg13_lv_nmos ad=63.19999f pd=0.74u as=0.1082p ps=1.34u w=0.26u l=0.38u
X101 cml_tlatch_50.xmux.xp.S1 B3_2_P B3_2_N VSS sg13_lv_nmos ad=56.9f pd=0.74u as=56.9f ps=0.74u w=0.17u l=0.17u
X102 cml_tlatch_89.xmux.xp.S1 cml_tlatch_44.INP cml_tlatch_44.INN VSS sg13_lv_nmos ad=56.9f pd=0.74u as=56.9f ps=0.74u w=0.17u l=0.17u
X103 cml_tlatch_8.xtail.S1 CKB0_P cml_tlatch_8.xmux.xn.S1 VSS sg13_lv_nmos ad=89.3f pd=0.85u as=89.3f ps=0.85u w=0.47u l=0.16u
X104 cml_tlatch_38.xmux.xp.S1 cml_tlatch_38.OUTN cml_tlatch_38.OUTP VSS sg13_lv_nmos ad=56.9f pd=0.74u as=56.9f ps=0.74u w=0.17u l=0.17u
X105 cml_tlatch_23.OUTP cml_tlatch_0.OUTN cml_tlatch_23.xmux.xn.S1 VSS sg13_lv_nmos ad=63.19999f pd=0.74u as=63.19999f ps=0.74u w=0.26u l=0.38u
X106 cml_tlatch_45.xtail.S1 CKHA3_N cml_tlatch_45.xmux.xp.S1 VSS sg13_lv_nmos ad=89.3f pd=0.85u as=89.3f ps=0.85u w=0.47u l=0.16u
X107 MOT31_P MOT31_N cml_tlatch_75.xmux.xp.S1 VSS sg13_lv_nmos ad=56.9f pd=0.74u as=56.9f ps=0.74u w=0.17u l=0.17u
X108 cml_tlatch_23.xtail.S1 CKA0_N cml_tlatch_23.xmux.xn.S1 VSS sg13_lv_nmos ad=89.3f pd=0.85u as=89.3f ps=0.85u w=0.47u l=0.16u
X109 MOT5_N MOT5_P cml_tlatch_16.xmux.xp.S1 VSS sg13_lv_nmos ad=56.9f pd=0.74u as=56.9f ps=0.74u w=0.17u l=0.17u
X110 cml_gate2_3.xamp.xn.S1 CKB0_P cml_gate2_3.xrtail.R1 VSS sg13_lv_nmos ad=0.1007p pd=0.91u as=0.1007p ps=0.91u w=0.53u l=0.13u
X111 ENA_P NM1_N cml_gate2_9.xrtail.R1 VSS sg13_lv_nmos ad=0.1007p pd=0.91u as=0.1007p ps=0.91u w=0.53u l=0.13u
X112 MOT20_N MOT20_P cml_tlatch_54.xmux.xp.S1 VSS sg13_lv_nmos ad=56.9f pd=0.74u as=0.1019p ps=1.34u w=0.17u l=0.17u
X113 cml_tlatch_96.xmux.xp.S1 cml_tlatch_5.INP cml_tlatch_5.INN VSS sg13_lv_nmos ad=56.9f pd=0.74u as=56.9f ps=0.74u w=0.17u l=0.17u
X114 cml_tlatch_47.xmux.xp.S1 CKB2_P cml_tlatch_47.xtail.S1 VSS sg13_lv_nmos ad=89.3f pd=0.85u as=89.3f ps=0.85u w=0.47u l=0.16u
X115 cml_tlatch_36.xtail.S1 CKB1_N cml_tlatch_36.xmux.xn.S1 VSS sg13_lv_nmos ad=89.3f pd=0.85u as=89.3f ps=0.85u w=0.47u l=0.16u
X116 VSS POLN cml_tlatch_85.xtail.S1 VSS sg13_lv_nmos ad=2.7982p pd=17.14u as=1.5637p ps=8.61u w=8.23u l=0.13u
X117 cml_tlatch_69.OUTN cml_tlatch_69.OUTP cml_tlatch_69.xmux.xp.S1 VSS sg13_lv_nmos ad=56.9f pd=0.74u as=0.1019p ps=1.34u w=0.17u l=0.17u
X118 VSS POLN cml_tlatch_48.xtail.S1 VSS sg13_lv_nmos ad=1.5637p pd=8.61u as=1.5637p ps=8.61u w=8.23u l=0.13u
X119 ENB1_P ENB_N cml_drv_0.xrtail.R1 VSS sg13_lv_nmos ad=56.2f pd=0.74u as=56.2f ps=0.74u w=0.16u l=0.19u
X120 GA2_P ENA1_N cml_gate2_5.xamp.xn.S1 VSS sg13_lv_nmos ad=0.1007p pd=0.91u as=0.1007p ps=0.91u w=0.53u l=0.13u
X121 cml_tlatch_22.OUTP cml_tlatch_22.OUTN cml_tlatch_22.xmux.xp.S1 VSS sg13_lv_nmos ad=56.9f pd=0.74u as=56.9f ps=0.74u w=0.17u l=0.17u
X122 A2_8_P A2_8_N cml_tlatch_85.xmux.xp.S1 VSS sg13_lv_nmos ad=56.9f pd=0.74u as=56.9f ps=0.74u w=0.17u l=0.17u
X123 MOT25_P MOT25_N cml_tlatch_72.xmux.xp.S1 VSS sg13_lv_nmos ad=56.9f pd=0.74u as=56.9f ps=0.74u w=0.17u l=0.17u
X124 cml_tlatch_81.xmux.xp.S1 B2_8_N B2_8_P VSS sg13_lv_nmos ad=56.9f pd=0.74u as=56.9f ps=0.74u w=0.17u l=0.17u
X125 cml_tlatch_18.OUTN cml_tlatch_18.OUTP cml_tlatch_18.xmux.xp.S1 VSS sg13_lv_nmos ad=56.9f pd=0.74u as=56.9f ps=0.74u w=0.17u l=0.17u
X126 cml_tlatch_3.xmux.xp.S1 MOT9_N MOT9_P VSS sg13_lv_nmos ad=56.9f pd=0.74u as=56.9f ps=0.74u w=0.17u l=0.17u
X127 cml_tlatch_8.xmux.xp.S1 cml_tlatch_8.OUTN cml_tlatch_8.OUTP VSS sg13_lv_nmos ad=56.9f pd=0.74u as=56.9f ps=0.74u w=0.17u l=0.17u
X128 cml_tlatch_41.xmux.xn.S1 D1_N cml_tlatch_41.OUTP VSS sg13_lv_nmos ad=63.19999f pd=0.74u as=63.19999f ps=0.74u w=0.26u l=0.38u
X129 MOT31_N B3_2_P cml_tlatch_75.xmux.xn.S1 VSS sg13_lv_nmos ad=63.19999f pd=0.74u as=63.19999f ps=0.74u w=0.26u l=0.38u
X130 A3_2_N cml_tlatch_58.OUTP cml_tlatch_57.xmux.xn.S1 VSS sg13_lv_nmos ad=63.19999f pd=0.74u as=63.19999f ps=0.74u w=0.26u l=0.38u
X131 MOT20_N MOT20_P cml_tlatch_54.xmux.xp.S1 VSS sg13_lv_nmos ad=56.9f pd=0.74u as=56.9f ps=0.74u w=0.17u l=0.17u
X132 MOT19_N MOT19_P cml_tlatch_78.xmux.xp.S1 VSS sg13_lv_nmos ad=56.9f pd=0.74u as=56.9f ps=0.74u w=0.17u l=0.17u
X133 cml_tlatch_70.xmux.xp.S1 cml_tlatch_63.INN cml_tlatch_63.INP VSS sg13_lv_nmos ad=56.9f pd=0.74u as=56.9f ps=0.74u w=0.17u l=0.17u
X134 MOT23_P B2_2_N cml_tlatch_80.xmux.xn.S1 VSS sg13_lv_nmos ad=63.19999f pd=0.74u as=63.19999f ps=0.74u w=0.26u l=0.38u
X135 cml_tlatch_7.xmux.xp.S1 cml_tlatch_7.OUTN cml_tlatch_7.OUTP VSS sg13_lv_nmos ad=56.9f pd=0.74u as=56.9f ps=0.74u w=0.17u l=0.17u
X136 cml_tlatch_94.xmux.xp.S1 CKJ_P cml_tlatch_94.xtail.S1 VSS sg13_lv_nmos ad=0.1598p pd=1.62u as=89.3f ps=0.85u w=0.47u l=0.16u
X137 cml_tlatch_43.xmux.xp.S1 CKHA1_N cml_tlatch_43.xtail.S1 VSS sg13_lv_nmos ad=89.3f pd=0.85u as=89.3f ps=0.85u w=0.47u l=0.16u
X138 cml_tlatch_97.xtail.S1 CKA1_N cml_tlatch_97.xmux.xn.S1 VSS sg13_lv_nmos ad=89.3f pd=0.85u as=89.3f ps=0.85u w=0.47u l=0.16u
X139 cml_tlatch_86.xmux.xp.S1 CKA2_N cml_tlatch_86.xtail.S1 VSS sg13_lv_nmos ad=89.3f pd=0.85u as=89.3f ps=0.85u w=0.47u l=0.16u
X140 cml_tlatch_63.xmux.xp.S1 MOT26_P MOT26_N VSS sg13_lv_nmos ad=56.9f pd=0.74u as=56.9f ps=0.74u w=0.17u l=0.17u
X141 cml_tlatch_57.xtail.S1 CKA3_N cml_tlatch_57.xmux.xn.S1 VSS sg13_lv_nmos ad=89.3f pd=0.85u as=89.3f ps=0.85u w=0.47u l=0.16u
X142 VSS POLN cml_tlatch_74.xtail.S1 VSS sg13_lv_nmos ad=2.7982p pd=17.14u as=1.5637p ps=8.61u w=8.23u l=0.13u
X143 cml_tlatch_52.xmux.xn.S1 A2_8_N MOT16_P VSS sg13_lv_nmos ad=63.19999f pd=0.74u as=63.19999f ps=0.74u w=0.26u l=0.38u
X144 A0_8_P A0_8_N cml_tlatch_9.xmux.xp.S1 VSS sg13_lv_nmos ad=56.9f pd=0.74u as=56.9f ps=0.74u w=0.17u l=0.17u
X145 cml_gate2_1.xamp.xn.S1 ENB1_P GB0_N VSS sg13_lv_nmos ad=0.1007p pd=0.91u as=0.1007p ps=0.91u w=0.53u l=0.13u
X146 cml_tlatch_74.xtail.S1 CKHB3_N cml_tlatch_74.xmux.xp.S1 VSS sg13_lv_nmos ad=89.3f pd=0.85u as=89.3f ps=0.85u w=0.47u l=0.16u
X147 cml_tlatch_33.xtail.S1 POLN VSS VSS sg13_lv_nmos ad=1.5637p pd=8.61u as=2.7982p ps=17.14u w=8.23u l=0.13u
X148 cml_gate2_2.xamp.xn.S1 ENA0_N GA1_P VSS sg13_lv_nmos ad=0.1007p pd=0.91u as=0.1007p ps=0.91u w=0.53u l=0.13u
X149 cml_tlatch_91.INN cml_tlatch_91.INP cml_tlatch_59.xmux.xp.S1 VSS sg13_lv_nmos ad=56.9f pd=0.74u as=56.9f ps=0.74u w=0.17u l=0.17u
X150 cml_tlatch_43.INN cml_tlatch_22.OUTP cml_tlatch_21.xmux.xn.S1 VSS sg13_lv_nmos ad=63.19999f pd=0.74u as=63.19999f ps=0.74u w=0.26u l=0.38u
X151 MOT29_P cml_tlatch_74.INN cml_tlatch_74.xmux.xn.S1 VSS sg13_lv_nmos ad=63.19999f pd=0.74u as=63.19999f ps=0.74u w=0.26u l=0.38u
X152 cml_tlatch_46.xmux.xp.S1 stub_bi_38.BOTN stub_bi_38.BOTP VSS sg13_lv_nmos ad=56.9f pd=0.74u as=56.9f ps=0.74u w=0.17u l=0.17u
X153 cml_tlatch_2.xtail.S1 CKB0_P cml_tlatch_2.xmux.xn.S1 VSS sg13_lv_nmos ad=89.3f pd=0.85u as=89.3f ps=0.85u w=0.47u l=0.16u
X154 MOT15_P MOT15_N cml_tlatch_6.xmux.xp.S1 VSS sg13_lv_nmos ad=56.9f pd=0.74u as=56.9f ps=0.74u w=0.17u l=0.17u
X155 cml_tlatch_21.xtail.S1 POLN VSS VSS sg13_lv_nmos ad=1.5637p pd=8.61u as=2.7982p ps=17.14u w=8.23u l=0.13u
X156 cml_tlatch_77.xtail.S1 CKHB2_N cml_tlatch_77.xmux.xp.S1 VSS sg13_lv_nmos ad=89.3f pd=0.85u as=89.3f ps=0.85u w=0.47u l=0.16u
X157 MOT6_N MOT6_P cml_tlatch_29.xmux.xp.S1 VSS sg13_lv_nmos ad=56.9f pd=0.74u as=56.9f ps=0.74u w=0.17u l=0.17u
X158 cml_tlatch_37.xtail.S1 CKB1_P cml_tlatch_37.xmux.xn.S1 VSS sg13_lv_nmos ad=0.1598p pd=1.62u as=89.3f ps=0.85u w=0.47u l=0.16u
X159 cml_tlatch_82.xmux.xp.S1 CKB2_N cml_tlatch_82.xtail.S1 VSS sg13_lv_nmos ad=89.3f pd=0.85u as=89.3f ps=0.85u w=0.47u l=0.16u
X160 cml_tlatch_96.xtail.S1 CKB1_N cml_tlatch_96.xmux.xn.S1 VSS sg13_lv_nmos ad=89.3f pd=0.85u as=89.3f ps=0.85u w=0.47u l=0.16u
X161 cml_tlatch_44.INP cml_tlatch_44.INN cml_tlatch_89.xmux.xp.S1 VSS sg13_lv_nmos ad=56.9f pd=0.74u as=56.9f ps=0.74u w=0.17u l=0.17u
X162 cml_tlatch_69.xmux.xp.S1 CKA3_N cml_tlatch_69.xtail.S1 VSS sg13_lv_nmos ad=89.3f pd=0.85u as=89.3f ps=0.85u w=0.47u l=0.16u
X163 cml_tlatch_10.xmux.xn.S1 CKB1_N cml_tlatch_10.xtail.S1 VSS sg13_lv_nmos ad=89.3f pd=0.85u as=89.3f ps=0.85u w=0.47u l=0.16u
X164 cml_tlatch_4.xmux.xn.S1 cml_tlatch_4.INN MOT11_P VSS sg13_lv_nmos ad=63.19999f pd=0.74u as=63.19999f ps=0.74u w=0.26u l=0.38u
X165 A2_2_N A2_2_P cml_tlatch_60.xmux.xp.S1 VSS sg13_lv_nmos ad=56.9f pd=0.74u as=56.9f ps=0.74u w=0.17u l=0.17u
X166 cml_tlatch_1.xmux.xn.S1 CKB0_N cml_tlatch_1.xtail.S1 VSS sg13_lv_nmos ad=89.3f pd=0.85u as=89.3f ps=0.85u w=0.47u l=0.16u
X167 cml_tlatch_97.xmux.xp.S1 cml_tlatch_24.INN cml_tlatch_24.INP VSS sg13_lv_nmos ad=56.9f pd=0.74u as=56.9f ps=0.74u w=0.17u l=0.17u
X168 cml_tlatch_5.INP cml_tlatch_5.INN cml_tlatch_96.xmux.xp.S1 VSS sg13_lv_nmos ad=56.9f pd=0.74u as=56.9f ps=0.74u w=0.17u l=0.17u
X169 hs_to_clk_6.D2 POLN VSS VSS sg13_lv_nmos ad=3.4p pd=20.68u as=1.9p ps=10.38u w=10u l=0.13u
X170 cml_tlatch_62.xtail.S1 CKHA3_P cml_tlatch_62.xmux.xn.S1 VSS sg13_lv_nmos ad=0.1598p pd=1.62u as=89.3f ps=0.85u w=0.47u l=0.16u
X171 cml_tlatch_83.xmux.xn.S1 CKB2_N cml_tlatch_83.xtail.S1 VSS sg13_lv_nmos ad=89.3f pd=0.85u as=89.3f ps=0.85u w=0.47u l=0.16u
X172 cml_tlatch_30.OUTP cml_tlatch_30.OUTN cml_tlatch_30.xmux.xp.S1 VSS sg13_lv_nmos ad=56.9f pd=0.74u as=56.9f ps=0.74u w=0.17u l=0.17u
X173 MOT1_N MOT1_P cml_tlatch_14.xmux.xp.S1 VSS sg13_lv_nmos ad=56.9f pd=0.74u as=0.1019p ps=1.34u w=0.17u l=0.17u
X174 cml_tlatch_70.xmux.xn.S1 CKA3_N cml_tlatch_70.xtail.S1 VSS sg13_lv_nmos ad=89.3f pd=0.85u as=89.3f ps=0.85u w=0.47u l=0.16u
X175 cml_drvb_9.xrtail.R2 CLK_W_P NM1_N VSS sg13_lv_nmos ad=0.1463p pd=1.15u as=0.2618p ps=2.22u w=0.77u l=0.21u
X176 cml_gate2_6.xamp.xn.S1 ENB0_N GB3_P VSS sg13_lv_nmos ad=0.1007p pd=0.91u as=0.1007p ps=0.91u w=0.53u l=0.13u
X177 cml_tlatch_37.xtail.S1 POLN VSS VSS sg13_lv_nmos ad=1.5637p pd=8.61u as=1.5637p ps=8.61u w=8.23u l=0.13u
X178 cml_tlatch_53.xmux.xp.S1 CKHA2_N cml_tlatch_53.xtail.S1 VSS sg13_lv_nmos ad=89.3f pd=0.85u as=89.3f ps=0.85u w=0.47u l=0.16u
X179 cml_tlatch_30.xmux.xn.S1 CKB0_P cml_tlatch_30.xtail.S1 VSS sg13_lv_nmos ad=89.3f pd=0.85u as=89.3f ps=0.85u w=0.47u l=0.16u
X180 cml_tlatch_38.xmux.xp.S1 cml_tlatch_38.OUTP cml_tlatch_38.OUTN VSS sg13_lv_nmos ad=56.9f pd=0.74u as=56.9f ps=0.74u w=0.17u l=0.17u
X181 cml_tlatch_79.xmux.xp.S1 MOT21_P MOT21_N VSS sg13_lv_nmos ad=56.9f pd=0.74u as=56.9f ps=0.74u w=0.17u l=0.17u
X182 cml_tlatch_76.xmux.xp.S1 cml_tlatch_87.INP cml_tlatch_87.INN VSS sg13_lv_nmos ad=56.9f pd=0.74u as=56.9f ps=0.74u w=0.17u l=0.17u
X183 cml_tlatch_73.INN cml_tlatch_67.OUTP cml_tlatch_66.xmux.xn.S1 VSS sg13_lv_nmos ad=63.19999f pd=0.74u as=63.19999f ps=0.74u w=0.26u l=0.38u
X184 cml_tlatch_67.OUTN cml_tlatch_67.OUTP cml_tlatch_67.xmux.xp.S1 VSS sg13_lv_nmos ad=56.9f pd=0.74u as=56.9f ps=0.74u w=0.17u l=0.17u
X185 MOT27_N MOT27_P cml_tlatch_73.xmux.xp.S1 VSS sg13_lv_nmos ad=56.9f pd=0.74u as=56.9f ps=0.74u w=0.17u l=0.17u
X186 A0_8_N A0_8_P cml_tlatch_9.xmux.xp.S1 VSS sg13_lv_nmos ad=56.9f pd=0.74u as=56.9f ps=0.74u w=0.17u l=0.17u
X187 cml_tlatch_42.xtail.S1 CKHA1_P cml_tlatch_42.xmux.xn.S1 VSS sg13_lv_nmos ad=89.3f pd=0.85u as=89.3f ps=0.85u w=0.47u l=0.16u
X188 cml_tlatch_92.xmux.xp.S1 J4_N J4_P VSS sg13_lv_nmos ad=56.9f pd=0.74u as=56.9f ps=0.74u w=0.17u l=0.17u
X189 cml_tlatch_17.xmux.xp.S1 MOT7_P MOT7_N VSS sg13_lv_nmos ad=56.9f pd=0.74u as=56.9f ps=0.74u w=0.17u l=0.17u
X190 cml_tlatch_63.xmux.xp.S1 CKHA3_N cml_tlatch_63.xtail.S1 VSS sg13_lv_nmos ad=89.3f pd=0.85u as=89.3f ps=0.85u w=0.47u l=0.16u
X191 cml_tlatch_91.xmux.xn.S1 CKA2_N cml_tlatch_91.xtail.S1 VSS sg13_lv_nmos ad=89.3f pd=0.85u as=89.3f ps=0.85u w=0.47u l=0.16u
X192 cml_tlatch_4.xmux.xp.S1 MOT11_P MOT11_N VSS sg13_lv_nmos ad=56.9f pd=0.74u as=56.9f ps=0.74u w=0.17u l=0.17u
X193 cml_gate2_2.xamp.xn.S1 CKB1_P cml_gate2_2.xrtail.R1 VSS sg13_lv_nmos ad=0.1007p pd=0.91u as=0.1007p ps=0.91u w=0.53u l=0.13u
X194 stub_bi_15.BOTP stub_bi_15.BOTN cml_tlatch_11.xmux.xp.S1 VSS sg13_lv_nmos ad=56.9f pd=0.74u as=56.9f ps=0.74u w=0.17u l=0.17u
X195 cml_tlatch_16.xtail.S1 POLN VSS VSS sg13_lv_nmos ad=1.5637p pd=8.61u as=1.5637p ps=8.61u w=8.23u l=0.13u
X196 cml_tlatch_2.xmux.xp.S1 CKB0_N cml_tlatch_2.xtail.S1 VSS sg13_lv_nmos ad=89.3f pd=0.85u as=89.3f ps=0.85u w=0.47u l=0.16u
X197 cml_tlatch_18.OUTN cml_tlatch_18.OUTP cml_tlatch_18.xmux.xp.S1 VSS sg13_lv_nmos ad=56.9f pd=0.74u as=56.9f ps=0.74u w=0.17u l=0.17u
X198 cml_tlatch_64.xmux.xp.S1 B3_8_P B3_8_N VSS sg13_lv_nmos ad=56.9f pd=0.74u as=56.9f ps=0.74u w=0.17u l=0.17u
X199 cml_tlatch_76.xmux.xp.S1 CKA2_N cml_tlatch_76.xtail.S1 VSS sg13_lv_nmos ad=89.3f pd=0.85u as=89.3f ps=0.85u w=0.47u l=0.16u
X200 cml_tlatch_36.xmux.xn.S1 CKB1_N cml_tlatch_36.xtail.S1 VSS sg13_lv_nmos ad=89.3f pd=0.85u as=89.3f ps=0.85u w=0.47u l=0.16u
X201 J2_N J2_P cml_tlatch_94.xmux.xp.S1 VSS sg13_lv_nmos ad=56.9f pd=0.74u as=56.9f ps=0.74u w=0.17u l=0.17u
X202 cml_tlatch_33.OUTP A0_2_N cml_tlatch_33.xmux.xn.S1 VSS sg13_lv_nmos ad=63.19999f pd=0.74u as=63.19999f ps=0.74u w=0.26u l=0.38u
X203 J2_P J2_N cml_tlatch_94.xmux.xp.S1 VSS sg13_lv_nmos ad=56.9f pd=0.74u as=56.9f ps=0.74u w=0.17u l=0.17u
X204 B2_2_N B2_2_P cml_tlatch_47.xmux.xp.S1 VSS sg13_lv_nmos ad=56.9f pd=0.74u as=56.9f ps=0.74u w=0.17u l=0.17u
X205 cml_tlatch_49.xmux.xp.S1 cml_tlatch_49.OUTN cml_tlatch_49.OUTP VSS sg13_lv_nmos ad=56.9f pd=0.74u as=56.9f ps=0.74u w=0.17u l=0.17u
X206 cml_tlatch_87.OUTN cml_tlatch_87.INP cml_tlatch_87.xmux.xn.S1 VSS sg13_lv_nmos ad=0.1082p pd=1.34u as=63.19999f ps=0.74u w=0.26u l=0.38u
X207 cml_tlatch_93.xmux.xn.S1 CKJ_P cml_tlatch_93.xtail.S1 VSS sg13_lv_nmos ad=89.3f pd=0.85u as=89.3f ps=0.85u w=0.47u l=0.16u
X208 cml_tlatch_28.xmux.xp.S1 CKHA0_N cml_tlatch_28.xtail.S1 VSS sg13_lv_nmos ad=89.3f pd=0.85u as=89.3f ps=0.85u w=0.47u l=0.16u
X209 MOT5_P MOT5_N cml_tlatch_16.xmux.xp.S1 VSS sg13_lv_nmos ad=56.9f pd=0.74u as=56.9f ps=0.74u w=0.17u l=0.17u
X210 cml_tlatch_39.xtail.S1 CKA1_N cml_tlatch_39.xmux.xp.S1 VSS sg13_lv_nmos ad=89.3f pd=0.85u as=89.3f ps=0.85u w=0.47u l=0.16u
X211 cml_tlatch_73.xtail.S1 CKHB3_P cml_tlatch_73.xmux.xn.S1 VSS sg13_lv_nmos ad=89.3f pd=0.85u as=89.3f ps=0.85u w=0.47u l=0.16u
X212 cml_tlatch_19.xmux.xp.S1 CKA1_P cml_tlatch_19.xtail.S1 VSS sg13_lv_nmos ad=89.3f pd=0.85u as=89.3f ps=0.85u w=0.47u l=0.16u
X213 cml_tlatch_8.OUTP cml_tlatch_98.OUTN cml_tlatch_8.xmux.xn.S1 VSS sg13_lv_nmos ad=63.19999f pd=0.74u as=63.19999f ps=0.74u w=0.26u l=0.38u
X214 cml_tlatch_88.xmux.xp.S1 cml_tlatch_74.INN cml_tlatch_74.INP VSS sg13_lv_nmos ad=56.9f pd=0.74u as=56.9f ps=0.74u w=0.17u l=0.17u
X215 cml_tlatch_74.xmux.xp.S1 MOT29_P MOT29_N VSS sg13_lv_nmos ad=56.9f pd=0.74u as=56.9f ps=0.74u w=0.17u l=0.17u
X216 cml_tlatch_39.xmux.xp.S1 cml_tlatch_97.INP cml_tlatch_97.INN VSS sg13_lv_nmos ad=56.9f pd=0.74u as=56.9f ps=0.74u w=0.17u l=0.17u
X217 cml_tlatch_40.xmux.xp.S1 CKA1_P cml_tlatch_40.xtail.S1 VSS sg13_lv_nmos ad=89.3f pd=0.85u as=89.3f ps=0.85u w=0.47u l=0.16u
X218 cml_tlatch_74.INN cml_tlatch_49.OUTP cml_tlatch_88.xmux.xn.S1 VSS sg13_lv_nmos ad=63.19999f pd=0.74u as=63.19999f ps=0.74u w=0.26u l=0.38u
X219 cml_tlatch_90.xmux.xp.S1 CKB2_P cml_tlatch_90.xtail.S1 VSS sg13_lv_nmos ad=89.3f pd=0.85u as=89.3f ps=0.85u w=0.47u l=0.16u
X220 cml_tlatch_91.OUTN cml_tlatch_91.OUTP cml_tlatch_91.xmux.xp.S1 VSS sg13_lv_nmos ad=56.9f pd=0.74u as=56.9f ps=0.74u w=0.17u l=0.17u
X221 cml_gate2_4.xrtail.R1 CKB3_N GA3_P VSS sg13_lv_nmos ad=0.1007p pd=0.91u as=0.1007p ps=0.91u w=0.53u l=0.13u
X222 cml_tlatch_34.xmux.xp.S1 A0_2_P A0_2_N VSS sg13_lv_nmos ad=56.9f pd=0.74u as=56.9f ps=0.74u w=0.17u l=0.17u
X223 cml_tlatch_95.xtail.S1 CKJ_P cml_tlatch_95.xmux.xn.S1 VSS sg13_lv_nmos ad=89.3f pd=0.85u as=89.3f ps=0.85u w=0.47u l=0.16u
X224 MOT18_P cml_tlatch_87.OUTN cml_tlatch_53.xmux.xn.S1 VSS sg13_lv_nmos ad=63.19999f pd=0.74u as=63.19999f ps=0.74u w=0.26u l=0.38u
X225 GA2_N ENA1_P cml_gate2_5.xamp.xn.S1 VSS sg13_lv_nmos ad=0.1007p pd=0.91u as=0.1007p ps=0.91u w=0.53u l=0.13u
X226 cml_tlatch_44.INP cml_tlatch_56.OUTN cml_tlatch_89.xmux.xn.S1 VSS sg13_lv_nmos ad=63.19999f pd=0.74u as=63.19999f ps=0.74u w=0.26u l=0.38u
X227 cml_tlatch_5.INP cml_tlatch_5.INN cml_tlatch_96.xmux.xp.S1 VSS sg13_lv_nmos ad=56.9f pd=0.74u as=56.9f ps=0.74u w=0.17u l=0.17u
X228 cml_tlatch_60.xmux.xp.S1 CKA2_P cml_tlatch_60.xtail.S1 VSS sg13_lv_nmos ad=0.1598p pd=1.62u as=89.3f ps=0.85u w=0.47u l=0.16u
X229 VDD cml_tlatch_22.OUTP VSS rppd l=5.17u w=1u
X230 cml_tlatch_95.xmux.xp.S1 J1_P J1_N VSS sg13_lv_nmos ad=56.9f pd=0.74u as=56.9f ps=0.74u w=0.17u l=0.17u
X231 MOT27_N MOT27_P cml_tlatch_73.xmux.xp.S1 VSS sg13_lv_nmos ad=56.9f pd=0.74u as=0.1019p ps=1.34u w=0.17u l=0.17u
X232 cml_tlatch_26.xmux.xp.S1 CKHA0_N cml_tlatch_26.xtail.S1 VSS sg13_lv_nmos ad=0.1598p pd=1.62u as=89.3f ps=0.85u w=0.47u l=0.16u
X233 cml_tlatch_10.xmux.xp.S1 CKB1_P cml_tlatch_10.xtail.S1 VSS sg13_lv_nmos ad=89.3f pd=0.85u as=89.3f ps=0.85u w=0.47u l=0.16u
X234 MOT1_N MOT1_P cml_tlatch_14.xmux.xp.S1 VSS sg13_lv_nmos ad=56.9f pd=0.74u as=56.9f ps=0.74u w=0.17u l=0.17u
X235 cml_tlatch_18.OUTP cml_tlatch_23.OUTN cml_tlatch_18.xmux.xn.S1 VSS sg13_lv_nmos ad=63.19999f pd=0.74u as=0.1082p ps=1.34u w=0.26u l=0.38u
X236 cml_tlatch_1.xtail.S1 POLN VSS VSS sg13_lv_nmos ad=1.5637p pd=8.61u as=2.7982p ps=17.14u w=8.23u l=0.13u
X237 A3_8_P A3_8_N cml_tlatch_68.xmux.xp.S1 VSS sg13_lv_nmos ad=56.9f pd=0.74u as=56.9f ps=0.74u w=0.17u l=0.17u
X238 MOT5_P cml_tlatch_98.OUTN cml_tlatch_16.xmux.xn.S1 VSS sg13_lv_nmos ad=63.19999f pd=0.74u as=63.19999f ps=0.74u w=0.26u l=0.38u
X239 cml_tlatch_86.xmux.xp.S1 cml_tlatch_86.OUTP cml_tlatch_86.OUTN VSS sg13_lv_nmos ad=56.9f pd=0.74u as=56.9f ps=0.74u w=0.17u l=0.17u
X240 B1_2_N stub_bi_31.BOTN cml_tlatch_36.xmux.xn.S1 VSS sg13_lv_nmos ad=63.19999f pd=0.74u as=63.19999f ps=0.74u w=0.26u l=0.38u
X241 cml_tlatch_71.xmux.xn.S1 cml_tlatch_44.INN cml_tlatch_71.OUTP VSS sg13_lv_nmos ad=63.19999f pd=0.74u as=63.19999f ps=0.74u w=0.26u l=0.38u
X242 stub_bi_43.BOTN VDD VSS rppd l=5.17u w=1u
X243 MOT14_N MOT14_P cml_tlatch_25.xmux.xp.S1 VSS sg13_lv_nmos ad=56.9f pd=0.74u as=56.9f ps=0.74u w=0.17u l=0.17u
X244 cml_tlatch_75.xtail.S1 CKHB3_N cml_tlatch_75.xmux.xp.S1 VSS sg13_lv_nmos ad=89.3f pd=0.85u as=89.3f ps=0.85u w=0.47u l=0.16u
X245 cml_tlatch_76.xmux.xp.S1 cml_tlatch_87.INP cml_tlatch_87.INN VSS sg13_lv_nmos ad=56.9f pd=0.74u as=56.9f ps=0.74u w=0.17u l=0.17u
X246 cml_tlatch_11.xmux.xp.S1 stub_bi_15.BOTP stub_bi_15.BOTN VSS sg13_lv_nmos ad=56.9f pd=0.74u as=56.9f ps=0.74u w=0.17u l=0.17u
X247 A1_2_P cml_tlatch_41.OUTN cml_tlatch_40.xmux.xn.S1 VSS sg13_lv_nmos ad=63.19999f pd=0.74u as=63.19999f ps=0.74u w=0.26u l=0.38u
X248 cml_tlatch_66.xmux.xp.S1 cml_tlatch_73.INP cml_tlatch_73.INN VSS sg13_lv_nmos ad=56.9f pd=0.74u as=56.9f ps=0.74u w=0.17u l=0.17u
X249 cml_gate2_1.xamp.xn.S1 CKA0_P cml_gate2_1.xrtail.R1 VSS sg13_lv_nmos ad=0.1007p pd=0.91u as=0.1007p ps=0.91u w=0.53u l=0.13u
X250 cml_tlatch_11.xmux.xn.S1 CKB1_P cml_tlatch_11.xtail.S1 VSS sg13_lv_nmos ad=89.3f pd=0.85u as=89.3f ps=0.85u w=0.47u l=0.16u
X251 cml_tlatch_86.xtail.S1 POLN VSS VSS sg13_lv_nmos ad=1.5637p pd=8.61u as=2.7982p ps=17.14u w=8.23u l=0.13u
X252 cml_tlatch_47.xmux.xp.S1 B2_2_N B2_2_P VSS sg13_lv_nmos ad=56.9f pd=0.74u as=56.9f ps=0.74u w=0.17u l=0.17u
X253 MOT0_P MOT0_N cml_tlatch_26.xmux.xp.S1 VSS sg13_lv_nmos ad=56.9f pd=0.74u as=56.9f ps=0.74u w=0.17u l=0.17u
X254 cml_tlatch_7.xmux.xp.S1 CKB0_P cml_tlatch_7.xtail.S1 VSS sg13_lv_nmos ad=89.3f pd=0.85u as=89.3f ps=0.85u w=0.47u l=0.16u
X255 cml_tlatch_17.xmux.xp.S1 MOT7_P MOT7_N VSS sg13_lv_nmos ad=56.9f pd=0.74u as=56.9f ps=0.74u w=0.17u l=0.17u
X256 VSS hs_to_clk_5.sg13_lv_nmos_2HGZLP_0.G VSS VSS sg13_lv_nmos ad=2.071p pd=11.28u as=0 ps=0 w=10.9u l=1.38u
X257 VSS POLN cml_tlatch_45.xtail.S1 VSS sg13_lv_nmos ad=2.7982p pd=17.14u as=1.5637p ps=8.61u w=8.23u l=0.13u
X258 cml_tlatch_33.xmux.xn.S1 CKA0_P cml_tlatch_33.xtail.S1 VSS sg13_lv_nmos ad=89.3f pd=0.85u as=0.1598p ps=1.62u w=0.47u l=0.16u
X259 cml_tlatch_0.OUTP cml_tlatch_0.OUTN cml_tlatch_0.xmux.xp.S1 VSS sg13_lv_nmos ad=56.9f pd=0.74u as=56.9f ps=0.74u w=0.17u l=0.17u
X260 cml_tlatch_86.xmux.xn.S1 CKA2_P cml_tlatch_86.xtail.S1 VSS sg13_lv_nmos ad=89.3f pd=0.85u as=89.3f ps=0.85u w=0.47u l=0.16u
X261 cml_tlatch_21.xmux.xp.S1 CKA1_P cml_tlatch_21.xtail.S1 VSS sg13_lv_nmos ad=89.3f pd=0.85u as=89.3f ps=0.85u w=0.47u l=0.16u
X262 cml_tlatch_25.xtail.S1 CKHA1_N cml_tlatch_25.xmux.xp.S1 VSS sg13_lv_nmos ad=0.1598p pd=1.62u as=89.3f ps=0.85u w=0.47u l=0.16u
X263 VSS hs_to_clk_2.sg13_lv_nmos_2HGZLP_0.G VSS VSS sg13_lv_nmos ad=2.071p pd=11.28u as=0 ps=0 w=10.9u l=1.38u
X264 cml_tlatch_5.xmux.xn.S1 CKHB1_P cml_tlatch_5.xtail.S1 VSS sg13_lv_nmos ad=89.3f pd=0.85u as=89.3f ps=0.85u w=0.47u l=0.16u
X265 cml_tlatch_71.OUTN cml_tlatch_44.INP cml_tlatch_71.xmux.xn.S1 VSS sg13_lv_nmos ad=63.19999f pd=0.74u as=0.1082p ps=1.34u w=0.26u l=0.38u
X266 cml_tlatch_72.xmux.xn.S1 B3_8_P MOT25_N VSS sg13_lv_nmos ad=63.19999f pd=0.74u as=0.1082p ps=1.34u w=0.26u l=0.38u
X267 cml_tlatch_56.OUTN cml_tlatch_56.OUTP cml_tlatch_56.xmux.xp.S1 VSS sg13_lv_nmos ad=56.9f pd=0.74u as=56.9f ps=0.74u w=0.17u l=0.17u
X268 cml_tlatch_56.xmux.xn.S1 CKA3_P cml_tlatch_56.xtail.S1 VSS sg13_lv_nmos ad=89.3f pd=0.85u as=89.3f ps=0.85u w=0.47u l=0.16u
X269 cml_tlatch_46.xmux.xn.S1 B2_2_P stub_bi_38.BOTP VSS sg13_lv_nmos ad=63.19999f pd=0.74u as=63.19999f ps=0.74u w=0.26u l=0.38u
X270 cml_gate2_8.xrtail.R1 NS1_P cml_gate2_8.xamp.xn.S1 VSS sg13_lv_nmos ad=0.1007p pd=0.91u as=0.1007p ps=0.91u w=0.53u l=0.13u
X271 stub_bi_49.BOTN stub_bi_49.BOTP cml_tlatch_84.xmux.xp.S1 VSS sg13_lv_nmos ad=56.9f pd=0.74u as=56.9f ps=0.74u w=0.17u l=0.17u
X272 cml_tlatch_15.xtail.S1 POLN VSS VSS sg13_lv_nmos ad=1.5637p pd=8.61u as=1.5637p ps=8.61u w=8.23u l=0.13u
X273 ENA_P J1_N cml_gate2_9.xamp.xn.S1 VSS sg13_lv_nmos ad=0.1007p pd=0.91u as=0.1007p ps=0.91u w=0.53u l=0.13u
X274 B3_8_P B3_8_N cml_tlatch_64.xmux.xp.S1 VSS sg13_lv_nmos ad=56.9f pd=0.74u as=0.1019p ps=1.34u w=0.17u l=0.17u
X275 cml_tlatch_18.xmux.xp.S1 CKA0_N cml_tlatch_18.xtail.S1 VSS sg13_lv_nmos ad=89.3f pd=0.85u as=0.1598p ps=1.62u w=0.47u l=0.16u
X276 cml_tlatch_32.xmux.xp.S1 cml_tlatch_32.OUTP cml_tlatch_32.OUTN VSS sg13_lv_nmos ad=56.9f pd=0.74u as=56.9f ps=0.74u w=0.17u l=0.17u
X277 cml_tlatch_43.xmux.xn.S1 cml_tlatch_43.INP MOT10_N VSS sg13_lv_nmos ad=63.19999f pd=0.74u as=63.19999f ps=0.74u w=0.26u l=0.38u
X278 stub_bi_43.BOTN D2_N cml_tlatch_48.xmux.xn.S1 VSS sg13_lv_nmos ad=63.19999f pd=0.74u as=63.19999f ps=0.74u w=0.26u l=0.38u
X279 J1_P J4_P cml_tlatch_95.xmux.xn.S1 VSS sg13_lv_nmos ad=63.19999f pd=0.74u as=63.19999f ps=0.74u w=0.26u l=0.38u
X280 cml_tlatch_49.xmux.xn.S1 CKB3_P cml_tlatch_49.xtail.S1 VSS sg13_lv_nmos ad=89.3f pd=0.85u as=89.3f ps=0.85u w=0.47u l=0.16u
X281 cml_tlatch_33.xmux.xp.S1 cml_tlatch_33.OUTP cml_tlatch_33.OUTN VSS sg13_lv_nmos ad=56.9f pd=0.74u as=56.9f ps=0.74u w=0.17u l=0.17u
X282 cml_tlatch_91.xmux.xp.S1 cml_tlatch_91.OUTN cml_tlatch_91.OUTP VSS sg13_lv_nmos ad=56.9f pd=0.74u as=56.9f ps=0.74u w=0.17u l=0.17u
X283 cml_tlatch_55.xmux.xn.S1 A2_2_N MOT22_P VSS sg13_lv_nmos ad=63.19999f pd=0.74u as=63.19999f ps=0.74u w=0.26u l=0.38u
X284 cml_tlatch_37.xtail.S1 CKB1_P cml_tlatch_37.xmux.xn.S1 VSS sg13_lv_nmos ad=89.3f pd=0.85u as=89.3f ps=0.85u w=0.47u l=0.16u
X285 VSS POLN cml_tlatch_98.xtail.S1 VSS sg13_lv_nmos ad=1.5637p pd=8.61u as=1.5637p ps=8.61u w=8.23u l=0.13u
X286 cml_tlatch_56.xmux.xn.S1 A3_2_N cml_tlatch_56.OUTP VSS sg13_lv_nmos ad=63.19999f pd=0.74u as=63.19999f ps=0.74u w=0.26u l=0.38u
X287 B2_8_N B2_8_P cml_tlatch_81.xmux.xp.S1 VSS sg13_lv_nmos ad=56.9f pd=0.74u as=56.9f ps=0.74u w=0.17u l=0.17u
X288 cml_tlatch_14.xmux.xp.S1 MOT1_N MOT1_P VSS sg13_lv_nmos ad=56.9f pd=0.74u as=56.9f ps=0.74u w=0.17u l=0.17u
X289 cml_tlatch_37.xmux.xp.S1 stub_bi_31.BOTP stub_bi_31.BOTN VSS sg13_lv_nmos ad=56.9f pd=0.74u as=56.9f ps=0.74u w=0.17u l=0.17u
X290 cml_tlatch_34.xmux.xp.S1 A0_2_P A0_2_N VSS sg13_lv_nmos ad=56.9f pd=0.74u as=56.9f ps=0.74u w=0.17u l=0.17u
X291 hs_to_clk_1.sg13_lv_nmos_2HGZLP_0.G VDD VSS rppd l=0.68u w=1u
X292 MOT8_N MOT8_P cml_tlatch_42.xmux.xp.S1 VSS sg13_lv_nmos ad=56.9f pd=0.74u as=56.9f ps=0.74u w=0.17u l=0.17u
X293 cml_tlatch_52.xmux.xp.S1 MOT16_N MOT16_P VSS sg13_lv_nmos ad=56.9f pd=0.74u as=56.9f ps=0.74u w=0.17u l=0.17u
X294 cml_tlatch_78.xmux.xp.S1 MOT19_N MOT19_P VSS sg13_lv_nmos ad=56.9f pd=0.74u as=56.9f ps=0.74u w=0.17u l=0.17u
X295 MOT24_P MOT24_N cml_tlatch_62.xmux.xp.S1 VSS sg13_lv_nmos ad=56.9f pd=0.74u as=56.9f ps=0.74u w=0.17u l=0.17u
X296 cml_tlatch_54.xmux.xn.S1 CKHA2_P cml_tlatch_54.xtail.S1 VSS sg13_lv_nmos ad=89.3f pd=0.85u as=0.1598p ps=1.62u w=0.47u l=0.16u
X297 cml_tlatch_86.OUTN cml_tlatch_87.OUTP cml_tlatch_86.xmux.xn.S1 VSS sg13_lv_nmos ad=63.19999f pd=0.74u as=63.19999f ps=0.74u w=0.26u l=0.38u
X298 VDD MOT5_P VSS rppd l=5.17u w=1u
X299 cml_tlatch_41.OUTN cml_tlatch_41.OUTP cml_tlatch_41.xmux.xp.S1 VSS sg13_lv_nmos ad=56.9f pd=0.74u as=56.9f ps=0.74u w=0.17u l=0.17u
X300 cml_tlatch_48.xmux.xp.S1 stub_bi_43.BOTN stub_bi_43.BOTP VSS sg13_lv_nmos ad=56.9f pd=0.74u as=56.9f ps=0.74u w=0.17u l=0.17u
X301 cml_tlatch_72.xtail.S1 CKHB3_N cml_tlatch_72.xmux.xp.S1 VSS sg13_lv_nmos ad=89.3f pd=0.85u as=89.3f ps=0.85u w=0.47u l=0.16u
X302 cml_tlatch_23.xmux.xp.S1 cml_tlatch_23.OUTN cml_tlatch_23.OUTP VSS sg13_lv_nmos ad=56.9f pd=0.74u as=56.9f ps=0.74u w=0.17u l=0.17u
X303 cml_tlatch_51.xmux.xp.S1 CKB3_N cml_tlatch_51.xtail.S1 VSS sg13_lv_nmos ad=89.3f pd=0.85u as=89.3f ps=0.85u w=0.47u l=0.16u
X304 cml_tlatch_83.xmux.xn.S1 CKB2_N cml_tlatch_83.xtail.S1 VSS sg13_lv_nmos ad=89.3f pd=0.85u as=89.3f ps=0.85u w=0.47u l=0.16u
X305 VDD A1_8_N VSS rppd l=5.17u w=1u
X306 cml_tlatch_43.xmux.xp.S1 MOT10_N MOT10_P VSS sg13_lv_nmos ad=56.9f pd=0.74u as=56.9f ps=0.74u w=0.17u l=0.17u
X307 cml_tlatch_56.OUTN A3_2_P cml_tlatch_56.xmux.xn.S1 VSS sg13_lv_nmos ad=63.19999f pd=0.74u as=63.19999f ps=0.74u w=0.26u l=0.38u
X308 cml_tlatch_4.xtail.S1 CKHB1_N cml_tlatch_4.xmux.xp.S1 VSS sg13_lv_nmos ad=89.3f pd=0.85u as=0.1598p ps=1.62u w=0.47u l=0.16u
X309 cml_tlatch_42.xmux.xp.S1 MOT8_N MOT8_P VSS sg13_lv_nmos ad=56.9f pd=0.74u as=56.9f ps=0.74u w=0.17u l=0.17u
X310 cml_tlatch_43.xtail.S1 CKHA1_P cml_tlatch_43.xmux.xn.S1 VSS sg13_lv_nmos ad=89.3f pd=0.85u as=89.3f ps=0.85u w=0.47u l=0.16u
X311 stub_bi_38.BOTN stub_bi_38.BOTP cml_tlatch_46.xmux.xp.S1 VSS sg13_lv_nmos ad=56.9f pd=0.74u as=56.9f ps=0.74u w=0.17u l=0.17u
X312 MOT31_N MOT31_P cml_tlatch_75.xmux.xp.S1 VSS sg13_lv_nmos ad=56.9f pd=0.74u as=56.9f ps=0.74u w=0.17u l=0.17u
X313 cml_tlatch_86.xmux.xp.S1 cml_tlatch_86.OUTP cml_tlatch_86.OUTN VSS sg13_lv_nmos ad=56.9f pd=0.74u as=56.9f ps=0.74u w=0.17u l=0.17u
X314 VSS POLN cml_tlatch_20.xtail.S1 VSS sg13_lv_nmos ad=1.5637p pd=8.61u as=1.5637p ps=8.61u w=8.23u l=0.13u
X315 cml_tlatch_84.xtail.S1 CKB2_P cml_tlatch_84.xmux.xn.S1 VSS sg13_lv_nmos ad=89.3f pd=0.85u as=89.3f ps=0.85u w=0.47u l=0.16u
X316 stub_bi_62.BOTP stub_bi_62.BOTN cml_tlatch_82.xmux.xp.S1 VSS sg13_lv_nmos ad=56.9f pd=0.74u as=56.9f ps=0.74u w=0.17u l=0.17u
X317 cml_tlatch_44.xmux.xn.S1 CKHA3_P cml_tlatch_44.xtail.S1 VSS sg13_lv_nmos ad=89.3f pd=0.85u as=89.3f ps=0.85u w=0.47u l=0.16u
X318 cml_tlatch_30.xmux.xn.S1 CKB0_P cml_tlatch_30.xtail.S1 VSS sg13_lv_nmos ad=89.3f pd=0.85u as=89.3f ps=0.85u w=0.47u l=0.16u
X319 cml_tlatch_29.xtail.S1 CKHA0_P cml_tlatch_29.xmux.xn.S1 VSS sg13_lv_nmos ad=89.3f pd=0.85u as=89.3f ps=0.85u w=0.47u l=0.16u
X320 MOT24_N MOT24_P cml_tlatch_62.xmux.xp.S1 VSS sg13_lv_nmos ad=56.9f pd=0.74u as=56.9f ps=0.74u w=0.17u l=0.17u
X321 MOT3_N cml_tlatch_7.OUTP cml_tlatch_15.xmux.xn.S1 VSS sg13_lv_nmos ad=63.19999f pd=0.74u as=0.1082p ps=1.34u w=0.26u l=0.38u
X322 A1_2_P A1_2_N cml_tlatch_40.xmux.xp.S1 VSS sg13_lv_nmos ad=56.9f pd=0.74u as=0.1019p ps=1.34u w=0.17u l=0.17u
X323 cml_tlatch_55.xmux.xp.S1 CKHA2_N cml_tlatch_55.xtail.S1 VSS sg13_lv_nmos ad=89.3f pd=0.85u as=89.3f ps=0.85u w=0.47u l=0.16u
X324 cml_tlatch_0.OUTP cml_tlatch_0.OUTN cml_tlatch_0.xmux.xp.S1 VSS sg13_lv_nmos ad=56.9f pd=0.74u as=56.9f ps=0.74u w=0.17u l=0.17u
X325 cml_tlatch_58.xtail.S1 CKA3_P cml_tlatch_58.xmux.xn.S1 VSS sg13_lv_nmos ad=89.3f pd=0.85u as=89.3f ps=0.85u w=0.47u l=0.16u
X326 cml_tlatch_90.xtail.S1 CKB2_P cml_tlatch_90.xmux.xp.S1 VSS sg13_lv_nmos ad=89.3f pd=0.85u as=0.1598p ps=1.62u w=0.47u l=0.16u
X327 cml_tlatch_95.xmux.xn.S1 CKJ_P cml_tlatch_95.xtail.S1 VSS sg13_lv_nmos ad=89.3f pd=0.85u as=89.3f ps=0.85u w=0.47u l=0.16u
X328 cml_tlatch_70.xmux.xn.S1 cml_tlatch_71.OUTN cml_tlatch_63.INP VSS sg13_lv_nmos ad=63.19999f pd=0.74u as=63.19999f ps=0.74u w=0.26u l=0.38u
X329 cml_tlatch_99.OUTN cml_tlatch_99.OUTP cml_tlatch_99.xmux.xp.S1 VSS sg13_lv_nmos ad=56.9f pd=0.74u as=56.9f ps=0.74u w=0.17u l=0.17u
X330 cml_tlatch_35.xtail.S1 CKB1_P cml_tlatch_35.xmux.xn.S1 VSS sg13_lv_nmos ad=89.3f pd=0.85u as=89.3f ps=0.85u w=0.47u l=0.16u
X331 cml_tlatch_31.xmux.xn.S1 CKB0_N cml_tlatch_31.xtail.S1 VSS sg13_lv_nmos ad=89.3f pd=0.85u as=89.3f ps=0.85u w=0.47u l=0.16u
X332 cml_tlatch_2.xmux.xp.S1 CKB0_N cml_tlatch_2.xtail.S1 VSS sg13_lv_nmos ad=89.3f pd=0.85u as=89.3f ps=0.85u w=0.47u l=0.16u
X333 MOT14_N A1_2_P cml_tlatch_25.xmux.xn.S1 VSS sg13_lv_nmos ad=63.19999f pd=0.74u as=63.19999f ps=0.74u w=0.26u l=0.38u
X334 cml_tlatch_49.xtail.S1 POLN VSS VSS sg13_lv_nmos ad=1.5637p pd=8.61u as=1.5637p ps=8.61u w=8.23u l=0.13u
X335 stub_bi_49.BOTN stub_bi_49.BOTP cml_tlatch_84.xmux.xp.S1 VSS sg13_lv_nmos ad=56.9f pd=0.74u as=56.9f ps=0.74u w=0.17u l=0.17u
X336 cml_tlatch_22.xmux.xp.S1 cml_tlatch_22.OUTN cml_tlatch_22.OUTP VSS sg13_lv_nmos ad=56.9f pd=0.74u as=56.9f ps=0.74u w=0.17u l=0.17u
X337 J2_P J1_N cml_tlatch_94.xmux.xn.S1 VSS sg13_lv_nmos ad=0.1082p pd=1.34u as=63.19999f ps=0.74u w=0.26u l=0.38u
X338 cml_tlatch_76.xmux.xp.S1 CKA2_N cml_tlatch_76.xtail.S1 VSS sg13_lv_nmos ad=89.3f pd=0.85u as=89.3f ps=0.85u w=0.47u l=0.16u
X339 VDD A3_2_N VSS rppd l=5.17u w=1u
X340 cml_tlatch_54.xtail.S1 CKHA2_N cml_tlatch_54.xmux.xp.S1 VSS sg13_lv_nmos ad=89.3f pd=0.85u as=89.3f ps=0.85u w=0.47u l=0.16u
X341 cml_tlatch_27.xmux.xp.S1 MOT2_P MOT2_N VSS sg13_lv_nmos ad=56.9f pd=0.74u as=56.9f ps=0.74u w=0.17u l=0.17u
X342 cml_tlatch_85.xmux.xp.S1 A2_8_N A2_8_P VSS sg13_lv_nmos ad=56.9f pd=0.74u as=56.9f ps=0.74u w=0.17u l=0.17u
X343 MOT21_P MOT21_N cml_tlatch_79.xmux.xp.S1 VSS sg13_lv_nmos ad=56.9f pd=0.74u as=56.9f ps=0.74u w=0.17u l=0.17u
X344 cml_tlatch_4.xmux.xn.S1 cml_tlatch_4.INP MOT11_N VSS sg13_lv_nmos ad=0.1082p pd=1.34u as=63.19999f ps=0.74u w=0.26u l=0.38u
X345 cml_gate2_0.xamp.xn.S1 CKA1_P cml_gate2_0.xrtail.R1 VSS sg13_lv_nmos ad=0.1007p pd=0.91u as=0.1007p ps=0.91u w=0.53u l=0.13u
X346 cml_tlatch_97.xmux.xp.S1 cml_tlatch_24.INP cml_tlatch_24.INN VSS sg13_lv_nmos ad=56.9f pd=0.74u as=56.9f ps=0.74u w=0.17u l=0.17u
X347 cml_tlatch_36.xmux.xp.S1 B1_2_P B1_2_N VSS sg13_lv_nmos ad=56.9f pd=0.74u as=56.9f ps=0.74u w=0.17u l=0.17u
X348 cml_tlatch_74.xmux.xp.S1 MOT29_N MOT29_P VSS sg13_lv_nmos ad=56.9f pd=0.74u as=56.9f ps=0.74u w=0.17u l=0.17u
X349 cml_tlatch_5.INP stub_bi_29.BOTP cml_tlatch_96.xmux.xn.S1 VSS sg13_lv_nmos ad=63.19999f pd=0.74u as=63.19999f ps=0.74u w=0.26u l=0.38u
X350 VSS POLN cml_tlatch_61.xtail.S1 VSS sg13_lv_nmos ad=2.7982p pd=17.14u as=1.5637p ps=8.61u w=8.23u l=0.13u
X351 cml_tlatch_88.xtail.S1 CKB3_P cml_tlatch_88.xmux.xp.S1 VSS sg13_lv_nmos ad=89.3f pd=0.85u as=89.3f ps=0.85u w=0.47u l=0.16u
X352 cml_tlatch_44.xmux.xn.S1 cml_tlatch_44.INP MOT28_N VSS sg13_lv_nmos ad=63.19999f pd=0.74u as=63.19999f ps=0.74u w=0.26u l=0.38u
X353 cml_tlatch_97.xmux.xp.S1 CKA1_P cml_tlatch_97.xtail.S1 VSS sg13_lv_nmos ad=0.1598p pd=1.62u as=89.3f ps=0.85u w=0.47u l=0.16u
X354 VSS POLN cml_tlatch_29.xtail.S1 VSS sg13_lv_nmos ad=2.7982p pd=17.14u as=1.5637p ps=8.61u w=8.23u l=0.13u
X355 MOT9_P MOT9_N cml_tlatch_3.xmux.xp.S1 VSS sg13_lv_nmos ad=56.9f pd=0.74u as=56.9f ps=0.74u w=0.17u l=0.17u
X356 cml_gate2_3.xamp.xn.S1 ENA0_N GA0_P VSS sg13_lv_nmos ad=0.1007p pd=0.91u as=0.1007p ps=0.91u w=0.53u l=0.13u
X357 VSS POLN cml_tlatch_73.xtail.S1 VSS sg13_lv_nmos ad=1.5637p pd=8.61u as=1.5637p ps=8.61u w=8.23u l=0.13u
X358 stub_bi_55.BOTN stub_bi_55.BOTP cml_tlatch_90.xmux.xp.S1 VSS sg13_lv_nmos ad=56.9f pd=0.74u as=56.9f ps=0.74u w=0.17u l=0.17u
X359 cml_tlatch_25.xmux.xp.S1 CKHA1_N cml_tlatch_25.xtail.S1 VSS sg13_lv_nmos ad=89.3f pd=0.85u as=89.3f ps=0.85u w=0.47u l=0.16u
X360 cml_tlatch_66.xmux.xn.S1 cml_tlatch_67.OUTP cml_tlatch_73.INN VSS sg13_lv_nmos ad=63.19999f pd=0.74u as=63.19999f ps=0.74u w=0.26u l=0.38u
X361 cml_tlatch_18.xmux.xp.S1 cml_tlatch_18.OUTN cml_tlatch_18.OUTP VSS sg13_lv_nmos ad=56.9f pd=0.74u as=56.9f ps=0.74u w=0.17u l=0.17u
X362 cml_tlatch_72.xmux.xp.S1 MOT25_P MOT25_N VSS sg13_lv_nmos ad=0.1019p pd=1.34u as=56.9f ps=0.74u w=0.17u l=0.17u
X363 MOT19_P stub_bi_63.BOTP cml_tlatch_78.xmux.xn.S1 VSS sg13_lv_nmos ad=63.19999f pd=0.74u as=0.1082p ps=1.34u w=0.26u l=0.38u
X364 cml_tlatch_63.INP cml_tlatch_63.INN cml_tlatch_70.xmux.xp.S1 VSS sg13_lv_nmos ad=56.9f pd=0.74u as=56.9f ps=0.74u w=0.17u l=0.17u
X365 cml_tlatch_53.xmux.xp.S1 MOT18_P MOT18_N VSS sg13_lv_nmos ad=56.9f pd=0.74u as=56.9f ps=0.74u w=0.17u l=0.17u
X366 cml_gate2_3.xamp.xn.S1 ENA0_P GA0_N VSS sg13_lv_nmos ad=0.1007p pd=0.91u as=0.1007p ps=0.91u w=0.53u l=0.13u
X367 cml_tlatch_9.xmux.xp.S1 A0_8_N A0_8_P VSS sg13_lv_nmos ad=56.9f pd=0.74u as=56.9f ps=0.74u w=0.17u l=0.17u
X368 cml_tlatch_92.xmux.xp.S1 J4_P J4_N VSS sg13_lv_nmos ad=56.9f pd=0.74u as=56.9f ps=0.74u w=0.17u l=0.17u
X369 cml_tlatch_98.OUTP cml_tlatch_98.OUTN cml_tlatch_98.xmux.xp.S1 VSS sg13_lv_nmos ad=56.9f pd=0.74u as=56.9f ps=0.74u w=0.17u l=0.17u
X370 A0_2_P cml_tlatch_38.OUTN cml_tlatch_34.xmux.xn.S1 VSS sg13_lv_nmos ad=63.19999f pd=0.74u as=63.19999f ps=0.74u w=0.26u l=0.38u
X371 cml_tlatch_49.OUTN cml_tlatch_49.OUTP cml_tlatch_49.xmux.xp.S1 VSS sg13_lv_nmos ad=56.9f pd=0.74u as=56.9f ps=0.74u w=0.17u l=0.17u
X372 cml_tlatch_71.xmux.xp.S1 cml_tlatch_71.OUTP cml_tlatch_71.OUTN VSS sg13_lv_nmos ad=0.1019p pd=1.34u as=56.9f ps=0.74u w=0.17u l=0.17u
X373 cml_tlatch_12.xmux.xn.S1 stub_bi_17.BOTP cml_tlatch_4.INP VSS sg13_lv_nmos ad=63.19999f pd=0.74u as=0.1082p ps=1.34u w=0.26u l=0.38u
X374 cml_tlatch_10.xmux.xp.S1 CKB1_P cml_tlatch_10.xtail.S1 VSS sg13_lv_nmos ad=89.3f pd=0.85u as=89.3f ps=0.85u w=0.47u l=0.16u
X375 cml_tlatch_26.xmux.xp.S1 CKHA0_N cml_tlatch_26.xtail.S1 VSS sg13_lv_nmos ad=89.3f pd=0.85u as=89.3f ps=0.85u w=0.47u l=0.16u
X376 A3_2_P A3_2_N cml_tlatch_57.xmux.xp.S1 VSS sg13_lv_nmos ad=56.9f pd=0.74u as=56.9f ps=0.74u w=0.17u l=0.17u
X377 cml_tlatch_89.xmux.xp.S1 cml_tlatch_44.INN cml_tlatch_44.INP VSS sg13_lv_nmos ad=56.9f pd=0.74u as=56.9f ps=0.74u w=0.17u l=0.17u
X378 cml_gate2_6.xrtail.R1 CKA3_N GB3_P VSS sg13_lv_nmos ad=0.1007p pd=0.91u as=0.1007p ps=0.91u w=0.53u l=0.13u
X379 MOT9_N B1_8_P cml_tlatch_3.xmux.xn.S1 VSS sg13_lv_nmos ad=63.19999f pd=0.74u as=63.19999f ps=0.74u w=0.26u l=0.38u
X380 cml_tlatch_64.xtail.S1 CKB3_N cml_tlatch_64.xmux.xn.S1 VSS sg13_lv_nmos ad=89.3f pd=0.85u as=0.1598p ps=1.62u w=0.47u l=0.16u
X381 GB2_N ENB0_P cml_gate2_7.xamp.xn.S1 VSS sg13_lv_nmos ad=0.1007p pd=0.91u as=0.1007p ps=0.91u w=0.53u l=0.13u
X382 MOT3_N MOT3_P cml_tlatch_15.xmux.xp.S1 VSS sg13_lv_nmos ad=56.9f pd=0.74u as=56.9f ps=0.74u w=0.17u l=0.17u
X383 cml_drv_2.xrtail.R1 ENB_N ENB0_P VSS sg13_lv_nmos ad=56.2f pd=0.74u as=56.2f ps=0.74u w=0.16u l=0.19u
X384 stub_bi_63.BOTP stub_bi_63.BOTN cml_tlatch_83.xmux.xp.S1 VSS sg13_lv_nmos ad=56.9f pd=0.74u as=56.9f ps=0.74u w=0.17u l=0.17u
X385 MOT9_N B1_8_P cml_tlatch_3.xmux.xn.S1 VSS sg13_lv_nmos ad=63.19999f pd=0.74u as=63.19999f ps=0.74u w=0.26u l=0.38u
X386 cml_tlatch_21.xmux.xp.S1 cml_tlatch_43.INN cml_tlatch_43.INP VSS sg13_lv_nmos ad=56.9f pd=0.74u as=56.9f ps=0.74u w=0.17u l=0.17u
X387 B3_2_N B3_2_P cml_tlatch_50.xmux.xp.S1 VSS sg13_lv_nmos ad=56.9f pd=0.74u as=56.9f ps=0.74u w=0.17u l=0.17u
X388 cml_tlatch_6.xmux.xp.S1 MOT15_P MOT15_N VSS sg13_lv_nmos ad=56.9f pd=0.74u as=56.9f ps=0.74u w=0.17u l=0.17u
X389 CKHA1_P GA1_N cml_drvb_2.xrtail.R2 VSS sg13_lv_nmos ad=0.2618p pd=2.22u as=0.1463p ps=1.15u w=0.77u l=0.21u
X390 stub_bi_15.BOTN cml_tlatch_4.INN cml_tlatch_11.xmux.xn.S1 VSS sg13_lv_nmos ad=63.19999f pd=0.74u as=63.19999f ps=0.74u w=0.26u l=0.38u
X391 cml_tlatch_37.xmux.xn.S1 CKB1_P cml_tlatch_37.xtail.S1 VSS sg13_lv_nmos ad=89.3f pd=0.85u as=89.3f ps=0.85u w=0.47u l=0.16u
X392 cml_tlatch_91.OUTN cml_tlatch_91.INP cml_tlatch_91.xmux.xn.S1 VSS sg13_lv_nmos ad=63.19999f pd=0.74u as=0.1082p ps=1.34u w=0.26u l=0.38u
X393 J4_N J4_P cml_tlatch_92.xmux.xp.S1 VSS sg13_lv_nmos ad=56.9f pd=0.74u as=0.1019p ps=1.34u w=0.17u l=0.17u
X394 cml_tlatch_47.xmux.xn.S1 stub_bi_43.BOTP B2_2_P VSS sg13_lv_nmos ad=63.19999f pd=0.74u as=0.1082p ps=1.34u w=0.26u l=0.38u
X395 cml_tlatch_92.xtail.S1 POLN VSS VSS sg13_lv_nmos ad=1.5637p pd=8.61u as=2.7982p ps=17.14u w=8.23u l=0.13u
X396 VSS POLN cml_tlatch_46.xtail.S1 VSS sg13_lv_nmos ad=2.7982p pd=17.14u as=1.5637p ps=8.61u w=8.23u l=0.13u
X397 stub_bi_49.BOTP stub_bi_55.BOTN cml_tlatch_84.xmux.xn.S1 VSS sg13_lv_nmos ad=63.19999f pd=0.74u as=63.19999f ps=0.74u w=0.26u l=0.38u
X398 B2_2_N stub_bi_43.BOTN cml_tlatch_47.xmux.xn.S1 VSS sg13_lv_nmos ad=63.19999f pd=0.74u as=63.19999f ps=0.74u w=0.26u l=0.38u
X399 cml_tlatch_23.xmux.xn.S1 cml_tlatch_0.OUTN cml_tlatch_23.OUTP VSS sg13_lv_nmos ad=63.19999f pd=0.74u as=63.19999f ps=0.74u w=0.26u l=0.38u
X400 cml_tlatch_38.OUTN cml_tlatch_38.OUTP cml_tlatch_38.xmux.xp.S1 VSS sg13_lv_nmos ad=56.9f pd=0.74u as=56.9f ps=0.74u w=0.17u l=0.17u
X401 MOT21_N MOT21_P cml_tlatch_79.xmux.xp.S1 VSS sg13_lv_nmos ad=56.9f pd=0.74u as=56.9f ps=0.74u w=0.17u l=0.17u
X402 cml_tlatch_61.OUTN D2_P cml_tlatch_61.xmux.xn.S1 VSS sg13_lv_nmos ad=63.19999f pd=0.74u as=63.19999f ps=0.74u w=0.26u l=0.38u
X403 cml_tlatch_85.xtail.S1 CKA2_N cml_tlatch_85.xmux.xn.S1 VSS sg13_lv_nmos ad=89.3f pd=0.85u as=89.3f ps=0.85u w=0.47u l=0.16u
X404 cml_tlatch_67.xmux.xp.S1 cml_tlatch_67.OUTP cml_tlatch_67.OUTN VSS sg13_lv_nmos ad=56.9f pd=0.74u as=56.9f ps=0.74u w=0.17u l=0.17u
X405 cml_tlatch_95.xmux.xp.S1 CKJ_N cml_tlatch_95.xtail.S1 VSS sg13_lv_nmos ad=0.1598p pd=1.62u as=89.3f ps=0.85u w=0.47u l=0.16u
X406 cml_tlatch_44.xmux.xp.S1 MOT28_P MOT28_N VSS sg13_lv_nmos ad=56.9f pd=0.74u as=56.9f ps=0.74u w=0.17u l=0.17u
X407 cml_tlatch_83.xtail.S1 CKB2_N cml_tlatch_83.xmux.xn.S1 VSS sg13_lv_nmos ad=89.3f pd=0.85u as=0.1598p ps=1.62u w=0.47u l=0.16u
X408 cml_tlatch_24.xmux.xp.S1 CKHA1_N cml_tlatch_24.xtail.S1 VSS sg13_lv_nmos ad=89.3f pd=0.85u as=89.3f ps=0.85u w=0.47u l=0.16u
X409 VSS POLN cml_tlatch_75.xtail.S1 VSS sg13_lv_nmos ad=2.7982p pd=17.14u as=1.5637p ps=8.61u w=8.23u l=0.13u
X410 cml_tlatch_62.xmux.xn.S1 CKHA3_P cml_tlatch_62.xtail.S1 VSS sg13_lv_nmos ad=89.3f pd=0.85u as=89.3f ps=0.85u w=0.47u l=0.16u
X411 cml_tlatch_53.xmux.xn.S1 cml_tlatch_87.OUTN MOT18_P VSS sg13_lv_nmos ad=63.19999f pd=0.74u as=63.19999f ps=0.74u w=0.26u l=0.38u
X412 cml_tlatch_6.xtail.S1 CKHB1_N cml_tlatch_6.xmux.xp.S1 VSS sg13_lv_nmos ad=0.1598p pd=1.62u as=89.3f ps=0.85u w=0.47u l=0.16u
X413 cml_tlatch_35.xtail.S1 CKB1_N cml_tlatch_35.xmux.xp.S1 VSS sg13_lv_nmos ad=0.1598p pd=1.62u as=89.3f ps=0.85u w=0.47u l=0.16u
X414 J4_P J4_N cml_tlatch_92.xmux.xp.S1 VSS sg13_lv_nmos ad=56.9f pd=0.74u as=56.9f ps=0.74u w=0.17u l=0.17u
X415 cml_tlatch_89.xmux.xp.S1 cml_tlatch_44.INN cml_tlatch_44.INP VSS sg13_lv_nmos ad=56.9f pd=0.74u as=56.9f ps=0.74u w=0.17u l=0.17u
X416 cml_tlatch_82.xmux.xn.S1 CKB2_P cml_tlatch_82.xtail.S1 VSS sg13_lv_nmos ad=89.3f pd=0.85u as=89.3f ps=0.85u w=0.47u l=0.16u
X417 VDD A0_8_P VSS rppd l=5.17u w=1u
X418 cml_tlatch_1.xmux.xn.S1 cml_tlatch_2.OUTN B0_8_P VSS sg13_lv_nmos ad=0.1082p pd=1.34u as=63.19999f ps=0.74u w=0.26u l=0.38u
X419 cml_tlatch_30.xtail.S1 CKB0_P cml_tlatch_30.xmux.xn.S1 VSS sg13_lv_nmos ad=89.3f pd=0.85u as=0.1598p ps=1.62u w=0.47u l=0.16u
X420 cml_tlatch_34.xmux.xn.S1 CKA0_N cml_tlatch_34.xtail.S1 VSS sg13_lv_nmos ad=89.3f pd=0.85u as=0.1598p ps=1.62u w=0.47u l=0.16u
X421 cml_tlatch_68.xmux.xp.S1 A3_8_P A3_8_N VSS sg13_lv_nmos ad=56.9f pd=0.74u as=56.9f ps=0.74u w=0.17u l=0.17u
X422 A1_8_P A1_8_N cml_tlatch_19.xmux.xp.S1 VSS sg13_lv_nmos ad=56.9f pd=0.74u as=56.9f ps=0.74u w=0.17u l=0.17u
X423 B3_8_N B3_8_P cml_tlatch_64.xmux.xp.S1 VSS sg13_lv_nmos ad=56.9f pd=0.74u as=56.9f ps=0.74u w=0.17u l=0.17u
X424 hs_to_clk_0.sg13_lv_nmos_2HGZLP_0.G CKA0_P VSS rppd l=4.25u w=1u
X425 cml_tlatch_66.xtail.S1 CKB3_N cml_tlatch_66.xmux.xn.S1 VSS sg13_lv_nmos ad=89.3f pd=0.85u as=89.3f ps=0.85u w=0.47u l=0.16u
X426 cml_tlatch_21.xmux.xn.S1 CKA1_N cml_tlatch_21.xtail.S1 VSS sg13_lv_nmos ad=0.1598p pd=1.62u as=89.3f ps=0.85u w=0.47u l=0.16u
X427 cml_tlatch_50.xtail.S1 CKB3_N cml_tlatch_50.xmux.xn.S1 VSS sg13_lv_nmos ad=89.3f pd=0.85u as=0.1598p ps=1.62u w=0.47u l=0.16u
X428 cml_tlatch_55.xmux.xp.S1 MOT22_P MOT22_N VSS sg13_lv_nmos ad=56.9f pd=0.74u as=56.9f ps=0.74u w=0.17u l=0.17u
X429 cml_tlatch_18.xmux.xp.S1 cml_tlatch_18.OUTN cml_tlatch_18.OUTP VSS sg13_lv_nmos ad=0.1019p pd=1.34u as=56.9f ps=0.74u w=0.17u l=0.17u
X430 cml_tlatch_51.xmux.xp.S1 cml_tlatch_51.OUTP cml_tlatch_51.OUTN VSS sg13_lv_nmos ad=56.9f pd=0.74u as=56.9f ps=0.74u w=0.17u l=0.17u
X431 cml_tlatch_87.xmux.xp.S1 CKA2_P cml_tlatch_87.xtail.S1 VSS sg13_lv_nmos ad=89.3f pd=0.85u as=0.1598p ps=1.62u w=0.47u l=0.16u
X432 cml_tlatch_99.xmux.xn.S1 cml_tlatch_33.OUTP cml_tlatch_99.OUTN VSS sg13_lv_nmos ad=63.19999f pd=0.74u as=63.19999f ps=0.74u w=0.26u l=0.38u
X433 cml_tlatch_31.xmux.xp.S1 B0_2_P B0_2_N VSS sg13_lv_nmos ad=0.1019p pd=1.34u as=56.9f ps=0.74u w=0.17u l=0.17u
X434 cml_tlatch_63.xtail.S1 CKHA3_P cml_tlatch_63.xmux.xn.S1 VSS sg13_lv_nmos ad=0.1598p pd=1.62u as=89.3f ps=0.85u w=0.47u l=0.16u
X435 MOT26_N MOT26_P cml_tlatch_63.xmux.xp.S1 VSS sg13_lv_nmos ad=56.9f pd=0.74u as=56.9f ps=0.74u w=0.17u l=0.17u
X436 cml_tlatch_32.xtail.S1 CKB0_N cml_tlatch_32.xmux.xp.S1 VSS sg13_lv_nmos ad=89.3f pd=0.85u as=89.3f ps=0.85u w=0.47u l=0.16u
X437 cml_tlatch_56.xmux.xp.S1 cml_tlatch_56.OUTN cml_tlatch_56.OUTP VSS sg13_lv_nmos ad=56.9f pd=0.74u as=56.9f ps=0.74u w=0.17u l=0.17u
X438 cml_tlatch_47.xmux.xp.S1 B2_2_P B2_2_N VSS sg13_lv_nmos ad=56.9f pd=0.74u as=56.9f ps=0.74u w=0.17u l=0.17u
X439 cml_tlatch_2.xtail.S1 CKB0_N cml_tlatch_2.xmux.xp.S1 VSS sg13_lv_nmos ad=89.3f pd=0.85u as=0.1598p ps=1.62u w=0.47u l=0.16u
X440 cml_tlatch_49.OUTP cml_tlatch_49.OUTN cml_tlatch_49.xmux.xp.S1 VSS sg13_lv_nmos ad=56.9f pd=0.74u as=56.9f ps=0.74u w=0.17u l=0.17u
X441 B0_8_P B0_8_N cml_tlatch_1.xmux.xp.S1 VSS sg13_lv_nmos ad=56.9f pd=0.74u as=0.1019p ps=1.34u w=0.17u l=0.17u
X442 cml_tlatch_41.OUTP D1_N cml_tlatch_41.xmux.xn.S1 VSS sg13_lv_nmos ad=63.19999f pd=0.74u as=63.19999f ps=0.74u w=0.26u l=0.38u
X443 cml_tlatch_69.xmux.xp.S1 cml_tlatch_69.OUTP cml_tlatch_69.OUTN VSS sg13_lv_nmos ad=56.9f pd=0.74u as=56.9f ps=0.74u w=0.17u l=0.17u
X444 cml_tlatch_54.xmux.xp.S1 CKHA2_N cml_tlatch_54.xtail.S1 VSS sg13_lv_nmos ad=89.3f pd=0.85u as=89.3f ps=0.85u w=0.47u l=0.16u
X445 cml_tlatch_98.xtail.S1 CKB0_P cml_tlatch_98.xmux.xp.S1 VSS sg13_lv_nmos ad=89.3f pd=0.85u as=89.3f ps=0.85u w=0.47u l=0.16u
X446 cml_tlatch_65.xmux.xn.S1 cml_tlatch_73.INP cml_tlatch_65.OUTN VSS sg13_lv_nmos ad=0.1082p pd=1.34u as=63.19999f ps=0.74u w=0.26u l=0.38u
X447 cml_tlatch_80.xmux.xn.S1 B2_2_N MOT23_P VSS sg13_lv_nmos ad=63.19999f pd=0.74u as=63.19999f ps=0.74u w=0.26u l=0.38u
X448 cml_tlatch_65.xmux.xp.S1 CKB3_N cml_tlatch_65.xtail.S1 VSS sg13_lv_nmos ad=89.3f pd=0.85u as=89.3f ps=0.85u w=0.47u l=0.16u
X449 cml_tlatch_90.xtail.S1 CKB2_N cml_tlatch_90.xmux.xn.S1 VSS sg13_lv_nmos ad=89.3f pd=0.85u as=89.3f ps=0.85u w=0.47u l=0.16u
X450 cml_tlatch_65.xmux.xn.S1 cml_tlatch_73.INP cml_tlatch_65.OUTN VSS sg13_lv_nmos ad=63.19999f pd=0.74u as=63.19999f ps=0.74u w=0.26u l=0.38u
X451 MOT29_N MOT29_P cml_tlatch_74.xmux.xp.S1 VSS sg13_lv_nmos ad=56.9f pd=0.74u as=56.9f ps=0.74u w=0.17u l=0.17u
X452 cml_tlatch_60.xtail.S1 CKA2_N cml_tlatch_60.xmux.xn.S1 VSS sg13_lv_nmos ad=89.3f pd=0.85u as=89.3f ps=0.85u w=0.47u l=0.16u
X453 cml_tlatch_43.xtail.S1 CKHA1_P cml_tlatch_43.xmux.xn.S1 VSS sg13_lv_nmos ad=89.3f pd=0.85u as=89.3f ps=0.85u w=0.47u l=0.16u
X454 VSS POLN cml_tlatch_71.xtail.S1 VSS sg13_lv_nmos ad=1.5637p pd=8.61u as=1.5637p ps=8.61u w=8.23u l=0.13u
X455 cml_tlatch_74.xmux.xn.S1 cml_tlatch_74.INN MOT29_P VSS sg13_lv_nmos ad=63.19999f pd=0.74u as=63.19999f ps=0.74u w=0.26u l=0.38u
X456 MOT16_P A2_8_N cml_tlatch_52.xmux.xn.S1 VSS sg13_lv_nmos ad=63.19999f pd=0.74u as=63.19999f ps=0.74u w=0.26u l=0.38u
X457 cml_tlatch_20.xmux.xn.S1 cml_tlatch_43.INP cml_tlatch_20.OUTN VSS sg13_lv_nmos ad=63.19999f pd=0.74u as=63.19999f ps=0.74u w=0.26u l=0.38u
X458 cml_tlatch_41.xmux.xp.S1 CKA1_N cml_tlatch_41.xtail.S1 VSS sg13_lv_nmos ad=89.3f pd=0.85u as=89.3f ps=0.85u w=0.47u l=0.16u
X459 cml_tlatch_91.xmux.xp.S1 cml_tlatch_91.OUTP cml_tlatch_91.OUTN VSS sg13_lv_nmos ad=56.9f pd=0.74u as=56.9f ps=0.74u w=0.17u l=0.17u
X460 A0_2_N cml_tlatch_38.OUTP cml_tlatch_34.xmux.xn.S1 VSS sg13_lv_nmos ad=63.19999f pd=0.74u as=0.1082p ps=1.34u w=0.26u l=0.38u
X461 cml_tlatch_92.xmux.xp.S1 J4_N J4_P VSS sg13_lv_nmos ad=56.9f pd=0.74u as=56.9f ps=0.74u w=0.17u l=0.17u
X462 cml_tlatch_44.xmux.xp.S1 CKHA3_N cml_tlatch_44.xtail.S1 VSS sg13_lv_nmos ad=89.3f pd=0.85u as=89.3f ps=0.85u w=0.47u l=0.16u
X463 cml_tlatch_64.xtail.S1 CKB3_P cml_tlatch_64.xmux.xp.S1 VSS sg13_lv_nmos ad=89.3f pd=0.85u as=89.3f ps=0.85u w=0.47u l=0.16u
X464 cml_tlatch_5.xmux.xp.S1 MOT13_P MOT13_N VSS sg13_lv_nmos ad=56.9f pd=0.74u as=56.9f ps=0.74u w=0.17u l=0.17u
X465 cml_tlatch_74.xmux.xn.S1 cml_tlatch_74.INN MOT29_P VSS sg13_lv_nmos ad=63.19999f pd=0.74u as=63.19999f ps=0.74u w=0.26u l=0.38u
X466 cml_tlatch_29.xtail.S1 CKHA0_P cml_tlatch_29.xmux.xn.S1 VSS sg13_lv_nmos ad=89.3f pd=0.85u as=89.3f ps=0.85u w=0.47u l=0.16u
X467 cml_tlatch_96.xmux.xp.S1 cml_tlatch_5.INN cml_tlatch_5.INP VSS sg13_lv_nmos ad=56.9f pd=0.74u as=56.9f ps=0.74u w=0.17u l=0.17u
X468 J1_N J1_P cml_tlatch_95.xmux.xp.S1 VSS sg13_lv_nmos ad=56.9f pd=0.74u as=56.9f ps=0.74u w=0.17u l=0.17u
X469 cml_tlatch_14.xmux.xp.S1 MOT1_P MOT1_N VSS sg13_lv_nmos ad=56.9f pd=0.74u as=56.9f ps=0.74u w=0.17u l=0.17u
X470 cml_tlatch_92.xmux.xp.S1 CKJ_P cml_tlatch_92.xtail.S1 VSS sg13_lv_nmos ad=0.1598p pd=1.62u as=89.3f ps=0.85u w=0.47u l=0.16u
X471 cml_tlatch_95.xmux.xn.S1 J4_P J1_P VSS sg13_lv_nmos ad=63.19999f pd=0.74u as=63.19999f ps=0.74u w=0.26u l=0.38u
X472 cml_gate2_8.xamp.xn.S1 NS1_P cml_gate2_8.xrtail.R1 VSS sg13_lv_nmos ad=0.1007p pd=0.91u as=0.1007p ps=0.91u w=0.53u l=0.13u
X473 A0_2_P A0_2_N cml_tlatch_34.xmux.xp.S1 VSS sg13_lv_nmos ad=56.9f pd=0.74u as=56.9f ps=0.74u w=0.17u l=0.17u
X474 cml_tlatch_67.OUTP cml_tlatch_67.OUTN cml_tlatch_67.xmux.xp.S1 VSS sg13_lv_nmos ad=56.9f pd=0.74u as=56.9f ps=0.74u w=0.17u l=0.17u
X475 VSS POLN cml_tlatch_72.xtail.S1 VSS sg13_lv_nmos ad=2.7982p pd=17.14u as=1.5637p ps=8.61u w=8.23u l=0.13u
X476 cml_tlatch_34.xtail.S1 CKA0_P cml_tlatch_34.xmux.xp.S1 VSS sg13_lv_nmos ad=89.3f pd=0.85u as=89.3f ps=0.85u w=0.47u l=0.16u
X477 cml_tlatch_68.xmux.xp.S1 A3_8_N A3_8_P VSS sg13_lv_nmos ad=56.9f pd=0.74u as=56.9f ps=0.74u w=0.17u l=0.17u
X478 cml_tlatch_3.xtail.S1 CKHB1_N cml_tlatch_3.xmux.xp.S1 VSS sg13_lv_nmos ad=0.1598p pd=1.62u as=89.3f ps=0.85u w=0.47u l=0.16u
X479 A3_8_P cml_tlatch_69.OUTN cml_tlatch_68.xmux.xn.S1 VSS sg13_lv_nmos ad=63.19999f pd=0.74u as=63.19999f ps=0.74u w=0.26u l=0.38u
X480 cml_tlatch_47.xmux.xp.S1 B2_2_P B2_2_N VSS sg13_lv_nmos ad=56.9f pd=0.74u as=56.9f ps=0.74u w=0.17u l=0.17u
X481 cml_tlatch_17.xtail.S1 CKHB0_P cml_tlatch_17.xmux.xn.S1 VSS sg13_lv_nmos ad=89.3f pd=0.85u as=89.3f ps=0.85u w=0.47u l=0.16u
X482 cml_tlatch_37.xmux.xp.S1 CKB1_N cml_tlatch_37.xtail.S1 VSS sg13_lv_nmos ad=89.3f pd=0.85u as=89.3f ps=0.85u w=0.47u l=0.16u
X483 MOT22_P MOT22_N cml_tlatch_55.xmux.xp.S1 VSS sg13_lv_nmos ad=56.9f pd=0.74u as=56.9f ps=0.74u w=0.17u l=0.17u
X484 B0_8_P B0_8_N cml_tlatch_1.xmux.xp.S1 VSS sg13_lv_nmos ad=56.9f pd=0.74u as=56.9f ps=0.74u w=0.17u l=0.17u
X485 B1_8_N B1_8_P cml_tlatch_10.xmux.xp.S1 VSS sg13_lv_nmos ad=56.9f pd=0.74u as=56.9f ps=0.74u w=0.17u l=0.17u
X486 cml_tlatch_38.OUTN cml_tlatch_38.OUTP cml_tlatch_38.xmux.xp.S1 VSS sg13_lv_nmos ad=56.9f pd=0.74u as=56.9f ps=0.74u w=0.17u l=0.17u
X487 cml_tlatch_13.xmux.xp.S1 stub_bi_17.BOTP stub_bi_17.BOTN VSS sg13_lv_nmos ad=56.9f pd=0.74u as=56.9f ps=0.74u w=0.17u l=0.17u
X488 J1_P J1_N cml_tlatch_95.xmux.xp.S1 VSS sg13_lv_nmos ad=56.9f pd=0.74u as=56.9f ps=0.74u w=0.17u l=0.17u
X489 ENA_N J1_P cml_gate2_9.xamp.xn.S1 VSS sg13_lv_nmos ad=0.1007p pd=0.91u as=0.1007p ps=0.91u w=0.53u l=0.13u
X490 cml_gate2_3.xamp.xn.S1 CKB0_P cml_gate2_3.xrtail.R1 VSS sg13_lv_nmos ad=0.1007p pd=0.91u as=0.1007p ps=0.91u w=0.53u l=0.13u
X491 stub_bi_15.BOTN stub_bi_15.BOTP cml_tlatch_11.xmux.xp.S1 VSS sg13_lv_nmos ad=56.9f pd=0.74u as=0.1019p ps=1.34u w=0.17u l=0.17u
X492 cml_tlatch_60.xtail.S1 CKA2_P cml_tlatch_60.xmux.xp.S1 VSS sg13_lv_nmos ad=89.3f pd=0.85u as=89.3f ps=0.85u w=0.47u l=0.16u
X493 cml_tlatch_80.xmux.xp.S1 CKHB2_N cml_tlatch_80.xtail.S1 VSS sg13_lv_nmos ad=89.3f pd=0.85u as=89.3f ps=0.85u w=0.47u l=0.16u
X494 cml_tlatch_10.xtail.S1 CKB1_P cml_tlatch_10.xmux.xp.S1 VSS sg13_lv_nmos ad=89.3f pd=0.85u as=0.1598p ps=1.62u w=0.47u l=0.16u
X495 cml_tlatch_55.xmux.xn.S1 A2_2_P MOT22_N VSS sg13_lv_nmos ad=63.19999f pd=0.74u as=63.19999f ps=0.74u w=0.26u l=0.38u
X496 cml_tlatch_31.xmux.xn.S1 CKB0_N cml_tlatch_31.xtail.S1 VSS sg13_lv_nmos ad=89.3f pd=0.85u as=89.3f ps=0.85u w=0.47u l=0.16u
X497 cml_tlatch_26.xtail.S1 CKHA0_N cml_tlatch_26.xmux.xp.S1 VSS sg13_lv_nmos ad=89.3f pd=0.85u as=89.3f ps=0.85u w=0.47u l=0.16u
X498 B2_2_P B2_2_N cml_tlatch_47.xmux.xp.S1 VSS sg13_lv_nmos ad=56.9f pd=0.74u as=56.9f ps=0.74u w=0.17u l=0.17u
X499 cml_tlatch_26.xmux.xp.S1 MOT0_N MOT0_P VSS sg13_lv_nmos ad=56.9f pd=0.74u as=56.9f ps=0.74u w=0.17u l=0.17u
X500 cml_tlatch_15.xmux.xp.S1 MOT3_N MOT3_P VSS sg13_lv_nmos ad=56.9f pd=0.74u as=56.9f ps=0.74u w=0.17u l=0.17u
X501 J4_P J4_N cml_tlatch_92.xmux.xp.S1 VSS sg13_lv_nmos ad=56.9f pd=0.74u as=56.9f ps=0.74u w=0.17u l=0.17u
X502 cml_drv_0.xrtail.R1 ENB_N ENB1_P VSS sg13_lv_nmos ad=56.2f pd=0.74u as=56.2f ps=0.74u w=0.16u l=0.19u
X503 cml_tlatch_70.xtail.S1 CKA3_P cml_tlatch_70.xmux.xp.S1 VSS sg13_lv_nmos ad=89.3f pd=0.85u as=89.3f ps=0.85u w=0.47u l=0.16u
X504 cml_tlatch_23.xmux.xn.S1 CKA0_N cml_tlatch_23.xtail.S1 VSS sg13_lv_nmos ad=89.3f pd=0.85u as=89.3f ps=0.85u w=0.47u l=0.16u
X505 cml_tlatch_94.xmux.xn.S1 CKJ_N cml_tlatch_94.xtail.S1 VSS sg13_lv_nmos ad=89.3f pd=0.85u as=89.3f ps=0.85u w=0.47u l=0.16u
X506 MOT11_N MOT11_P cml_tlatch_4.xmux.xp.S1 VSS sg13_lv_nmos ad=56.9f pd=0.74u as=56.9f ps=0.74u w=0.17u l=0.17u
X507 stub_bi_29.BOTN stub_bi_29.BOTP cml_tlatch_35.xmux.xp.S1 VSS sg13_lv_nmos ad=56.9f pd=0.74u as=56.9f ps=0.74u w=0.17u l=0.17u
X508 VSS POLN cml_tlatch_93.xtail.S1 VSS sg13_lv_nmos ad=2.7982p pd=17.14u as=1.5637p ps=8.61u w=8.23u l=0.13u
X509 cml_tlatch_74.xtail.S1 CKHB3_P cml_tlatch_74.xmux.xn.S1 VSS sg13_lv_nmos ad=89.3f pd=0.85u as=89.3f ps=0.85u w=0.47u l=0.16u
X510 GA2_P ENA1_N cml_gate2_5.xamp.xn.S1 VSS sg13_lv_nmos ad=0.1007p pd=0.91u as=0.1007p ps=0.91u w=0.53u l=0.13u
X511 MOT15_N B1_2_P cml_tlatch_6.xmux.xn.S1 VSS sg13_lv_nmos ad=63.19999f pd=0.74u as=63.19999f ps=0.74u w=0.26u l=0.38u
X512 cml_tlatch_47.xtail.S1 CKB2_P cml_tlatch_47.xmux.xp.S1 VSS sg13_lv_nmos ad=89.3f pd=0.85u as=89.3f ps=0.85u w=0.47u l=0.16u
X513 cml_tlatch_97.xtail.S1 CKA1_P cml_tlatch_97.xmux.xp.S1 VSS sg13_lv_nmos ad=89.3f pd=0.85u as=89.3f ps=0.85u w=0.47u l=0.16u
X514 cml_tlatch_56.xmux.xp.S1 cml_tlatch_56.OUTP cml_tlatch_56.OUTN VSS sg13_lv_nmos ad=56.9f pd=0.74u as=56.9f ps=0.74u w=0.17u l=0.17u
X515 cml_tlatch_55.xmux.xp.S1 MOT22_P MOT22_N VSS sg13_lv_nmos ad=0.1019p pd=1.34u as=56.9f ps=0.74u w=0.17u l=0.17u
X516 MOT20_P cml_tlatch_91.OUTN cml_tlatch_54.xmux.xn.S1 VSS sg13_lv_nmos ad=63.19999f pd=0.74u as=63.19999f ps=0.74u w=0.26u l=0.38u
X517 MOT30_N MOT30_P cml_tlatch_45.xmux.xp.S1 VSS sg13_lv_nmos ad=56.9f pd=0.74u as=56.9f ps=0.74u w=0.17u l=0.17u
X518 stub_bi_55.BOTN stub_bi_38.BOTP cml_tlatch_90.xmux.xn.S1 VSS sg13_lv_nmos ad=63.19999f pd=0.74u as=63.19999f ps=0.74u w=0.26u l=0.38u
X519 cml_tlatch_25.xmux.xp.S1 CKHA1_N cml_tlatch_25.xtail.S1 VSS sg13_lv_nmos ad=89.3f pd=0.85u as=89.3f ps=0.85u w=0.47u l=0.16u
X520 cml_tlatch_0.OUTN cml_tlatch_99.OUTP cml_tlatch_0.xmux.xn.S1 VSS sg13_lv_nmos ad=63.19999f pd=0.74u as=0.1082p ps=1.34u w=0.26u l=0.38u
X521 cml_tlatch_0.xtail.S1 CKA0_N cml_tlatch_0.xmux.xp.S1 VSS sg13_lv_nmos ad=89.3f pd=0.85u as=89.3f ps=0.85u w=0.47u l=0.16u
X522 MOT29_N MOT29_P cml_tlatch_74.xmux.xp.S1 VSS sg13_lv_nmos ad=56.9f pd=0.74u as=0.1019p ps=1.34u w=0.17u l=0.17u
X523 cml_tlatch_52.xtail.S1 CKHA2_N cml_tlatch_52.xmux.xp.S1 VSS sg13_lv_nmos ad=89.3f pd=0.85u as=89.3f ps=0.85u w=0.47u l=0.16u
X524 VSS POLN cml_tlatch_88.xtail.S1 VSS sg13_lv_nmos ad=2.7982p pd=17.14u as=1.5637p ps=8.61u w=8.23u l=0.13u
X525 cml_tlatch_0.xtail.S1 CKA0_P cml_tlatch_0.xmux.xn.S1 VSS sg13_lv_nmos ad=89.3f pd=0.85u as=89.3f ps=0.85u w=0.47u l=0.16u
X526 cml_tlatch_25.xmux.xp.S1 MOT14_P MOT14_N VSS sg13_lv_nmos ad=56.9f pd=0.74u as=56.9f ps=0.74u w=0.17u l=0.17u
X527 stub_bi_15.BOTN stub_bi_15.BOTP cml_tlatch_11.xmux.xp.S1 VSS sg13_lv_nmos ad=56.9f pd=0.74u as=56.9f ps=0.74u w=0.17u l=0.17u
X528 cml_tlatch_10.xmux.xn.S1 stub_bi_15.BOTN B1_8_N VSS sg13_lv_nmos ad=0.1082p pd=1.34u as=63.19999f ps=0.74u w=0.26u l=0.38u
X529 cml_tlatch_63.INP cml_tlatch_71.OUTN cml_tlatch_70.xmux.xn.S1 VSS sg13_lv_nmos ad=0.1082p pd=1.34u as=63.19999f ps=0.74u w=0.26u l=0.38u
X530 cml_tlatch_6.xmux.xp.S1 CKHB1_N cml_tlatch_6.xtail.S1 VSS sg13_lv_nmos ad=89.3f pd=0.85u as=89.3f ps=0.85u w=0.47u l=0.16u
X531 cml_tlatch_82.xtail.S1 CKB2_P cml_tlatch_82.xmux.xn.S1 VSS sg13_lv_nmos ad=89.3f pd=0.85u as=89.3f ps=0.85u w=0.47u l=0.16u
X532 cml_tlatch_91.OUTP cml_tlatch_91.OUTN cml_tlatch_91.xmux.xp.S1 VSS sg13_lv_nmos ad=56.9f pd=0.74u as=56.9f ps=0.74u w=0.17u l=0.17u
X533 cml_gate2_1.xamp.xn.S1 ENB1_P GB0_N VSS sg13_lv_nmos ad=0.1007p pd=0.91u as=0.1007p ps=0.91u w=0.53u l=0.13u
X534 cml_tlatch_33.xtail.S1 POLN VSS VSS sg13_lv_nmos ad=1.5637p pd=8.61u as=1.5637p ps=8.61u w=8.23u l=0.13u
X535 cml_tlatch_87.xmux.xn.S1 cml_tlatch_87.INP cml_tlatch_87.OUTN VSS sg13_lv_nmos ad=63.19999f pd=0.74u as=63.19999f ps=0.74u w=0.26u l=0.38u
X536 cml_tlatch_97.INN cml_tlatch_97.INP cml_tlatch_39.xmux.xp.S1 VSS sg13_lv_nmos ad=56.9f pd=0.74u as=56.9f ps=0.74u w=0.17u l=0.17u
X537 MOT1_P MOT1_N cml_tlatch_14.xmux.xp.S1 VSS sg13_lv_nmos ad=56.9f pd=0.74u as=56.9f ps=0.74u w=0.17u l=0.17u
X538 B1_8_P B1_8_N cml_tlatch_10.xmux.xp.S1 VSS sg13_lv_nmos ad=56.9f pd=0.74u as=56.9f ps=0.74u w=0.17u l=0.17u
X539 cml_tlatch_43.xtail.S1 CKHA1_N cml_tlatch_43.xmux.xp.S1 VSS sg13_lv_nmos ad=89.3f pd=0.85u as=89.3f ps=0.85u w=0.47u l=0.16u
X540 stub_bi_31.BOTN stub_bi_31.BOTP cml_tlatch_37.xmux.xp.S1 VSS sg13_lv_nmos ad=56.9f pd=0.74u as=0.1019p ps=1.34u w=0.17u l=0.17u
X541 cml_tlatch_42.xmux.xp.S1 MOT8_P MOT8_N VSS sg13_lv_nmos ad=56.9f pd=0.74u as=56.9f ps=0.74u w=0.17u l=0.17u
X542 cml_tlatch_25.xmux.xp.S1 MOT14_N MOT14_P VSS sg13_lv_nmos ad=56.9f pd=0.74u as=56.9f ps=0.74u w=0.17u l=0.17u
X543 cml_tlatch_87.xmux.xn.S1 cml_tlatch_87.INP cml_tlatch_87.OUTN VSS sg13_lv_nmos ad=63.19999f pd=0.74u as=63.19999f ps=0.74u w=0.26u l=0.38u
X544 MOT16_P MOT16_N cml_tlatch_52.xmux.xp.S1 VSS sg13_lv_nmos ad=56.9f pd=0.74u as=0.1019p ps=1.34u w=0.17u l=0.17u
X545 MOT19_P MOT19_N cml_tlatch_78.xmux.xp.S1 VSS sg13_lv_nmos ad=56.9f pd=0.74u as=56.9f ps=0.74u w=0.17u l=0.17u
X546 cml_tlatch_14.xtail.S1 CKHB0_P cml_tlatch_14.xmux.xn.S1 VSS sg13_lv_nmos ad=89.3f pd=0.85u as=89.3f ps=0.85u w=0.47u l=0.16u
X547 cml_tlatch_5.INN stub_bi_29.BOTN cml_tlatch_96.xmux.xn.S1 VSS sg13_lv_nmos ad=63.19999f pd=0.74u as=63.19999f ps=0.74u w=0.26u l=0.38u
X548 cml_tlatch_84.xtail.S1 CKB2_N cml_tlatch_84.xmux.xp.S1 VSS sg13_lv_nmos ad=89.3f pd=0.85u as=89.3f ps=0.85u w=0.47u l=0.16u
X549 cml_tlatch_8.xmux.xn.S1 cml_tlatch_98.OUTN cml_tlatch_8.OUTP VSS sg13_lv_nmos ad=63.19999f pd=0.74u as=63.19999f ps=0.74u w=0.26u l=0.38u
X550 GA1_P ENA0_N cml_gate2_2.xamp.xn.S1 VSS sg13_lv_nmos ad=0.1007p pd=0.91u as=0.1007p ps=0.91u w=0.53u l=0.13u
X551 cml_tlatch_65.OUTP cml_tlatch_65.OUTN cml_tlatch_65.xmux.xp.S1 VSS sg13_lv_nmos ad=56.9f pd=0.74u as=56.9f ps=0.74u w=0.17u l=0.17u
X552 stub_bi_43.BOTP stub_bi_43.BOTN cml_tlatch_48.xmux.xp.S1 VSS sg13_lv_nmos ad=56.9f pd=0.74u as=56.9f ps=0.74u w=0.17u l=0.17u
X553 cml_tlatch_77.xmux.xp.S1 CKHB2_N cml_tlatch_77.xtail.S1 VSS sg13_lv_nmos ad=89.3f pd=0.85u as=89.3f ps=0.85u w=0.47u l=0.16u
X554 cml_tlatch_8.xmux.xn.S1 cml_tlatch_98.OUTN cml_tlatch_8.OUTP VSS sg13_lv_nmos ad=63.19999f pd=0.74u as=63.19999f ps=0.74u w=0.26u l=0.38u
X555 cml_tlatch_88.xmux.xn.S1 cml_tlatch_49.OUTP cml_tlatch_74.INN VSS sg13_lv_nmos ad=63.19999f pd=0.74u as=63.19999f ps=0.74u w=0.26u l=0.38u
X556 cml_tlatch_73.xmux.xn.S1 cml_tlatch_73.INP MOT27_N VSS sg13_lv_nmos ad=63.19999f pd=0.74u as=0.1082p ps=1.34u w=0.26u l=0.38u
X557 MOT23_N MOT23_P cml_tlatch_80.xmux.xp.S1 VSS sg13_lv_nmos ad=56.9f pd=0.74u as=56.9f ps=0.74u w=0.17u l=0.17u
X558 cml_tlatch_75.xmux.xp.S1 MOT31_P MOT31_N VSS sg13_lv_nmos ad=56.9f pd=0.74u as=56.9f ps=0.74u w=0.17u l=0.17u
X559 VDD CKHA0_P VSS rppd l=13.09u w=1u
X560 cml_tlatch_42.xtail.S1 CKHA1_N cml_tlatch_42.xmux.xp.S1 VSS sg13_lv_nmos ad=89.3f pd=0.85u as=89.3f ps=0.85u w=0.47u l=0.16u
X561 cml_tlatch_86.OUTN cml_tlatch_86.OUTP cml_tlatch_86.xmux.xp.S1 VSS sg13_lv_nmos ad=56.9f pd=0.74u as=56.9f ps=0.74u w=0.17u l=0.17u
X562 cml_tlatch_82.xmux.xp.S1 stub_bi_62.BOTN stub_bi_62.BOTP VSS sg13_lv_nmos ad=56.9f pd=0.74u as=56.9f ps=0.74u w=0.17u l=0.17u
X563 VDD cml_tlatch_41.OUTN VSS rppd l=5.17u w=1u
X564 cml_gate2_9.xamp.xn.S1 NM1_P cml_gate2_9.xrtail.R1 VSS sg13_lv_nmos ad=0.1007p pd=0.91u as=0.1007p ps=0.91u w=0.53u l=0.13u
X565 cml_tlatch_51.xmux.xn.S1 D3_P cml_tlatch_51.OUTN VSS sg13_lv_nmos ad=0.1082p pd=1.34u as=63.19999f ps=0.74u w=0.26u l=0.38u
X566 cml_tlatch_62.xmux.xp.S1 MOT24_P MOT24_N VSS sg13_lv_nmos ad=56.9f pd=0.74u as=56.9f ps=0.74u w=0.17u l=0.17u
X567 cml_tlatch_85.xtail.S1 CKA2_N cml_tlatch_85.xmux.xn.S1 VSS sg13_lv_nmos ad=89.3f pd=0.85u as=89.3f ps=0.85u w=0.47u l=0.16u
X568 cml_gate2_6.xamp.xn.S1 ENB0_N GB3_P VSS sg13_lv_nmos ad=0.1007p pd=0.91u as=0.1007p ps=0.91u w=0.53u l=0.13u
X569 cml_tlatch_15.xmux.xp.S1 MOT3_N MOT3_P VSS sg13_lv_nmos ad=56.9f pd=0.74u as=56.9f ps=0.74u w=0.17u l=0.17u
X570 cml_tlatch_51.xmux.xn.S1 D3_P cml_tlatch_51.OUTN VSS sg13_lv_nmos ad=63.19999f pd=0.74u as=63.19999f ps=0.74u w=0.26u l=0.38u
X571 cml_tlatch_35.xtail.S1 CKB1_N cml_tlatch_35.xmux.xp.S1 VSS sg13_lv_nmos ad=89.3f pd=0.85u as=89.3f ps=0.85u w=0.47u l=0.16u
X572 cml_tlatch_2.xmux.xp.S1 cml_tlatch_2.OUTP cml_tlatch_2.OUTN VSS sg13_lv_nmos ad=56.9f pd=0.74u as=56.9f ps=0.74u w=0.17u l=0.17u
X573 cml_tlatch_41.xmux.xn.S1 D1_P cml_tlatch_41.OUTN VSS sg13_lv_nmos ad=63.19999f pd=0.74u as=63.19999f ps=0.74u w=0.26u l=0.38u
X574 stub_bi_31.BOTN stub_bi_31.BOTP cml_tlatch_37.xmux.xp.S1 VSS sg13_lv_nmos ad=56.9f pd=0.74u as=56.9f ps=0.74u w=0.17u l=0.17u
X575 cml_tlatch_65.xtail.S1 POLN VSS VSS sg13_lv_nmos ad=1.5637p pd=8.61u as=2.7982p ps=17.14u w=8.23u l=0.13u
X576 cml_tlatch_29.xmux.xn.S1 CKHA0_P cml_tlatch_29.xtail.S1 VSS sg13_lv_nmos ad=89.3f pd=0.85u as=0.1598p ps=1.62u w=0.47u l=0.16u
X577 A3_2_N A3_2_P cml_tlatch_57.xmux.xp.S1 VSS sg13_lv_nmos ad=56.9f pd=0.74u as=56.9f ps=0.74u w=0.17u l=0.17u
X578 MOT16_P MOT16_N cml_tlatch_52.xmux.xp.S1 VSS sg13_lv_nmos ad=56.9f pd=0.74u as=56.9f ps=0.74u w=0.17u l=0.17u
X579 cml_tlatch_7.OUTN cml_tlatch_7.OUTP cml_tlatch_7.xmux.xp.S1 VSS sg13_lv_nmos ad=56.9f pd=0.74u as=56.9f ps=0.74u w=0.17u l=0.17u
X580 cml_tlatch_38.xmux.xn.S1 CKA0_P cml_tlatch_38.xtail.S1 VSS sg13_lv_nmos ad=89.3f pd=0.85u as=89.3f ps=0.85u w=0.47u l=0.16u
X581 VSS hs_to_clk_2.sg13_lv_nmos_2HGZLP_0.G VSS VSS sg13_lv_nmos ad=2.071p pd=11.28u as=0 ps=0 w=10.9u l=1.38u
X582 cml_tlatch_71.OUTP cml_tlatch_44.INN cml_tlatch_71.xmux.xn.S1 VSS sg13_lv_nmos ad=63.19999f pd=0.74u as=0.1082p ps=1.34u w=0.26u l=0.38u
X583 cml_tlatch_1.xmux.xn.S1 cml_tlatch_2.OUTP B0_8_N VSS sg13_lv_nmos ad=63.19999f pd=0.74u as=0.1082p ps=1.34u w=0.26u l=0.38u
X584 cml_tlatch_81.xtail.S1 CKB2_N cml_tlatch_81.xmux.xn.S1 VSS sg13_lv_nmos ad=0.1598p pd=1.62u as=89.3f ps=0.85u w=0.47u l=0.16u
X585 cml_tlatch_46.xmux.xn.S1 B2_2_N stub_bi_38.BOTN VSS sg13_lv_nmos ad=63.19999f pd=0.74u as=63.19999f ps=0.74u w=0.26u l=0.38u
X586 cml_tlatch_22.OUTN cml_tlatch_24.INP cml_tlatch_22.xmux.xn.S1 VSS sg13_lv_nmos ad=63.19999f pd=0.74u as=63.19999f ps=0.74u w=0.26u l=0.38u
X587 cml_tlatch_84.xmux.xp.S1 stub_bi_49.BOTP stub_bi_49.BOTN VSS sg13_lv_nmos ad=56.9f pd=0.74u as=56.9f ps=0.74u w=0.17u l=0.17u
X588 cml_tlatch_23.OUTP cml_tlatch_23.OUTN cml_tlatch_23.xmux.xp.S1 VSS sg13_lv_nmos ad=56.9f pd=0.74u as=56.9f ps=0.74u w=0.17u l=0.17u
X589 MOT2_N MOT2_P cml_tlatch_27.xmux.xp.S1 VSS sg13_lv_nmos ad=56.9f pd=0.74u as=56.9f ps=0.74u w=0.17u l=0.17u
X590 cml_tlatch_3.xmux.xp.S1 CKHB1_N cml_tlatch_3.xtail.S1 VSS sg13_lv_nmos ad=89.3f pd=0.85u as=89.3f ps=0.85u w=0.47u l=0.16u
X591 cml_tlatch_40.xmux.xp.S1 A1_2_P A1_2_N VSS sg13_lv_nmos ad=56.9f pd=0.74u as=56.9f ps=0.74u w=0.17u l=0.17u
X592 cml_tlatch_79.xmux.xp.S1 MOT21_N MOT21_P VSS sg13_lv_nmos ad=56.9f pd=0.74u as=56.9f ps=0.74u w=0.17u l=0.17u
X593 B1_2_N B1_2_P cml_tlatch_36.xmux.xp.S1 VSS sg13_lv_nmos ad=56.9f pd=0.74u as=56.9f ps=0.74u w=0.17u l=0.17u
X594 cml_tlatch_21.xtail.S1 CKA1_N cml_tlatch_21.xmux.xn.S1 VSS sg13_lv_nmos ad=89.3f pd=0.85u as=89.3f ps=0.85u w=0.47u l=0.16u
X595 cml_tlatch_91.xmux.xn.S1 cml_tlatch_91.INP cml_tlatch_91.OUTN VSS sg13_lv_nmos ad=63.19999f pd=0.74u as=63.19999f ps=0.74u w=0.26u l=0.38u
X596 cml_tlatch_24.xmux.xp.S1 MOT12_N MOT12_P VSS sg13_lv_nmos ad=56.9f pd=0.74u as=56.9f ps=0.74u w=0.17u l=0.17u
X597 cml_tlatch_51.OUTP cml_tlatch_51.OUTN cml_tlatch_51.xmux.xp.S1 VSS sg13_lv_nmos ad=56.9f pd=0.74u as=56.9f ps=0.74u w=0.17u l=0.17u
X598 cml_tlatch_5.xtail.S1 CKHB1_N cml_tlatch_5.xmux.xp.S1 VSS sg13_lv_nmos ad=89.3f pd=0.85u as=0.1598p ps=1.62u w=0.47u l=0.16u
X599 cml_tlatch_31.xtail.S1 CKB0_N cml_tlatch_31.xmux.xn.S1 VSS sg13_lv_nmos ad=89.3f pd=0.85u as=0.1598p ps=1.62u w=0.47u l=0.16u
X600 cml_tlatch_24.xtail.S1 CKHA1_P cml_tlatch_24.xmux.xn.S1 VSS sg13_lv_nmos ad=89.3f pd=0.85u as=89.3f ps=0.85u w=0.47u l=0.16u
X601 cml_tlatch_47.xmux.xn.S1 stub_bi_43.BOTN B2_2_N VSS sg13_lv_nmos ad=63.19999f pd=0.74u as=63.19999f ps=0.74u w=0.26u l=0.38u
X602 cml_tlatch_91.OUTP cml_tlatch_91.OUTN cml_tlatch_91.xmux.xp.S1 VSS sg13_lv_nmos ad=56.9f pd=0.74u as=56.9f ps=0.74u w=0.17u l=0.17u
X603 cml_tlatch_98.xtail.S1 CKB0_P cml_tlatch_98.xmux.xp.S1 VSS sg13_lv_nmos ad=89.3f pd=0.85u as=89.3f ps=0.85u w=0.47u l=0.16u
X604 cml_tlatch_48.xmux.xn.S1 D2_N stub_bi_43.BOTN VSS sg13_lv_nmos ad=63.19999f pd=0.74u as=0.1082p ps=1.34u w=0.26u l=0.38u
X605 cml_tlatch_90.xmux.xp.S1 stub_bi_55.BOTP stub_bi_55.BOTN VSS sg13_lv_nmos ad=56.9f pd=0.74u as=56.9f ps=0.74u w=0.17u l=0.17u
X606 cml_tlatch_18.OUTP cml_tlatch_18.OUTN cml_tlatch_18.xmux.xp.S1 VSS sg13_lv_nmos ad=56.9f pd=0.74u as=56.9f ps=0.74u w=0.17u l=0.17u
X607 cml_tlatch_55.xmux.xn.S1 CKHA2_P cml_tlatch_55.xtail.S1 VSS sg13_lv_nmos ad=89.3f pd=0.85u as=89.3f ps=0.85u w=0.47u l=0.16u
X608 cml_tlatch_77.xmux.xp.S1 MOT17_P MOT17_N VSS sg13_lv_nmos ad=56.9f pd=0.74u as=56.9f ps=0.74u w=0.17u l=0.17u
X609 MOT5_N cml_tlatch_98.OUTP cml_tlatch_16.xmux.xn.S1 VSS sg13_lv_nmos ad=63.19999f pd=0.74u as=63.19999f ps=0.74u w=0.26u l=0.38u
X610 MOT25_N MOT25_P cml_tlatch_72.xmux.xp.S1 VSS sg13_lv_nmos ad=56.9f pd=0.74u as=56.9f ps=0.74u w=0.17u l=0.17u
X611 cml_tlatch_56.xtail.S1 CKA3_N cml_tlatch_56.xmux.xp.S1 VSS sg13_lv_nmos ad=89.3f pd=0.85u as=89.3f ps=0.85u w=0.47u l=0.16u
X612 ENA1_N VDD VSS rppd l=8.13u w=1u
X613 B0_2_N B0_2_P cml_tlatch_31.xmux.xp.S1 VSS sg13_lv_nmos ad=56.9f pd=0.74u as=56.9f ps=0.74u w=0.17u l=0.17u
X614 A0_8_P A0_8_N cml_tlatch_9.xmux.xp.S1 VSS sg13_lv_nmos ad=56.9f pd=0.74u as=0.1019p ps=1.34u w=0.17u l=0.17u
X615 cml_tlatch_20.xmux.xp.S1 CKA1_N cml_tlatch_20.xtail.S1 VSS sg13_lv_nmos ad=89.3f pd=0.85u as=89.3f ps=0.85u w=0.47u l=0.16u
X616 VDD cml_tlatch_91.OUTP VSS rppd l=5.17u w=1u
X617 cml_drv_2.xrtail.R1 ENB_N ENB0_P VSS sg13_lv_nmos ad=56.2f pd=0.74u as=56.2f ps=0.74u w=0.16u l=0.19u
X618 cml_tlatch_42.xmux.xp.S1 MOT8_P MOT8_N VSS sg13_lv_nmos ad=0.1019p pd=1.34u as=56.9f ps=0.74u w=0.17u l=0.17u
X619 cml_tlatch_60.xtail.S1 CKA2_N cml_tlatch_60.xmux.xn.S1 VSS sg13_lv_nmos ad=89.3f pd=0.85u as=89.3f ps=0.85u w=0.47u l=0.16u
X620 cml_tlatch_33.xmux.xp.S1 cml_tlatch_33.OUTN cml_tlatch_33.OUTP VSS sg13_lv_nmos ad=56.9f pd=0.74u as=56.9f ps=0.74u w=0.17u l=0.17u
X621 cml_gate2_9.xrtail.R1 NM1_N ENA_P VSS sg13_lv_nmos ad=0.1007p pd=0.91u as=0.1802p ps=1.74u w=0.53u l=0.13u
X622 cml_tlatch_86.xmux.xp.S1 cml_tlatch_86.OUTN cml_tlatch_86.OUTP VSS sg13_lv_nmos ad=56.9f pd=0.74u as=56.9f ps=0.74u w=0.17u l=0.17u
X623 cml_tlatch_77.xmux.xp.S1 MOT17_N MOT17_P VSS sg13_lv_nmos ad=56.9f pd=0.74u as=56.9f ps=0.74u w=0.17u l=0.17u
X624 cml_tlatch_57.xmux.xp.S1 A3_2_N A3_2_P VSS sg13_lv_nmos ad=56.9f pd=0.74u as=56.9f ps=0.74u w=0.17u l=0.17u
X625 cml_tlatch_56.OUTP A3_2_N cml_tlatch_56.xmux.xn.S1 VSS sg13_lv_nmos ad=63.19999f pd=0.74u as=63.19999f ps=0.74u w=0.26u l=0.38u
X626 cml_tlatch_30.xtail.S1 CKB0_N cml_tlatch_30.xmux.xp.S1 VSS sg13_lv_nmos ad=89.3f pd=0.85u as=89.3f ps=0.85u w=0.47u l=0.16u
X627 cml_tlatch_52.xmux.xp.S1 CKHA2_N cml_tlatch_52.xtail.S1 VSS sg13_lv_nmos ad=89.3f pd=0.85u as=89.3f ps=0.85u w=0.47u l=0.16u
X628 cml_gate2_4.xrtail.R1 CKB3_N GA3_P VSS sg13_lv_nmos ad=0.1007p pd=0.91u as=0.1007p ps=0.91u w=0.53u l=0.13u
X629 cml_tlatch_75.xmux.xp.S1 MOT31_P MOT31_N VSS sg13_lv_nmos ad=56.9f pd=0.74u as=56.9f ps=0.74u w=0.17u l=0.17u
X630 cml_tlatch_11.xmux.xp.S1 CKB1_N cml_tlatch_11.xtail.S1 VSS sg13_lv_nmos ad=89.3f pd=0.85u as=89.3f ps=0.85u w=0.47u l=0.16u
X631 GA2_N ENA1_P cml_gate2_5.xamp.xn.S1 VSS sg13_lv_nmos ad=0.1007p pd=0.91u as=0.1007p ps=0.91u w=0.53u l=0.13u
X632 cml_tlatch_86.xmux.xn.S1 cml_tlatch_87.OUTP cml_tlatch_86.OUTN VSS sg13_lv_nmos ad=63.19999f pd=0.74u as=63.19999f ps=0.74u w=0.26u l=0.38u
X633 cml_tlatch_47.xtail.S1 CKB2_N cml_tlatch_47.xmux.xn.S1 VSS sg13_lv_nmos ad=0.1598p pd=1.62u as=89.3f ps=0.85u w=0.47u l=0.16u
X634 cml_tlatch_17.xtail.S1 CKHB0_P cml_tlatch_17.xmux.xn.S1 VSS sg13_lv_nmos ad=89.3f pd=0.85u as=89.3f ps=0.85u w=0.47u l=0.16u
X635 cml_tlatch_28.xmux.xp.S1 MOT4_P MOT4_N VSS sg13_lv_nmos ad=56.9f pd=0.74u as=56.9f ps=0.74u w=0.17u l=0.17u
X636 cml_tlatch_37.xmux.xp.S1 CKB1_N cml_tlatch_37.xtail.S1 VSS sg13_lv_nmos ad=89.3f pd=0.85u as=89.3f ps=0.85u w=0.47u l=0.16u
X637 cml_tlatch_83.xmux.xp.S1 stub_bi_63.BOTP stub_bi_63.BOTN VSS sg13_lv_nmos ad=56.9f pd=0.74u as=56.9f ps=0.74u w=0.17u l=0.17u
X638 cml_tlatch_83.xmux.xp.S1 stub_bi_63.BOTN stub_bi_63.BOTP VSS sg13_lv_nmos ad=56.9f pd=0.74u as=56.9f ps=0.74u w=0.17u l=0.17u
X639 cml_tlatch_43.INP cml_tlatch_43.INN cml_tlatch_21.xmux.xp.S1 VSS sg13_lv_nmos ad=56.9f pd=0.74u as=56.9f ps=0.74u w=0.17u l=0.17u
X640 MOT15_N MOT15_P cml_tlatch_6.xmux.xp.S1 VSS sg13_lv_nmos ad=56.9f pd=0.74u as=56.9f ps=0.74u w=0.17u l=0.17u
X641 cml_tlatch_51.xtail.S1 CKB3_P cml_tlatch_51.xmux.xn.S1 VSS sg13_lv_nmos ad=89.3f pd=0.85u as=0.1598p ps=1.62u w=0.47u l=0.16u
X642 cml_tlatch_1.xtail.S1 POLN VSS VSS sg13_lv_nmos ad=1.5637p pd=8.61u as=1.5637p ps=8.61u w=8.23u l=0.13u
X643 cml_tlatch_20.xmux.xp.S1 cml_tlatch_20.OUTP cml_tlatch_20.OUTN VSS sg13_lv_nmos ad=56.9f pd=0.74u as=56.9f ps=0.74u w=0.17u l=0.17u
X644 cml_tlatch_71.OUTP cml_tlatch_71.OUTN cml_tlatch_71.xmux.xp.S1 VSS sg13_lv_nmos ad=56.9f pd=0.74u as=56.9f ps=0.74u w=0.17u l=0.17u
X645 cml_tlatch_62.xmux.xp.S1 CKHA3_N cml_tlatch_62.xtail.S1 VSS sg13_lv_nmos ad=89.3f pd=0.85u as=89.3f ps=0.85u w=0.47u l=0.16u
X646 MOT23_P MOT23_N cml_tlatch_80.xmux.xp.S1 VSS sg13_lv_nmos ad=56.9f pd=0.74u as=56.9f ps=0.74u w=0.17u l=0.17u
X647 MOT4_N cml_tlatch_99.OUTP cml_tlatch_28.xmux.xn.S1 VSS sg13_lv_nmos ad=63.19999f pd=0.74u as=0.1082p ps=1.34u w=0.26u l=0.38u
X648 A1_8_N A1_8_P cml_tlatch_19.xmux.xp.S1 VSS sg13_lv_nmos ad=56.9f pd=0.74u as=56.9f ps=0.74u w=0.17u l=0.17u
X649 cml_tlatch_38.OUTP cml_tlatch_38.OUTN cml_tlatch_38.xmux.xp.S1 VSS sg13_lv_nmos ad=56.9f pd=0.74u as=56.9f ps=0.74u w=0.17u l=0.17u
X650 cml_gate2_1.xamp.xn.S1 CKA0_P cml_gate2_1.xrtail.R1 VSS sg13_lv_nmos ad=0.1007p pd=0.91u as=0.1007p ps=0.91u w=0.53u l=0.13u
X651 cml_drvb_8.xrtail.R2 VSS VSS rppd l=2.72u w=1u
X652 cml_tlatch_84.xmux.xp.S1 CKB2_N cml_tlatch_84.xtail.S1 VSS sg13_lv_nmos ad=89.3f pd=0.85u as=89.3f ps=0.85u w=0.47u l=0.16u
X653 cml_tlatch_98.xmux.xp.S1 cml_tlatch_98.OUTN cml_tlatch_98.OUTP VSS sg13_lv_nmos ad=56.9f pd=0.74u as=56.9f ps=0.74u w=0.17u l=0.17u
X654 cml_tlatch_50.xmux.xp.S1 B3_2_P B3_2_N VSS sg13_lv_nmos ad=56.9f pd=0.74u as=56.9f ps=0.74u w=0.17u l=0.17u
X655 cml_gate2_7.xamp.xn.S1 ENB0_N GB2_P VSS sg13_lv_nmos ad=0.1007p pd=0.91u as=0.1007p ps=0.91u w=0.53u l=0.13u
X656 cml_tlatch_54.xmux.xp.S1 MOT20_P MOT20_N VSS sg13_lv_nmos ad=56.9f pd=0.74u as=56.9f ps=0.74u w=0.17u l=0.17u
X657 cml_tlatch_80.xmux.xn.S1 B2_2_P MOT23_N VSS sg13_lv_nmos ad=63.19999f pd=0.74u as=63.19999f ps=0.74u w=0.26u l=0.38u
X658 cml_tlatch_71.xmux.xp.S1 CKA3_N cml_tlatch_71.xtail.S1 VSS sg13_lv_nmos ad=89.3f pd=0.85u as=0.1598p ps=1.62u w=0.47u l=0.16u
X659 cml_tlatch_93.xmux.xp.S1 CLK_W_N CLK_W_P VSS sg13_lv_nmos ad=56.9f pd=0.74u as=56.9f ps=0.74u w=0.17u l=0.17u
X660 cml_gate2_2.xamp.xn.S1 ENA0_P GA1_N VSS sg13_lv_nmos ad=0.1007p pd=0.91u as=0.1007p ps=0.91u w=0.53u l=0.13u
X661 B1_2_N B1_2_P cml_tlatch_36.xmux.xp.S1 VSS sg13_lv_nmos ad=56.9f pd=0.74u as=56.9f ps=0.74u w=0.17u l=0.17u
X662 cml_tlatch_66.xtail.S1 CKB3_P cml_tlatch_66.xmux.xp.S1 VSS sg13_lv_nmos ad=89.3f pd=0.85u as=89.3f ps=0.85u w=0.47u l=0.16u
X663 cml_tlatch_61.xtail.S1 CKA2_P cml_tlatch_61.xmux.xn.S1 VSS sg13_lv_nmos ad=89.3f pd=0.85u as=89.3f ps=0.85u w=0.47u l=0.16u
X664 cml_tlatch_7.xtail.S1 CKB0_P cml_tlatch_7.xmux.xp.S1 VSS sg13_lv_nmos ad=89.3f pd=0.85u as=89.3f ps=0.85u w=0.47u l=0.16u
X665 cml_tlatch_97.INP cml_tlatch_97.INN cml_tlatch_39.xmux.xp.S1 VSS sg13_lv_nmos ad=56.9f pd=0.74u as=56.9f ps=0.74u w=0.17u l=0.17u
X666 cml_tlatch_7.xtail.S1 CKB0_N cml_tlatch_7.xmux.xn.S1 VSS sg13_lv_nmos ad=89.3f pd=0.85u as=89.3f ps=0.85u w=0.47u l=0.16u
X667 cml_tlatch_24.xmux.xn.S1 cml_tlatch_24.INP MOT12_N VSS sg13_lv_nmos ad=0.1082p pd=1.34u as=63.19999f ps=0.74u w=0.26u l=0.38u
X668 A3_8_N A3_8_P cml_tlatch_68.xmux.xp.S1 VSS sg13_lv_nmos ad=56.9f pd=0.74u as=56.9f ps=0.74u w=0.17u l=0.17u
X669 cml_tlatch_72.xmux.xp.S1 MOT25_N MOT25_P VSS sg13_lv_nmos ad=56.9f pd=0.74u as=56.9f ps=0.74u w=0.17u l=0.17u
X670 B2_8_P B2_8_N cml_tlatch_81.xmux.xp.S1 VSS sg13_lv_nmos ad=56.9f pd=0.74u as=56.9f ps=0.74u w=0.17u l=0.17u
X671 cml_tlatch_61.xmux.xp.S1 cml_tlatch_61.OUTN cml_tlatch_61.OUTP VSS sg13_lv_nmos ad=56.9f pd=0.74u as=56.9f ps=0.74u w=0.17u l=0.17u
X672 GA1_N ENA0_P cml_gate2_2.xamp.xn.S1 VSS sg13_lv_nmos ad=0.1007p pd=0.91u as=0.1007p ps=0.91u w=0.53u l=0.13u
X673 cml_tlatch_19.xmux.xp.S1 A1_8_N A1_8_P VSS sg13_lv_nmos ad=56.9f pd=0.74u as=56.9f ps=0.74u w=0.17u l=0.17u
X674 MOT11_N cml_tlatch_4.INP cml_tlatch_4.xmux.xn.S1 VSS sg13_lv_nmos ad=63.19999f pd=0.74u as=63.19999f ps=0.74u w=0.26u l=0.38u
X675 cml_gate2_8.xamp.xn.S1 J2_P ENB_N VSS sg13_lv_nmos ad=0.1007p pd=0.91u as=0.1007p ps=0.91u w=0.53u l=0.13u
X676 MOT5_N MOT5_P cml_tlatch_16.xmux.xp.S1 VSS sg13_lv_nmos ad=56.9f pd=0.74u as=56.9f ps=0.74u w=0.17u l=0.17u
X677 cml_tlatch_99.OUTP cml_tlatch_33.OUTN cml_tlatch_99.xmux.xn.S1 VSS sg13_lv_nmos ad=0.1082p pd=1.34u as=63.19999f ps=0.74u w=0.26u l=0.38u
X678 cml_tlatch_6.xmux.xp.S1 CKHB1_N cml_tlatch_6.xtail.S1 VSS sg13_lv_nmos ad=89.3f pd=0.85u as=89.3f ps=0.85u w=0.47u l=0.16u
X679 cml_tlatch_35.xmux.xp.S1 CKB1_N cml_tlatch_35.xtail.S1 VSS sg13_lv_nmos ad=89.3f pd=0.85u as=89.3f ps=0.85u w=0.47u l=0.16u
X680 cml_tlatch_58.xmux.xp.S1 cml_tlatch_58.OUTP cml_tlatch_58.OUTN VSS sg13_lv_nmos ad=56.9f pd=0.74u as=56.9f ps=0.74u w=0.17u l=0.17u
X681 MOT22_N MOT22_P cml_tlatch_55.xmux.xp.S1 VSS sg13_lv_nmos ad=56.9f pd=0.74u as=56.9f ps=0.74u w=0.17u l=0.17u
X682 cml_tlatch_18.OUTP cml_tlatch_18.OUTN cml_tlatch_18.xmux.xp.S1 VSS sg13_lv_nmos ad=56.9f pd=0.74u as=56.9f ps=0.74u w=0.17u l=0.17u
X683 MOT11_N cml_tlatch_4.INP cml_tlatch_4.xmux.xn.S1 VSS sg13_lv_nmos ad=63.19999f pd=0.74u as=63.19999f ps=0.74u w=0.26u l=0.38u
X684 cml_tlatch_13.xmux.xp.S1 stub_bi_17.BOTN stub_bi_17.BOTP VSS sg13_lv_nmos ad=56.9f pd=0.74u as=56.9f ps=0.74u w=0.17u l=0.17u
X685 cml_tlatch_51.OUTN cml_tlatch_51.OUTP cml_tlatch_51.xmux.xp.S1 VSS sg13_lv_nmos ad=56.9f pd=0.74u as=56.9f ps=0.74u w=0.17u l=0.17u
X686 ENA1_P ENA_N cml_drv_1.xrtail.R1 VSS sg13_lv_nmos ad=56.2f pd=0.74u as=56.2f ps=0.74u w=0.16u l=0.19u
X687 B0_2_N B0_2_P cml_tlatch_31.xmux.xp.S1 VSS sg13_lv_nmos ad=56.9f pd=0.74u as=56.9f ps=0.74u w=0.17u l=0.17u
X688 cml_tlatch_99.OUTP cml_tlatch_33.OUTN cml_tlatch_99.xmux.xn.S1 VSS sg13_lv_nmos ad=63.19999f pd=0.74u as=63.19999f ps=0.74u w=0.26u l=0.38u
X689 cml_tlatch_56.OUTP cml_tlatch_56.OUTN cml_tlatch_56.xmux.xp.S1 VSS sg13_lv_nmos ad=56.9f pd=0.74u as=56.9f ps=0.74u w=0.17u l=0.17u
X690 CLK_W_P CLK_W_N cml_tlatch_93.xmux.xp.S1 VSS sg13_lv_nmos ad=56.9f pd=0.74u as=0.1019p ps=1.34u w=0.17u l=0.17u
X691 J4_P CLK_W_P cml_tlatch_92.xmux.xn.S1 VSS sg13_lv_nmos ad=0.1082p pd=1.34u as=63.19999f ps=0.74u w=0.26u l=0.38u
X692 cml_tlatch_69.OUTN cml_tlatch_69.OUTP cml_tlatch_69.xmux.xp.S1 VSS sg13_lv_nmos ad=56.9f pd=0.74u as=56.9f ps=0.74u w=0.17u l=0.17u
X693 cml_tlatch_78.xmux.xp.S1 MOT19_P MOT19_N VSS sg13_lv_nmos ad=56.9f pd=0.74u as=56.9f ps=0.74u w=0.17u l=0.17u
X694 VDD J1_P VSS rppd l=5.17u w=1u
X695 cml_tlatch_14.xtail.S1 CKHB0_P cml_tlatch_14.xmux.xn.S1 VSS sg13_lv_nmos ad=89.3f pd=0.85u as=89.3f ps=0.85u w=0.47u l=0.16u
X696 cml_tlatch_19.xmux.xp.S1 A1_8_P A1_8_N VSS sg13_lv_nmos ad=0.1019p pd=1.34u as=56.9f ps=0.74u w=0.17u l=0.17u
X697 stub_bi_62.BOTN stub_bi_62.BOTP cml_tlatch_82.xmux.xp.S1 VSS sg13_lv_nmos ad=56.9f pd=0.74u as=56.9f ps=0.74u w=0.17u l=0.17u
X698 VSS POLN cml_tlatch_98.xtail.S1 VSS sg13_lv_nmos ad=2.7982p pd=17.14u as=1.5637p ps=8.61u w=8.23u l=0.13u
X699 cml_tlatch_73.INN cml_tlatch_67.OUTP cml_tlatch_66.xmux.xn.S1 VSS sg13_lv_nmos ad=63.19999f pd=0.74u as=63.19999f ps=0.74u w=0.26u l=0.38u
X700 cml_tlatch_63.xmux.xn.S1 CKHA3_P cml_tlatch_63.xtail.S1 VSS sg13_lv_nmos ad=89.3f pd=0.85u as=89.3f ps=0.85u w=0.47u l=0.16u
X701 stub_bi_38.BOTP stub_bi_38.BOTN cml_tlatch_46.xmux.xp.S1 VSS sg13_lv_nmos ad=56.9f pd=0.74u as=56.9f ps=0.74u w=0.17u l=0.17u
X702 cml_tlatch_6.xmux.xp.S1 MOT15_N MOT15_P VSS sg13_lv_nmos ad=56.9f pd=0.74u as=56.9f ps=0.74u w=0.17u l=0.17u
X703 cml_tlatch_54.xmux.xn.S1 cml_tlatch_91.OUTN MOT20_P VSS sg13_lv_nmos ad=63.19999f pd=0.74u as=63.19999f ps=0.74u w=0.26u l=0.38u
X704 cml_tlatch_90.xmux.xn.S1 stub_bi_38.BOTP stub_bi_55.BOTN VSS sg13_lv_nmos ad=63.19999f pd=0.74u as=63.19999f ps=0.74u w=0.26u l=0.38u
X705 cml_tlatch_29.xmux.xp.S1 MOT6_P MOT6_N VSS sg13_lv_nmos ad=56.9f pd=0.74u as=56.9f ps=0.74u w=0.17u l=0.17u
X706 cml_tlatch_43.INN cml_tlatch_43.INP cml_tlatch_21.xmux.xp.S1 VSS sg13_lv_nmos ad=56.9f pd=0.74u as=0.1019p ps=1.34u w=0.17u l=0.17u
X707 cml_tlatch_29.xmux.xn.S1 A0_2_N MOT6_P VSS sg13_lv_nmos ad=63.19999f pd=0.74u as=63.19999f ps=0.74u w=0.26u l=0.38u
X708 hs_to_clk_5.D2 CK_N CKB3_P VSS sg13_lv_nmos ad=0.228p pd=1.58u as=0.408p ps=3.08u w=1.2u l=0.2u
X709 cml_tlatch_39.xmux.xp.S1 cml_tlatch_97.INN cml_tlatch_97.INP VSS sg13_lv_nmos ad=0.1019p pd=1.34u as=56.9f ps=0.74u w=0.17u l=0.17u
X710 cml_tlatch_76.xmux.xn.S1 CKA2_P cml_tlatch_76.xtail.S1 VSS sg13_lv_nmos ad=89.3f pd=0.85u as=89.3f ps=0.85u w=0.47u l=0.16u
X711 cml_tlatch_55.xtail.S1 CKHA2_P cml_tlatch_55.xmux.xn.S1 VSS sg13_lv_nmos ad=89.3f pd=0.85u as=89.3f ps=0.85u w=0.47u l=0.16u
X712 cml_tlatch_8.xmux.xp.S1 cml_tlatch_8.OUTN cml_tlatch_8.OUTP VSS sg13_lv_nmos ad=56.9f pd=0.74u as=56.9f ps=0.74u w=0.17u l=0.17u
X713 cml_tlatch_18.OUTN cml_tlatch_23.OUTP cml_tlatch_18.xmux.xn.S1 VSS sg13_lv_nmos ad=63.19999f pd=0.74u as=63.19999f ps=0.74u w=0.26u l=0.38u
X714 cml_drv_0.xrtail.R1 ENB_N ENB1_P VSS sg13_lv_nmos ad=56.2f pd=0.74u as=56.2f ps=0.74u w=0.16u l=0.19u
X715 cml_tlatch_71.OUTP cml_tlatch_71.OUTN cml_tlatch_71.xmux.xp.S1 VSS sg13_lv_nmos ad=56.9f pd=0.74u as=56.9f ps=0.74u w=0.17u l=0.17u
X716 VSS POLN cml_tlatch_20.xtail.S1 VSS sg13_lv_nmos ad=2.7982p pd=17.14u as=1.5637p ps=8.61u w=8.23u l=0.13u
X717 cml_tlatch_67.xmux.xp.S1 cml_tlatch_67.OUTN cml_tlatch_67.OUTP VSS sg13_lv_nmos ad=56.9f pd=0.74u as=56.9f ps=0.74u w=0.17u l=0.17u
X718 cml_tlatch_51.xtail.S1 CKB3_N cml_tlatch_51.xmux.xp.S1 VSS sg13_lv_nmos ad=89.3f pd=0.85u as=89.3f ps=0.85u w=0.47u l=0.16u
X719 MOT18_N MOT18_P cml_tlatch_53.xmux.xp.S1 VSS sg13_lv_nmos ad=56.9f pd=0.74u as=56.9f ps=0.74u w=0.17u l=0.17u
X720 cml_tlatch_3.xmux.xn.S1 B1_8_P MOT9_N VSS sg13_lv_nmos ad=63.19999f pd=0.74u as=63.19999f ps=0.74u w=0.26u l=0.38u
X721 cml_tlatch_63.xmux.xp.S1 MOT26_P MOT26_N VSS sg13_lv_nmos ad=56.9f pd=0.74u as=56.9f ps=0.74u w=0.17u l=0.17u
X722 stub_bi_49.BOTN stub_bi_55.BOTP cml_tlatch_84.xmux.xn.S1 VSS sg13_lv_nmos ad=63.19999f pd=0.74u as=63.19999f ps=0.74u w=0.26u l=0.38u
X723 cml_tlatch_60.xmux.xp.S1 A2_2_P A2_2_N VSS sg13_lv_nmos ad=56.9f pd=0.74u as=56.9f ps=0.74u w=0.17u l=0.17u
X724 cml_tlatch_88.xmux.xp.S1 cml_tlatch_74.INP cml_tlatch_74.INN VSS sg13_lv_nmos ad=56.9f pd=0.74u as=56.9f ps=0.74u w=0.17u l=0.17u
X725 cml_tlatch_30.xmux.xp.S1 cml_tlatch_30.OUTN cml_tlatch_30.OUTP VSS sg13_lv_nmos ad=56.9f pd=0.74u as=56.9f ps=0.74u w=0.17u l=0.17u
X726 cml_tlatch_1.xmux.xp.S1 B0_8_N B0_8_P VSS sg13_lv_nmos ad=56.9f pd=0.74u as=56.9f ps=0.74u w=0.17u l=0.17u
X727 cml_tlatch_76.xtail.S1 POLN VSS VSS sg13_lv_nmos ad=1.5637p pd=8.61u as=2.7982p ps=17.14u w=8.23u l=0.13u
X728 VSS POLN cml_tlatch_42.xtail.S1 VSS sg13_lv_nmos ad=2.7982p pd=17.14u as=1.5637p ps=8.61u w=8.23u l=0.13u
X729 cml_tlatch_84.xmux.xn.S1 CKB2_P cml_tlatch_84.xtail.S1 VSS sg13_lv_nmos ad=89.3f pd=0.85u as=89.3f ps=0.85u w=0.47u l=0.16u
X730 cml_tlatch_18.xtail.S1 CKA0_P cml_tlatch_18.xmux.xn.S1 VSS sg13_lv_nmos ad=89.3f pd=0.85u as=89.3f ps=0.85u w=0.47u l=0.16u
X731 stub_bi_17.BOTN stub_bi_17.BOTP cml_tlatch_13.xmux.xp.S1 VSS sg13_lv_nmos ad=56.9f pd=0.74u as=56.9f ps=0.74u w=0.17u l=0.17u
X732 cml_tlatch_45.xtail.S1 CKHA3_P cml_tlatch_45.xmux.xn.S1 VSS sg13_lv_nmos ad=89.3f pd=0.85u as=89.3f ps=0.85u w=0.47u l=0.16u
X733 cml_tlatch_44.xtail.S1 CKHA3_P cml_tlatch_44.xmux.xn.S1 VSS sg13_lv_nmos ad=0.1598p pd=1.62u as=89.3f ps=0.85u w=0.47u l=0.16u
X734 MOT28_N MOT28_P cml_tlatch_44.xmux.xp.S1 VSS sg13_lv_nmos ad=56.9f pd=0.74u as=56.9f ps=0.74u w=0.17u l=0.17u
X735 cml_tlatch_19.xmux.xp.S1 A1_8_N A1_8_P VSS sg13_lv_nmos ad=56.9f pd=0.74u as=56.9f ps=0.74u w=0.17u l=0.17u
X736 cml_tlatch_71.xmux.xn.S1 CKA3_P cml_tlatch_71.xtail.S1 VSS sg13_lv_nmos ad=89.3f pd=0.85u as=89.3f ps=0.85u w=0.47u l=0.16u
X737 stub_bi_31.BOTP stub_bi_31.BOTN cml_tlatch_37.xmux.xp.S1 VSS sg13_lv_nmos ad=56.9f pd=0.74u as=56.9f ps=0.74u w=0.17u l=0.17u
X738 MOT3_P MOT3_N cml_tlatch_15.xmux.xp.S1 VSS sg13_lv_nmos ad=56.9f pd=0.74u as=0.1019p ps=1.34u w=0.17u l=0.17u
X739 cml_tlatch_44.INP cml_tlatch_44.INN cml_tlatch_89.xmux.xp.S1 VSS sg13_lv_nmos ad=56.9f pd=0.74u as=56.9f ps=0.74u w=0.17u l=0.17u
X740 cml_tlatch_3.xmux.xp.S1 CKHB1_N cml_tlatch_3.xtail.S1 VSS sg13_lv_nmos ad=89.3f pd=0.85u as=89.3f ps=0.85u w=0.47u l=0.16u
X741 cml_tlatch_61.xmux.xn.S1 D2_P cml_tlatch_61.OUTN VSS sg13_lv_nmos ad=63.19999f pd=0.74u as=63.19999f ps=0.74u w=0.26u l=0.38u
X742 cml_tlatch_17.xmux.xn.S1 CKHB0_P cml_tlatch_17.xtail.S1 VSS sg13_lv_nmos ad=89.3f pd=0.85u as=0.1598p ps=1.62u w=0.47u l=0.16u
X743 cml_tlatch_20.xmux.xn.S1 CKA1_P cml_tlatch_20.xtail.S1 VSS sg13_lv_nmos ad=89.3f pd=0.85u as=89.3f ps=0.85u w=0.47u l=0.16u
X744 cml_tlatch_93.xmux.xp.S1 CKJ_N cml_tlatch_93.xtail.S1 VSS sg13_lv_nmos ad=89.3f pd=0.85u as=89.3f ps=0.85u w=0.47u l=0.16u
X745 cml_tlatch_37.xtail.S1 CKB1_N cml_tlatch_37.xmux.xp.S1 VSS sg13_lv_nmos ad=89.3f pd=0.85u as=0.1598p ps=1.62u w=0.47u l=0.16u
X746 B0_2_N VDD VSS rppd l=5.17u w=1u
X747 cml_tlatch_9.xmux.xp.S1 A0_8_P A0_8_N VSS sg13_lv_nmos ad=56.9f pd=0.74u as=56.9f ps=0.74u w=0.17u l=0.17u
X748 ENA0_N ENA_P cml_drv_3.xrtail.R1 VSS sg13_lv_nmos ad=56.2f pd=0.74u as=56.2f ps=0.74u w=0.16u l=0.19u
X749 cml_tlatch_89.xmux.xp.S1 CKA3_P cml_tlatch_89.xtail.S1 VSS sg13_lv_nmos ad=89.3f pd=0.85u as=89.3f ps=0.85u w=0.47u l=0.16u
X750 cml_tlatch_8.OUTP VDD VSS rppd l=5.17u w=1u
X751 cml_tlatch_19.xmux.xp.S1 A1_8_N A1_8_P VSS sg13_lv_nmos ad=56.9f pd=0.74u as=56.9f ps=0.74u w=0.17u l=0.17u
X752 stub_bi_43.BOTN stub_bi_43.BOTP cml_tlatch_48.xmux.xp.S1 VSS sg13_lv_nmos ad=56.9f pd=0.74u as=56.9f ps=0.74u w=0.17u l=0.17u
X753 cml_gate2_5.xrtail.R1 CKB2_P cml_gate2_5.xamp.xn.S1 VSS sg13_lv_nmos ad=0.1007p pd=0.91u as=0.1007p ps=0.91u w=0.53u l=0.13u
X754 cml_tlatch_35.xmux.xn.S1 CKB1_P cml_tlatch_35.xtail.S1 VSS sg13_lv_nmos ad=89.3f pd=0.85u as=89.3f ps=0.85u w=0.47u l=0.16u
X755 MOT18_P cml_tlatch_87.OUTN cml_tlatch_53.xmux.xn.S1 VSS sg13_lv_nmos ad=63.19999f pd=0.74u as=63.19999f ps=0.74u w=0.26u l=0.38u
X756 cml_tlatch_8.OUTN cml_tlatch_8.OUTP cml_tlatch_8.xmux.xp.S1 VSS sg13_lv_nmos ad=56.9f pd=0.74u as=56.9f ps=0.74u w=0.17u l=0.17u
X757 cml_tlatch_24.xtail.S1 CKHA1_P cml_tlatch_24.xmux.xn.S1 VSS sg13_lv_nmos ad=89.3f pd=0.85u as=89.3f ps=0.85u w=0.47u l=0.16u
X758 MOT22_N MOT22_P cml_tlatch_55.xmux.xp.S1 VSS sg13_lv_nmos ad=56.9f pd=0.74u as=56.9f ps=0.74u w=0.17u l=0.17u
X759 cml_tlatch_85.xmux.xp.S1 CKA2_P cml_tlatch_85.xtail.S1 VSS sg13_lv_nmos ad=89.3f pd=0.85u as=89.3f ps=0.85u w=0.47u l=0.16u
X760 cml_tlatch_59.xmux.xn.S1 CKA2_P cml_tlatch_59.xtail.S1 VSS sg13_lv_nmos ad=89.3f pd=0.85u as=89.3f ps=0.85u w=0.47u l=0.16u
X761 cml_tlatch_45.xtail.S1 CKHA3_N cml_tlatch_45.xmux.xp.S1 VSS sg13_lv_nmos ad=89.3f pd=0.85u as=0.1598p ps=1.62u w=0.47u l=0.16u
X762 cml_tlatch_18.xmux.xp.S1 cml_tlatch_18.OUTP cml_tlatch_18.OUTN VSS sg13_lv_nmos ad=56.9f pd=0.74u as=56.9f ps=0.74u w=0.17u l=0.17u
X763 cml_tlatch_2.xtail.S1 POLN VSS VSS sg13_lv_nmos ad=1.5637p pd=8.61u as=2.7982p ps=17.14u w=8.23u l=0.13u
X764 cml_tlatch_45.xmux.xp.S1 MOT30_P MOT30_N VSS sg13_lv_nmos ad=56.9f pd=0.74u as=56.9f ps=0.74u w=0.17u l=0.17u
X765 cml_gate2_3.xamp.xn.S1 ENA0_N GA0_P VSS sg13_lv_nmos ad=0.1007p pd=0.91u as=0.1007p ps=0.91u w=0.53u l=0.13u
X766 cml_tlatch_88.xmux.xp.S1 CKB3_P cml_tlatch_88.xtail.S1 VSS sg13_lv_nmos ad=89.3f pd=0.85u as=89.3f ps=0.85u w=0.47u l=0.16u
X767 VSS POLN cml_tlatch_73.xtail.S1 VSS sg13_lv_nmos ad=2.7982p pd=17.14u as=1.5637p ps=8.61u w=8.23u l=0.13u
X768 cml_tlatch_78.xmux.xp.S1 MOT19_P MOT19_N VSS sg13_lv_nmos ad=0.1019p pd=1.34u as=56.9f ps=0.74u w=0.17u l=0.17u
X769 MOT27_N MOT27_P cml_tlatch_73.xmux.xp.S1 VSS sg13_lv_nmos ad=56.9f pd=0.74u as=56.9f ps=0.74u w=0.17u l=0.17u
X770 cml_tlatch_63.INN cml_tlatch_63.INP cml_tlatch_70.xmux.xp.S1 VSS sg13_lv_nmos ad=56.9f pd=0.74u as=56.9f ps=0.74u w=0.17u l=0.17u
X771 cml_tlatch_66.xmux.xp.S1 cml_tlatch_73.INN cml_tlatch_73.INP VSS sg13_lv_nmos ad=56.9f pd=0.74u as=56.9f ps=0.74u w=0.17u l=0.17u
X772 cml_tlatch_80.xmux.xn.S1 CKHB2_P cml_tlatch_80.xtail.S1 VSS sg13_lv_nmos ad=89.3f pd=0.85u as=89.3f ps=0.85u w=0.47u l=0.16u
X773 cml_tlatch_99.OUTN cml_tlatch_33.OUTP cml_tlatch_99.xmux.xn.S1 VSS sg13_lv_nmos ad=63.19999f pd=0.74u as=63.19999f ps=0.74u w=0.26u l=0.38u
X774 VDD MOT4_N VSS rppd l=5.17u w=1u
X775 cml_tlatch_66.xmux.xp.S1 CKB3_P cml_tlatch_66.xtail.S1 VSS sg13_lv_nmos ad=89.3f pd=0.85u as=89.3f ps=0.85u w=0.47u l=0.16u
X776 cml_tlatch_74.INP cml_tlatch_74.INN cml_tlatch_88.xmux.xp.S1 VSS sg13_lv_nmos ad=56.9f pd=0.74u as=0.1019p ps=1.34u w=0.17u l=0.17u
X777 stub_bi_38.BOTP stub_bi_38.BOTN cml_tlatch_46.xmux.xp.S1 VSS sg13_lv_nmos ad=56.9f pd=0.74u as=56.9f ps=0.74u w=0.17u l=0.17u
X778 cml_tlatch_30.xtail.S1 CKB0_N cml_tlatch_30.xmux.xp.S1 VSS sg13_lv_nmos ad=89.3f pd=0.85u as=89.3f ps=0.85u w=0.47u l=0.16u
X779 cml_tlatch_4.xmux.xp.S1 MOT11_P MOT11_N VSS sg13_lv_nmos ad=56.9f pd=0.74u as=56.9f ps=0.74u w=0.17u l=0.17u
X780 cml_tlatch_40.xmux.xn.S1 cml_tlatch_41.OUTP A1_2_N VSS sg13_lv_nmos ad=63.19999f pd=0.74u as=63.19999f ps=0.74u w=0.26u l=0.38u
X781 cml_tlatch_39.xmux.xp.S1 cml_tlatch_97.INP cml_tlatch_97.INN VSS sg13_lv_nmos ad=56.9f pd=0.74u as=56.9f ps=0.74u w=0.17u l=0.17u
X782 cml_drv_2.xrtail.R1 ENB_P ENB0_N VSS sg13_lv_nmos ad=56.2f pd=0.74u as=56.2f ps=0.74u w=0.16u l=0.19u
X783 cml_tlatch_16.xmux.xp.S1 MOT5_N MOT5_P VSS sg13_lv_nmos ad=56.9f pd=0.74u as=56.9f ps=0.74u w=0.17u l=0.17u
X784 MOT14_P MOT14_N cml_tlatch_25.xmux.xp.S1 VSS sg13_lv_nmos ad=56.9f pd=0.74u as=56.9f ps=0.74u w=0.17u l=0.17u
X785 cml_tlatch_11.xmux.xp.S1 CKB1_N cml_tlatch_11.xtail.S1 VSS sg13_lv_nmos ad=89.3f pd=0.85u as=89.3f ps=0.85u w=0.47u l=0.16u
X786 CKA2_N CK_N hs_to_clk_7.D2 VSS sg13_lv_nmos ad=0.228p pd=1.58u as=0.408p ps=3.08u w=1.2u l=0.2u
X787 MOT8_N MOT8_P cml_tlatch_42.xmux.xp.S1 VSS sg13_lv_nmos ad=56.9f pd=0.74u as=56.9f ps=0.74u w=0.17u l=0.17u
X788 MOT13_N MOT13_P cml_tlatch_5.xmux.xp.S1 VSS sg13_lv_nmos ad=56.9f pd=0.74u as=56.9f ps=0.74u w=0.17u l=0.17u
X789 cml_tlatch_65.OUTN cml_tlatch_73.INP cml_tlatch_65.xmux.xn.S1 VSS sg13_lv_nmos ad=63.19999f pd=0.74u as=63.19999f ps=0.74u w=0.26u l=0.38u
X790 cml_tlatch_65.xmux.xp.S1 cml_tlatch_65.OUTN cml_tlatch_65.OUTP VSS sg13_lv_nmos ad=56.9f pd=0.74u as=56.9f ps=0.74u w=0.17u l=0.17u
X791 cml_tlatch_33.OUTN A0_2_P cml_tlatch_33.xmux.xn.S1 VSS sg13_lv_nmos ad=0.1082p pd=1.34u as=63.19999f ps=0.74u w=0.26u l=0.38u
X792 VSS POLN cml_tlatch_94.xtail.S1 VSS sg13_lv_nmos ad=2.7982p pd=17.14u as=1.5637p ps=8.61u w=8.23u l=0.13u
X793 cml_tlatch_5.xmux.xn.S1 cml_tlatch_5.INN MOT13_P VSS sg13_lv_nmos ad=63.19999f pd=0.74u as=63.19999f ps=0.74u w=0.26u l=0.38u
X794 VSS POLN cml_tlatch_22.xtail.S1 VSS sg13_lv_nmos ad=1.5637p pd=8.61u as=1.5637p ps=8.61u w=8.23u l=0.13u
X795 cml_gate2_6.xrtail.R1 CKA3_N GB3_P VSS sg13_lv_nmos ad=0.1007p pd=0.91u as=0.1007p ps=0.91u w=0.53u l=0.13u
X796 cml_drvb_3.xrtail.R2 VSS VSS rppd l=2.72u w=1u
X797 cml_tlatch_52.xmux.xn.S1 A2_8_N MOT16_P VSS sg13_lv_nmos ad=63.19999f pd=0.74u as=63.19999f ps=0.74u w=0.26u l=0.38u
X798 cml_gate2_2.xrtail.R1 CKB1_P cml_gate2_2.xamp.xn.S1 VSS sg13_lv_nmos ad=0.1007p pd=0.91u as=0.1802p ps=1.74u w=0.53u l=0.13u
X799 GB2_N ENB0_P cml_gate2_7.xamp.xn.S1 VSS sg13_lv_nmos ad=0.1007p pd=0.91u as=0.1007p ps=0.91u w=0.53u l=0.13u
X800 cml_tlatch_33.OUTN A0_2_P cml_tlatch_33.xmux.xn.S1 VSS sg13_lv_nmos ad=63.19999f pd=0.74u as=63.19999f ps=0.74u w=0.26u l=0.38u
X801 J2_P J2_N cml_tlatch_94.xmux.xp.S1 VSS sg13_lv_nmos ad=56.9f pd=0.74u as=56.9f ps=0.74u w=0.17u l=0.17u
X802 cml_tlatch_62.xmux.xp.S1 CKHA3_N cml_tlatch_62.xtail.S1 VSS sg13_lv_nmos ad=89.3f pd=0.85u as=89.3f ps=0.85u w=0.47u l=0.16u
X803 MOT16_N A2_8_P cml_tlatch_52.xmux.xn.S1 VSS sg13_lv_nmos ad=63.19999f pd=0.74u as=63.19999f ps=0.74u w=0.26u l=0.38u
X804 B2_2_N B2_2_P cml_tlatch_47.xmux.xp.S1 VSS sg13_lv_nmos ad=56.9f pd=0.74u as=56.9f ps=0.74u w=0.17u l=0.17u
X805 cml_tlatch_65.OUTN cml_tlatch_65.OUTP cml_tlatch_65.xmux.xp.S1 VSS sg13_lv_nmos ad=56.9f pd=0.74u as=56.9f ps=0.74u w=0.17u l=0.17u
X806 MOT29_P cml_tlatch_74.INN cml_tlatch_74.xmux.xn.S1 VSS sg13_lv_nmos ad=63.19999f pd=0.74u as=63.19999f ps=0.74u w=0.26u l=0.38u
X807 cml_tlatch_1.xmux.xp.S1 B0_8_N B0_8_P VSS sg13_lv_nmos ad=56.9f pd=0.74u as=56.9f ps=0.74u w=0.17u l=0.17u
X808 cml_tlatch_14.xmux.xn.S1 CKHB0_P cml_tlatch_14.xtail.S1 VSS sg13_lv_nmos ad=89.3f pd=0.85u as=0.1598p ps=1.62u w=0.47u l=0.16u
X809 cml_tlatch_91.INN A2_2_P cml_tlatch_59.xmux.xn.S1 VSS sg13_lv_nmos ad=63.19999f pd=0.74u as=63.19999f ps=0.74u w=0.26u l=0.38u
X810 MOT24_N MOT24_P cml_tlatch_62.xmux.xp.S1 VSS sg13_lv_nmos ad=56.9f pd=0.74u as=56.9f ps=0.74u w=0.17u l=0.17u
X811 cml_tlatch_92.xtail.S1 POLN VSS VSS sg13_lv_nmos ad=1.5637p pd=8.61u as=1.5637p ps=8.61u w=8.23u l=0.13u
X812 J1_P J4_P cml_tlatch_95.xmux.xn.S1 VSS sg13_lv_nmos ad=63.19999f pd=0.74u as=63.19999f ps=0.74u w=0.26u l=0.38u
X813 cml_tlatch_68.xmux.xn.S1 cml_tlatch_69.OUTN A3_8_P VSS sg13_lv_nmos ad=63.19999f pd=0.74u as=63.19999f ps=0.74u w=0.26u l=0.38u
X814 MOT3_P MOT3_N cml_tlatch_15.xmux.xp.S1 VSS sg13_lv_nmos ad=56.9f pd=0.74u as=56.9f ps=0.74u w=0.17u l=0.17u
X815 cml_tlatch_2.OUTN cml_tlatch_2.OUTP cml_tlatch_2.xmux.xp.S1 VSS sg13_lv_nmos ad=56.9f pd=0.74u as=56.9f ps=0.74u w=0.17u l=0.17u
X816 cml_tlatch_65.OUTP cml_tlatch_65.OUTN cml_tlatch_65.xmux.xp.S1 VSS sg13_lv_nmos ad=56.9f pd=0.74u as=56.9f ps=0.74u w=0.17u l=0.17u
X817 cml_tlatch_9.xmux.xp.S1 A0_8_P A0_8_N VSS sg13_lv_nmos ad=0.1019p pd=1.34u as=56.9f ps=0.74u w=0.17u l=0.17u
X818 cml_tlatch_96.xtail.S1 CKB1_P cml_tlatch_96.xmux.xp.S1 VSS sg13_lv_nmos ad=89.3f pd=0.85u as=89.3f ps=0.85u w=0.47u l=0.16u
X819 cml_tlatch_61.xtail.S1 CKA2_P cml_tlatch_61.xmux.xn.S1 VSS sg13_lv_nmos ad=89.3f pd=0.85u as=89.3f ps=0.85u w=0.47u l=0.16u
X820 cml_tlatch_50.xtail.S1 CKB3_P cml_tlatch_50.xmux.xp.S1 VSS sg13_lv_nmos ad=89.3f pd=0.85u as=89.3f ps=0.85u w=0.47u l=0.16u
X821 cml_tlatch_57.xmux.xp.S1 A3_2_P A3_2_N VSS sg13_lv_nmos ad=56.9f pd=0.74u as=56.9f ps=0.74u w=0.17u l=0.17u
X822 MOT22_N A2_2_P cml_tlatch_55.xmux.xn.S1 VSS sg13_lv_nmos ad=63.19999f pd=0.74u as=63.19999f ps=0.74u w=0.26u l=0.38u
X823 MOT7_N MOT7_P cml_tlatch_17.xmux.xp.S1 VSS sg13_lv_nmos ad=56.9f pd=0.74u as=56.9f ps=0.74u w=0.17u l=0.17u
X824 cml_tlatch_7.xtail.S1 CKB0_N cml_tlatch_7.xmux.xn.S1 VSS sg13_lv_nmos ad=89.3f pd=0.85u as=89.3f ps=0.85u w=0.47u l=0.16u
X825 cml_gate2_0.xamp.xn.S1 ENB1_P GB1_N VSS sg13_lv_nmos ad=0.1007p pd=0.91u as=0.1007p ps=0.91u w=0.53u l=0.13u
X826 cml_tlatch_12.xmux.xn.S1 stub_bi_17.BOTN cml_tlatch_4.INN VSS sg13_lv_nmos ad=63.19999f pd=0.74u as=63.19999f ps=0.74u w=0.26u l=0.38u
X827 cml_tlatch_24.xtail.S1 CKHA1_N cml_tlatch_24.xmux.xp.S1 VSS sg13_lv_nmos ad=89.3f pd=0.85u as=89.3f ps=0.85u w=0.47u l=0.16u
X828 cml_tlatch_15.xtail.S1 CKHB0_P cml_tlatch_15.xmux.xn.S1 VSS sg13_lv_nmos ad=89.3f pd=0.85u as=89.3f ps=0.85u w=0.47u l=0.16u
X829 cml_tlatch_22.xmux.xp.S1 CKA1_N cml_tlatch_22.xtail.S1 VSS sg13_lv_nmos ad=89.3f pd=0.85u as=89.3f ps=0.85u w=0.47u l=0.16u
X830 MOT24_N VDD VSS rppd l=5.17u w=1u
X831 cml_tlatch_77.xmux.xn.S1 CKHB2_P cml_tlatch_77.xtail.S1 VSS sg13_lv_nmos ad=89.3f pd=0.85u as=89.3f ps=0.85u w=0.47u l=0.16u
X832 MOT21_P MOT21_N cml_tlatch_79.xmux.xp.S1 VSS sg13_lv_nmos ad=56.9f pd=0.74u as=56.9f ps=0.74u w=0.17u l=0.17u
X833 cml_tlatch_70.xmux.xn.S1 CKA3_N cml_tlatch_70.xtail.S1 VSS sg13_lv_nmos ad=89.3f pd=0.85u as=89.3f ps=0.85u w=0.47u l=0.16u
X834 cml_tlatch_45.xmux.xp.S1 MOT30_N MOT30_P VSS sg13_lv_nmos ad=56.9f pd=0.74u as=56.9f ps=0.74u w=0.17u l=0.17u
X835 cml_tlatch_48.xtail.S1 CKB2_P cml_tlatch_48.xmux.xn.S1 VSS sg13_lv_nmos ad=0.1598p pd=1.62u as=89.3f ps=0.85u w=0.47u l=0.16u
X836 GA3_P CKB3_N cml_gate2_4.xrtail.R1 VSS sg13_lv_nmos ad=0.1007p pd=0.91u as=0.1007p ps=0.91u w=0.53u l=0.13u
X837 CLK_W_N CLK_W_P cml_tlatch_93.xmux.xp.S1 VSS sg13_lv_nmos ad=56.9f pd=0.74u as=56.9f ps=0.74u w=0.17u l=0.17u
X838 GB1_N ENB1_P cml_gate2_0.xamp.xn.S1 VSS sg13_lv_nmos ad=0.1007p pd=0.91u as=0.1007p ps=0.91u w=0.53u l=0.13u
X839 cml_tlatch_51.xmux.xp.S1 cml_tlatch_51.OUTN cml_tlatch_51.OUTP VSS sg13_lv_nmos ad=56.9f pd=0.74u as=56.9f ps=0.74u w=0.17u l=0.17u
X840 cml_tlatch_11.xmux.xp.S1 stub_bi_15.BOTP stub_bi_15.BOTN VSS sg13_lv_nmos ad=56.9f pd=0.74u as=56.9f ps=0.74u w=0.17u l=0.17u
X841 cml_tlatch_92.xmux.xn.S1 CKJ_N cml_tlatch_92.xtail.S1 VSS sg13_lv_nmos ad=89.3f pd=0.85u as=89.3f ps=0.85u w=0.47u l=0.16u
X842 ENA1_N ENA_P cml_drv_1.xrtail.R1 VSS sg13_lv_nmos ad=56.2f pd=0.74u as=56.2f ps=0.74u w=0.16u l=0.19u
X843 cml_tlatch_91.xmux.xp.S1 cml_tlatch_91.OUTN cml_tlatch_91.OUTP VSS sg13_lv_nmos ad=56.9f pd=0.74u as=56.9f ps=0.74u w=0.17u l=0.17u
X844 cml_tlatch_66.xmux.xn.S1 CKB3_N cml_tlatch_66.xtail.S1 VSS sg13_lv_nmos ad=89.3f pd=0.85u as=89.3f ps=0.85u w=0.47u l=0.16u
X845 cml_tlatch_93.xtail.S1 CKJ_N cml_tlatch_93.xmux.xp.S1 VSS sg13_lv_nmos ad=89.3f pd=0.85u as=89.3f ps=0.85u w=0.47u l=0.16u
X846 MOT17_N MOT17_P cml_tlatch_77.xmux.xp.S1 VSS sg13_lv_nmos ad=56.9f pd=0.74u as=56.9f ps=0.74u w=0.17u l=0.17u
X847 cml_tlatch_72.xmux.xp.S1 MOT25_P MOT25_N VSS sg13_lv_nmos ad=56.9f pd=0.74u as=56.9f ps=0.74u w=0.17u l=0.17u
X848 J2_N J1_P cml_tlatch_94.xmux.xn.S1 VSS sg13_lv_nmos ad=63.19999f pd=0.74u as=63.19999f ps=0.74u w=0.26u l=0.38u
X849 VDD cml_tlatch_38.OUTN VSS rppd l=5.17u w=1u
X850 cml_tlatch_91.xmux.xn.S1 CKA2_N cml_tlatch_91.xtail.S1 VSS sg13_lv_nmos ad=89.3f pd=0.85u as=89.3f ps=0.85u w=0.47u l=0.16u
X851 cml_tlatch_33.OUTN cml_tlatch_33.OUTP cml_tlatch_33.xmux.xp.S1 VSS sg13_lv_nmos ad=56.9f pd=0.74u as=56.9f ps=0.74u w=0.17u l=0.17u
X852 cml_tlatch_2.xmux.xn.S1 cml_tlatch_7.OUTN cml_tlatch_2.OUTP VSS sg13_lv_nmos ad=0.1082p pd=1.34u as=63.19999f ps=0.74u w=0.26u l=0.38u
X853 cml_tlatch_16.xmux.xp.S1 MOT5_N MOT5_P VSS sg13_lv_nmos ad=56.9f pd=0.74u as=56.9f ps=0.74u w=0.17u l=0.17u
X854 cml_tlatch_57.xmux.xp.S1 A3_2_P A3_2_N VSS sg13_lv_nmos ad=56.9f pd=0.74u as=56.9f ps=0.74u w=0.17u l=0.17u
X855 cml_tlatch_7.xmux.xp.S1 cml_tlatch_7.OUTP cml_tlatch_7.OUTN VSS sg13_lv_nmos ad=56.9f pd=0.74u as=56.9f ps=0.74u w=0.17u l=0.17u
X856 MOT8_N MOT8_P cml_tlatch_42.xmux.xp.S1 VSS sg13_lv_nmos ad=56.9f pd=0.74u as=56.9f ps=0.74u w=0.17u l=0.17u
X857 A2_8_N A2_8_P cml_tlatch_85.xmux.xp.S1 VSS sg13_lv_nmos ad=56.9f pd=0.74u as=56.9f ps=0.74u w=0.17u l=0.17u
X858 cml_tlatch_33.OUTP cml_tlatch_33.OUTN cml_tlatch_33.xmux.xp.S1 VSS sg13_lv_nmos ad=56.9f pd=0.74u as=56.9f ps=0.74u w=0.17u l=0.17u
X859 B1_8_N stub_bi_15.BOTN cml_tlatch_10.xmux.xn.S1 VSS sg13_lv_nmos ad=63.19999f pd=0.74u as=63.19999f ps=0.74u w=0.26u l=0.38u
X860 cml_tlatch_70.xmux.xn.S1 cml_tlatch_71.OUTN cml_tlatch_63.INP VSS sg13_lv_nmos ad=63.19999f pd=0.74u as=63.19999f ps=0.74u w=0.26u l=0.38u
X861 cml_tlatch_76.xmux.xp.S1 cml_tlatch_87.INN cml_tlatch_87.INP VSS sg13_lv_nmos ad=56.9f pd=0.74u as=56.9f ps=0.74u w=0.17u l=0.17u
X862 cml_tlatch_86.OUTP cml_tlatch_86.OUTN cml_tlatch_86.xmux.xp.S1 VSS sg13_lv_nmos ad=56.9f pd=0.74u as=0.1019p ps=1.34u w=0.17u l=0.17u
X863 MOT17_P MOT17_N cml_tlatch_77.xmux.xp.S1 VSS sg13_lv_nmos ad=56.9f pd=0.74u as=56.9f ps=0.74u w=0.17u l=0.17u
X864 cml_tlatch_51.OUTP cml_tlatch_51.OUTN cml_tlatch_51.xmux.xp.S1 VSS sg13_lv_nmos ad=56.9f pd=0.74u as=56.9f ps=0.74u w=0.17u l=0.17u
X865 A3_2_P A3_2_N cml_tlatch_57.xmux.xp.S1 VSS sg13_lv_nmos ad=56.9f pd=0.74u as=56.9f ps=0.74u w=0.17u l=0.17u
X866 stub_bi_55.BOTP stub_bi_55.BOTN cml_tlatch_90.xmux.xp.S1 VSS sg13_lv_nmos ad=56.9f pd=0.74u as=56.9f ps=0.74u w=0.17u l=0.17u
X867 cml_tlatch_9.xmux.xp.S1 CKA0_P cml_tlatch_9.xtail.S1 VSS sg13_lv_nmos ad=89.3f pd=0.85u as=89.3f ps=0.85u w=0.47u l=0.16u
X868 cml_tlatch_65.xtail.S1 CKB3_N cml_tlatch_65.xmux.xp.S1 VSS sg13_lv_nmos ad=89.3f pd=0.85u as=89.3f ps=0.85u w=0.47u l=0.16u
X869 cml_tlatch_62.xmux.xp.S1 MOT24_N MOT24_P VSS sg13_lv_nmos ad=56.9f pd=0.74u as=56.9f ps=0.74u w=0.17u l=0.17u
X870 cml_tlatch_80.xmux.xp.S1 MOT23_P MOT23_N VSS sg13_lv_nmos ad=56.9f pd=0.74u as=56.9f ps=0.74u w=0.17u l=0.17u
X871 cml_tlatch_90.xmux.xn.S1 CKB2_N cml_tlatch_90.xtail.S1 VSS sg13_lv_nmos ad=89.3f pd=0.85u as=89.3f ps=0.85u w=0.47u l=0.16u
X872 cml_tlatch_32.xmux.xp.S1 cml_tlatch_32.OUTP cml_tlatch_32.OUTN VSS sg13_lv_nmos ad=56.9f pd=0.74u as=56.9f ps=0.74u w=0.17u l=0.17u
X873 cml_tlatch_22.xmux.xn.S1 cml_tlatch_24.INP cml_tlatch_22.OUTN VSS sg13_lv_nmos ad=63.19999f pd=0.74u as=63.19999f ps=0.74u w=0.26u l=0.38u
X874 cml_tlatch_87.OUTN cml_tlatch_87.INP cml_tlatch_87.xmux.xn.S1 VSS sg13_lv_nmos ad=63.19999f pd=0.74u as=63.19999f ps=0.74u w=0.26u l=0.38u
X875 MOT31_N MOT31_P cml_tlatch_75.xmux.xp.S1 VSS sg13_lv_nmos ad=56.9f pd=0.74u as=56.9f ps=0.74u w=0.17u l=0.17u
X876 cml_tlatch_17.xmux.xn.S1 B0_2_N MOT7_P VSS sg13_lv_nmos ad=63.19999f pd=0.74u as=63.19999f ps=0.74u w=0.26u l=0.38u
X877 cml_tlatch_96.xmux.xn.S1 stub_bi_29.BOTN cml_tlatch_5.INN VSS sg13_lv_nmos ad=63.19999f pd=0.74u as=63.19999f ps=0.74u w=0.26u l=0.38u
X878 cml_tlatch_89.xmux.xn.S1 CKA3_N cml_tlatch_89.xtail.S1 VSS sg13_lv_nmos ad=89.3f pd=0.85u as=89.3f ps=0.85u w=0.47u l=0.16u
X879 CKB2_N CK_P hs_to_clk_4.D2 VSS sg13_lv_nmos ad=0.228p pd=1.58u as=0.228p ps=1.58u w=1.2u l=0.2u
X880 cml_tlatch_91.INP cml_tlatch_91.INN cml_tlatch_59.xmux.xp.S1 VSS sg13_lv_nmos ad=56.9f pd=0.74u as=56.9f ps=0.74u w=0.17u l=0.17u
X881 MOT4_N MOT4_P cml_tlatch_28.xmux.xp.S1 VSS sg13_lv_nmos ad=56.9f pd=0.74u as=56.9f ps=0.74u w=0.17u l=0.17u
X882 cml_tlatch_44.xmux.xn.S1 cml_tlatch_44.INP MOT28_N VSS sg13_lv_nmos ad=63.19999f pd=0.74u as=0.1082p ps=1.34u w=0.26u l=0.38u
X883 stub_bi_63.BOTP stub_bi_63.BOTN cml_tlatch_83.xmux.xp.S1 VSS sg13_lv_nmos ad=56.9f pd=0.74u as=56.9f ps=0.74u w=0.17u l=0.17u
X884 cml_tlatch_80.xtail.S1 CKHB2_P cml_tlatch_80.xmux.xn.S1 VSS sg13_lv_nmos ad=89.3f pd=0.85u as=89.3f ps=0.85u w=0.47u l=0.16u
X885 stub_bi_63.BOTN stub_bi_63.BOTP cml_tlatch_83.xmux.xp.S1 VSS sg13_lv_nmos ad=56.9f pd=0.74u as=56.9f ps=0.74u w=0.17u l=0.17u
X886 MOT0_P A0_8_N cml_tlatch_26.xmux.xn.S1 VSS sg13_lv_nmos ad=0.1082p pd=1.34u as=63.19999f ps=0.74u w=0.26u l=0.38u
X887 MOT10_P MOT10_N cml_tlatch_43.xmux.xp.S1 VSS sg13_lv_nmos ad=56.9f pd=0.74u as=56.9f ps=0.74u w=0.17u l=0.17u
X888 cml_tlatch_96.xmux.xn.S1 stub_bi_29.BOTN cml_tlatch_5.INN VSS sg13_lv_nmos ad=63.19999f pd=0.74u as=63.19999f ps=0.74u w=0.26u l=0.38u
X889 cml_tlatch_69.OUTP cml_tlatch_63.INN cml_tlatch_69.xmux.xn.S1 VSS sg13_lv_nmos ad=63.19999f pd=0.74u as=63.19999f ps=0.74u w=0.26u l=0.38u
X890 cml_tlatch_8.OUTP cml_tlatch_98.OUTN cml_tlatch_8.xmux.xn.S1 VSS sg13_lv_nmos ad=63.19999f pd=0.74u as=63.19999f ps=0.74u w=0.26u l=0.38u
X891 cml_drv_0.xrtail.R1 ENB_P ENB1_N VSS sg13_lv_nmos ad=56.2f pd=0.74u as=56.2f ps=0.74u w=0.16u l=0.19u
X892 cml_tlatch_6.xmux.xp.S1 MOT15_P MOT15_N VSS sg13_lv_nmos ad=56.9f pd=0.74u as=56.9f ps=0.74u w=0.17u l=0.17u
X893 cml_tlatch_45.xtail.S1 CKHA3_P cml_tlatch_45.xmux.xn.S1 VSS sg13_lv_nmos ad=89.3f pd=0.85u as=89.3f ps=0.85u w=0.47u l=0.16u
X894 cml_tlatch_97.xmux.xn.S1 cml_tlatch_97.INN cml_tlatch_24.INP VSS sg13_lv_nmos ad=63.19999f pd=0.74u as=63.19999f ps=0.74u w=0.26u l=0.38u
X895 cml_tlatch_11.xtail.S1 CKB1_N cml_tlatch_11.xmux.xp.S1 VSS sg13_lv_nmos ad=89.3f pd=0.85u as=0.1598p ps=1.62u w=0.47u l=0.16u
X896 cml_tlatch_34.xmux.xp.S1 CKA0_P cml_tlatch_34.xtail.S1 VSS sg13_lv_nmos ad=89.3f pd=0.85u as=89.3f ps=0.85u w=0.47u l=0.16u
X897 cml_tlatch_36.xmux.xn.S1 stub_bi_31.BOTP B1_2_P VSS sg13_lv_nmos ad=0.1082p pd=1.34u as=63.19999f ps=0.74u w=0.26u l=0.38u
X898 ENA_N J1_P cml_gate2_9.xamp.xn.S1 VSS sg13_lv_nmos ad=0.1802p pd=1.74u as=0.1007p ps=0.91u w=0.53u l=0.13u
X899 cml_tlatch_40.xmux.xp.S1 A1_2_N A1_2_P VSS sg13_lv_nmos ad=56.9f pd=0.74u as=56.9f ps=0.74u w=0.17u l=0.17u
X900 cml_tlatch_37.xmux.xp.S1 stub_bi_31.BOTP stub_bi_31.BOTN VSS sg13_lv_nmos ad=56.9f pd=0.74u as=56.9f ps=0.74u w=0.17u l=0.17u
X901 cml_tlatch_75.xtail.S1 CKHB3_P cml_tlatch_75.xmux.xn.S1 VSS sg13_lv_nmos ad=89.3f pd=0.85u as=89.3f ps=0.85u w=0.47u l=0.16u
X902 cml_tlatch_0.xmux.xp.S1 cml_tlatch_0.OUTN cml_tlatch_0.OUTP VSS sg13_lv_nmos ad=56.9f pd=0.74u as=56.9f ps=0.74u w=0.17u l=0.17u
X903 cml_tlatch_51.OUTN D3_P cml_tlatch_51.xmux.xn.S1 VSS sg13_lv_nmos ad=63.19999f pd=0.74u as=63.19999f ps=0.74u w=0.26u l=0.38u
X904 MOT26_P MOT26_N cml_tlatch_63.xmux.xp.S1 VSS sg13_lv_nmos ad=56.9f pd=0.74u as=56.9f ps=0.74u w=0.17u l=0.17u
X905 cml_tlatch_22.OUTP cml_tlatch_24.INN cml_tlatch_22.xmux.xn.S1 VSS sg13_lv_nmos ad=63.19999f pd=0.74u as=63.19999f ps=0.74u w=0.26u l=0.38u
X906 cml_tlatch_86.OUTP cml_tlatch_86.OUTN cml_tlatch_86.xmux.xp.S1 VSS sg13_lv_nmos ad=56.9f pd=0.74u as=56.9f ps=0.74u w=0.17u l=0.17u
X907 cml_tlatch_41.OUTN cml_tlatch_41.OUTP cml_tlatch_41.xmux.xp.S1 VSS sg13_lv_nmos ad=56.9f pd=0.74u as=56.9f ps=0.74u w=0.17u l=0.17u
X908 cml_tlatch_23.xmux.xp.S1 cml_tlatch_23.OUTN cml_tlatch_23.OUTP VSS sg13_lv_nmos ad=56.9f pd=0.74u as=56.9f ps=0.74u w=0.17u l=0.17u
X909 cml_tlatch_12.xtail.S1 CKB1_N cml_tlatch_12.xmux.xn.S1 VSS sg13_lv_nmos ad=89.3f pd=0.85u as=89.3f ps=0.85u w=0.47u l=0.16u
X910 VDD cml_tlatch_87.INN VSS rppd l=5.17u w=1u
X911 cml_tlatch_36.xmux.xp.S1 B1_2_P B1_2_N VSS sg13_lv_nmos ad=56.9f pd=0.74u as=56.9f ps=0.74u w=0.17u l=0.17u
X912 cml_tlatch_85.xmux.xp.S1 CKA2_P cml_tlatch_85.xtail.S1 VSS sg13_lv_nmos ad=89.3f pd=0.85u as=89.3f ps=0.85u w=0.47u l=0.16u
X913 cml_tlatch_98.xmux.xn.S1 CKB0_N cml_tlatch_98.xtail.S1 VSS sg13_lv_nmos ad=89.3f pd=0.85u as=89.3f ps=0.85u w=0.47u l=0.16u
X914 cml_tlatch_22.OUTP cml_tlatch_22.OUTN cml_tlatch_22.xmux.xp.S1 VSS sg13_lv_nmos ad=56.9f pd=0.74u as=56.9f ps=0.74u w=0.17u l=0.17u
X915 cml_tlatch_49.OUTN cml_tlatch_49.OUTP cml_tlatch_49.xmux.xp.S1 VSS sg13_lv_nmos ad=56.9f pd=0.74u as=56.9f ps=0.74u w=0.17u l=0.17u
X916 cml_gate2_7.xrtail.R1 CKA2_P cml_gate2_7.xamp.xn.S1 VSS sg13_lv_nmos ad=0.1007p pd=0.91u as=0.1007p ps=0.91u w=0.53u l=0.13u
X917 A2_8_P A2_8_N cml_tlatch_85.xmux.xp.S1 VSS sg13_lv_nmos ad=56.9f pd=0.74u as=56.9f ps=0.74u w=0.17u l=0.17u
X918 cml_tlatch_81.xmux.xp.S1 B2_8_N B2_8_P VSS sg13_lv_nmos ad=56.9f pd=0.74u as=56.9f ps=0.74u w=0.17u l=0.17u
X919 CLK_W_P J2_P cml_tlatch_93.xmux.xn.S1 VSS sg13_lv_nmos ad=0.1082p pd=1.34u as=63.19999f ps=0.74u w=0.26u l=0.38u
X920 cml_tlatch_61.OUTP cml_tlatch_61.OUTN cml_tlatch_61.xmux.xp.S1 VSS sg13_lv_nmos ad=56.9f pd=0.74u as=0.1019p ps=1.34u w=0.17u l=0.17u
X921 MOT25_P MOT25_N cml_tlatch_72.xmux.xp.S1 VSS sg13_lv_nmos ad=56.9f pd=0.74u as=56.9f ps=0.74u w=0.17u l=0.17u
X922 cml_drvb_2.xrtail.R2 GA1_P CKHA1_N VSS sg13_lv_nmos ad=0.1463p pd=1.15u as=0.2618p ps=2.22u w=0.77u l=0.21u
X923 cml_tlatch_71.xtail.S1 CKA3_N cml_tlatch_71.xmux.xp.S1 VSS sg13_lv_nmos ad=89.3f pd=0.85u as=89.3f ps=0.85u w=0.47u l=0.16u
X924 cml_tlatch_49.xtail.S1 CKB3_N cml_tlatch_49.xmux.xp.S1 VSS sg13_lv_nmos ad=89.3f pd=0.85u as=0.1598p ps=1.62u w=0.47u l=0.16u
X925 cml_tlatch_75.xtail.S1 CKHB3_N cml_tlatch_75.xmux.xp.S1 VSS sg13_lv_nmos ad=89.3f pd=0.85u as=0.1598p ps=1.62u w=0.47u l=0.16u
X926 GA2_P CKB2_N cml_gate2_5.xrtail.R1 VSS sg13_lv_nmos ad=0.1007p pd=0.91u as=0.1007p ps=0.91u w=0.53u l=0.13u
X927 cml_tlatch_35.xmux.xp.S1 stub_bi_29.BOTN stub_bi_29.BOTP VSS sg13_lv_nmos ad=56.9f pd=0.74u as=56.9f ps=0.74u w=0.17u l=0.17u
X928 cml_tlatch_58.OUTN cml_tlatch_58.OUTP cml_tlatch_58.xmux.xp.S1 VSS sg13_lv_nmos ad=56.9f pd=0.74u as=56.9f ps=0.74u w=0.17u l=0.17u
X929 cml_tlatch_18.xmux.xp.S1 cml_tlatch_18.OUTN cml_tlatch_18.OUTP VSS sg13_lv_nmos ad=56.9f pd=0.74u as=56.9f ps=0.74u w=0.17u l=0.17u
X930 VDD MOT20_P VSS rppd l=5.17u w=1u
X931 cml_tlatch_46.xmux.xn.S1 CKB2_P cml_tlatch_46.xtail.S1 VSS sg13_lv_nmos ad=89.3f pd=0.85u as=89.3f ps=0.85u w=0.47u l=0.16u
X932 stub_bi_17.BOTP stub_bi_17.BOTN cml_tlatch_13.xmux.xp.S1 VSS sg13_lv_nmos ad=56.9f pd=0.74u as=0.1019p ps=1.34u w=0.17u l=0.17u
X933 cml_tlatch_3.xmux.xp.S1 MOT9_N MOT9_P VSS sg13_lv_nmos ad=56.9f pd=0.74u as=56.9f ps=0.74u w=0.17u l=0.17u
X934 cml_tlatch_86.xmux.xn.S1 CKA2_P cml_tlatch_86.xtail.S1 VSS sg13_lv_nmos ad=89.3f pd=0.85u as=0.1598p ps=1.62u w=0.47u l=0.16u
X935 cml_tlatch_31.xmux.xp.S1 B0_2_P B0_2_N VSS sg13_lv_nmos ad=56.9f pd=0.74u as=56.9f ps=0.74u w=0.17u l=0.17u
X936 cml_tlatch_21.xmux.xp.S1 CKA1_P cml_tlatch_21.xtail.S1 VSS sg13_lv_nmos ad=89.3f pd=0.85u as=89.3f ps=0.85u w=0.47u l=0.16u
X937 cml_tlatch_99.OUTN cml_tlatch_99.OUTP cml_tlatch_99.xmux.xp.S1 VSS sg13_lv_nmos ad=56.9f pd=0.74u as=56.9f ps=0.74u w=0.17u l=0.17u
X938 cml_tlatch_24.INP cml_tlatch_24.INN cml_tlatch_97.xmux.xp.S1 VSS sg13_lv_nmos ad=56.9f pd=0.74u as=56.9f ps=0.74u w=0.17u l=0.17u
X939 cml_tlatch_69.xmux.xp.S1 cml_tlatch_69.OUTP cml_tlatch_69.OUTN VSS sg13_lv_nmos ad=56.9f pd=0.74u as=56.9f ps=0.74u w=0.17u l=0.17u
X940 MOT19_N MOT19_P cml_tlatch_78.xmux.xp.S1 VSS sg13_lv_nmos ad=56.9f pd=0.74u as=56.9f ps=0.74u w=0.17u l=0.17u
X941 cml_tlatch_33.OUTP cml_tlatch_33.OUTN cml_tlatch_33.xmux.xp.S1 VSS sg13_lv_nmos ad=56.9f pd=0.74u as=56.9f ps=0.74u w=0.17u l=0.17u
X942 cml_tlatch_0.xmux.xn.S1 CKA0_P cml_tlatch_0.xtail.S1 VSS sg13_lv_nmos ad=0.1598p pd=1.62u as=89.3f ps=0.85u w=0.47u l=0.16u
X943 B2_2_N stub_bi_43.BOTN cml_tlatch_47.xmux.xn.S1 VSS sg13_lv_nmos ad=63.19999f pd=0.74u as=63.19999f ps=0.74u w=0.26u l=0.38u
X944 cml_tlatch_77.xtail.S1 CKHB2_P cml_tlatch_77.xmux.xn.S1 VSS sg13_lv_nmos ad=89.3f pd=0.85u as=89.3f ps=0.85u w=0.47u l=0.16u
X945 MOT17_N B2_8_P cml_tlatch_77.xmux.xn.S1 VSS sg13_lv_nmos ad=63.19999f pd=0.74u as=0.1082p ps=1.34u w=0.26u l=0.38u
X946 A1_8_N A1_8_P cml_tlatch_19.xmux.xp.S1 VSS sg13_lv_nmos ad=56.9f pd=0.74u as=56.9f ps=0.74u w=0.17u l=0.17u
X947 J4_N J4_P cml_tlatch_92.xmux.xp.S1 VSS sg13_lv_nmos ad=56.9f pd=0.74u as=56.9f ps=0.74u w=0.17u l=0.17u
X948 MOT30_P A3_2_N cml_tlatch_45.xmux.xn.S1 VSS sg13_lv_nmos ad=63.19999f pd=0.74u as=63.19999f ps=0.74u w=0.26u l=0.38u
X949 cml_tlatch_16.xmux.xn.S1 cml_tlatch_98.OUTP MOT5_N VSS sg13_lv_nmos ad=63.19999f pd=0.74u as=63.19999f ps=0.74u w=0.26u l=0.38u
X950 VSS POLN cml_tlatch_64.xtail.S1 VSS sg13_lv_nmos ad=2.7982p pd=17.14u as=1.5637p ps=8.61u w=8.23u l=0.13u
X951 cml_tlatch_59.xtail.S1 CKA2_N cml_tlatch_59.xmux.xp.S1 VSS sg13_lv_nmos ad=89.3f pd=0.85u as=89.3f ps=0.85u w=0.47u l=0.16u
X952 cml_tlatch_73.xmux.xp.S1 MOT27_N MOT27_P VSS sg13_lv_nmos ad=0.1019p pd=1.34u as=56.9f ps=0.74u w=0.17u l=0.17u
X953 MOT15_P MOT15_N cml_tlatch_6.xmux.xp.S1 VSS sg13_lv_nmos ad=56.9f pd=0.74u as=56.9f ps=0.74u w=0.17u l=0.17u
X954 cml_tlatch_12.xmux.xp.S1 CKB1_P cml_tlatch_12.xtail.S1 VSS sg13_lv_nmos ad=89.3f pd=0.85u as=89.3f ps=0.85u w=0.47u l=0.16u
X955 MOT6_N MOT6_P cml_tlatch_29.xmux.xp.S1 VSS sg13_lv_nmos ad=56.9f pd=0.74u as=56.9f ps=0.74u w=0.17u l=0.17u
X956 cml_tlatch_41.xmux.xp.S1 cml_tlatch_41.OUTP cml_tlatch_41.OUTN VSS sg13_lv_nmos ad=0.1019p pd=1.34u as=56.9f ps=0.74u w=0.17u l=0.17u
X957 cml_tlatch_61.OUTP cml_tlatch_61.OUTN cml_tlatch_61.xmux.xp.S1 VSS sg13_lv_nmos ad=56.9f pd=0.74u as=56.9f ps=0.74u w=0.17u l=0.17u
X958 cml_tlatch_49.xmux.xn.S1 B3_2_P cml_tlatch_49.OUTN VSS sg13_lv_nmos ad=0.1082p pd=1.34u as=63.19999f ps=0.74u w=0.26u l=0.38u
X959 cml_tlatch_72.xtail.S1 CKHB3_P cml_tlatch_72.xmux.xn.S1 VSS sg13_lv_nmos ad=89.3f pd=0.85u as=89.3f ps=0.85u w=0.47u l=0.16u
X960 cml_gate2_2.xrtail.R1 CKB1_N GA1_P VSS sg13_lv_nmos ad=0.1007p pd=0.91u as=0.1007p ps=0.91u w=0.53u l=0.13u
X961 cml_tlatch_8.OUTP cml_tlatch_8.OUTN cml_tlatch_8.xmux.xp.S1 VSS sg13_lv_nmos ad=56.9f pd=0.74u as=56.9f ps=0.74u w=0.17u l=0.17u
X962 cml_tlatch_97.INP cml_tlatch_97.INN cml_tlatch_39.xmux.xp.S1 VSS sg13_lv_nmos ad=56.9f pd=0.74u as=56.9f ps=0.74u w=0.17u l=0.17u
X963 CKA3_N CK_N hs_to_clk_6.D2 VSS sg13_lv_nmos ad=0.228p pd=1.58u as=0.408p ps=3.08u w=1.2u l=0.2u
X964 cml_gate2_0.xrtail.R1 CKA1_P cml_gate2_0.xamp.xn.S1 VSS sg13_lv_nmos ad=0.1007p pd=0.91u as=0.1802p ps=1.74u w=0.53u l=0.13u
X965 cml_gate2_9.xamp.xn.S1 J1_P ENA_N VSS sg13_lv_nmos ad=0.1007p pd=0.91u as=0.1007p ps=0.91u w=0.53u l=0.13u
X966 cml_tlatch_7.OUTP cml_tlatch_8.OUTN cml_tlatch_7.xmux.xn.S1 VSS sg13_lv_nmos ad=63.19999f pd=0.74u as=63.19999f ps=0.74u w=0.26u l=0.38u
X967 cml_tlatch_15.xmux.xp.S1 MOT3_P MOT3_N VSS sg13_lv_nmos ad=56.9f pd=0.74u as=56.9f ps=0.74u w=0.17u l=0.17u
X968 cml_tlatch_20.OUTN cml_tlatch_20.OUTP cml_tlatch_20.xmux.xp.S1 VSS sg13_lv_nmos ad=56.9f pd=0.74u as=56.9f ps=0.74u w=0.17u l=0.17u
X969 stub_bi_17.BOTP stub_bi_17.BOTN cml_tlatch_13.xmux.xp.S1 VSS sg13_lv_nmos ad=56.9f pd=0.74u as=56.9f ps=0.74u w=0.17u l=0.17u
X970 cml_tlatch_49.xmux.xn.S1 B3_2_P cml_tlatch_49.OUTN VSS sg13_lv_nmos ad=63.19999f pd=0.74u as=63.19999f ps=0.74u w=0.26u l=0.38u
X971 cml_tlatch_71.xmux.xp.S1 cml_tlatch_71.OUTN cml_tlatch_71.OUTP VSS sg13_lv_nmos ad=56.9f pd=0.74u as=56.9f ps=0.74u w=0.17u l=0.17u
X972 cml_tlatch_53.xmux.xp.S1 MOT18_P MOT18_N VSS sg13_lv_nmos ad=56.9f pd=0.74u as=56.9f ps=0.74u w=0.17u l=0.17u
X973 cml_tlatch_39.xmux.xn.S1 A1_2_P cml_tlatch_97.INN VSS sg13_lv_nmos ad=63.19999f pd=0.74u as=63.19999f ps=0.74u w=0.26u l=0.38u
X974 A2_2_N A2_2_P cml_tlatch_60.xmux.xp.S1 VSS sg13_lv_nmos ad=56.9f pd=0.74u as=56.9f ps=0.74u w=0.17u l=0.17u
X975 cml_tlatch_32.xmux.xn.S1 D0_P cml_tlatch_32.OUTN VSS sg13_lv_nmos ad=63.19999f pd=0.74u as=0.1082p ps=1.34u w=0.26u l=0.38u
X976 cml_tlatch_86.OUTN cml_tlatch_87.OUTP cml_tlatch_86.xmux.xn.S1 VSS sg13_lv_nmos ad=63.19999f pd=0.74u as=0.1082p ps=1.34u w=0.26u l=0.38u
X977 cml_tlatch_98.OUTP cml_tlatch_98.OUTN cml_tlatch_98.xmux.xp.S1 VSS sg13_lv_nmos ad=56.9f pd=0.74u as=56.9f ps=0.74u w=0.17u l=0.17u
X978 GA0_P ENA0_N cml_gate2_3.xamp.xn.S1 VSS sg13_lv_nmos ad=0.1007p pd=0.91u as=0.1007p ps=0.91u w=0.53u l=0.13u
X979 cml_tlatch_42.xmux.xp.S1 CKHA1_N cml_tlatch_42.xtail.S1 VSS sg13_lv_nmos ad=89.3f pd=0.85u as=89.3f ps=0.85u w=0.47u l=0.16u
X980 cml_tlatch_13.xmux.xp.S1 stub_bi_17.BOTP stub_bi_17.BOTN VSS sg13_lv_nmos ad=56.9f pd=0.74u as=56.9f ps=0.74u w=0.17u l=0.17u
X981 VSS POLN cml_tlatch_70.xtail.S1 VSS sg13_lv_nmos ad=2.7982p pd=17.14u as=1.5637p ps=8.61u w=8.23u l=0.13u
X982 cml_tlatch_24.xtail.S1 POLN VSS VSS sg13_lv_nmos ad=1.5637p pd=8.61u as=1.5637p ps=8.61u w=8.23u l=0.13u
X983 MOT25_P MOT25_N cml_tlatch_72.xmux.xp.S1 VSS sg13_lv_nmos ad=56.9f pd=0.74u as=0.1019p ps=1.34u w=0.17u l=0.17u
X984 cml_tlatch_40.xtail.S1 CKA1_P cml_tlatch_40.xmux.xp.S1 VSS sg13_lv_nmos ad=89.3f pd=0.85u as=89.3f ps=0.85u w=0.47u l=0.16u
X985 cml_tlatch_65.OUTP VDD VSS rppd l=5.17u w=1u
X986 cml_tlatch_72.xtail.S1 CKHB3_N cml_tlatch_72.xmux.xp.S1 VSS sg13_lv_nmos ad=89.3f pd=0.85u as=0.1598p ps=1.62u w=0.47u l=0.16u
X987 cml_tlatch_79.xmux.xp.S1 MOT21_P MOT21_N VSS sg13_lv_nmos ad=56.9f pd=0.74u as=56.9f ps=0.74u w=0.17u l=0.17u
X988 cml_tlatch_89.xmux.xp.S1 cml_tlatch_44.INN cml_tlatch_44.INP VSS sg13_lv_nmos ad=56.9f pd=0.74u as=56.9f ps=0.74u w=0.17u l=0.17u
X989 cml_tlatch_69.xtail.S1 CKA3_P cml_tlatch_69.xmux.xn.S1 VSS sg13_lv_nmos ad=89.3f pd=0.85u as=89.3f ps=0.85u w=0.47u l=0.16u
X990 cml_tlatch_67.OUTN cml_tlatch_67.OUTP cml_tlatch_67.xmux.xp.S1 VSS sg13_lv_nmos ad=56.9f pd=0.74u as=56.9f ps=0.74u w=0.17u l=0.17u
X991 cml_tlatch_15.xtail.S1 CKHB0_P cml_tlatch_15.xmux.xn.S1 VSS sg13_lv_nmos ad=89.3f pd=0.85u as=89.3f ps=0.85u w=0.47u l=0.16u
X992 cml_tlatch_83.xtail.S1 POLN VSS VSS sg13_lv_nmos ad=1.5637p pd=8.61u as=2.7982p ps=17.14u w=8.23u l=0.13u
X993 MOT23_N B2_2_P cml_tlatch_80.xmux.xn.S1 VSS sg13_lv_nmos ad=63.19999f pd=0.74u as=63.19999f ps=0.74u w=0.26u l=0.38u
X994 A0_8_N A0_8_P cml_tlatch_9.xmux.xp.S1 VSS sg13_lv_nmos ad=56.9f pd=0.74u as=56.9f ps=0.74u w=0.17u l=0.17u
X995 cml_tlatch_52.xmux.xn.S1 A2_8_P MOT16_N VSS sg13_lv_nmos ad=63.19999f pd=0.74u as=63.19999f ps=0.74u w=0.26u l=0.38u
X996 cml_tlatch_81.xmux.xp.S1 B2_8_N B2_8_P VSS sg13_lv_nmos ad=56.9f pd=0.74u as=56.9f ps=0.74u w=0.17u l=0.17u
X997 VSS POLN cml_tlatch_27.xtail.S1 VSS sg13_lv_nmos ad=1.5637p pd=8.61u as=1.5637p ps=8.61u w=8.23u l=0.13u
X998 cml_tlatch_44.xmux.xn.S1 CKHA3_P cml_tlatch_44.xtail.S1 VSS sg13_lv_nmos ad=89.3f pd=0.85u as=89.3f ps=0.85u w=0.47u l=0.16u
X999 cml_tlatch_38.xtail.S1 CKA0_P cml_tlatch_38.xmux.xn.S1 VSS sg13_lv_nmos ad=89.3f pd=0.85u as=89.3f ps=0.85u w=0.47u l=0.16u
X1000 cml_tlatch_36.xtail.S1 CKB1_P cml_tlatch_36.xmux.xp.S1 VSS sg13_lv_nmos ad=89.3f pd=0.85u as=89.3f ps=0.85u w=0.47u l=0.16u
X1001 cml_tlatch_75.xmux.xp.S1 MOT31_N MOT31_P VSS sg13_lv_nmos ad=56.9f pd=0.74u as=56.9f ps=0.74u w=0.17u l=0.17u
X1002 cml_tlatch_60.xtail.S1 CKA2_P cml_tlatch_60.xmux.xp.S1 VSS sg13_lv_nmos ad=89.3f pd=0.85u as=89.3f ps=0.85u w=0.47u l=0.16u
X1003 cml_tlatch_99.xmux.xn.S1 CKA0_N cml_tlatch_99.xtail.S1 VSS sg13_lv_nmos ad=89.3f pd=0.85u as=0.1598p ps=1.62u w=0.47u l=0.16u
X1004 GB3_P CKA3_N cml_gate2_6.xrtail.R1 VSS sg13_lv_nmos ad=0.1007p pd=0.91u as=0.1007p ps=0.91u w=0.53u l=0.13u
X1005 cml_tlatch_55.xmux.xp.S1 MOT22_P MOT22_N VSS sg13_lv_nmos ad=56.9f pd=0.74u as=56.9f ps=0.74u w=0.17u l=0.17u
X1006 J4_N J4_P cml_tlatch_92.xmux.xp.S1 VSS sg13_lv_nmos ad=56.9f pd=0.74u as=56.9f ps=0.74u w=0.17u l=0.17u
X1007 cml_tlatch_18.OUTN cml_tlatch_18.OUTP cml_tlatch_18.xmux.xp.S1 VSS sg13_lv_nmos ad=56.9f pd=0.74u as=56.9f ps=0.74u w=0.17u l=0.17u
X1008 MOT12_N cml_tlatch_24.INP cml_tlatch_24.xmux.xn.S1 VSS sg13_lv_nmos ad=63.19999f pd=0.74u as=63.19999f ps=0.74u w=0.26u l=0.38u
X1009 cml_tlatch_19.xtail.S1 CKA1_N cml_tlatch_19.xmux.xn.S1 VSS sg13_lv_nmos ad=89.3f pd=0.85u as=89.3f ps=0.85u w=0.47u l=0.16u
X1010 MOT12_N cml_tlatch_24.INP cml_tlatch_24.xmux.xn.S1 VSS sg13_lv_nmos ad=63.19999f pd=0.74u as=63.19999f ps=0.74u w=0.26u l=0.38u
X1011 cml_tlatch_61.xmux.xp.S1 CKA2_N cml_tlatch_61.xtail.S1 VSS sg13_lv_nmos ad=89.3f pd=0.85u as=89.3f ps=0.85u w=0.47u l=0.16u
X1012 cml_tlatch_20.xmux.xp.S1 cml_tlatch_20.OUTN cml_tlatch_20.OUTP VSS sg13_lv_nmos ad=56.9f pd=0.74u as=56.9f ps=0.74u w=0.17u l=0.17u
X1013 MOT20_N MOT20_P cml_tlatch_54.xmux.xp.S1 VSS sg13_lv_nmos ad=56.9f pd=0.74u as=56.9f ps=0.74u w=0.17u l=0.17u
X1014 MOT19_N MOT19_P cml_tlatch_78.xmux.xp.S1 VSS sg13_lv_nmos ad=56.9f pd=0.74u as=56.9f ps=0.74u w=0.17u l=0.17u
X1015 stub_bi_55.BOTN VDD VSS rppd l=5.17u w=1u
X1016 cml_tlatch_70.xmux.xp.S1 cml_tlatch_63.INN cml_tlatch_63.INP VSS sg13_lv_nmos ad=56.9f pd=0.74u as=56.9f ps=0.74u w=0.17u l=0.17u
X1017 cml_tlatch_70.xmux.xp.S1 cml_tlatch_63.INP cml_tlatch_63.INN VSS sg13_lv_nmos ad=56.9f pd=0.74u as=56.9f ps=0.74u w=0.17u l=0.17u
X1018 cml_tlatch_44.xmux.xp.S1 MOT28_P MOT28_N VSS sg13_lv_nmos ad=56.9f pd=0.74u as=56.9f ps=0.74u w=0.17u l=0.17u
X1019 cml_tlatch_73.xmux.xp.S1 MOT27_P MOT27_N VSS sg13_lv_nmos ad=56.9f pd=0.74u as=56.9f ps=0.74u w=0.17u l=0.17u
X1020 cml_tlatch_4.xmux.xn.S1 cml_tlatch_4.INP MOT11_N VSS sg13_lv_nmos ad=63.19999f pd=0.74u as=63.19999f ps=0.74u w=0.26u l=0.38u
X1021 cml_tlatch_73.INP cml_tlatch_73.INN cml_tlatch_66.xmux.xp.S1 VSS sg13_lv_nmos ad=56.9f pd=0.74u as=56.9f ps=0.74u w=0.17u l=0.17u
X1022 MOT1_P B0_8_N cml_tlatch_14.xmux.xn.S1 VSS sg13_lv_nmos ad=63.19999f pd=0.74u as=63.19999f ps=0.74u w=0.26u l=0.38u
X1023 hs_to_clk_3.sg13_lv_nmos_2HGZLP_0.G CKA1_P VSS rppd l=4.25u w=1u
X1024 cml_tlatch_99.xtail.S1 POLN VSS VSS sg13_lv_nmos ad=1.5637p pd=8.61u as=2.7982p ps=17.14u w=8.23u l=0.13u
X1025 VSS POLN cml_tlatch_43.xtail.S1 VSS sg13_lv_nmos ad=2.7982p pd=17.14u as=1.5637p ps=8.61u w=8.23u l=0.13u
X1026 cml_tlatch_99.xmux.xn.S1 cml_tlatch_33.OUTN cml_tlatch_99.OUTP VSS sg13_lv_nmos ad=63.19999f pd=0.74u as=63.19999f ps=0.74u w=0.26u l=0.38u
X1027 cml_tlatch_46.xmux.xp.S1 stub_bi_38.BOTN stub_bi_38.BOTP VSS sg13_lv_nmos ad=56.9f pd=0.74u as=56.9f ps=0.74u w=0.17u l=0.17u
X1028 cml_tlatch_9.xmux.xp.S1 CKA0_P cml_tlatch_9.xtail.S1 VSS sg13_lv_nmos ad=89.3f pd=0.85u as=89.3f ps=0.85u w=0.47u l=0.16u
X1029 cml_gate2_9.xrtail.R1 NM1_N ENA_P VSS sg13_lv_nmos ad=0.1007p pd=0.91u as=0.1007p ps=0.91u w=0.53u l=0.13u
X1030 MOT6_N MOT6_P cml_tlatch_29.xmux.xp.S1 VSS sg13_lv_nmos ad=56.9f pd=0.74u as=56.9f ps=0.74u w=0.17u l=0.17u
X1031 MOT5_P MOT5_N cml_tlatch_16.xmux.xp.S1 VSS sg13_lv_nmos ad=56.9f pd=0.74u as=0.1019p ps=1.34u w=0.17u l=0.17u
X1032 B3_8_N B3_8_P cml_tlatch_64.xmux.xp.S1 VSS sg13_lv_nmos ad=56.9f pd=0.74u as=56.9f ps=0.74u w=0.17u l=0.17u
X1033 cml_tlatch_66.xmux.xn.S1 cml_tlatch_67.OUTP cml_tlatch_73.INN VSS sg13_lv_nmos ad=63.19999f pd=0.74u as=0.1082p ps=1.34u w=0.26u l=0.38u
X1034 cml_tlatch_46.xtail.S1 CKB2_P cml_tlatch_46.xmux.xn.S1 VSS sg13_lv_nmos ad=89.3f pd=0.85u as=89.3f ps=0.85u w=0.47u l=0.16u
X1035 cml_tlatch_26.xmux.xn.S1 CKHA0_P cml_tlatch_26.xtail.S1 VSS sg13_lv_nmos ad=89.3f pd=0.85u as=89.3f ps=0.85u w=0.47u l=0.16u
X1036 cml_tlatch_8.xmux.xp.S1 cml_tlatch_8.OUTP cml_tlatch_8.OUTN VSS sg13_lv_nmos ad=56.9f pd=0.74u as=56.9f ps=0.74u w=0.17u l=0.17u
X1037 hs_to_clk_2.D2 CK_N CKB1_P VSS sg13_lv_nmos ad=0.228p pd=1.58u as=0.408p ps=3.08u w=1.2u l=0.2u
X1038 cml_tlatch_94.xmux.xp.S1 J2_N J2_P VSS sg13_lv_nmos ad=56.9f pd=0.74u as=56.9f ps=0.74u w=0.17u l=0.17u
X1039 MOT20_P cml_tlatch_91.OUTN cml_tlatch_54.xmux.xn.S1 VSS sg13_lv_nmos ad=63.19999f pd=0.74u as=63.19999f ps=0.74u w=0.26u l=0.38u
X1040 A2_2_N A2_2_P cml_tlatch_60.xmux.xp.S1 VSS sg13_lv_nmos ad=56.9f pd=0.74u as=56.9f ps=0.74u w=0.17u l=0.17u
X1041 cml_tlatch_38.xtail.S1 CKA0_N cml_tlatch_38.xmux.xp.S1 VSS sg13_lv_nmos ad=89.3f pd=0.85u as=89.3f ps=0.85u w=0.47u l=0.16u
X1042 cml_tlatch_5.INP cml_tlatch_5.INN cml_tlatch_96.xmux.xp.S1 VSS sg13_lv_nmos ad=56.9f pd=0.74u as=56.9f ps=0.74u w=0.17u l=0.17u
X1043 cml_tlatch_47.xmux.xp.S1 B2_2_P B2_2_N VSS sg13_lv_nmos ad=56.9f pd=0.74u as=56.9f ps=0.74u w=0.17u l=0.17u
X1044 stub_bi_55.BOTN stub_bi_38.BOTP cml_tlatch_90.xmux.xn.S1 VSS sg13_lv_nmos ad=63.19999f pd=0.74u as=63.19999f ps=0.74u w=0.26u l=0.38u
X1045 VDD MOT22_N VSS rppd l=5.17u w=1u
X1046 cml_tlatch_78.xmux.xp.S1 CKHB2_N cml_tlatch_78.xtail.S1 VSS sg13_lv_nmos ad=89.3f pd=0.85u as=0.1598p ps=1.62u w=0.47u l=0.16u
X1047 MOT1_N MOT1_P cml_tlatch_14.xmux.xp.S1 VSS sg13_lv_nmos ad=56.9f pd=0.74u as=56.9f ps=0.74u w=0.17u l=0.17u
X1048 cml_tlatch_67.xmux.xn.S1 CKB3_P cml_tlatch_67.xtail.S1 VSS sg13_lv_nmos ad=89.3f pd=0.85u as=89.3f ps=0.85u w=0.47u l=0.16u
X1049 cml_tlatch_49.OUTP cml_tlatch_49.OUTN cml_tlatch_49.xmux.xp.S1 VSS sg13_lv_nmos ad=56.9f pd=0.74u as=56.9f ps=0.74u w=0.17u l=0.17u
X1050 cml_tlatch_94.xmux.xn.S1 J1_P J2_N VSS sg13_lv_nmos ad=63.19999f pd=0.74u as=63.19999f ps=0.74u w=0.26u l=0.38u
X1051 cml_tlatch_75.xtail.S1 CKHB3_P cml_tlatch_75.xmux.xn.S1 VSS sg13_lv_nmos ad=89.3f pd=0.85u as=89.3f ps=0.85u w=0.47u l=0.16u
X1052 cml_tlatch_99.xtail.S1 CKA0_P cml_tlatch_99.xmux.xp.S1 VSS sg13_lv_nmos ad=89.3f pd=0.85u as=89.3f ps=0.85u w=0.47u l=0.16u
X1053 A3_8_P A3_8_N cml_tlatch_68.xmux.xp.S1 VSS sg13_lv_nmos ad=56.9f pd=0.74u as=56.9f ps=0.74u w=0.17u l=0.17u
X1054 VSS POLN cml_tlatch_12.xtail.S1 VSS sg13_lv_nmos ad=1.5637p pd=8.61u as=1.5637p ps=8.61u w=8.23u l=0.13u
X1055 cml_tlatch_55.xmux.xp.S1 MOT22_N MOT22_P VSS sg13_lv_nmos ad=56.9f pd=0.74u as=56.9f ps=0.74u w=0.17u l=0.17u
X1056 cml_tlatch_67.xtail.S1 POLN VSS VSS sg13_lv_nmos ad=1.5637p pd=8.61u as=2.7982p ps=17.14u w=8.23u l=0.13u
X1057 cml_tlatch_15.xmux.xp.S1 MOT3_N MOT3_P VSS sg13_lv_nmos ad=56.9f pd=0.74u as=56.9f ps=0.74u w=0.17u l=0.17u
X1058 cml_tlatch_19.xtail.S1 CKA1_N cml_tlatch_19.xmux.xn.S1 VSS sg13_lv_nmos ad=89.3f pd=0.85u as=89.3f ps=0.85u w=0.47u l=0.16u
X1059 cml_tlatch_10.xmux.xp.S1 B1_8_P B1_8_N VSS sg13_lv_nmos ad=0.1019p pd=1.34u as=56.9f ps=0.74u w=0.17u l=0.17u
X1060 cml_tlatch_38.xmux.xp.S1 cml_tlatch_38.OUTP cml_tlatch_38.OUTN VSS sg13_lv_nmos ad=56.9f pd=0.74u as=56.9f ps=0.74u w=0.17u l=0.17u
X1061 cml_tlatch_79.xmux.xp.S1 MOT21_P MOT21_N VSS sg13_lv_nmos ad=0.1019p pd=1.34u as=56.9f ps=0.74u w=0.17u l=0.17u
X1062 cml_tlatch_40.xtail.S1 CKA1_N cml_tlatch_40.xmux.xn.S1 VSS sg13_lv_nmos ad=89.3f pd=0.85u as=89.3f ps=0.85u w=0.47u l=0.16u
X1063 MOT29_N MOT29_P cml_tlatch_74.xmux.xp.S1 VSS sg13_lv_nmos ad=56.9f pd=0.74u as=56.9f ps=0.74u w=0.17u l=0.17u
X1064 MOT14_N MOT14_P cml_tlatch_25.xmux.xp.S1 VSS sg13_lv_nmos ad=56.9f pd=0.74u as=0.1019p ps=1.34u w=0.17u l=0.17u
X1065 cml_tlatch_76.xmux.xp.S1 cml_tlatch_87.INP cml_tlatch_87.INN VSS sg13_lv_nmos ad=56.9f pd=0.74u as=56.9f ps=0.74u w=0.17u l=0.17u
X1066 cml_tlatch_73.xmux.xp.S1 CKHB3_N cml_tlatch_73.xtail.S1 VSS sg13_lv_nmos ad=89.3f pd=0.85u as=89.3f ps=0.85u w=0.47u l=0.16u
X1067 cml_tlatch_2.xmux.xp.S1 cml_tlatch_2.OUTP cml_tlatch_2.OUTN VSS sg13_lv_nmos ad=56.9f pd=0.74u as=56.9f ps=0.74u w=0.17u l=0.17u
X1068 cml_tlatch_41.xmux.xp.S1 cml_tlatch_41.OUTN cml_tlatch_41.OUTP VSS sg13_lv_nmos ad=56.9f pd=0.74u as=56.9f ps=0.74u w=0.17u l=0.17u
X1069 A0_8_N A0_8_P cml_tlatch_9.xmux.xp.S1 VSS sg13_lv_nmos ad=56.9f pd=0.74u as=56.9f ps=0.74u w=0.17u l=0.17u
X1070 CKB0_N hs_to_clk_1.sg13_lv_nmos_2HGZLP_0.G VSS rppd l=4.25u w=1u
X1071 cml_tlatch_98.xmux.xn.S1 CKB0_N cml_tlatch_98.xtail.S1 VSS sg13_lv_nmos ad=89.3f pd=0.85u as=89.3f ps=0.85u w=0.47u l=0.16u
X1072 cml_tlatch_92.xmux.xp.S1 J4_N J4_P VSS sg13_lv_nmos ad=56.9f pd=0.74u as=56.9f ps=0.74u w=0.17u l=0.17u
X1073 cml_tlatch_31.xtail.S1 CKB0_P cml_tlatch_31.xmux.xp.S1 VSS sg13_lv_nmos ad=89.3f pd=0.85u as=89.3f ps=0.85u w=0.47u l=0.16u
X1074 cml_tlatch_17.xmux.xp.S1 MOT7_P MOT7_N VSS sg13_lv_nmos ad=56.9f pd=0.74u as=56.9f ps=0.74u w=0.17u l=0.17u
X1075 cml_tlatch_5.xmux.xp.S1 MOT13_P MOT13_N VSS sg13_lv_nmos ad=56.9f pd=0.74u as=56.9f ps=0.74u w=0.17u l=0.17u
X1076 cml_tlatch_4.INP cml_tlatch_4.INN cml_tlatch_12.xmux.xp.S1 VSS sg13_lv_nmos ad=56.9f pd=0.74u as=56.9f ps=0.74u w=0.17u l=0.17u
X1077 cml_tlatch_71.xtail.S1 CKA3_N cml_tlatch_71.xmux.xp.S1 VSS sg13_lv_nmos ad=89.3f pd=0.85u as=89.3f ps=0.85u w=0.47u l=0.16u
X1078 cml_tlatch_35.xmux.xp.S1 stub_bi_29.BOTP stub_bi_29.BOTN VSS sg13_lv_nmos ad=0.1019p pd=1.34u as=56.9f ps=0.74u w=0.17u l=0.17u
X1079 ENA1_N ENA_P cml_drv_1.xrtail.R1 VSS sg13_lv_nmos ad=56.2f pd=0.74u as=0.1012p ps=1.34u w=0.16u l=0.19u
X1080 A0_2_P A0_2_N cml_tlatch_34.xmux.xp.S1 VSS sg13_lv_nmos ad=56.9f pd=0.74u as=56.9f ps=0.74u w=0.17u l=0.17u
X1081 cml_tlatch_69.OUTP cml_tlatch_69.OUTN cml_tlatch_69.xmux.xp.S1 VSS sg13_lv_nmos ad=56.9f pd=0.74u as=56.9f ps=0.74u w=0.17u l=0.17u
X1082 VDD cml_tlatch_23.OUTN VSS rppd l=5.17u w=1u
X1083 VSS POLN cml_tlatch_95.xtail.S1 VSS sg13_lv_nmos ad=2.7982p pd=17.14u as=1.5637p ps=8.61u w=8.23u l=0.13u
X1084 cml_tlatch_61.OUTN D2_P cml_tlatch_61.xmux.xn.S1 VSS sg13_lv_nmos ad=63.19999f pd=0.74u as=0.1082p ps=1.34u w=0.26u l=0.38u
X1085 GA1_N ENA0_P cml_gate2_2.xamp.xn.S1 VSS sg13_lv_nmos ad=0.1007p pd=0.91u as=0.1007p ps=0.91u w=0.53u l=0.13u
X1086 cml_tlatch_56.OUTN cml_tlatch_56.OUTP cml_tlatch_56.xmux.xp.S1 VSS sg13_lv_nmos ad=56.9f pd=0.74u as=56.9f ps=0.74u w=0.17u l=0.17u
X1087 cml_drvb_0.xrtail.R2 GB1_P CKHB1_N VSS sg13_lv_nmos ad=0.1463p pd=1.15u as=0.2618p ps=2.22u w=0.77u l=0.21u
X1088 cml_tlatch_53.xmux.xn.S1 cml_tlatch_87.OUTN MOT18_P VSS sg13_lv_nmos ad=63.19999f pd=0.74u as=63.19999f ps=0.74u w=0.26u l=0.38u
X1089 stub_bi_15.BOTN stub_bi_15.BOTP cml_tlatch_11.xmux.xp.S1 VSS sg13_lv_nmos ad=56.9f pd=0.74u as=56.9f ps=0.74u w=0.17u l=0.17u
X1090 J2_N J2_P cml_tlatch_94.xmux.xp.S1 VSS sg13_lv_nmos ad=56.9f pd=0.74u as=56.9f ps=0.74u w=0.17u l=0.17u
X1091 J1_P J1_N cml_tlatch_95.xmux.xp.S1 VSS sg13_lv_nmos ad=56.9f pd=0.74u as=56.9f ps=0.74u w=0.17u l=0.17u
X1092 cml_tlatch_67.xtail.S1 CKB3_N cml_tlatch_67.xmux.xp.S1 VSS sg13_lv_nmos ad=0.1598p pd=1.62u as=89.3f ps=0.85u w=0.47u l=0.16u
X1093 MOT18_N cml_tlatch_87.OUTP cml_tlatch_53.xmux.xn.S1 VSS sg13_lv_nmos ad=63.19999f pd=0.74u as=63.19999f ps=0.74u w=0.26u l=0.38u
X1094 GB2_P CKA2_N cml_gate2_7.xrtail.R1 VSS sg13_lv_nmos ad=0.1007p pd=0.91u as=0.1007p ps=0.91u w=0.53u l=0.13u
X1095 cml_tlatch_44.INN cml_tlatch_56.OUTP cml_tlatch_89.xmux.xn.S1 VSS sg13_lv_nmos ad=63.19999f pd=0.74u as=63.19999f ps=0.74u w=0.26u l=0.38u
X1096 cml_tlatch_26.xmux.xp.S1 MOT0_N MOT0_P VSS sg13_lv_nmos ad=56.9f pd=0.74u as=56.9f ps=0.74u w=0.17u l=0.17u
X1097 cml_tlatch_31.xmux.xn.S1 cml_tlatch_32.OUTP B0_2_N VSS sg13_lv_nmos ad=0.1082p pd=1.34u as=63.19999f ps=0.74u w=0.26u l=0.38u
X1098 cml_tlatch_15.xmux.xn.S1 CKHB0_P cml_tlatch_15.xtail.S1 VSS sg13_lv_nmos ad=89.3f pd=0.85u as=0.1598p ps=1.62u w=0.47u l=0.16u
X1099 cml_tlatch_37.xmux.xn.S1 D1_N stub_bi_31.BOTN VSS sg13_lv_nmos ad=0.1082p pd=1.34u as=63.19999f ps=0.74u w=0.26u l=0.38u
X1100 GA3_N ENA1_P cml_gate2_4.xamp.xn.S1 VSS sg13_lv_nmos ad=0.1007p pd=0.91u as=0.1007p ps=0.91u w=0.53u l=0.13u
X1101 cml_tlatch_59.xtail.S1 CKA2_N cml_tlatch_59.xmux.xp.S1 VSS sg13_lv_nmos ad=89.3f pd=0.85u as=89.3f ps=0.85u w=0.47u l=0.16u
X1102 MOT5_P MOT5_N cml_tlatch_16.xmux.xp.S1 VSS sg13_lv_nmos ad=56.9f pd=0.74u as=56.9f ps=0.74u w=0.17u l=0.17u
X1103 MOT31_P B3_2_N cml_tlatch_75.xmux.xn.S1 VSS sg13_lv_nmos ad=63.19999f pd=0.74u as=63.19999f ps=0.74u w=0.26u l=0.38u
X1104 cml_tlatch_40.xtail.S1 CKA1_N cml_tlatch_40.xmux.xn.S1 VSS sg13_lv_nmos ad=89.3f pd=0.85u as=89.3f ps=0.85u w=0.47u l=0.16u
X1105 cml_tlatch_87.INP cml_tlatch_87.INN cml_tlatch_76.xmux.xp.S1 VSS sg13_lv_nmos ad=56.9f pd=0.74u as=56.9f ps=0.74u w=0.17u l=0.17u
X1106 cml_tlatch_72.xtail.S1 CKHB3_P cml_tlatch_72.xmux.xn.S1 VSS sg13_lv_nmos ad=89.3f pd=0.85u as=89.3f ps=0.85u w=0.47u l=0.16u
X1107 cml_tlatch_99.xmux.xn.S1 cml_tlatch_33.OUTP cml_tlatch_99.OUTN VSS sg13_lv_nmos ad=63.19999f pd=0.74u as=63.19999f ps=0.74u w=0.26u l=0.38u
X1108 A1_2_N cml_tlatch_41.OUTP cml_tlatch_40.xmux.xn.S1 VSS sg13_lv_nmos ad=63.19999f pd=0.74u as=63.19999f ps=0.74u w=0.26u l=0.38u
X1109 cml_tlatch_64.xmux.xp.S1 B3_8_N B3_8_P VSS sg13_lv_nmos ad=56.9f pd=0.74u as=56.9f ps=0.74u w=0.17u l=0.17u
X1110 stub_bi_15.BOTP cml_tlatch_4.INP cml_tlatch_11.xmux.xn.S1 VSS sg13_lv_nmos ad=63.19999f pd=0.74u as=63.19999f ps=0.74u w=0.26u l=0.38u
X1111 cml_tlatch_81.xtail.S1 CKB2_P cml_tlatch_81.xmux.xp.S1 VSS sg13_lv_nmos ad=89.3f pd=0.85u as=89.3f ps=0.85u w=0.47u l=0.16u
X1112 cml_tlatch_90.xmux.xp.S1 stub_bi_55.BOTN stub_bi_55.BOTP VSS sg13_lv_nmos ad=56.9f pd=0.74u as=56.9f ps=0.74u w=0.17u l=0.17u
X1113 cml_tlatch_34.xmux.xp.S1 A0_2_P A0_2_N VSS sg13_lv_nmos ad=56.9f pd=0.74u as=56.9f ps=0.74u w=0.17u l=0.17u
X1114 cml_tlatch_52.xmux.xp.S1 MOT16_N MOT16_P VSS sg13_lv_nmos ad=56.9f pd=0.74u as=56.9f ps=0.74u w=0.17u l=0.17u
X1115 cml_tlatch_61.OUTN cml_tlatch_61.OUTP cml_tlatch_61.xmux.xp.S1 VSS sg13_lv_nmos ad=56.9f pd=0.74u as=56.9f ps=0.74u w=0.17u l=0.17u
X1116 cml_tlatch_46.xtail.S1 CKB2_N cml_tlatch_46.xmux.xp.S1 VSS sg13_lv_nmos ad=0.1598p pd=1.62u as=89.3f ps=0.85u w=0.47u l=0.16u
X1117 MOT23_N MOT23_P cml_tlatch_80.xmux.xp.S1 VSS sg13_lv_nmos ad=56.9f pd=0.74u as=0.1019p ps=1.34u w=0.17u l=0.17u
X1118 cml_tlatch_32.OUTN cml_tlatch_32.OUTP cml_tlatch_32.xmux.xp.S1 VSS sg13_lv_nmos ad=56.9f pd=0.74u as=56.9f ps=0.74u w=0.17u l=0.17u
X1119 cml_tlatch_65.xmux.xn.S1 cml_tlatch_73.INP cml_tlatch_65.OUTN VSS sg13_lv_nmos ad=63.19999f pd=0.74u as=63.19999f ps=0.74u w=0.26u l=0.38u
X1120 cml_gate2_0.xrtail.R1 CKA1_N GB1_P VSS sg13_lv_nmos ad=0.1007p pd=0.91u as=0.1007p ps=0.91u w=0.53u l=0.13u
X1121 MOT26_N VDD VSS rppd l=5.17u w=1u
X1122 cml_tlatch_78.xmux.xn.S1 CKHB2_P cml_tlatch_78.xtail.S1 VSS sg13_lv_nmos ad=89.3f pd=0.85u as=89.3f ps=0.85u w=0.47u l=0.16u
X1123 cml_tlatch_91.INP A2_2_N cml_tlatch_59.xmux.xn.S1 VSS sg13_lv_nmos ad=63.19999f pd=0.74u as=63.19999f ps=0.74u w=0.26u l=0.38u
X1124 cml_tlatch_16.xtail.S1 CKHB0_P cml_tlatch_16.xmux.xn.S1 VSS sg13_lv_nmos ad=89.3f pd=0.85u as=89.3f ps=0.85u w=0.47u l=0.16u
X1125 cml_gate2_1.xamp.xn.S1 ENB1_N GB0_P VSS sg13_lv_nmos ad=0.1007p pd=0.91u as=0.1007p ps=0.91u w=0.53u l=0.13u
X1126 MOT13_P cml_tlatch_5.INN cml_tlatch_5.xmux.xn.S1 VSS sg13_lv_nmos ad=63.19999f pd=0.74u as=63.19999f ps=0.74u w=0.26u l=0.38u
X1127 cml_tlatch_43.xmux.xp.S1 MOT10_N MOT10_P VSS sg13_lv_nmos ad=56.9f pd=0.74u as=56.9f ps=0.74u w=0.17u l=0.17u
X1128 cml_tlatch_33.xmux.xn.S1 A0_2_P cml_tlatch_33.OUTN VSS sg13_lv_nmos ad=63.19999f pd=0.74u as=63.19999f ps=0.74u w=0.26u l=0.38u
X1129 cml_tlatch_64.xmux.xp.S1 B3_8_N B3_8_P VSS sg13_lv_nmos ad=0.1019p pd=1.34u as=56.9f ps=0.74u w=0.17u l=0.17u
X1130 cml_tlatch_58.OUTP cml_tlatch_58.OUTN cml_tlatch_58.xmux.xp.S1 VSS sg13_lv_nmos ad=56.9f pd=0.74u as=56.9f ps=0.74u w=0.17u l=0.17u
X1131 stub_bi_62.BOTP stub_bi_62.BOTN cml_tlatch_82.xmux.xp.S1 VSS sg13_lv_nmos ad=56.9f pd=0.74u as=56.9f ps=0.74u w=0.17u l=0.17u
X1132 CKB2_N hs_to_clk_4.sg13_lv_nmos_2HGZLP_0.G VSS rppd l=4.25u w=1u
X1133 stub_bi_49.BOTP stub_bi_49.BOTN cml_tlatch_84.xmux.xp.S1 VSS sg13_lv_nmos ad=56.9f pd=0.74u as=56.9f ps=0.74u w=0.17u l=0.17u
X1134 cml_tlatch_59.xmux.xn.S1 A2_2_P cml_tlatch_91.INN VSS sg13_lv_nmos ad=63.19999f pd=0.74u as=63.19999f ps=0.74u w=0.26u l=0.38u
X1135 MOT1_P MOT1_N cml_tlatch_14.xmux.xp.S1 VSS sg13_lv_nmos ad=56.9f pd=0.74u as=56.9f ps=0.74u w=0.17u l=0.17u
X1136 B1_8_P B1_8_N cml_tlatch_10.xmux.xp.S1 VSS sg13_lv_nmos ad=56.9f pd=0.74u as=56.9f ps=0.74u w=0.17u l=0.17u
X1137 cml_tlatch_27.xtail.S1 CKHA0_N cml_tlatch_27.xmux.xp.S1 VSS sg13_lv_nmos ad=89.3f pd=0.85u as=89.3f ps=0.85u w=0.47u l=0.16u
X1138 stub_bi_31.BOTN stub_bi_31.BOTP cml_tlatch_37.xmux.xp.S1 VSS sg13_lv_nmos ad=56.9f pd=0.74u as=56.9f ps=0.74u w=0.17u l=0.17u
X1139 cml_tlatch_47.xmux.xp.S1 B2_2_N B2_2_P VSS sg13_lv_nmos ad=56.9f pd=0.74u as=56.9f ps=0.74u w=0.17u l=0.17u
X1140 A1_2_P A1_2_N cml_tlatch_40.xmux.xp.S1 VSS sg13_lv_nmos ad=56.9f pd=0.74u as=56.9f ps=0.74u w=0.17u l=0.17u
X1141 VSS hs_to_clk_0.sg13_lv_nmos_2HGZLP_0.G VSS VSS sg13_lv_nmos ad=2.071p pd=11.28u as=0 ps=0 w=10.9u l=1.38u
X1142 cml_tlatch_95.xmux.xn.S1 J4_P J1_P VSS sg13_lv_nmos ad=63.19999f pd=0.74u as=63.19999f ps=0.74u w=0.26u l=0.38u
X1143 cml_tlatch_0.OUTP cml_tlatch_0.OUTN cml_tlatch_0.xmux.xp.S1 VSS sg13_lv_nmos ad=56.9f pd=0.74u as=56.9f ps=0.74u w=0.17u l=0.17u
X1144 ENB_P J2_N cml_gate2_8.xamp.xn.S1 VSS sg13_lv_nmos ad=0.1802p pd=1.74u as=0.1007p ps=0.91u w=0.53u l=0.13u
X1145 cml_tlatch_68.xmux.xn.S1 CKA3_N cml_tlatch_68.xtail.S1 VSS sg13_lv_nmos ad=0.1598p pd=1.62u as=89.3f ps=0.85u w=0.47u l=0.16u
X1146 cml_tlatch_8.xmux.xn.S1 cml_tlatch_98.OUTP cml_tlatch_8.OUTN VSS sg13_lv_nmos ad=0.1082p pd=1.34u as=63.19999f ps=0.74u w=0.26u l=0.38u
X1147 J1_N J4_N cml_tlatch_95.xmux.xn.S1 VSS sg13_lv_nmos ad=63.19999f pd=0.74u as=63.19999f ps=0.74u w=0.26u l=0.38u
X1148 cml_tlatch_63.xmux.xp.S1 MOT26_N MOT26_P VSS sg13_lv_nmos ad=56.9f pd=0.74u as=56.9f ps=0.74u w=0.17u l=0.17u
X1149 A3_8_P cml_tlatch_69.OUTN cml_tlatch_68.xmux.xn.S1 VSS sg13_lv_nmos ad=63.19999f pd=0.74u as=0.1082p ps=1.34u w=0.26u l=0.38u
X1150 cml_tlatch_57.xtail.S1 POLN VSS VSS sg13_lv_nmos ad=1.5637p pd=8.61u as=1.5637p ps=8.61u w=8.23u l=0.13u
X1151 cml_tlatch_23.OUTP cml_tlatch_23.OUTN cml_tlatch_23.xmux.xp.S1 VSS sg13_lv_nmos ad=56.9f pd=0.74u as=56.9f ps=0.74u w=0.17u l=0.17u
X1152 cml_tlatch_36.xtail.S1 CKB1_P cml_tlatch_36.xmux.xp.S1 VSS sg13_lv_nmos ad=89.3f pd=0.85u as=89.3f ps=0.85u w=0.47u l=0.16u
X1153 cml_tlatch_83.xmux.xn.S1 stub_bi_49.BOTP stub_bi_63.BOTN VSS sg13_lv_nmos ad=63.19999f pd=0.74u as=63.19999f ps=0.74u w=0.26u l=0.38u
X1154 MOT23_N MOT23_P cml_tlatch_80.xmux.xp.S1 VSS sg13_lv_nmos ad=56.9f pd=0.74u as=56.9f ps=0.74u w=0.17u l=0.17u
X1155 cml_tlatch_65.xtail.S1 CKB3_P cml_tlatch_65.xmux.xn.S1 VSS sg13_lv_nmos ad=89.3f pd=0.85u as=89.3f ps=0.85u w=0.47u l=0.16u
X1156 cml_tlatch_55.xmux.xn.S1 A2_2_P MOT22_N VSS sg13_lv_nmos ad=63.19999f pd=0.74u as=63.19999f ps=0.74u w=0.26u l=0.38u
X1157 cml_tlatch_99.OUTP cml_tlatch_99.OUTN cml_tlatch_99.xmux.xp.S1 VSS sg13_lv_nmos ad=56.9f pd=0.74u as=56.9f ps=0.74u w=0.17u l=0.17u
X1158 cml_tlatch_56.OUTN cml_tlatch_56.OUTP cml_tlatch_56.xmux.xp.S1 VSS sg13_lv_nmos ad=56.9f pd=0.74u as=56.9f ps=0.74u w=0.17u l=0.17u
X1159 cml_tlatch_86.xmux.xp.S1 CKA2_N cml_tlatch_86.xtail.S1 VSS sg13_lv_nmos ad=89.3f pd=0.85u as=89.3f ps=0.85u w=0.47u l=0.16u
X1160 cml_tlatch_49.xmux.xp.S1 cml_tlatch_49.OUTP cml_tlatch_49.OUTN VSS sg13_lv_nmos ad=56.9f pd=0.74u as=56.9f ps=0.74u w=0.17u l=0.17u
X1161 cml_tlatch_27.xmux.xp.S1 MOT2_P MOT2_N VSS sg13_lv_nmos ad=56.9f pd=0.74u as=56.9f ps=0.74u w=0.17u l=0.17u
X1162 cml_tlatch_86.xmux.xn.S1 cml_tlatch_87.OUTP cml_tlatch_86.OUTN VSS sg13_lv_nmos ad=63.19999f pd=0.74u as=63.19999f ps=0.74u w=0.26u l=0.38u
X1163 cml_tlatch_2.xtail.S1 POLN VSS VSS sg13_lv_nmos ad=1.5637p pd=8.61u as=1.5637p ps=8.61u w=8.23u l=0.13u
X1164 cml_tlatch_61.xmux.xp.S1 CKA2_N cml_tlatch_61.xtail.S1 VSS sg13_lv_nmos ad=89.3f pd=0.85u as=89.3f ps=0.85u w=0.47u l=0.16u
X1165 ENA0_P ENA_N cml_drv_3.xrtail.R1 VSS sg13_lv_nmos ad=56.2f pd=0.74u as=56.2f ps=0.74u w=0.16u l=0.19u
X1166 VSS POLN cml_tlatch_82.xtail.S1 VSS sg13_lv_nmos ad=1.5637p pd=8.61u as=1.5637p ps=8.61u w=8.23u l=0.13u
X1167 stub_bi_29.BOTP stub_bi_29.BOTN cml_tlatch_35.xmux.xp.S1 VSS sg13_lv_nmos ad=56.9f pd=0.74u as=56.9f ps=0.74u w=0.17u l=0.17u
X1168 MOT2_P cml_tlatch_23.OUTN cml_tlatch_27.xmux.xn.S1 VSS sg13_lv_nmos ad=0.1082p pd=1.34u as=63.19999f ps=0.74u w=0.26u l=0.38u
X1169 MOT12_P MOT12_N cml_tlatch_24.xmux.xp.S1 VSS sg13_lv_nmos ad=56.9f pd=0.74u as=56.9f ps=0.74u w=0.17u l=0.17u
X1170 cml_tlatch_98.xtail.S1 CKB0_N cml_tlatch_98.xmux.xn.S1 VSS sg13_lv_nmos ad=89.3f pd=0.85u as=0.1598p ps=1.62u w=0.47u l=0.16u
X1171 cml_tlatch_70.xtail.S1 CKA3_P cml_tlatch_70.xmux.xp.S1 VSS sg13_lv_nmos ad=89.3f pd=0.85u as=89.3f ps=0.85u w=0.47u l=0.16u
X1172 VSS hs_to_clk_7.sg13_lv_nmos_2HGZLP_0.G VSS VSS sg13_lv_nmos ad=2.071p pd=11.28u as=0 ps=0 w=10.9u l=1.38u
X1173 cml_tlatch_99.xmux.xp.S1 cml_tlatch_99.OUTP cml_tlatch_99.OUTN VSS sg13_lv_nmos ad=56.9f pd=0.74u as=56.9f ps=0.74u w=0.17u l=0.17u
X1174 A3_2_N A3_2_P cml_tlatch_57.xmux.xp.S1 VSS sg13_lv_nmos ad=56.9f pd=0.74u as=56.9f ps=0.74u w=0.17u l=0.17u
X1175 cml_gate2_4.xamp.xn.S1 ENA1_N GA3_P VSS sg13_lv_nmos ad=0.1007p pd=0.91u as=0.1007p ps=0.91u w=0.53u l=0.13u
X1176 stub_bi_55.BOTN stub_bi_55.BOTP cml_tlatch_90.xmux.xp.S1 VSS sg13_lv_nmos ad=56.9f pd=0.74u as=56.9f ps=0.74u w=0.17u l=0.17u
X1177 cml_tlatch_7.OUTN cml_tlatch_7.OUTP cml_tlatch_7.xmux.xp.S1 VSS sg13_lv_nmos ad=56.9f pd=0.74u as=56.9f ps=0.74u w=0.17u l=0.17u
X1178 cml_tlatch_97.xmux.xp.S1 cml_tlatch_24.INN cml_tlatch_24.INP VSS sg13_lv_nmos ad=56.9f pd=0.74u as=56.9f ps=0.74u w=0.17u l=0.17u
X1179 cml_tlatch_1.xmux.xn.S1 CKB0_N cml_tlatch_1.xtail.S1 VSS sg13_lv_nmos ad=89.3f pd=0.85u as=89.3f ps=0.85u w=0.47u l=0.16u
X1180 cml_gate2_3.xrtail.R1 CKB0_N GA0_P VSS sg13_lv_nmos ad=0.1007p pd=0.91u as=0.1007p ps=0.91u w=0.53u l=0.13u
X1181 cml_tlatch_9.xmux.xp.S1 A0_8_N A0_8_P VSS sg13_lv_nmos ad=56.9f pd=0.74u as=56.9f ps=0.74u w=0.17u l=0.17u
X1182 cml_tlatch_26.xmux.xn.S1 CKHA0_P cml_tlatch_26.xtail.S1 VSS sg13_lv_nmos ad=89.3f pd=0.85u as=89.3f ps=0.85u w=0.47u l=0.16u
X1183 cml_tlatch_88.xmux.xn.S1 CKB3_N cml_tlatch_88.xtail.S1 VSS sg13_lv_nmos ad=89.3f pd=0.85u as=89.3f ps=0.85u w=0.47u l=0.16u
X1184 cml_tlatch_24.INN cml_tlatch_24.INP cml_tlatch_97.xmux.xp.S1 VSS sg13_lv_nmos ad=56.9f pd=0.74u as=0.1019p ps=1.34u w=0.17u l=0.17u
X1185 cml_tlatch_78.xmux.xp.S1 MOT19_N MOT19_P VSS sg13_lv_nmos ad=56.9f pd=0.74u as=56.9f ps=0.74u w=0.17u l=0.17u
X1186 cml_tlatch_22.xmux.xn.S1 cml_tlatch_24.INN cml_tlatch_22.OUTP VSS sg13_lv_nmos ad=63.19999f pd=0.74u as=63.19999f ps=0.74u w=0.26u l=0.38u
X1187 MOT24_P MOT24_N cml_tlatch_62.xmux.xp.S1 VSS sg13_lv_nmos ad=56.9f pd=0.74u as=56.9f ps=0.74u w=0.17u l=0.17u
X1188 MOT27_P MOT27_N cml_tlatch_73.xmux.xp.S1 VSS sg13_lv_nmos ad=56.9f pd=0.74u as=56.9f ps=0.74u w=0.17u l=0.17u
X1189 hs_to_clk_4.sg13_lv_nmos_2HGZLP_0.G VDD VSS rppd l=0.68u w=1u
X1190 cml_tlatch_7.xmux.xn.S1 cml_tlatch_8.OUTP cml_tlatch_7.OUTN VSS sg13_lv_nmos ad=63.19999f pd=0.74u as=0.1082p ps=1.34u w=0.26u l=0.38u
X1191 MOT28_P MOT28_N cml_tlatch_44.xmux.xp.S1 VSS sg13_lv_nmos ad=56.9f pd=0.74u as=56.9f ps=0.74u w=0.17u l=0.17u
X1192 cml_tlatch_29.xmux.xp.S1 MOT6_P MOT6_N VSS sg13_lv_nmos ad=56.9f pd=0.74u as=56.9f ps=0.74u w=0.17u l=0.17u
X1193 cml_tlatch_41.OUTN cml_tlatch_41.OUTP cml_tlatch_41.xmux.xp.S1 VSS sg13_lv_nmos ad=56.9f pd=0.74u as=56.9f ps=0.74u w=0.17u l=0.17u
X1194 cml_tlatch_57.xmux.xn.S1 CKA3_N cml_tlatch_57.xtail.S1 VSS sg13_lv_nmos ad=0.1598p pd=1.62u as=89.3f ps=0.85u w=0.47u l=0.16u
X1195 cml_tlatch_63.INP cml_tlatch_71.OUTN cml_tlatch_70.xmux.xn.S1 VSS sg13_lv_nmos ad=63.19999f pd=0.74u as=63.19999f ps=0.74u w=0.26u l=0.38u
X1196 cml_tlatch_0.xtail.S1 CKA0_P cml_tlatch_0.xmux.xn.S1 VSS sg13_lv_nmos ad=89.3f pd=0.85u as=89.3f ps=0.85u w=0.47u l=0.16u
X1197 cml_tlatch_43.xmux.xp.S1 MOT10_N MOT10_P VSS sg13_lv_nmos ad=0.1019p pd=1.34u as=56.9f ps=0.74u w=0.17u l=0.17u
X1198 VSS POLN cml_tlatch_22.xtail.S1 VSS sg13_lv_nmos ad=2.7982p pd=17.14u as=1.5637p ps=8.61u w=8.23u l=0.13u
X1199 cml_tlatch_4.INP VDD VSS rppd l=5.17u w=1u
X1200 VSS POLN cml_tlatch_51.xtail.S1 VSS sg13_lv_nmos ad=2.7982p pd=17.14u as=1.5637p ps=8.61u w=8.23u l=0.13u
X1201 cml_tlatch_8.xmux.xp.S1 cml_tlatch_8.OUTN cml_tlatch_8.OUTP VSS sg13_lv_nmos ad=56.9f pd=0.74u as=56.9f ps=0.74u w=0.17u l=0.17u
X1202 cml_tlatch_32.xtail.S1 CKB0_P cml_tlatch_32.xmux.xn.S1 VSS sg13_lv_nmos ad=0.1598p pd=1.62u as=89.3f ps=0.85u w=0.47u l=0.16u
X1203 cml_tlatch_22.xmux.xn.S1 CKA1_P cml_tlatch_22.xtail.S1 VSS sg13_lv_nmos ad=89.3f pd=0.85u as=89.3f ps=0.85u w=0.47u l=0.16u
X1204 cml_tlatch_22.OUTN cml_tlatch_24.INP cml_tlatch_22.xmux.xn.S1 VSS sg13_lv_nmos ad=63.19999f pd=0.74u as=63.19999f ps=0.74u w=0.26u l=0.38u
X1205 MOT3_N MOT3_P cml_tlatch_15.xmux.xp.S1 VSS sg13_lv_nmos ad=56.9f pd=0.74u as=56.9f ps=0.74u w=0.17u l=0.17u
X1206 cml_tlatch_20.xmux.xp.S1 cml_tlatch_20.OUTP cml_tlatch_20.OUTN VSS sg13_lv_nmos ad=56.9f pd=0.74u as=56.9f ps=0.74u w=0.17u l=0.17u
X1207 stub_bi_62.BOTP stub_bi_62.BOTN cml_tlatch_82.xmux.xp.S1 VSS sg13_lv_nmos ad=56.9f pd=0.74u as=56.9f ps=0.74u w=0.17u l=0.17u
X1208 MOT18_N MOT18_P cml_tlatch_53.xmux.xp.S1 VSS sg13_lv_nmos ad=56.9f pd=0.74u as=56.9f ps=0.74u w=0.17u l=0.17u
X1209 VDD MOT23_N VSS rppd l=5.17u w=1u
X1210 B3_2_N B3_2_P cml_tlatch_50.xmux.xp.S1 VSS sg13_lv_nmos ad=56.9f pd=0.74u as=0.1019p ps=1.34u w=0.17u l=0.17u
X1211 cml_tlatch_26.xmux.xn.S1 A0_8_N MOT0_P VSS sg13_lv_nmos ad=63.19999f pd=0.74u as=63.19999f ps=0.74u w=0.26u l=0.38u
X1212 cml_tlatch_5.INN stub_bi_29.BOTN cml_tlatch_96.xmux.xn.S1 VSS sg13_lv_nmos ad=63.19999f pd=0.74u as=63.19999f ps=0.74u w=0.26u l=0.38u
X1213 cml_tlatch_69.xmux.xn.S1 cml_tlatch_63.INN cml_tlatch_69.OUTP VSS sg13_lv_nmos ad=63.19999f pd=0.74u as=63.19999f ps=0.74u w=0.26u l=0.38u
X1214 cml_tlatch_98.xmux.xp.S1 cml_tlatch_98.OUTN cml_tlatch_98.OUTP VSS sg13_lv_nmos ad=56.9f pd=0.74u as=56.9f ps=0.74u w=0.17u l=0.17u
X1215 cml_tlatch_26.xmux.xn.S1 A0_8_N MOT0_P VSS sg13_lv_nmos ad=63.19999f pd=0.74u as=63.19999f ps=0.74u w=0.26u l=0.38u
X1216 cml_tlatch_24.INP cml_tlatch_97.INN cml_tlatch_97.xmux.xn.S1 VSS sg13_lv_nmos ad=63.19999f pd=0.74u as=63.19999f ps=0.74u w=0.26u l=0.38u
X1217 cml_tlatch_80.xmux.xp.S1 MOT23_N MOT23_P VSS sg13_lv_nmos ad=56.9f pd=0.74u as=56.9f ps=0.74u w=0.17u l=0.17u
X1218 cml_gate2_4.xrtail.R1 CKB3_P cml_gate2_4.xamp.xn.S1 VSS sg13_lv_nmos ad=0.1007p pd=0.91u as=0.1007p ps=0.91u w=0.53u l=0.13u
X1219 cml_tlatch_57.xmux.xp.S1 CKA3_P cml_tlatch_57.xtail.S1 VSS sg13_lv_nmos ad=89.3f pd=0.85u as=89.3f ps=0.85u w=0.47u l=0.16u
X1220 cml_tlatch_31.xtail.S1 CKB0_P cml_tlatch_31.xmux.xp.S1 VSS sg13_lv_nmos ad=89.3f pd=0.85u as=89.3f ps=0.85u w=0.47u l=0.16u
X1221 cml_tlatch_13.xmux.xn.S1 CKB1_P cml_tlatch_13.xtail.S1 VSS sg13_lv_nmos ad=89.3f pd=0.85u as=89.3f ps=0.85u w=0.47u l=0.16u
X1222 cml_tlatch_81.xmux.xp.S1 CKB2_P cml_tlatch_81.xtail.S1 VSS sg13_lv_nmos ad=89.3f pd=0.85u as=89.3f ps=0.85u w=0.47u l=0.16u
X1223 cml_tlatch_86.xmux.xp.S1 cml_tlatch_86.OUTN cml_tlatch_86.OUTP VSS sg13_lv_nmos ad=56.9f pd=0.74u as=56.9f ps=0.74u w=0.17u l=0.17u
X1224 stub_bi_31.BOTP D1_P cml_tlatch_37.xmux.xn.S1 VSS sg13_lv_nmos ad=63.19999f pd=0.74u as=63.19999f ps=0.74u w=0.26u l=0.38u
X1225 cml_tlatch_33.xtail.S1 CKA0_N cml_tlatch_33.xmux.xp.S1 VSS sg13_lv_nmos ad=89.3f pd=0.85u as=89.3f ps=0.85u w=0.47u l=0.16u
X1226 cml_tlatch_68.xmux.xp.S1 CKA3_P cml_tlatch_68.xtail.S1 VSS sg13_lv_nmos ad=89.3f pd=0.85u as=0.1598p ps=1.62u w=0.47u l=0.16u
X1227 cml_tlatch_36.xtail.S1 POLN VSS VSS sg13_lv_nmos ad=1.5637p pd=8.61u as=2.7982p ps=17.14u w=8.23u l=0.13u
X1228 MOT21_N MOT21_P cml_tlatch_79.xmux.xp.S1 VSS sg13_lv_nmos ad=56.9f pd=0.74u as=56.9f ps=0.74u w=0.17u l=0.17u
X1229 cml_tlatch_67.xmux.xp.S1 cml_tlatch_67.OUTP cml_tlatch_67.OUTN VSS sg13_lv_nmos ad=56.9f pd=0.74u as=56.9f ps=0.74u w=0.17u l=0.17u
X1230 cml_tlatch_78.xtail.S1 CKHB2_P cml_tlatch_78.xmux.xn.S1 VSS sg13_lv_nmos ad=89.3f pd=0.85u as=89.3f ps=0.85u w=0.47u l=0.16u
X1231 MOT19_N stub_bi_63.BOTN cml_tlatch_78.xmux.xn.S1 VSS sg13_lv_nmos ad=63.19999f pd=0.74u as=0.1082p ps=1.34u w=0.26u l=0.38u
X1232 B1_2_P stub_bi_31.BOTP cml_tlatch_36.xmux.xn.S1 VSS sg13_lv_nmos ad=63.19999f pd=0.74u as=63.19999f ps=0.74u w=0.26u l=0.38u
X1233 cml_tlatch_51.xmux.xn.S1 D3_P cml_tlatch_51.OUTN VSS sg13_lv_nmos ad=63.19999f pd=0.74u as=63.19999f ps=0.74u w=0.26u l=0.38u
X1234 cml_tlatch_22.xmux.xp.S1 cml_tlatch_22.OUTN cml_tlatch_22.OUTP VSS sg13_lv_nmos ad=56.9f pd=0.74u as=56.9f ps=0.74u w=0.17u l=0.17u
X1235 cml_tlatch_11.xtail.S1 POLN VSS VSS sg13_lv_nmos ad=1.5637p pd=8.61u as=1.5637p ps=8.61u w=8.23u l=0.13u
X1236 CLK_W_P CLK_W_N cml_tlatch_93.xmux.xp.S1 VSS sg13_lv_nmos ad=56.9f pd=0.74u as=56.9f ps=0.74u w=0.17u l=0.17u
X1237 cml_tlatch_27.xmux.xp.S1 MOT2_P MOT2_N VSS sg13_lv_nmos ad=56.9f pd=0.74u as=56.9f ps=0.74u w=0.17u l=0.17u
X1238 cml_tlatch_43.INP cml_tlatch_43.INN cml_tlatch_21.xmux.xp.S1 VSS sg13_lv_nmos ad=56.9f pd=0.74u as=56.9f ps=0.74u w=0.17u l=0.17u
X1239 cml_tlatch_96.xmux.xp.S1 CKB1_P cml_tlatch_96.xtail.S1 VSS sg13_lv_nmos ad=89.3f pd=0.85u as=89.3f ps=0.85u w=0.47u l=0.16u
X1240 B2_8_P B2_8_N cml_tlatch_81.xmux.xp.S1 VSS sg13_lv_nmos ad=56.9f pd=0.74u as=56.9f ps=0.74u w=0.17u l=0.17u
X1241 cml_tlatch_97.xmux.xp.S1 cml_tlatch_24.INN cml_tlatch_24.INP VSS sg13_lv_nmos ad=56.9f pd=0.74u as=56.9f ps=0.74u w=0.17u l=0.17u
X1242 cml_tlatch_50.xmux.xp.S1 CKB3_P cml_tlatch_50.xtail.S1 VSS sg13_lv_nmos ad=89.3f pd=0.85u as=89.3f ps=0.85u w=0.47u l=0.16u
X1243 cml_tlatch_74.xmux.xp.S1 MOT29_N MOT29_P VSS sg13_lv_nmos ad=0.1019p pd=1.34u as=56.9f ps=0.74u w=0.17u l=0.17u
X1244 cml_tlatch_87.xtail.S1 POLN VSS VSS sg13_lv_nmos ad=1.5637p pd=8.61u as=1.5637p ps=8.61u w=8.23u l=0.13u
X1245 cml_tlatch_91.xmux.xp.S1 CKA2_P cml_tlatch_91.xtail.S1 VSS sg13_lv_nmos ad=89.3f pd=0.85u as=89.3f ps=0.85u w=0.47u l=0.16u
X1246 cml_tlatch_67.OUTN cml_tlatch_74.INP cml_tlatch_67.xmux.xn.S1 VSS sg13_lv_nmos ad=63.19999f pd=0.74u as=63.19999f ps=0.74u w=0.26u l=0.38u
X1247 cml_tlatch_18.xmux.xp.S1 cml_tlatch_18.OUTP cml_tlatch_18.OUTN VSS sg13_lv_nmos ad=56.9f pd=0.74u as=56.9f ps=0.74u w=0.17u l=0.17u
X1248 GB1_N ENB1_P cml_gate2_0.xamp.xn.S1 VSS sg13_lv_nmos ad=0.1007p pd=0.91u as=0.1007p ps=0.91u w=0.53u l=0.13u
X1249 cml_tlatch_92.xmux.xp.S1 J4_P J4_N VSS sg13_lv_nmos ad=56.9f pd=0.74u as=56.9f ps=0.74u w=0.17u l=0.17u
X1250 MOT9_P MOT9_N cml_tlatch_3.xmux.xp.S1 VSS sg13_lv_nmos ad=56.9f pd=0.74u as=56.9f ps=0.74u w=0.17u l=0.17u
X1251 cml_tlatch_39.xmux.xn.S1 CKA1_P cml_tlatch_39.xtail.S1 VSS sg13_lv_nmos ad=89.3f pd=0.85u as=89.3f ps=0.85u w=0.47u l=0.16u
X1252 cml_tlatch_44.INN cml_tlatch_44.INP cml_tlatch_89.xmux.xp.S1 VSS sg13_lv_nmos ad=56.9f pd=0.74u as=56.9f ps=0.74u w=0.17u l=0.17u
X1253 cml_tlatch_73.xtail.S1 CKHB3_P cml_tlatch_73.xmux.xn.S1 VSS sg13_lv_nmos ad=89.3f pd=0.85u as=89.3f ps=0.85u w=0.47u l=0.16u
X1254 cml_tlatch_27.xmux.xp.S1 CKHA0_N cml_tlatch_27.xtail.S1 VSS sg13_lv_nmos ad=89.3f pd=0.85u as=89.3f ps=0.85u w=0.47u l=0.16u
X1255 cml_tlatch_38.OUTP cml_tlatch_38.OUTN cml_tlatch_38.xmux.xp.S1 VSS sg13_lv_nmos ad=56.9f pd=0.74u as=56.9f ps=0.74u w=0.17u l=0.17u
X1256 cml_tlatch_16.xmux.xp.S1 MOT5_P MOT5_N VSS sg13_lv_nmos ad=56.9f pd=0.74u as=56.9f ps=0.74u w=0.17u l=0.17u
X1257 cml_tlatch_97.xmux.xp.S1 cml_tlatch_24.INN cml_tlatch_24.INP VSS sg13_lv_nmos ad=56.9f pd=0.74u as=56.9f ps=0.74u w=0.17u l=0.17u
X1258 cml_tlatch_54.xmux.xp.S1 MOT20_P MOT20_N VSS sg13_lv_nmos ad=56.9f pd=0.74u as=56.9f ps=0.74u w=0.17u l=0.17u
X1259 cml_tlatch_78.xmux.xp.S1 MOT19_P MOT19_N VSS sg13_lv_nmos ad=56.9f pd=0.74u as=56.9f ps=0.74u w=0.17u l=0.17u
X1260 cml_tlatch_98.OUTN cml_tlatch_98.OUTP cml_tlatch_98.xmux.xp.S1 VSS sg13_lv_nmos ad=56.9f pd=0.74u as=0.1019p ps=1.34u w=0.17u l=0.17u
X1261 cml_tlatch_67.OUTN cml_tlatch_67.OUTP cml_tlatch_67.xmux.xp.S1 VSS sg13_lv_nmos ad=56.9f pd=0.74u as=56.9f ps=0.74u w=0.17u l=0.17u
X1262 cml_tlatch_63.INN cml_tlatch_63.INP cml_tlatch_70.xmux.xp.S1 VSS sg13_lv_nmos ad=56.9f pd=0.74u as=56.9f ps=0.74u w=0.17u l=0.17u
X1263 cml_tlatch_63.INP cml_tlatch_63.INN cml_tlatch_70.xmux.xp.S1 VSS sg13_lv_nmos ad=56.9f pd=0.74u as=56.9f ps=0.74u w=0.17u l=0.17u
X1264 cml_tlatch_41.xtail.S1 CKA1_P cml_tlatch_41.xmux.xn.S1 VSS sg13_lv_nmos ad=89.3f pd=0.85u as=89.3f ps=0.85u w=0.47u l=0.16u
X1265 cml_tlatch_92.xmux.xp.S1 J4_P J4_N VSS sg13_lv_nmos ad=0.1019p pd=1.34u as=56.9f ps=0.74u w=0.17u l=0.17u
X1266 cml_tlatch_65.xmux.xn.S1 CKB3_P cml_tlatch_65.xtail.S1 VSS sg13_lv_nmos ad=89.3f pd=0.85u as=89.3f ps=0.85u w=0.47u l=0.16u
X1267 GB3_N ENB0_P cml_gate2_6.xamp.xn.S1 VSS sg13_lv_nmos ad=0.1007p pd=0.91u as=0.1007p ps=0.91u w=0.53u l=0.13u
X1268 cml_tlatch_23.xtail.S1 CKA0_P cml_tlatch_23.xmux.xp.S1 VSS sg13_lv_nmos ad=89.3f pd=0.85u as=89.3f ps=0.85u w=0.47u l=0.16u
X1269 cml_tlatch_23.xtail.S1 CKA0_N cml_tlatch_23.xmux.xn.S1 VSS sg13_lv_nmos ad=89.3f pd=0.85u as=89.3f ps=0.85u w=0.47u l=0.16u
X1270 cml_tlatch_47.xmux.xn.S1 stub_bi_43.BOTN B2_2_N VSS sg13_lv_nmos ad=63.19999f pd=0.74u as=0.1082p ps=1.34u w=0.26u l=0.38u
X1271 cml_tlatch_29.xmux.xp.S1 MOT6_P MOT6_N VSS sg13_lv_nmos ad=56.9f pd=0.74u as=56.9f ps=0.74u w=0.17u l=0.17u
X1272 VDD MOT17_N VSS rppd l=5.17u w=1u
X1273 cml_tlatch_61.xmux.xn.S1 D2_P cml_tlatch_61.OUTN VSS sg13_lv_nmos ad=63.19999f pd=0.74u as=63.19999f ps=0.74u w=0.26u l=0.38u
X1274 cml_tlatch_61.xmux.xp.S1 cml_tlatch_61.OUTN cml_tlatch_61.OUTP VSS sg13_lv_nmos ad=56.9f pd=0.74u as=56.9f ps=0.74u w=0.17u l=0.17u
X1275 cml_tlatch_9.xmux.xn.S1 CKA0_N cml_tlatch_9.xtail.S1 VSS sg13_lv_nmos ad=89.3f pd=0.85u as=0.1598p ps=1.62u w=0.47u l=0.16u
X1276 cml_tlatch_49.xmux.xn.S1 B3_2_N cml_tlatch_49.OUTP VSS sg13_lv_nmos ad=0.1082p pd=1.34u as=63.19999f ps=0.74u w=0.26u l=0.38u
X1277 cml_tlatch_45.xmux.xn.S1 A3_2_N MOT30_P VSS sg13_lv_nmos ad=63.19999f pd=0.74u as=63.19999f ps=0.74u w=0.26u l=0.38u
X1278 cml_tlatch_50.xmux.xp.S1 B3_2_N B3_2_P VSS sg13_lv_nmos ad=56.9f pd=0.74u as=56.9f ps=0.74u w=0.17u l=0.17u
X1279 cml_tlatch_16.xtail.S1 CKHB0_P cml_tlatch_16.xmux.xn.S1 VSS sg13_lv_nmos ad=89.3f pd=0.85u as=89.3f ps=0.85u w=0.47u l=0.16u
X1280 cml_tlatch_87.INN cml_tlatch_91.OUTP cml_tlatch_76.xmux.xn.S1 VSS sg13_lv_nmos ad=0.1082p pd=1.34u as=63.19999f ps=0.74u w=0.26u l=0.38u
X1281 cml_tlatch_49.xmux.xn.S1 B3_2_N cml_tlatch_49.OUTP VSS sg13_lv_nmos ad=63.19999f pd=0.74u as=63.19999f ps=0.74u w=0.26u l=0.38u
X1282 MOT3_N MOT3_P cml_tlatch_15.xmux.xp.S1 VSS sg13_lv_nmos ad=56.9f pd=0.74u as=56.9f ps=0.74u w=0.17u l=0.17u
X1283 cml_tlatch_13.xmux.xp.S1 stub_bi_17.BOTN stub_bi_17.BOTP VSS sg13_lv_nmos ad=56.9f pd=0.74u as=56.9f ps=0.74u w=0.17u l=0.17u
X1284 cml_tlatch_53.xmux.xn.S1 cml_tlatch_87.OUTP MOT18_N VSS sg13_lv_nmos ad=63.19999f pd=0.74u as=63.19999f ps=0.74u w=0.26u l=0.38u
X1285 cml_tlatch_21.xmux.xp.S1 cml_tlatch_43.INP cml_tlatch_43.INN VSS sg13_lv_nmos ad=56.9f pd=0.74u as=56.9f ps=0.74u w=0.17u l=0.17u
X1286 cml_tlatch_21.xmux.xp.S1 cml_tlatch_43.INN cml_tlatch_43.INP VSS sg13_lv_nmos ad=0.1019p pd=1.34u as=56.9f ps=0.74u w=0.17u l=0.17u
X1287 cml_tlatch_51.OUTN cml_tlatch_51.OUTP cml_tlatch_51.xmux.xp.S1 VSS sg13_lv_nmos ad=56.9f pd=0.74u as=56.9f ps=0.74u w=0.17u l=0.17u
X1288 cml_tlatch_39.xmux.xn.S1 A1_2_N cml_tlatch_97.INP VSS sg13_lv_nmos ad=63.19999f pd=0.74u as=63.19999f ps=0.74u w=0.26u l=0.38u
X1289 cml_tlatch_33.xmux.xn.S1 CKA0_P cml_tlatch_33.xtail.S1 VSS sg13_lv_nmos ad=89.3f pd=0.85u as=89.3f ps=0.85u w=0.47u l=0.16u
X1290 cml_tlatch_60.xmux.xp.S1 A2_2_P A2_2_N VSS sg13_lv_nmos ad=56.9f pd=0.74u as=56.9f ps=0.74u w=0.17u l=0.17u
X1291 cml_tlatch_98.OUTN cml_tlatch_98.OUTP cml_tlatch_98.xmux.xp.S1 VSS sg13_lv_nmos ad=56.9f pd=0.74u as=56.9f ps=0.74u w=0.17u l=0.17u
X1292 CLK_W_P CLK_W_N cml_tlatch_93.xmux.xp.S1 VSS sg13_lv_nmos ad=56.9f pd=0.74u as=56.9f ps=0.74u w=0.17u l=0.17u
X1293 B2_8_P stub_bi_62.BOTP cml_tlatch_81.xmux.xn.S1 VSS sg13_lv_nmos ad=63.19999f pd=0.74u as=63.19999f ps=0.74u w=0.26u l=0.38u
X1294 cml_tlatch_7.xmux.xn.S1 cml_tlatch_8.OUTN cml_tlatch_7.OUTP VSS sg13_lv_nmos ad=63.19999f pd=0.74u as=63.19999f ps=0.74u w=0.26u l=0.38u
X1295 cml_tlatch_49.OUTN B3_2_P cml_tlatch_49.xmux.xn.S1 VSS sg13_lv_nmos ad=63.19999f pd=0.74u as=63.19999f ps=0.74u w=0.26u l=0.38u
X1296 cml_tlatch_8.xmux.xp.S1 CKB0_N cml_tlatch_8.xtail.S1 VSS sg13_lv_nmos ad=89.3f pd=0.85u as=89.3f ps=0.85u w=0.47u l=0.16u
X1297 cml_tlatch_68.xmux.xp.S1 A3_8_N A3_8_P VSS sg13_lv_nmos ad=56.9f pd=0.74u as=56.9f ps=0.74u w=0.17u l=0.17u
X1298 cml_tlatch_68.xmux.xn.S1 CKA3_N cml_tlatch_68.xtail.S1 VSS sg13_lv_nmos ad=89.3f pd=0.85u as=89.3f ps=0.85u w=0.47u l=0.16u
X1299 MOT22_P MOT22_N cml_tlatch_55.xmux.xp.S1 VSS sg13_lv_nmos ad=56.9f pd=0.74u as=56.9f ps=0.74u w=0.17u l=0.17u
X1300 cml_tlatch_7.xmux.xn.S1 cml_tlatch_8.OUTN cml_tlatch_7.OUTP VSS sg13_lv_nmos ad=63.19999f pd=0.74u as=63.19999f ps=0.74u w=0.26u l=0.38u
X1301 B1_8_N B1_8_P cml_tlatch_10.xmux.xp.S1 VSS sg13_lv_nmos ad=56.9f pd=0.74u as=56.9f ps=0.74u w=0.17u l=0.17u
X1302 cml_tlatch_38.OUTN cml_tlatch_38.OUTP cml_tlatch_38.xmux.xp.S1 VSS sg13_lv_nmos ad=56.9f pd=0.74u as=56.9f ps=0.74u w=0.17u l=0.17u
X1303 MOT21_N MOT21_P cml_tlatch_79.xmux.xp.S1 VSS sg13_lv_nmos ad=56.9f pd=0.74u as=56.9f ps=0.74u w=0.17u l=0.17u
X1304 cml_tlatch_74.xmux.xp.S1 MOT29_P MOT29_N VSS sg13_lv_nmos ad=56.9f pd=0.74u as=56.9f ps=0.74u w=0.17u l=0.17u
X1305 stub_bi_49.BOTP VDD VSS rppd l=5.17u w=1u
X1306 cml_tlatch_59.xmux.xp.S1 cml_tlatch_91.INP cml_tlatch_91.INN VSS sg13_lv_nmos ad=56.9f pd=0.74u as=56.9f ps=0.74u w=0.17u l=0.17u
X1307 cml_tlatch_87.INN cml_tlatch_87.INP cml_tlatch_76.xmux.xp.S1 VSS sg13_lv_nmos ad=56.9f pd=0.74u as=0.1019p ps=1.34u w=0.17u l=0.17u
X1308 cml_tlatch_5.xmux.xn.S1 cml_tlatch_5.INP MOT13_N VSS sg13_lv_nmos ad=63.19999f pd=0.74u as=63.19999f ps=0.74u w=0.26u l=0.38u
X1309 A1_8_P A1_8_N cml_tlatch_19.xmux.xp.S1 VSS sg13_lv_nmos ad=56.9f pd=0.74u as=56.9f ps=0.74u w=0.17u l=0.17u
X1310 cml_tlatch_9.xmux.xp.S1 A0_8_P A0_8_N VSS sg13_lv_nmos ad=56.9f pd=0.74u as=56.9f ps=0.74u w=0.17u l=0.17u
X1311 cml_tlatch_18.xmux.xp.S1 CKA0_N cml_tlatch_18.xtail.S1 VSS sg13_lv_nmos ad=89.3f pd=0.85u as=89.3f ps=0.85u w=0.47u l=0.16u
X1312 MOT3_P cml_tlatch_7.OUTN cml_tlatch_15.xmux.xn.S1 VSS sg13_lv_nmos ad=63.19999f pd=0.74u as=63.19999f ps=0.74u w=0.26u l=0.38u
X1313 cml_tlatch_41.xtail.S1 CKA1_P cml_tlatch_41.xmux.xn.S1 VSS sg13_lv_nmos ad=89.3f pd=0.85u as=89.3f ps=0.85u w=0.47u l=0.16u
X1314 cml_tlatch_37.xmux.xp.S1 stub_bi_31.BOTN stub_bi_31.BOTP VSS sg13_lv_nmos ad=0.1019p pd=1.34u as=56.9f ps=0.74u w=0.17u l=0.17u
X1315 J4_P J4_N cml_tlatch_92.xmux.xp.S1 VSS sg13_lv_nmos ad=56.9f pd=0.74u as=56.9f ps=0.74u w=0.17u l=0.17u
X1316 cml_tlatch_86.xmux.xp.S1 CKA2_N cml_tlatch_86.xtail.S1 VSS sg13_lv_nmos ad=89.3f pd=0.85u as=89.3f ps=0.85u w=0.47u l=0.16u
X1317 VDD cml_tlatch_44.INN VSS rppd l=5.17u w=1u
X1318 MOT11_N MOT11_P cml_tlatch_4.xmux.xp.S1 VSS sg13_lv_nmos ad=56.9f pd=0.74u as=0.1019p ps=1.34u w=0.17u l=0.17u
X1319 cml_tlatch_95.xmux.xp.S1 J1_P J1_N VSS sg13_lv_nmos ad=56.9f pd=0.74u as=56.9f ps=0.74u w=0.17u l=0.17u
X1320 stub_bi_29.BOTN stub_bi_29.BOTP cml_tlatch_35.xmux.xp.S1 VSS sg13_lv_nmos ad=56.9f pd=0.74u as=56.9f ps=0.74u w=0.17u l=0.17u
X1321 cml_tlatch_80.xmux.xn.S1 B2_2_P MOT23_N VSS sg13_lv_nmos ad=63.19999f pd=0.74u as=63.19999f ps=0.74u w=0.26u l=0.38u
X1322 cml_tlatch_79.xtail.S1 POLN VSS VSS sg13_lv_nmos ad=1.5637p pd=8.61u as=2.7982p ps=17.14u w=8.23u l=0.13u
X1323 cml_tlatch_34.xmux.xp.S1 A0_2_N A0_2_P VSS sg13_lv_nmos ad=56.9f pd=0.74u as=56.9f ps=0.74u w=0.17u l=0.17u
X1324 cml_tlatch_18.xmux.xp.S1 cml_tlatch_18.OUTP cml_tlatch_18.OUTN VSS sg13_lv_nmos ad=56.9f pd=0.74u as=56.9f ps=0.74u w=0.17u l=0.17u
X1325 A1_8_P A1_8_N cml_tlatch_19.xmux.xp.S1 VSS sg13_lv_nmos ad=56.9f pd=0.74u as=56.9f ps=0.74u w=0.17u l=0.17u
X1326 cml_tlatch_12.xmux.xn.S1 CKB1_N cml_tlatch_12.xtail.S1 VSS sg13_lv_nmos ad=89.3f pd=0.85u as=89.3f ps=0.85u w=0.47u l=0.16u
X1327 B3_8_N B3_8_P cml_tlatch_64.xmux.xp.S1 VSS sg13_lv_nmos ad=56.9f pd=0.74u as=56.9f ps=0.74u w=0.17u l=0.17u
X1328 MOT24_P VDD VSS rppd l=5.17u w=1u
X1329 cml_tlatch_27.xmux.xn.S1 CKHA0_P cml_tlatch_27.xtail.S1 VSS sg13_lv_nmos ad=89.3f pd=0.85u as=89.3f ps=0.85u w=0.47u l=0.16u
X1330 cml_tlatch_87.xmux.xn.S1 CKA2_N cml_tlatch_87.xtail.S1 VSS sg13_lv_nmos ad=89.3f pd=0.85u as=89.3f ps=0.85u w=0.47u l=0.16u
X1331 cml_tlatch_52.xtail.S1 CKHA2_P cml_tlatch_52.xmux.xn.S1 VSS sg13_lv_nmos ad=89.3f pd=0.85u as=89.3f ps=0.85u w=0.47u l=0.16u
X1332 cml_tlatch_30.xmux.xp.S1 cml_tlatch_30.OUTN cml_tlatch_30.OUTP VSS sg13_lv_nmos ad=56.9f pd=0.74u as=56.9f ps=0.74u w=0.17u l=0.17u
X1333 MOT16_N A2_8_P cml_tlatch_52.xmux.xn.S1 VSS sg13_lv_nmos ad=63.19999f pd=0.74u as=63.19999f ps=0.74u w=0.26u l=0.38u
X1334 cml_tlatch_20.OUTP cml_tlatch_20.OUTN cml_tlatch_20.xmux.xp.S1 VSS sg13_lv_nmos ad=56.9f pd=0.74u as=56.9f ps=0.74u w=0.17u l=0.17u
X1335 MOT30_N MOT30_P cml_tlatch_45.xmux.xp.S1 VSS sg13_lv_nmos ad=56.9f pd=0.74u as=56.9f ps=0.74u w=0.17u l=0.17u
X1336 GA2_P CKB2_N cml_gate2_5.xrtail.R1 VSS sg13_lv_nmos ad=0.1007p pd=0.91u as=0.1007p ps=0.91u w=0.53u l=0.13u
X1337 stub_bi_29.BOTP VDD VSS rppd l=5.17u w=1u
X1338 cml_tlatch_95.xmux.xp.S1 J1_N J1_P VSS sg13_lv_nmos ad=56.9f pd=0.74u as=56.9f ps=0.74u w=0.17u l=0.17u
X1339 cml_tlatch_10.xmux.xn.S1 CKB1_N cml_tlatch_10.xtail.S1 VSS sg13_lv_nmos ad=89.3f pd=0.85u as=89.3f ps=0.85u w=0.47u l=0.16u
X1340 cml_tlatch_79.xmux.xp.S1 CKHB2_N cml_tlatch_79.xtail.S1 VSS sg13_lv_nmos ad=89.3f pd=0.85u as=0.1598p ps=1.62u w=0.47u l=0.16u
X1341 MOT0_P MOT0_N cml_tlatch_26.xmux.xp.S1 VSS sg13_lv_nmos ad=56.9f pd=0.74u as=56.9f ps=0.74u w=0.17u l=0.17u
X1342 cml_tlatch_49.OUTP cml_tlatch_49.OUTN cml_tlatch_49.xmux.xp.S1 VSS sg13_lv_nmos ad=56.9f pd=0.74u as=56.9f ps=0.74u w=0.17u l=0.17u
X1343 cml_tlatch_1.xmux.xn.S1 CKB0_N cml_tlatch_1.xtail.S1 VSS sg13_lv_nmos ad=89.3f pd=0.85u as=89.3f ps=0.85u w=0.47u l=0.16u
X1344 cml_tlatch_95.xmux.xn.S1 J4_N J1_N VSS sg13_lv_nmos ad=63.19999f pd=0.74u as=63.19999f ps=0.74u w=0.26u l=0.38u
X1345 cml_tlatch_24.xmux.xn.S1 cml_tlatch_24.INP MOT12_N VSS sg13_lv_nmos ad=63.19999f pd=0.74u as=63.19999f ps=0.74u w=0.26u l=0.38u
X1346 cml_tlatch_87.INN cml_tlatch_87.INP cml_tlatch_76.xmux.xp.S1 VSS sg13_lv_nmos ad=56.9f pd=0.74u as=56.9f ps=0.74u w=0.17u l=0.17u
X1347 cml_tlatch_65.OUTN cml_tlatch_65.OUTP cml_tlatch_65.xmux.xp.S1 VSS sg13_lv_nmos ad=56.9f pd=0.74u as=56.9f ps=0.74u w=0.17u l=0.17u
X1348 cml_tlatch_4.xtail.S1 CKHB1_N cml_tlatch_4.xmux.xp.S1 VSS sg13_lv_nmos ad=89.3f pd=0.85u as=89.3f ps=0.85u w=0.47u l=0.16u
X1349 cml_tlatch_16.xmux.xp.S1 MOT5_N MOT5_P VSS sg13_lv_nmos ad=56.9f pd=0.74u as=56.9f ps=0.74u w=0.17u l=0.17u
X1350 A3_8_N cml_tlatch_69.OUTP cml_tlatch_68.xmux.xn.S1 VSS sg13_lv_nmos ad=63.19999f pd=0.74u as=63.19999f ps=0.74u w=0.26u l=0.38u
X1351 cml_tlatch_97.xmux.xn.S1 CKA1_N cml_tlatch_97.xtail.S1 VSS sg13_lv_nmos ad=89.3f pd=0.85u as=89.3f ps=0.85u w=0.47u l=0.16u
X1352 cml_tlatch_64.xmux.xp.S1 B3_8_P B3_8_N VSS sg13_lv_nmos ad=56.9f pd=0.74u as=56.9f ps=0.74u w=0.17u l=0.17u
X1353 cml_tlatch_57.xmux.xn.S1 CKA3_N cml_tlatch_57.xtail.S1 VSS sg13_lv_nmos ad=89.3f pd=0.85u as=89.3f ps=0.85u w=0.47u l=0.16u
X1354 cml_gate2_1.xrtail.R1 CKA0_N GB0_P VSS sg13_lv_nmos ad=0.1007p pd=0.91u as=0.1007p ps=0.91u w=0.53u l=0.13u
X1355 cml_gate2_8.xamp.xn.S1 J2_N ENB_P VSS sg13_lv_nmos ad=0.1007p pd=0.91u as=0.1007p ps=0.91u w=0.53u l=0.13u
X1356 cml_tlatch_67.xmux.xp.S1 CKB3_N cml_tlatch_67.xtail.S1 VSS sg13_lv_nmos ad=89.3f pd=0.85u as=89.3f ps=0.85u w=0.47u l=0.16u
X1357 cml_tlatch_74.xmux.xp.S1 CKHB3_N cml_tlatch_74.xtail.S1 VSS sg13_lv_nmos ad=89.3f pd=0.85u as=89.3f ps=0.85u w=0.47u l=0.16u
X1358 cml_tlatch_97.INN cml_tlatch_97.INP cml_tlatch_39.xmux.xp.S1 VSS sg13_lv_nmos ad=56.9f pd=0.74u as=56.9f ps=0.74u w=0.17u l=0.17u
X1359 cml_tlatch_11.xmux.xp.S1 stub_bi_15.BOTN stub_bi_15.BOTP VSS sg13_lv_nmos ad=56.9f pd=0.74u as=56.9f ps=0.74u w=0.17u l=0.17u
X1360 cml_tlatch_76.xmux.xp.S1 cml_tlatch_87.INN cml_tlatch_87.INP VSS sg13_lv_nmos ad=56.9f pd=0.74u as=56.9f ps=0.74u w=0.17u l=0.17u
X1361 cml_tlatch_8.OUTN cml_tlatch_8.OUTP cml_tlatch_8.xmux.xp.S1 VSS sg13_lv_nmos ad=56.9f pd=0.74u as=56.9f ps=0.74u w=0.17u l=0.17u
X1362 cml_tlatch_14.xmux.xn.S1 B0_8_N MOT1_P VSS sg13_lv_nmos ad=63.19999f pd=0.74u as=63.19999f ps=0.74u w=0.26u l=0.38u
X1363 cml_tlatch_25.xtail.S1 CKHA1_P cml_tlatch_25.xmux.xn.S1 VSS sg13_lv_nmos ad=89.3f pd=0.85u as=0.1598p ps=1.62u w=0.47u l=0.16u
X1364 stub_bi_55.BOTP stub_bi_55.BOTN cml_tlatch_90.xmux.xp.S1 VSS sg13_lv_nmos ad=56.9f pd=0.74u as=56.9f ps=0.74u w=0.17u l=0.17u
X1365 cml_tlatch_32.xmux.xp.S1 cml_tlatch_32.OUTP cml_tlatch_32.OUTN VSS sg13_lv_nmos ad=56.9f pd=0.74u as=56.9f ps=0.74u w=0.17u l=0.17u
X1366 cml_tlatch_23.OUTN cml_tlatch_23.OUTP cml_tlatch_23.xmux.xp.S1 VSS sg13_lv_nmos ad=56.9f pd=0.74u as=56.9f ps=0.74u w=0.17u l=0.17u
X1367 cml_tlatch_96.xmux.xn.S1 CKB1_N cml_tlatch_96.xtail.S1 VSS sg13_lv_nmos ad=89.3f pd=0.85u as=89.3f ps=0.85u w=0.47u l=0.16u
X1368 cml_tlatch_14.xmux.xp.S1 MOT1_P MOT1_N VSS sg13_lv_nmos ad=56.9f pd=0.74u as=56.9f ps=0.74u w=0.17u l=0.17u
X1369 cml_tlatch_49.xmux.xp.S1 cml_tlatch_49.OUTN cml_tlatch_49.OUTP VSS sg13_lv_nmos ad=56.9f pd=0.74u as=56.9f ps=0.74u w=0.17u l=0.17u
X1370 cml_tlatch_48.xtail.S1 CKB2_N cml_tlatch_48.xmux.xp.S1 VSS sg13_lv_nmos ad=89.3f pd=0.85u as=89.3f ps=0.85u w=0.47u l=0.16u
X1371 MOT10_P MOT10_N cml_tlatch_43.xmux.xp.S1 VSS sg13_lv_nmos ad=56.9f pd=0.74u as=56.9f ps=0.74u w=0.17u l=0.17u
X1372 cml_tlatch_68.xmux.xp.S1 A3_8_N A3_8_P VSS sg13_lv_nmos ad=56.9f pd=0.74u as=56.9f ps=0.74u w=0.17u l=0.17u
X1373 B3_8_P B3_8_N cml_tlatch_64.xmux.xp.S1 VSS sg13_lv_nmos ad=56.9f pd=0.74u as=56.9f ps=0.74u w=0.17u l=0.17u
X1374 A1_2_N A1_2_P cml_tlatch_40.xmux.xp.S1 VSS sg13_lv_nmos ad=56.9f pd=0.74u as=56.9f ps=0.74u w=0.17u l=0.17u
X1375 MOT16_N MOT16_P cml_tlatch_52.xmux.xp.S1 VSS sg13_lv_nmos ad=56.9f pd=0.74u as=56.9f ps=0.74u w=0.17u l=0.17u
X1376 cml_tlatch_45.xmux.xp.S1 MOT30_N MOT30_P VSS sg13_lv_nmos ad=56.9f pd=0.74u as=56.9f ps=0.74u w=0.17u l=0.17u
X1377 cml_tlatch_54.xmux.xn.S1 cml_tlatch_91.OUTN MOT20_P VSS sg13_lv_nmos ad=63.19999f pd=0.74u as=63.19999f ps=0.74u w=0.26u l=0.38u
X1378 B0_8_P B0_8_N cml_tlatch_1.xmux.xp.S1 VSS sg13_lv_nmos ad=56.9f pd=0.74u as=56.9f ps=0.74u w=0.17u l=0.17u
X1379 GA1_P CKB1_N cml_gate2_2.xrtail.R1 VSS sg13_lv_nmos ad=0.1007p pd=0.91u as=0.1007p ps=0.91u w=0.53u l=0.13u
X1380 cml_tlatch_13.xmux.xn.S1 CKB1_P cml_tlatch_13.xtail.S1 VSS sg13_lv_nmos ad=89.3f pd=0.85u as=89.3f ps=0.85u w=0.47u l=0.16u
X1381 cml_tlatch_90.xmux.xn.S1 stub_bi_38.BOTP stub_bi_55.BOTN VSS sg13_lv_nmos ad=63.19999f pd=0.74u as=0.1082p ps=1.34u w=0.26u l=0.38u
X1382 cml_tlatch_70.xmux.xn.S1 cml_tlatch_71.OUTP cml_tlatch_63.INN VSS sg13_lv_nmos ad=63.19999f pd=0.74u as=63.19999f ps=0.74u w=0.26u l=0.38u
X1383 cml_tlatch_29.xtail.S1 CKHA0_N cml_tlatch_29.xmux.xp.S1 VSS sg13_lv_nmos ad=89.3f pd=0.85u as=89.3f ps=0.85u w=0.47u l=0.16u
X1384 stub_bi_55.BOTP stub_bi_38.BOTN cml_tlatch_90.xmux.xn.S1 VSS sg13_lv_nmos ad=63.19999f pd=0.74u as=63.19999f ps=0.74u w=0.26u l=0.38u
X1385 cml_tlatch_41.OUTP cml_tlatch_41.OUTN cml_tlatch_41.xmux.xp.S1 VSS sg13_lv_nmos ad=56.9f pd=0.74u as=56.9f ps=0.74u w=0.17u l=0.17u
X1386 cml_tlatch_10.xmux.xp.S1 B1_8_N B1_8_P VSS sg13_lv_nmos ad=56.9f pd=0.74u as=56.9f ps=0.74u w=0.17u l=0.17u
X1387 B2_2_P B2_2_N cml_tlatch_47.xmux.xp.S1 VSS sg13_lv_nmos ad=56.9f pd=0.74u as=56.9f ps=0.74u w=0.17u l=0.17u
X1388 cml_tlatch_16.xmux.xn.S1 CKHB0_P cml_tlatch_16.xtail.S1 VSS sg13_lv_nmos ad=89.3f pd=0.85u as=0.1598p ps=1.62u w=0.47u l=0.16u
X1389 MOT14_P MOT14_N cml_tlatch_25.xmux.xp.S1 VSS sg13_lv_nmos ad=56.9f pd=0.74u as=56.9f ps=0.74u w=0.17u l=0.17u
X1390 cml_gate2_6.xrtail.R1 CKA3_P cml_gate2_6.xamp.xn.S1 VSS sg13_lv_nmos ad=0.1007p pd=0.91u as=0.1007p ps=0.91u w=0.53u l=0.13u
X1391 cml_tlatch_53.xtail.S1 CKHA2_N cml_tlatch_53.xmux.xp.S1 VSS sg13_lv_nmos ad=89.3f pd=0.85u as=89.3f ps=0.85u w=0.47u l=0.16u
X1392 J2_N J1_P cml_tlatch_94.xmux.xn.S1 VSS sg13_lv_nmos ad=63.19999f pd=0.74u as=63.19999f ps=0.74u w=0.26u l=0.38u
X1393 cml_tlatch_0.xmux.xp.S1 cml_tlatch_0.OUTN cml_tlatch_0.OUTP VSS sg13_lv_nmos ad=56.9f pd=0.74u as=56.9f ps=0.74u w=0.17u l=0.17u
X1394 cml_tlatch_36.xmux.xn.S1 CKB1_N cml_tlatch_36.xtail.S1 VSS sg13_lv_nmos ad=89.3f pd=0.85u as=89.3f ps=0.85u w=0.47u l=0.16u
X1395 GB2_P ENB0_N cml_gate2_7.xamp.xn.S1 VSS sg13_lv_nmos ad=0.1007p pd=0.91u as=0.1007p ps=0.91u w=0.53u l=0.13u
X1396 MOT26_P MOT26_N cml_tlatch_63.xmux.xp.S1 VSS sg13_lv_nmos ad=56.9f pd=0.74u as=56.9f ps=0.74u w=0.17u l=0.17u
X1397 hs_to_clk_3.D2 CK_N CKA1_N VSS sg13_lv_nmos ad=0.228p pd=1.58u as=0.228p ps=1.58u w=1.2u l=0.2u
X1398 cml_tlatch_65.xmux.xp.S1 cml_tlatch_65.OUTN cml_tlatch_65.OUTP VSS sg13_lv_nmos ad=56.9f pd=0.74u as=56.9f ps=0.74u w=0.17u l=0.17u
X1399 cml_tlatch_93.xmux.xn.S1 CKJ_P cml_tlatch_93.xtail.S1 VSS sg13_lv_nmos ad=0.1598p pd=1.62u as=89.3f ps=0.85u w=0.47u l=0.16u
X1400 A0_2_N A0_2_P cml_tlatch_34.xmux.xp.S1 VSS sg13_lv_nmos ad=56.9f pd=0.74u as=56.9f ps=0.74u w=0.17u l=0.17u
X1401 B0_2_P B0_2_N cml_tlatch_31.xmux.xp.S1 VSS sg13_lv_nmos ad=56.9f pd=0.74u as=0.1019p ps=1.34u w=0.17u l=0.17u
X1402 cml_tlatch_42.xmux.xn.S1 CKHA1_P cml_tlatch_42.xtail.S1 VSS sg13_lv_nmos ad=89.3f pd=0.85u as=89.3f ps=0.85u w=0.47u l=0.16u
X1403 cml_tlatch_58.xmux.xn.S1 CKA3_P cml_tlatch_58.xtail.S1 VSS sg13_lv_nmos ad=0.1598p pd=1.62u as=89.3f ps=0.85u w=0.47u l=0.16u
X1404 cml_tlatch_99.xmux.xp.S1 cml_tlatch_99.OUTN cml_tlatch_99.OUTP VSS sg13_lv_nmos ad=56.9f pd=0.74u as=56.9f ps=0.74u w=0.17u l=0.17u
X1405 cml_tlatch_19.xmux.xp.S1 CKA1_P cml_tlatch_19.xtail.S1 VSS sg13_lv_nmos ad=89.3f pd=0.85u as=89.3f ps=0.85u w=0.47u l=0.16u
X1406 cml_tlatch_56.xmux.xp.S1 cml_tlatch_56.OUTP cml_tlatch_56.OUTN VSS sg13_lv_nmos ad=56.9f pd=0.74u as=56.9f ps=0.74u w=0.17u l=0.17u
X1407 cml_tlatch_73.xtail.S1 CKHB3_P cml_tlatch_73.xmux.xn.S1 VSS sg13_lv_nmos ad=89.3f pd=0.85u as=89.3f ps=0.85u w=0.47u l=0.16u
X1408 MOT2_N MOT2_P cml_tlatch_27.xmux.xp.S1 VSS sg13_lv_nmos ad=56.9f pd=0.74u as=0.1019p ps=1.34u w=0.17u l=0.17u
X1409 MOT30_P MOT30_N cml_tlatch_45.xmux.xp.S1 VSS sg13_lv_nmos ad=56.9f pd=0.74u as=56.9f ps=0.74u w=0.17u l=0.17u
X1410 cml_tlatch_90.xmux.xp.S1 CKB2_P cml_tlatch_90.xtail.S1 VSS sg13_lv_nmos ad=89.3f pd=0.85u as=89.3f ps=0.85u w=0.47u l=0.16u
X1411 cml_tlatch_35.xmux.xp.S1 stub_bi_29.BOTN stub_bi_29.BOTP VSS sg13_lv_nmos ad=56.9f pd=0.74u as=56.9f ps=0.74u w=0.17u l=0.17u
X1412 VSS POLN cml_tlatch_60.xtail.S1 VSS sg13_lv_nmos ad=1.5637p pd=8.61u as=1.5637p ps=8.61u w=8.23u l=0.13u
X1413 cml_tlatch_79.xmux.xn.S1 CKHB2_P cml_tlatch_79.xtail.S1 VSS sg13_lv_nmos ad=89.3f pd=0.85u as=89.3f ps=0.85u w=0.47u l=0.16u
X1414 cml_tlatch_24.xmux.xp.S1 MOT12_N MOT12_P VSS sg13_lv_nmos ad=56.9f pd=0.74u as=56.9f ps=0.74u w=0.17u l=0.17u
X1415 cml_tlatch_25.xmux.xp.S1 MOT14_P MOT14_N VSS sg13_lv_nmos ad=56.9f pd=0.74u as=56.9f ps=0.74u w=0.17u l=0.17u
X1416 VSS hs_to_clk_7.sg13_lv_nmos_2HGZLP_0.G VSS VSS sg13_lv_nmos ad=2.071p pd=11.28u as=0 ps=0 w=10.9u l=1.38u
X1417 cml_tlatch_23.xtail.S1 POLN VSS VSS sg13_lv_nmos ad=1.5637p pd=8.61u as=2.7982p ps=17.14u w=8.23u l=0.13u
X1418 cml_tlatch_20.xmux.xn.S1 CKA1_P cml_tlatch_20.xtail.S1 VSS sg13_lv_nmos ad=89.3f pd=0.85u as=89.3f ps=0.85u w=0.47u l=0.16u
X1419 VSS POLN cml_tlatch_86.xtail.S1 VSS sg13_lv_nmos ad=2.7982p pd=17.14u as=1.5637p ps=8.61u w=8.23u l=0.13u
X1420 cml_tlatch_30.xmux.xn.S1 B0_2_N cml_tlatch_30.OUTP VSS sg13_lv_nmos ad=63.19999f pd=0.74u as=0.1082p ps=1.34u w=0.26u l=0.38u
X1421 cml_tlatch_91.OUTP cml_tlatch_91.OUTN cml_tlatch_91.xmux.xp.S1 VSS sg13_lv_nmos ad=56.9f pd=0.74u as=56.9f ps=0.74u w=0.17u l=0.17u
X1422 cml_tlatch_57.xmux.xp.S1 A3_2_P A3_2_N VSS sg13_lv_nmos ad=56.9f pd=0.74u as=56.9f ps=0.74u w=0.17u l=0.17u
X1423 cml_tlatch_90.xmux.xp.S1 stub_bi_55.BOTP stub_bi_55.BOTN VSS sg13_lv_nmos ad=56.9f pd=0.74u as=56.9f ps=0.74u w=0.17u l=0.17u
X1424 cml_tlatch_7.xmux.xp.S1 cml_tlatch_7.OUTP cml_tlatch_7.OUTN VSS sg13_lv_nmos ad=56.9f pd=0.74u as=56.9f ps=0.74u w=0.17u l=0.17u
X1425 cml_tlatch_99.OUTN cml_tlatch_99.OUTP cml_tlatch_99.xmux.xp.S1 VSS sg13_lv_nmos ad=56.9f pd=0.74u as=0.1019p ps=1.34u w=0.17u l=0.17u
X1426 cml_tlatch_99.xtail.S1 POLN VSS VSS sg13_lv_nmos ad=1.5637p pd=8.61u as=1.5637p ps=8.61u w=8.23u l=0.13u
X1427 cml_tlatch_28.xtail.S1 CKHA0_N cml_tlatch_28.xmux.xp.S1 VSS sg13_lv_nmos ad=89.3f pd=0.85u as=89.3f ps=0.85u w=0.47u l=0.16u
X1428 B0_2_P B0_2_N cml_tlatch_31.xmux.xp.S1 VSS sg13_lv_nmos ad=56.9f pd=0.74u as=56.9f ps=0.74u w=0.17u l=0.17u
X1429 cml_tlatch_42.xmux.xp.S1 MOT8_P MOT8_N VSS sg13_lv_nmos ad=56.9f pd=0.74u as=56.9f ps=0.74u w=0.17u l=0.17u
X1430 cml_tlatch_52.xmux.xn.S1 CKHA2_P cml_tlatch_52.xtail.S1 VSS sg13_lv_nmos ad=89.3f pd=0.85u as=89.3f ps=0.85u w=0.47u l=0.16u
X1431 MOT19_P MOT19_N cml_tlatch_78.xmux.xp.S1 VSS sg13_lv_nmos ad=56.9f pd=0.74u as=56.9f ps=0.74u w=0.17u l=0.17u
X1432 cml_tlatch_85.xmux.xp.S1 A2_8_P A2_8_N VSS sg13_lv_nmos ad=0.1019p pd=1.34u as=56.9f ps=0.74u w=0.17u l=0.17u
X1433 stub_bi_31.BOTN D1_N cml_tlatch_37.xmux.xn.S1 VSS sg13_lv_nmos ad=63.19999f pd=0.74u as=63.19999f ps=0.74u w=0.26u l=0.38u
X1434 cml_tlatch_59.xmux.xn.S1 CKA2_P cml_tlatch_59.xtail.S1 VSS sg13_lv_nmos ad=89.3f pd=0.85u as=0.1598p ps=1.62u w=0.47u l=0.16u
X1435 cml_tlatch_67.xmux.xn.S1 cml_tlatch_74.INP cml_tlatch_67.OUTN VSS sg13_lv_nmos ad=63.19999f pd=0.74u as=63.19999f ps=0.74u w=0.26u l=0.38u
X1436 cml_tlatch_44.xmux.xp.S1 MOT28_N MOT28_P VSS sg13_lv_nmos ad=56.9f pd=0.74u as=56.9f ps=0.74u w=0.17u l=0.17u
X1437 cml_tlatch_73.xmux.xp.S1 MOT27_N MOT27_P VSS sg13_lv_nmos ad=56.9f pd=0.74u as=56.9f ps=0.74u w=0.17u l=0.17u
X1438 cml_tlatch_11.xmux.xn.S1 CKB1_P cml_tlatch_11.xtail.S1 VSS sg13_lv_nmos ad=89.3f pd=0.85u as=89.3f ps=0.85u w=0.47u l=0.16u
X1439 cml_tlatch_75.xmux.xn.S1 B3_2_N MOT31_P VSS sg13_lv_nmos ad=63.19999f pd=0.74u as=63.19999f ps=0.74u w=0.26u l=0.38u
X1440 CLK_W_N CLK_W_P cml_tlatch_93.xmux.xp.S1 VSS sg13_lv_nmos ad=56.9f pd=0.74u as=56.9f ps=0.74u w=0.17u l=0.17u
X1441 cml_tlatch_33.xmux.xn.S1 CKA0_P cml_tlatch_33.xtail.S1 VSS sg13_lv_nmos ad=89.3f pd=0.85u as=89.3f ps=0.85u w=0.47u l=0.16u
X1442 CKHA3_N VDD VSS rppd l=13.09u w=1u
X1443 cml_tlatch_77.xmux.xp.S1 MOT17_N MOT17_P VSS sg13_lv_nmos ad=56.9f pd=0.74u as=56.9f ps=0.74u w=0.17u l=0.17u
X1444 cml_tlatch_51.xmux.xp.S1 cml_tlatch_51.OUTN cml_tlatch_51.OUTP VSS sg13_lv_nmos ad=56.9f pd=0.74u as=56.9f ps=0.74u w=0.17u l=0.17u
X1445 MOT10_P MOT10_N cml_tlatch_43.xmux.xp.S1 VSS sg13_lv_nmos ad=56.9f pd=0.74u as=56.9f ps=0.74u w=0.17u l=0.17u
X1446 MOT24_P A3_8_N cml_tlatch_62.xmux.xn.S1 VSS sg13_lv_nmos ad=63.19999f pd=0.74u as=63.19999f ps=0.74u w=0.26u l=0.38u
X1447 cml_tlatch_55.xtail.S1 POLN VSS VSS sg13_lv_nmos ad=1.5637p pd=8.61u as=2.7982p ps=17.14u w=8.23u l=0.13u
X1448 cml_tlatch_11.xmux.xn.S1 cml_tlatch_4.INP stub_bi_15.BOTP VSS sg13_lv_nmos ad=63.19999f pd=0.74u as=63.19999f ps=0.74u w=0.26u l=0.38u
X1449 cml_tlatch_87.OUTP cml_tlatch_87.OUTN cml_tlatch_87.xmux.xp.S1 VSS sg13_lv_nmos ad=56.9f pd=0.74u as=56.9f ps=0.74u w=0.17u l=0.17u
X1450 cml_tlatch_75.xmux.xp.S1 MOT31_P MOT31_N VSS sg13_lv_nmos ad=56.9f pd=0.74u as=56.9f ps=0.74u w=0.17u l=0.17u
X1451 cml_tlatch_1.xtail.S1 CKB0_N cml_tlatch_1.xmux.xn.S1 VSS sg13_lv_nmos ad=89.3f pd=0.85u as=0.1598p ps=1.62u w=0.47u l=0.16u
X1452 cml_tlatch_22.xmux.xp.S1 cml_tlatch_22.OUTP cml_tlatch_22.OUTN VSS sg13_lv_nmos ad=56.9f pd=0.74u as=56.9f ps=0.74u w=0.17u l=0.17u
X1453 cml_tlatch_11.xmux.xn.S1 cml_tlatch_4.INP stub_bi_15.BOTP VSS sg13_lv_nmos ad=63.19999f pd=0.74u as=63.19999f ps=0.74u w=0.26u l=0.38u
X1454 cml_tlatch_62.xmux.xn.S1 CKHA3_P cml_tlatch_62.xtail.S1 VSS sg13_lv_nmos ad=89.3f pd=0.85u as=89.3f ps=0.85u w=0.47u l=0.16u
X1455 cml_tlatch_82.xmux.xp.S1 stub_bi_62.BOTN stub_bi_62.BOTP VSS sg13_lv_nmos ad=56.9f pd=0.74u as=56.9f ps=0.74u w=0.17u l=0.17u
X1456 cml_tlatch_59.xmux.xp.S1 cml_tlatch_91.INN cml_tlatch_91.INP VSS sg13_lv_nmos ad=0.1019p pd=1.34u as=56.9f ps=0.74u w=0.17u l=0.17u
X1457 cml_tlatch_15.xmux.xp.S1 MOT3_P MOT3_N VSS sg13_lv_nmos ad=56.9f pd=0.74u as=56.9f ps=0.74u w=0.17u l=0.17u
X1458 cml_tlatch_28.xmux.xp.S1 MOT4_P MOT4_N VSS sg13_lv_nmos ad=56.9f pd=0.74u as=56.9f ps=0.74u w=0.17u l=0.17u
X1459 cml_tlatch_59.xmux.xn.S1 A2_2_N cml_tlatch_91.INP VSS sg13_lv_nmos ad=63.19999f pd=0.74u as=63.19999f ps=0.74u w=0.26u l=0.38u
X1460 cml_tlatch_33.OUTN cml_tlatch_33.OUTP cml_tlatch_33.xmux.xp.S1 VSS sg13_lv_nmos ad=56.9f pd=0.74u as=56.9f ps=0.74u w=0.17u l=0.17u
X1461 VSS POLN cml_tlatch_12.xtail.S1 VSS sg13_lv_nmos ad=2.7982p pd=17.14u as=1.5637p ps=8.61u w=8.23u l=0.13u
X1462 cml_tlatch_34.xmux.xn.S1 CKA0_N cml_tlatch_34.xtail.S1 VSS sg13_lv_nmos ad=89.3f pd=0.85u as=89.3f ps=0.85u w=0.47u l=0.16u
X1463 cml_tlatch_18.xmux.xp.S1 CKA0_N cml_tlatch_18.xtail.S1 VSS sg13_lv_nmos ad=89.3f pd=0.85u as=89.3f ps=0.85u w=0.47u l=0.16u
X1464 MOT4_P cml_tlatch_99.OUTN cml_tlatch_28.xmux.xn.S1 VSS sg13_lv_nmos ad=0.1082p pd=1.34u as=63.19999f ps=0.74u w=0.26u l=0.38u
X1465 cml_tlatch_5.xmux.xn.S1 cml_tlatch_5.INN MOT13_P VSS sg13_lv_nmos ad=63.19999f pd=0.74u as=0.1082p ps=1.34u w=0.26u l=0.38u
X1466 cml_tlatch_0.xmux.xp.S1 cml_tlatch_0.OUTN cml_tlatch_0.OUTP VSS sg13_lv_nmos ad=56.9f pd=0.74u as=56.9f ps=0.74u w=0.17u l=0.17u
X1467 cml_tlatch_67.xtail.S1 CKB3_P cml_tlatch_67.xmux.xn.S1 VSS sg13_lv_nmos ad=89.3f pd=0.85u as=89.3f ps=0.85u w=0.47u l=0.16u
X1468 MOT23_P MOT23_N cml_tlatch_80.xmux.xp.S1 VSS sg13_lv_nmos ad=56.9f pd=0.74u as=56.9f ps=0.74u w=0.17u l=0.17u
X1469 cml_tlatch_32.xmux.xn.S1 CKB0_P cml_tlatch_32.xtail.S1 VSS sg13_lv_nmos ad=89.3f pd=0.85u as=89.3f ps=0.85u w=0.47u l=0.16u
X1470 cml_tlatch_2.xmux.xp.S1 cml_tlatch_2.OUTP cml_tlatch_2.OUTN VSS sg13_lv_nmos ad=0.1019p pd=1.34u as=56.9f ps=0.74u w=0.17u l=0.17u
X1471 cml_tlatch_86.OUTP cml_tlatch_86.OUTN cml_tlatch_86.xmux.xp.S1 VSS sg13_lv_nmos ad=56.9f pd=0.74u as=56.9f ps=0.74u w=0.17u l=0.17u
X1472 cml_tlatch_99.xmux.xp.S1 CKA0_P cml_tlatch_99.xtail.S1 VSS sg13_lv_nmos ad=89.3f pd=0.85u as=89.3f ps=0.85u w=0.47u l=0.16u
X1473 cml_tlatch_64.xmux.xn.S1 CKB3_N cml_tlatch_64.xtail.S1 VSS sg13_lv_nmos ad=89.3f pd=0.85u as=89.3f ps=0.85u w=0.47u l=0.16u
X1474 MOT16_P MOT16_N cml_tlatch_52.xmux.xp.S1 VSS sg13_lv_nmos ad=56.9f pd=0.74u as=56.9f ps=0.74u w=0.17u l=0.17u
X1475 cml_tlatch_38.xmux.xn.S1 D0_N cml_tlatch_38.OUTP VSS sg13_lv_nmos ad=63.19999f pd=0.74u as=63.19999f ps=0.74u w=0.26u l=0.38u
X1476 cml_tlatch_62.xmux.xp.S1 MOT24_N MOT24_P VSS sg13_lv_nmos ad=56.9f pd=0.74u as=56.9f ps=0.74u w=0.17u l=0.17u
X1477 A1_8_P cml_tlatch_20.OUTN cml_tlatch_19.xmux.xn.S1 VSS sg13_lv_nmos ad=63.19999f pd=0.74u as=63.19999f ps=0.74u w=0.26u l=0.38u
X1478 cml_drv_1.xrtail.R1 ENA_P ENA1_N VSS sg13_lv_nmos ad=56.2f pd=0.74u as=56.2f ps=0.74u w=0.16u l=0.19u
X1479 cml_tlatch_91.INN A2_2_P cml_tlatch_59.xmux.xn.S1 VSS sg13_lv_nmos ad=63.19999f pd=0.74u as=0.1082p ps=1.34u w=0.26u l=0.38u
X1480 cml_tlatch_48.xmux.xp.S1 CKB2_N cml_tlatch_48.xtail.S1 VSS sg13_lv_nmos ad=89.3f pd=0.85u as=89.3f ps=0.85u w=0.47u l=0.16u
X1481 cml_tlatch_40.xtail.S1 POLN VSS VSS sg13_lv_nmos ad=1.5637p pd=8.61u as=1.5637p ps=8.61u w=8.23u l=0.13u
X1482 cml_tlatch_58.xmux.xp.S1 CKA3_N cml_tlatch_58.xtail.S1 VSS sg13_lv_nmos ad=89.3f pd=0.85u as=0.1598p ps=1.62u w=0.47u l=0.16u
X1483 cml_tlatch_73.xtail.S1 CKHB3_N cml_tlatch_73.xmux.xp.S1 VSS sg13_lv_nmos ad=0.1598p pd=1.62u as=89.3f ps=0.85u w=0.47u l=0.16u
X1484 cml_tlatch_27.xmux.xn.S1 CKHA0_P cml_tlatch_27.xtail.S1 VSS sg13_lv_nmos ad=89.3f pd=0.85u as=89.3f ps=0.85u w=0.47u l=0.16u
X1485 MOT2_N MOT2_P cml_tlatch_27.xmux.xp.S1 VSS sg13_lv_nmos ad=56.9f pd=0.74u as=56.9f ps=0.74u w=0.17u l=0.17u
X1486 MOT9_N MOT9_P cml_tlatch_3.xmux.xp.S1 VSS sg13_lv_nmos ad=56.9f pd=0.74u as=56.9f ps=0.74u w=0.17u l=0.17u
X1487 cml_tlatch_79.xmux.xp.S1 MOT21_N MOT21_P VSS sg13_lv_nmos ad=56.9f pd=0.74u as=56.9f ps=0.74u w=0.17u l=0.17u
X1488 B1_2_N B1_2_P cml_tlatch_36.xmux.xp.S1 VSS sg13_lv_nmos ad=56.9f pd=0.74u as=56.9f ps=0.74u w=0.17u l=0.17u
X1489 MOT29_P MOT29_N cml_tlatch_74.xmux.xp.S1 VSS sg13_lv_nmos ad=56.9f pd=0.74u as=56.9f ps=0.74u w=0.17u l=0.17u
X1490 cml_tlatch_13.xtail.S1 CKB1_P cml_tlatch_13.xmux.xn.S1 VSS sg13_lv_nmos ad=89.3f pd=0.85u as=0.1598p ps=1.62u w=0.47u l=0.16u
X1491 hs_to_clk_2.D2 CK_P CKB1_N VSS sg13_lv_nmos ad=0.408p pd=3.08u as=0.228p ps=1.58u w=1.2u l=0.2u
X1492 cml_tlatch_49.OUTP VDD VSS rppd l=5.17u w=1u
X1493 cml_tlatch_56.xtail.S1 CKA3_P cml_tlatch_56.xmux.xn.S1 VSS sg13_lv_nmos ad=89.3f pd=0.85u as=89.3f ps=0.85u w=0.47u l=0.16u
X1494 cml_tlatch_68.xtail.S1 CKA3_P cml_tlatch_68.xmux.xp.S1 VSS sg13_lv_nmos ad=89.3f pd=0.85u as=89.3f ps=0.85u w=0.47u l=0.16u
X1495 cml_tlatch_24.xmux.xp.S1 MOT12_N MOT12_P VSS sg13_lv_nmos ad=0.1019p pd=1.34u as=56.9f ps=0.74u w=0.17u l=0.17u
X1496 cml_tlatch_89.xmux.xp.S1 cml_tlatch_44.INP cml_tlatch_44.INN VSS sg13_lv_nmos ad=56.9f pd=0.74u as=56.9f ps=0.74u w=0.17u l=0.17u
X1497 cml_gate2_8.xrtail.R1 NS1_N ENB_P VSS sg13_lv_nmos ad=0.1007p pd=0.91u as=0.1007p ps=0.91u w=0.53u l=0.13u
X1498 cml_tlatch_38.xmux.xp.S1 cml_tlatch_38.OUTN cml_tlatch_38.OUTP VSS sg13_lv_nmos ad=56.9f pd=0.74u as=56.9f ps=0.74u w=0.17u l=0.17u
X1499 cml_tlatch_83.xmux.xn.S1 CKB2_N cml_tlatch_83.xtail.S1 VSS sg13_lv_nmos ad=89.3f pd=0.85u as=89.3f ps=0.85u w=0.47u l=0.16u
X1500 GB2_P CKA2_N cml_gate2_7.xrtail.R1 VSS sg13_lv_nmos ad=0.1007p pd=0.91u as=0.1007p ps=0.91u w=0.53u l=0.13u
X1501 MOT5_N MOT5_P cml_tlatch_16.xmux.xp.S1 VSS sg13_lv_nmos ad=56.9f pd=0.74u as=56.9f ps=0.74u w=0.17u l=0.17u
X1502 cml_tlatch_90.xmux.xp.S1 stub_bi_55.BOTP stub_bi_55.BOTN VSS sg13_lv_nmos ad=56.9f pd=0.74u as=56.9f ps=0.74u w=0.17u l=0.17u
X1503 cml_tlatch_18.OUTP cml_tlatch_18.OUTN cml_tlatch_18.xmux.xp.S1 VSS sg13_lv_nmos ad=56.9f pd=0.74u as=56.9f ps=0.74u w=0.17u l=0.17u
X1504 cml_tlatch_4.xtail.S1 CKHB1_N cml_tlatch_4.xmux.xp.S1 VSS sg13_lv_nmos ad=89.3f pd=0.85u as=89.3f ps=0.85u w=0.47u l=0.16u
X1505 MOT25_N MOT25_P cml_tlatch_72.xmux.xp.S1 VSS sg13_lv_nmos ad=56.9f pd=0.74u as=56.9f ps=0.74u w=0.17u l=0.17u
X1506 MOT20_N MOT20_P cml_tlatch_54.xmux.xp.S1 VSS sg13_lv_nmos ad=56.9f pd=0.74u as=56.9f ps=0.74u w=0.17u l=0.17u
X1507 cml_tlatch_27.xmux.xn.S1 cml_tlatch_23.OUTN MOT2_P VSS sg13_lv_nmos ad=63.19999f pd=0.74u as=63.19999f ps=0.74u w=0.26u l=0.38u
X1508 GA3_N ENA1_P cml_gate2_4.xamp.xn.S1 VSS sg13_lv_nmos ad=0.1802p pd=1.74u as=0.1007p ps=0.91u w=0.53u l=0.13u
X1509 cml_tlatch_27.xmux.xn.S1 cml_tlatch_23.OUTN MOT2_P VSS sg13_lv_nmos ad=63.19999f pd=0.74u as=63.19999f ps=0.74u w=0.26u l=0.38u
X1510 cml_tlatch_69.OUTN cml_tlatch_69.OUTP cml_tlatch_69.xmux.xp.S1 VSS sg13_lv_nmos ad=56.9f pd=0.74u as=56.9f ps=0.74u w=0.17u l=0.17u
X1511 cml_tlatch_2.xmux.xn.S1 CKB0_P cml_tlatch_2.xtail.S1 VSS sg13_lv_nmos ad=89.3f pd=0.85u as=89.3f ps=0.85u w=0.47u l=0.16u
X1512 cml_tlatch_33.xmux.xp.S1 cml_tlatch_33.OUTN cml_tlatch_33.OUTP VSS sg13_lv_nmos ad=56.9f pd=0.74u as=56.9f ps=0.74u w=0.17u l=0.17u
X1513 cml_tlatch_22.xmux.xp.S1 CKA1_N cml_tlatch_22.xtail.S1 VSS sg13_lv_nmos ad=89.3f pd=0.85u as=0.1598p ps=1.62u w=0.47u l=0.16u
X1514 cml_tlatch_71.OUTN cml_tlatch_71.OUTP cml_tlatch_71.xmux.xp.S1 VSS sg13_lv_nmos ad=56.9f pd=0.74u as=56.9f ps=0.74u w=0.17u l=0.17u
X1515 cml_tlatch_55.xmux.xp.S1 CKHA2_N cml_tlatch_55.xtail.S1 VSS sg13_lv_nmos ad=0.1598p pd=1.62u as=89.3f ps=0.85u w=0.47u l=0.16u
X1516 cml_tlatch_77.xmux.xp.S1 MOT17_N MOT17_P VSS sg13_lv_nmos ad=0.1019p pd=1.34u as=56.9f ps=0.74u w=0.17u l=0.17u
X1517 stub_bi_62.BOTN stub_bi_62.BOTP cml_tlatch_82.xmux.xp.S1 VSS sg13_lv_nmos ad=56.9f pd=0.74u as=56.9f ps=0.74u w=0.17u l=0.17u
X1518 A2_8_P A2_8_N cml_tlatch_85.xmux.xp.S1 VSS sg13_lv_nmos ad=56.9f pd=0.74u as=56.9f ps=0.74u w=0.17u l=0.17u
X1519 cml_tlatch_82.xtail.S1 CKB2_N cml_tlatch_82.xmux.xp.S1 VSS sg13_lv_nmos ad=89.3f pd=0.85u as=89.3f ps=0.85u w=0.47u l=0.16u
X1520 cml_tlatch_90.xtail.S1 CKB2_P cml_tlatch_90.xmux.xp.S1 VSS sg13_lv_nmos ad=89.3f pd=0.85u as=89.3f ps=0.85u w=0.47u l=0.16u
X1521 cml_tlatch_61.OUTP cml_tlatch_61.OUTN cml_tlatch_61.xmux.xp.S1 VSS sg13_lv_nmos ad=56.9f pd=0.74u as=56.9f ps=0.74u w=0.17u l=0.17u
X1522 cml_tlatch_0.xmux.xn.S1 cml_tlatch_99.OUTN cml_tlatch_0.OUTP VSS sg13_lv_nmos ad=63.19999f pd=0.74u as=63.19999f ps=0.74u w=0.26u l=0.38u
X1523 cml_tlatch_96.xmux.xn.S1 CKB1_N cml_tlatch_96.xtail.S1 VSS sg13_lv_nmos ad=89.3f pd=0.85u as=89.3f ps=0.85u w=0.47u l=0.16u
X1524 cml_tlatch_57.xmux.xp.S1 A3_2_N A3_2_P VSS sg13_lv_nmos ad=56.9f pd=0.74u as=56.9f ps=0.74u w=0.17u l=0.17u
X1525 MOT25_P MOT25_N cml_tlatch_72.xmux.xp.S1 VSS sg13_lv_nmos ad=56.9f pd=0.74u as=56.9f ps=0.74u w=0.17u l=0.17u
X1526 cml_tlatch_50.xmux.xn.S1 CKB3_N cml_tlatch_50.xtail.S1 VSS sg13_lv_nmos ad=89.3f pd=0.85u as=89.3f ps=0.85u w=0.47u l=0.16u
X1527 B3_2_P B3_2_N cml_tlatch_50.xmux.xp.S1 VSS sg13_lv_nmos ad=56.9f pd=0.74u as=56.9f ps=0.74u w=0.17u l=0.17u
X1528 cml_tlatch_79.xtail.S1 CKHB2_P cml_tlatch_79.xmux.xn.S1 VSS sg13_lv_nmos ad=89.3f pd=0.85u as=89.3f ps=0.85u w=0.47u l=0.16u
X1529 cml_tlatch_83.xmux.xn.S1 stub_bi_49.BOTN stub_bi_63.BOTP VSS sg13_lv_nmos ad=0.1082p pd=1.34u as=63.19999f ps=0.74u w=0.26u l=0.38u
X1530 cml_tlatch_6.xtail.S1 CKHB1_P cml_tlatch_6.xmux.xn.S1 VSS sg13_lv_nmos ad=89.3f pd=0.85u as=0.1598p ps=1.62u w=0.47u l=0.16u
X1531 cml_tlatch_22.OUTP cml_tlatch_24.INN cml_tlatch_22.xmux.xn.S1 VSS sg13_lv_nmos ad=63.19999f pd=0.74u as=63.19999f ps=0.74u w=0.26u l=0.38u
X1532 cml_tlatch_15.xmux.xp.S1 MOT3_P MOT3_N VSS sg13_lv_nmos ad=56.9f pd=0.74u as=56.9f ps=0.74u w=0.17u l=0.17u
X1533 cml_tlatch_28.xmux.xp.S1 MOT4_P MOT4_N VSS sg13_lv_nmos ad=56.9f pd=0.74u as=56.9f ps=0.74u w=0.17u l=0.17u
X1534 cml_tlatch_43.INN cml_tlatch_43.INP cml_tlatch_21.xmux.xp.S1 VSS sg13_lv_nmos ad=56.9f pd=0.74u as=56.9f ps=0.74u w=0.17u l=0.17u
X1535 stub_bi_17.BOTP stub_bi_17.BOTN cml_tlatch_13.xmux.xp.S1 VSS sg13_lv_nmos ad=56.9f pd=0.74u as=56.9f ps=0.74u w=0.17u l=0.17u
X1536 cml_tlatch_83.xmux.xp.S1 stub_bi_63.BOTN stub_bi_63.BOTP VSS sg13_lv_nmos ad=56.9f pd=0.74u as=56.9f ps=0.74u w=0.17u l=0.17u
X1537 cml_tlatch_3.xmux.xp.S1 MOT9_N MOT9_P VSS sg13_lv_nmos ad=56.9f pd=0.74u as=56.9f ps=0.74u w=0.17u l=0.17u
X1538 cml_tlatch_43.INP cml_tlatch_43.INN cml_tlatch_21.xmux.xp.S1 VSS sg13_lv_nmos ad=56.9f pd=0.74u as=56.9f ps=0.74u w=0.17u l=0.17u
X1539 cml_gate2_1.xamp.xn.S1 ENB1_N GB0_P VSS sg13_lv_nmos ad=0.1007p pd=0.91u as=0.1007p ps=0.91u w=0.53u l=0.13u
X1540 cml_tlatch_93.xmux.xp.S1 CLK_W_N CLK_W_P VSS sg13_lv_nmos ad=56.9f pd=0.74u as=56.9f ps=0.74u w=0.17u l=0.17u
X1541 cml_tlatch_98.xmux.xp.S1 cml_tlatch_98.OUTP cml_tlatch_98.OUTN VSS sg13_lv_nmos ad=56.9f pd=0.74u as=56.9f ps=0.74u w=0.17u l=0.17u
X1542 cml_tlatch_74.xtail.S1 CKHB3_P cml_tlatch_74.xmux.xn.S1 VSS sg13_lv_nmos ad=89.3f pd=0.85u as=89.3f ps=0.85u w=0.47u l=0.16u
X1543 cml_tlatch_0.OUTN cml_tlatch_0.OUTP cml_tlatch_0.xmux.xp.S1 VSS sg13_lv_nmos ad=56.9f pd=0.74u as=56.9f ps=0.74u w=0.17u l=0.17u
X1544 cml_tlatch_28.xmux.xp.S1 CKHA0_N cml_tlatch_28.xtail.S1 VSS sg13_lv_nmos ad=89.3f pd=0.85u as=89.3f ps=0.85u w=0.47u l=0.16u
X1545 cml_tlatch_75.xmux.xp.S1 MOT31_N MOT31_P VSS sg13_lv_nmos ad=56.9f pd=0.74u as=56.9f ps=0.74u w=0.17u l=0.17u
X1546 GB1_P CKA1_N cml_gate2_0.xrtail.R1 VSS sg13_lv_nmos ad=0.1007p pd=0.91u as=0.1007p ps=0.91u w=0.53u l=0.13u
X1547 cml_tlatch_17.xtail.S1 CKHB0_N cml_tlatch_17.xmux.xp.S1 VSS sg13_lv_nmos ad=89.3f pd=0.85u as=89.3f ps=0.85u w=0.47u l=0.16u
X1548 A1_8_N A1_8_P cml_tlatch_19.xmux.xp.S1 VSS sg13_lv_nmos ad=56.9f pd=0.74u as=56.9f ps=0.74u w=0.17u l=0.17u
X1549 cml_tlatch_39.xtail.S1 CKA1_N cml_tlatch_39.xmux.xp.S1 VSS sg13_lv_nmos ad=89.3f pd=0.85u as=89.3f ps=0.85u w=0.47u l=0.16u
X1550 cml_tlatch_55.xmux.xp.S1 MOT22_N MOT22_P VSS sg13_lv_nmos ad=56.9f pd=0.74u as=56.9f ps=0.74u w=0.17u l=0.17u
X1551 cml_tlatch_38.xmux.xp.S1 cml_tlatch_38.OUTP cml_tlatch_38.OUTN VSS sg13_lv_nmos ad=56.9f pd=0.74u as=56.9f ps=0.74u w=0.17u l=0.17u
X1552 cml_tlatch_17.xtail.S1 POLN VSS VSS sg13_lv_nmos ad=1.5637p pd=8.61u as=1.5637p ps=8.61u w=8.23u l=0.13u
X1553 cml_tlatch_10.xmux.xp.S1 B1_8_P B1_8_N VSS sg13_lv_nmos ad=56.9f pd=0.74u as=56.9f ps=0.74u w=0.17u l=0.17u
X1554 cml_tlatch_79.xmux.xp.S1 MOT21_P MOT21_N VSS sg13_lv_nmos ad=56.9f pd=0.74u as=56.9f ps=0.74u w=0.17u l=0.17u
X1555 cml_tlatch_91.INN cml_tlatch_91.INP cml_tlatch_59.xmux.xp.S1 VSS sg13_lv_nmos ad=56.9f pd=0.74u as=56.9f ps=0.74u w=0.17u l=0.17u
X1556 MOT15_P MOT15_N cml_tlatch_6.xmux.xp.S1 VSS sg13_lv_nmos ad=56.9f pd=0.74u as=56.9f ps=0.74u w=0.17u l=0.17u
X1557 MOT0_P A0_8_N cml_tlatch_26.xmux.xn.S1 VSS sg13_lv_nmos ad=63.19999f pd=0.74u as=63.19999f ps=0.74u w=0.26u l=0.38u
X1558 VSS POLN hs_to_clk_2.D2 VSS sg13_lv_nmos ad=1.9p pd=10.38u as=3.4p ps=20.68u w=10u l=0.13u
X1559 cml_tlatch_58.xmux.xn.S1 CKA3_P cml_tlatch_58.xtail.S1 VSS sg13_lv_nmos ad=89.3f pd=0.85u as=89.3f ps=0.85u w=0.47u l=0.16u
X1560 cml_tlatch_93.xmux.xp.S1 CLK_W_N CLK_W_P VSS sg13_lv_nmos ad=0.1019p pd=1.34u as=56.9f ps=0.74u w=0.17u l=0.17u
X1561 cml_tlatch_69.OUTP cml_tlatch_63.INN cml_tlatch_69.xmux.xn.S1 VSS sg13_lv_nmos ad=63.19999f pd=0.74u as=0.1082p ps=1.34u w=0.26u l=0.38u
X1562 stub_bi_31.BOTP stub_bi_31.BOTN cml_tlatch_37.xmux.xp.S1 VSS sg13_lv_nmos ad=56.9f pd=0.74u as=56.9f ps=0.74u w=0.17u l=0.17u
X1563 cml_tlatch_37.xmux.xn.S1 D1_P stub_bi_31.BOTP VSS sg13_lv_nmos ad=63.19999f pd=0.74u as=63.19999f ps=0.74u w=0.26u l=0.38u
X1564 cml_tlatch_63.xtail.S1 CKHA3_N cml_tlatch_63.xmux.xp.S1 VSS sg13_lv_nmos ad=89.3f pd=0.85u as=89.3f ps=0.85u w=0.47u l=0.16u
X1565 cml_tlatch_44.INP cml_tlatch_44.INN cml_tlatch_89.xmux.xp.S1 VSS sg13_lv_nmos ad=56.9f pd=0.74u as=56.9f ps=0.74u w=0.17u l=0.17u
X1566 MOT20_N cml_tlatch_91.OUTP cml_tlatch_54.xmux.xn.S1 VSS sg13_lv_nmos ad=63.19999f pd=0.74u as=0.1082p ps=1.34u w=0.26u l=0.38u
X1567 cml_tlatch_97.INP cml_tlatch_97.INN cml_tlatch_39.xmux.xp.S1 VSS sg13_lv_nmos ad=56.9f pd=0.74u as=56.9f ps=0.74u w=0.17u l=0.17u
X1568 J4_N CLK_W_N cml_tlatch_92.xmux.xn.S1 VSS sg13_lv_nmos ad=0.1082p pd=1.34u as=63.19999f ps=0.74u w=0.26u l=0.38u
X1569 cml_tlatch_35.xmux.xp.S1 stub_bi_29.BOTP stub_bi_29.BOTN VSS sg13_lv_nmos ad=56.9f pd=0.74u as=56.9f ps=0.74u w=0.17u l=0.17u
X1570 cml_tlatch_67.OUTP cml_tlatch_74.INN cml_tlatch_67.xmux.xn.S1 VSS sg13_lv_nmos ad=63.19999f pd=0.74u as=63.19999f ps=0.74u w=0.26u l=0.38u
X1571 VDD MOT19_N VSS rppd l=5.17u w=1u
X1572 cml_tlatch_37.xmux.xn.S1 D1_P stub_bi_31.BOTP VSS sg13_lv_nmos ad=63.19999f pd=0.74u as=63.19999f ps=0.74u w=0.26u l=0.38u
X1573 A0_2_P A0_2_N cml_tlatch_34.xmux.xp.S1 VSS sg13_lv_nmos ad=56.9f pd=0.74u as=0.1019p ps=1.34u w=0.17u l=0.17u
X1574 cml_tlatch_76.xtail.S1 CKA2_N cml_tlatch_76.xmux.xp.S1 VSS sg13_lv_nmos ad=89.3f pd=0.85u as=89.3f ps=0.85u w=0.47u l=0.16u
X1575 cml_tlatch_73.INN VDD VSS rppd l=5.17u w=1u
X1576 cml_tlatch_19.xmux.xp.S1 A1_8_N A1_8_P VSS sg13_lv_nmos ad=56.9f pd=0.74u as=56.9f ps=0.74u w=0.17u l=0.17u
X1577 stub_bi_43.BOTN stub_bi_43.BOTP cml_tlatch_48.xmux.xp.S1 VSS sg13_lv_nmos ad=56.9f pd=0.74u as=56.9f ps=0.74u w=0.17u l=0.17u
X1578 MOT6_P MOT6_N cml_tlatch_29.xmux.xp.S1 VSS sg13_lv_nmos ad=56.9f pd=0.74u as=56.9f ps=0.74u w=0.17u l=0.17u
X1579 cml_tlatch_30.OUTP cml_tlatch_30.OUTN cml_tlatch_30.xmux.xp.S1 VSS sg13_lv_nmos ad=56.9f pd=0.74u as=56.9f ps=0.74u w=0.17u l=0.17u
X1580 MOT31_P MOT31_N cml_tlatch_75.xmux.xp.S1 VSS sg13_lv_nmos ad=56.9f pd=0.74u as=56.9f ps=0.74u w=0.17u l=0.17u
X1581 cml_tlatch_32.OUTP cml_tlatch_32.OUTN cml_tlatch_32.xmux.xp.S1 VSS sg13_lv_nmos ad=56.9f pd=0.74u as=0.1019p ps=1.34u w=0.17u l=0.17u
X1582 MOT5_N MOT5_P cml_tlatch_16.xmux.xp.S1 VSS sg13_lv_nmos ad=56.9f pd=0.74u as=56.9f ps=0.74u w=0.17u l=0.17u
X1583 cml_tlatch_98.OUTP cml_tlatch_30.OUTN cml_tlatch_98.xmux.xn.S1 VSS sg13_lv_nmos ad=63.19999f pd=0.74u as=63.19999f ps=0.74u w=0.26u l=0.38u
X1584 MOT22_N MOT22_P cml_tlatch_55.xmux.xp.S1 VSS sg13_lv_nmos ad=56.9f pd=0.74u as=56.9f ps=0.74u w=0.17u l=0.17u
X1585 cml_tlatch_90.xmux.xn.S1 stub_bi_38.BOTN stub_bi_55.BOTP VSS sg13_lv_nmos ad=63.19999f pd=0.74u as=63.19999f ps=0.74u w=0.26u l=0.38u
X1586 MOT6_P A0_2_N cml_tlatch_29.xmux.xn.S1 VSS sg13_lv_nmos ad=63.19999f pd=0.74u as=0.1082p ps=1.34u w=0.26u l=0.38u
X1587 B1_2_P B1_2_N cml_tlatch_36.xmux.xp.S1 VSS sg13_lv_nmos ad=56.9f pd=0.74u as=56.9f ps=0.74u w=0.17u l=0.17u
X1588 cml_tlatch_51.OUTN cml_tlatch_51.OUTP cml_tlatch_51.xmux.xp.S1 VSS sg13_lv_nmos ad=56.9f pd=0.74u as=56.9f ps=0.74u w=0.17u l=0.17u
X1589 cml_tlatch_45.xmux.xp.S1 MOT30_P MOT30_N VSS sg13_lv_nmos ad=56.9f pd=0.74u as=56.9f ps=0.74u w=0.17u l=0.17u
X1590 cml_tlatch_64.xtail.S1 CKB3_N cml_tlatch_64.xmux.xn.S1 VSS sg13_lv_nmos ad=89.3f pd=0.85u as=89.3f ps=0.85u w=0.47u l=0.16u
X1591 VDD CKHB2_P VSS rppd l=13.09u w=1u
X1592 cml_tlatch_29.xmux.xn.S1 A0_2_P MOT6_N VSS sg13_lv_nmos ad=63.19999f pd=0.74u as=63.19999f ps=0.74u w=0.26u l=0.38u
X1593 cml_tlatch_3.xtail.S1 CKHB1_P cml_tlatch_3.xmux.xn.S1 VSS sg13_lv_nmos ad=89.3f pd=0.85u as=0.1598p ps=1.62u w=0.47u l=0.16u
X1594 cml_tlatch_69.OUTN cml_tlatch_69.OUTP cml_tlatch_69.xmux.xp.S1 VSS sg13_lv_nmos ad=56.9f pd=0.74u as=56.9f ps=0.74u w=0.17u l=0.17u
X1595 cml_tlatch_65.xmux.xp.S1 cml_tlatch_65.OUTP cml_tlatch_65.OUTN VSS sg13_lv_nmos ad=56.9f pd=0.74u as=56.9f ps=0.74u w=0.17u l=0.17u
X1596 cml_gate2_4.xamp.xn.S1 ENA1_N GA3_P VSS sg13_lv_nmos ad=0.1007p pd=0.91u as=0.1007p ps=0.91u w=0.53u l=0.13u
X1597 MOT27_N MOT27_P cml_tlatch_73.xmux.xp.S1 VSS sg13_lv_nmos ad=56.9f pd=0.74u as=56.9f ps=0.74u w=0.17u l=0.17u
X1598 cml_tlatch_37.xmux.xn.S1 CKB1_P cml_tlatch_37.xtail.S1 VSS sg13_lv_nmos ad=89.3f pd=0.85u as=89.3f ps=0.85u w=0.47u l=0.16u
X1599 cml_tlatch_39.xtail.S1 CKA1_N cml_tlatch_39.xmux.xp.S1 VSS sg13_lv_nmos ad=89.3f pd=0.85u as=89.3f ps=0.85u w=0.47u l=0.16u
X1600 cml_gate2_3.xrtail.R1 CKB0_N GA0_P VSS sg13_lv_nmos ad=0.1007p pd=0.91u as=0.1007p ps=0.91u w=0.53u l=0.13u
X1601 cml_tlatch_87.INP cml_tlatch_91.OUTN cml_tlatch_76.xmux.xn.S1 VSS sg13_lv_nmos ad=0.1082p pd=1.34u as=63.19999f ps=0.74u w=0.26u l=0.38u
X1602 stub_bi_15.BOTP stub_bi_15.BOTN cml_tlatch_11.xmux.xp.S1 VSS sg13_lv_nmos ad=56.9f pd=0.74u as=56.9f ps=0.74u w=0.17u l=0.17u
X1603 cml_tlatch_31.xmux.xn.S1 cml_tlatch_32.OUTN B0_2_P VSS sg13_lv_nmos ad=63.19999f pd=0.74u as=0.1082p ps=1.34u w=0.26u l=0.38u
X1604 cml_tlatch_25.xmux.xn.S1 A1_2_N MOT14_P VSS sg13_lv_nmos ad=0.1082p pd=1.34u as=63.19999f ps=0.74u w=0.26u l=0.38u
X1605 ENB0_P ENB_N cml_drv_2.xrtail.R1 VSS sg13_lv_nmos ad=0.1012p pd=1.34u as=56.2f ps=0.74u w=0.16u l=0.19u
X1606 cml_tlatch_8.xmux.xp.S1 cml_tlatch_8.OUTP cml_tlatch_8.OUTN VSS sg13_lv_nmos ad=56.9f pd=0.74u as=56.9f ps=0.74u w=0.17u l=0.17u
X1607 cml_tlatch_51.xmux.xp.S1 cml_tlatch_51.OUTP cml_tlatch_51.OUTN VSS sg13_lv_nmos ad=56.9f pd=0.74u as=56.9f ps=0.74u w=0.17u l=0.17u
X1608 cml_tlatch_83.xtail.S1 CKB2_N cml_tlatch_83.xmux.xn.S1 VSS sg13_lv_nmos ad=89.3f pd=0.85u as=89.3f ps=0.85u w=0.47u l=0.16u
X1609 cml_tlatch_14.xtail.S1 CKHB0_N cml_tlatch_14.xmux.xp.S1 VSS sg13_lv_nmos ad=89.3f pd=0.85u as=89.3f ps=0.85u w=0.47u l=0.16u
X1610 MOT13_N MOT13_P cml_tlatch_5.xmux.xp.S1 VSS sg13_lv_nmos ad=56.9f pd=0.74u as=0.1019p ps=1.34u w=0.17u l=0.17u
X1611 cml_tlatch_88.xtail.S1 CKB3_N cml_tlatch_88.xmux.xn.S1 VSS sg13_lv_nmos ad=89.3f pd=0.85u as=89.3f ps=0.85u w=0.47u l=0.16u
X1612 CKHB3_N VDD VSS rppd l=13.09u w=1u
X1613 cml_tlatch_8.xmux.xp.S1 cml_tlatch_8.OUTN cml_tlatch_8.OUTP VSS sg13_lv_nmos ad=0.1019p pd=1.34u as=56.9f ps=0.74u w=0.17u l=0.17u
X1614 cml_tlatch_23.xmux.xp.S1 cml_tlatch_23.OUTP cml_tlatch_23.OUTN VSS sg13_lv_nmos ad=56.9f pd=0.74u as=56.9f ps=0.74u w=0.17u l=0.17u
X1615 cml_tlatch_94.xmux.xp.S1 CKJ_P cml_tlatch_94.xtail.S1 VSS sg13_lv_nmos ad=89.3f pd=0.85u as=89.3f ps=0.85u w=0.47u l=0.16u
X1616 MOT21_P stub_bi_55.BOTP cml_tlatch_79.xmux.xn.S1 VSS sg13_lv_nmos ad=0.1082p pd=1.34u as=63.19999f ps=0.74u w=0.26u l=0.38u
X1617 cml_tlatch_32.OUTP cml_tlatch_32.OUTN cml_tlatch_32.xmux.xp.S1 VSS sg13_lv_nmos ad=56.9f pd=0.74u as=56.9f ps=0.74u w=0.17u l=0.17u
X1618 VSS POLN cml_tlatch_44.xtail.S1 VSS sg13_lv_nmos ad=1.5637p pd=8.61u as=1.5637p ps=8.61u w=8.23u l=0.13u
X1619 cml_tlatch_80.xtail.S1 POLN VSS VSS sg13_lv_nmos ad=1.5637p pd=8.61u as=2.7982p ps=17.14u w=8.23u l=0.13u
X1620 cml_tlatch_76.xmux.xn.S1 cml_tlatch_91.OUTP cml_tlatch_87.INN VSS sg13_lv_nmos ad=63.19999f pd=0.74u as=63.19999f ps=0.74u w=0.26u l=0.38u
X1621 cml_tlatch_98.xmux.xp.S1 cml_tlatch_98.OUTP cml_tlatch_98.OUTN VSS sg13_lv_nmos ad=56.9f pd=0.74u as=56.9f ps=0.74u w=0.17u l=0.17u
X1622 MOT26_P VDD VSS rppd l=5.17u w=1u
X1623 cml_tlatch_49.OUTP B3_2_N cml_tlatch_49.xmux.xn.S1 VSS sg13_lv_nmos ad=63.19999f pd=0.74u as=63.19999f ps=0.74u w=0.26u l=0.38u
X1624 cml_tlatch_67.xmux.xp.S1 cml_tlatch_67.OUTN cml_tlatch_67.OUTP VSS sg13_lv_nmos ad=56.9f pd=0.74u as=56.9f ps=0.74u w=0.17u l=0.17u
X1625 cml_tlatch_34.xmux.xn.S1 CKA0_N cml_tlatch_34.xtail.S1 VSS sg13_lv_nmos ad=89.3f pd=0.85u as=89.3f ps=0.85u w=0.47u l=0.16u
X1626 cml_tlatch_28.xmux.xn.S1 CKHA0_P cml_tlatch_28.xtail.S1 VSS sg13_lv_nmos ad=89.3f pd=0.85u as=89.3f ps=0.85u w=0.47u l=0.16u
X1627 cml_tlatch_76.xmux.xn.S1 cml_tlatch_91.OUTP cml_tlatch_87.INN VSS sg13_lv_nmos ad=63.19999f pd=0.74u as=63.19999f ps=0.74u w=0.26u l=0.38u
X1628 cml_tlatch_73.INP cml_tlatch_73.INN cml_tlatch_66.xmux.xp.S1 VSS sg13_lv_nmos ad=56.9f pd=0.74u as=56.9f ps=0.74u w=0.17u l=0.17u
X1629 A3_8_P A3_8_N cml_tlatch_68.xmux.xp.S1 VSS sg13_lv_nmos ad=56.9f pd=0.74u as=56.9f ps=0.74u w=0.17u l=0.17u
X1630 cml_tlatch_63.xmux.xp.S1 MOT26_P MOT26_N VSS sg13_lv_nmos ad=0.1019p pd=1.34u as=56.9f ps=0.74u w=0.17u l=0.17u
X1631 cml_tlatch_53.xtail.S1 CKHA2_P cml_tlatch_53.xmux.xn.S1 VSS sg13_lv_nmos ad=89.3f pd=0.85u as=89.3f ps=0.85u w=0.47u l=0.16u
X1632 cml_tlatch_40.xmux.xp.S1 A1_2_P A1_2_N VSS sg13_lv_nmos ad=56.9f pd=0.74u as=56.9f ps=0.74u w=0.17u l=0.17u
X1633 cml_tlatch_88.xmux.xp.S1 cml_tlatch_74.INN cml_tlatch_74.INP VSS sg13_lv_nmos ad=56.9f pd=0.74u as=56.9f ps=0.74u w=0.17u l=0.17u
X1634 cml_tlatch_55.xmux.xp.S1 MOT22_N MOT22_P VSS sg13_lv_nmos ad=56.9f pd=0.74u as=56.9f ps=0.74u w=0.17u l=0.17u
X1635 B2_2_N B2_2_P cml_tlatch_47.xmux.xp.S1 VSS sg13_lv_nmos ad=56.9f pd=0.74u as=56.9f ps=0.74u w=0.17u l=0.17u
X1636 stub_bi_29.BOTP B1_2_P cml_tlatch_35.xmux.xn.S1 VSS sg13_lv_nmos ad=63.19999f pd=0.74u as=63.19999f ps=0.74u w=0.26u l=0.38u
X1637 VSS cml_gate2_6.xrtail.R1 VSS rppd l=4.86u w=1u
X1638 cml_tlatch_10.xmux.xp.S1 B1_8_P B1_8_N VSS sg13_lv_nmos ad=56.9f pd=0.74u as=56.9f ps=0.74u w=0.17u l=0.17u
X1639 MOT18_N cml_tlatch_87.OUTP cml_tlatch_53.xmux.xn.S1 VSS sg13_lv_nmos ad=63.19999f pd=0.74u as=63.19999f ps=0.74u w=0.26u l=0.38u
X1640 cml_tlatch_1.xmux.xp.S1 B0_8_N B0_8_P VSS sg13_lv_nmos ad=56.9f pd=0.74u as=56.9f ps=0.74u w=0.17u l=0.17u
X1641 cml_tlatch_38.xmux.xp.S1 cml_tlatch_38.OUTP cml_tlatch_38.OUTN VSS sg13_lv_nmos ad=56.9f pd=0.74u as=56.9f ps=0.74u w=0.17u l=0.17u
X1642 cml_tlatch_14.xtail.S1 POLN VSS VSS sg13_lv_nmos ad=1.5637p pd=8.61u as=2.7982p ps=17.14u w=8.23u l=0.13u
X1643 cml_tlatch_82.xmux.xp.S1 CKB2_N cml_tlatch_82.xtail.S1 VSS sg13_lv_nmos ad=89.3f pd=0.85u as=89.3f ps=0.85u w=0.47u l=0.16u
X1644 cml_tlatch_19.xmux.xp.S1 A1_8_N A1_8_P VSS sg13_lv_nmos ad=56.9f pd=0.74u as=56.9f ps=0.74u w=0.17u l=0.17u
X1645 cml_tlatch_96.xtail.S1 CKB1_N cml_tlatch_96.xmux.xn.S1 VSS sg13_lv_nmos ad=89.3f pd=0.85u as=0.1598p ps=1.62u w=0.47u l=0.16u
X1646 cml_tlatch_49.xmux.xn.S1 B3_2_P cml_tlatch_49.OUTN VSS sg13_lv_nmos ad=63.19999f pd=0.74u as=63.19999f ps=0.74u w=0.26u l=0.38u
X1647 B1_8_P B1_8_N cml_tlatch_10.xmux.xp.S1 VSS sg13_lv_nmos ad=56.9f pd=0.74u as=56.9f ps=0.74u w=0.17u l=0.17u
X1648 cml_gate2_4.xrtail.R1 CKB3_P cml_gate2_4.xamp.xn.S1 VSS sg13_lv_nmos ad=0.1007p pd=0.91u as=0.1007p ps=0.91u w=0.53u l=0.13u
X1649 cml_tlatch_25.xmux.xp.S1 MOT14_N MOT14_P VSS sg13_lv_nmos ad=56.9f pd=0.74u as=56.9f ps=0.74u w=0.17u l=0.17u
X1650 cml_tlatch_50.xtail.S1 CKB3_N cml_tlatch_50.xmux.xn.S1 VSS sg13_lv_nmos ad=89.3f pd=0.85u as=89.3f ps=0.85u w=0.47u l=0.16u
X1651 cml_tlatch_69.xmux.xp.S1 CKA3_N cml_tlatch_69.xtail.S1 VSS sg13_lv_nmos ad=89.3f pd=0.85u as=0.1598p ps=1.62u w=0.47u l=0.16u
X1652 MOT3_P MOT3_N cml_tlatch_15.xmux.xp.S1 VSS sg13_lv_nmos ad=56.9f pd=0.74u as=56.9f ps=0.74u w=0.17u l=0.17u
X1653 cml_tlatch_7.OUTP cml_tlatch_8.OUTN cml_tlatch_7.xmux.xn.S1 VSS sg13_lv_nmos ad=63.19999f pd=0.74u as=63.19999f ps=0.74u w=0.26u l=0.38u
X1654 cml_tlatch_88.xmux.xp.S1 cml_tlatch_74.INN cml_tlatch_74.INP VSS sg13_lv_nmos ad=0.1019p pd=1.34u as=56.9f ps=0.74u w=0.17u l=0.17u
X1655 VDD cml_tlatch_20.OUTN VSS rppd l=5.17u w=1u
X1656 cml_tlatch_2.OUTN cml_tlatch_2.OUTP cml_tlatch_2.xmux.xp.S1 VSS sg13_lv_nmos ad=56.9f pd=0.74u as=56.9f ps=0.74u w=0.17u l=0.17u
X1657 cml_tlatch_5.xtail.S1 CKHB1_N cml_tlatch_5.xmux.xp.S1 VSS sg13_lv_nmos ad=89.3f pd=0.85u as=89.3f ps=0.85u w=0.47u l=0.16u
X1658 cml_tlatch_35.xmux.xp.S1 stub_bi_29.BOTP stub_bi_29.BOTN VSS sg13_lv_nmos ad=56.9f pd=0.74u as=56.9f ps=0.74u w=0.17u l=0.17u
X1659 cml_tlatch_98.xtail.S1 CKB0_P cml_tlatch_98.xmux.xp.S1 VSS sg13_lv_nmos ad=89.3f pd=0.85u as=89.3f ps=0.85u w=0.47u l=0.16u
X1660 cml_tlatch_33.xmux.xp.S1 CKA0_N cml_tlatch_33.xtail.S1 VSS sg13_lv_nmos ad=89.3f pd=0.85u as=89.3f ps=0.85u w=0.47u l=0.16u
X1661 cml_tlatch_12.xmux.xp.S1 cml_tlatch_4.INN cml_tlatch_4.INP VSS sg13_lv_nmos ad=0.1019p pd=1.34u as=56.9f ps=0.74u w=0.17u l=0.17u
X1662 cml_tlatch_68.xtail.S1 CKA3_P cml_tlatch_68.xmux.xp.S1 VSS sg13_lv_nmos ad=89.3f pd=0.85u as=89.3f ps=0.85u w=0.47u l=0.16u
X1663 cml_tlatch_5.INP cml_tlatch_5.INN cml_tlatch_96.xmux.xp.S1 VSS sg13_lv_nmos ad=56.9f pd=0.74u as=56.9f ps=0.74u w=0.17u l=0.17u
X1664 cml_tlatch_99.OUTP cml_tlatch_99.OUTN cml_tlatch_99.xmux.xp.S1 VSS sg13_lv_nmos ad=56.9f pd=0.74u as=56.9f ps=0.74u w=0.17u l=0.17u
X1665 cml_tlatch_15.xmux.xn.S1 cml_tlatch_7.OUTN MOT3_P VSS sg13_lv_nmos ad=63.19999f pd=0.74u as=63.19999f ps=0.74u w=0.26u l=0.38u
X1666 MOT1_N MOT1_P cml_tlatch_14.xmux.xp.S1 VSS sg13_lv_nmos ad=56.9f pd=0.74u as=56.9f ps=0.74u w=0.17u l=0.17u
X1667 VSS POLN cml_tlatch_84.xtail.S1 VSS sg13_lv_nmos ad=1.5637p pd=8.61u as=1.5637p ps=8.61u w=8.23u l=0.13u
X1668 cml_tlatch_1.xtail.S1 CKB0_P cml_tlatch_1.xmux.xp.S1 VSS sg13_lv_nmos ad=89.3f pd=0.85u as=89.3f ps=0.85u w=0.47u l=0.16u
X1669 cml_tlatch_45.xmux.xp.S1 MOT30_P MOT30_N VSS sg13_lv_nmos ad=56.9f pd=0.74u as=56.9f ps=0.74u w=0.17u l=0.17u
X1670 cml_tlatch_41.xmux.xp.S1 CKA1_N cml_tlatch_41.xtail.S1 VSS sg13_lv_nmos ad=89.3f pd=0.85u as=89.3f ps=0.85u w=0.47u l=0.16u
X1671 MOT12_P MOT12_N cml_tlatch_24.xmux.xp.S1 VSS sg13_lv_nmos ad=56.9f pd=0.74u as=56.9f ps=0.74u w=0.17u l=0.17u
X1672 cml_tlatch_49.xtail.S1 CKB3_P cml_tlatch_49.xmux.xn.S1 VSS sg13_lv_nmos ad=89.3f pd=0.85u as=89.3f ps=0.85u w=0.47u l=0.16u
X1673 cml_tlatch_64.xtail.S1 CKB3_P cml_tlatch_64.xmux.xp.S1 VSS sg13_lv_nmos ad=0.1598p pd=1.62u as=89.3f ps=0.85u w=0.47u l=0.16u
X1674 cml_tlatch_76.xmux.xp.S1 cml_tlatch_87.INP cml_tlatch_87.INN VSS sg13_lv_nmos ad=56.9f pd=0.74u as=56.9f ps=0.74u w=0.17u l=0.17u
X1675 MOT14_N MOT14_P cml_tlatch_25.xmux.xp.S1 VSS sg13_lv_nmos ad=56.9f pd=0.74u as=56.9f ps=0.74u w=0.17u l=0.17u
X1676 cml_tlatch_52.xmux.xn.S1 A2_8_P MOT16_N VSS sg13_lv_nmos ad=63.19999f pd=0.74u as=63.19999f ps=0.74u w=0.26u l=0.38u
X1677 cml_tlatch_11.xmux.xp.S1 stub_bi_15.BOTP stub_bi_15.BOTN VSS sg13_lv_nmos ad=56.9f pd=0.74u as=56.9f ps=0.74u w=0.17u l=0.17u
X1678 VDD cml_tlatch_71.OUTP VSS rppd l=5.17u w=1u
X1679 cml_tlatch_69.OUTN cml_tlatch_63.INP cml_tlatch_69.xmux.xn.S1 VSS sg13_lv_nmos ad=63.19999f pd=0.74u as=63.19999f ps=0.74u w=0.26u l=0.38u
X1680 cml_tlatch_69.xtail.S1 CKA3_P cml_tlatch_69.xmux.xn.S1 VSS sg13_lv_nmos ad=89.3f pd=0.85u as=89.3f ps=0.85u w=0.47u l=0.16u
X1681 cml_tlatch_66.xmux.xp.S1 cml_tlatch_73.INP cml_tlatch_73.INN VSS sg13_lv_nmos ad=56.9f pd=0.74u as=56.9f ps=0.74u w=0.17u l=0.17u
X1682 cml_drvb_4.xrtail.R2 VSS VSS rppd l=2.72u w=1u
X1683 cml_tlatch_98.OUTN cml_tlatch_30.OUTP cml_tlatch_98.xmux.xn.S1 VSS sg13_lv_nmos ad=63.19999f pd=0.74u as=63.19999f ps=0.74u w=0.26u l=0.38u
X1684 cml_tlatch_87.xtail.S1 CKA2_P cml_tlatch_87.xmux.xp.S1 VSS sg13_lv_nmos ad=89.3f pd=0.85u as=89.3f ps=0.85u w=0.47u l=0.16u
X1685 cml_tlatch_34.xtail.S1 CKA0_P cml_tlatch_34.xmux.xp.S1 VSS sg13_lv_nmos ad=89.3f pd=0.85u as=89.3f ps=0.85u w=0.47u l=0.16u
X1686 cml_tlatch_17.xmux.xp.S1 MOT7_P MOT7_N VSS sg13_lv_nmos ad=56.9f pd=0.74u as=56.9f ps=0.74u w=0.17u l=0.17u
X1687 cml_tlatch_59.xmux.xn.S1 A2_2_P cml_tlatch_91.INN VSS sg13_lv_nmos ad=63.19999f pd=0.74u as=63.19999f ps=0.74u w=0.26u l=0.38u
X1688 cml_tlatch_77.xtail.S1 POLN VSS VSS sg13_lv_nmos ad=1.5637p pd=8.61u as=2.7982p ps=17.14u w=8.23u l=0.13u
X1689 GB3_N ENB0_P cml_gate2_6.xamp.xn.S1 VSS sg13_lv_nmos ad=0.1802p pd=1.74u as=0.1007p ps=0.91u w=0.53u l=0.13u
X1690 cml_tlatch_4.xmux.xp.S1 MOT11_P MOT11_N VSS sg13_lv_nmos ad=56.9f pd=0.74u as=56.9f ps=0.74u w=0.17u l=0.17u
X1691 cml_tlatch_39.xmux.xp.S1 cml_tlatch_97.INP cml_tlatch_97.INN VSS sg13_lv_nmos ad=56.9f pd=0.74u as=56.9f ps=0.74u w=0.17u l=0.17u
X1692 cml_gate2_5.xamp.xn.S1 ENA1_N GA2_P VSS sg13_lv_nmos ad=0.1007p pd=0.91u as=0.1007p ps=0.91u w=0.53u l=0.13u
X1693 cml_tlatch_54.xtail.S1 CKHA2_N cml_tlatch_54.xmux.xp.S1 VSS sg13_lv_nmos ad=89.3f pd=0.85u as=89.3f ps=0.85u w=0.47u l=0.16u
X1694 cml_tlatch_40.xmux.xp.S1 A1_2_P A1_2_N VSS sg13_lv_nmos ad=56.9f pd=0.74u as=56.9f ps=0.74u w=0.17u l=0.17u
X1695 J1_N J4_N cml_tlatch_95.xmux.xn.S1 VSS sg13_lv_nmos ad=63.19999f pd=0.74u as=63.19999f ps=0.74u w=0.26u l=0.38u
X1696 A2_8_N A2_8_P cml_tlatch_85.xmux.xp.S1 VSS sg13_lv_nmos ad=56.9f pd=0.74u as=56.9f ps=0.74u w=0.17u l=0.17u
X1697 cml_tlatch_31.xmux.xp.S1 B0_2_N B0_2_P VSS sg13_lv_nmos ad=56.9f pd=0.74u as=56.9f ps=0.74u w=0.17u l=0.17u
X1698 MOT8_N MOT8_P cml_tlatch_42.xmux.xp.S1 VSS sg13_lv_nmos ad=56.9f pd=0.74u as=56.9f ps=0.74u w=0.17u l=0.17u
X1699 cml_tlatch_56.xmux.xp.S1 CKA3_N cml_tlatch_56.xtail.S1 VSS sg13_lv_nmos ad=0.1598p pd=1.62u as=89.3f ps=0.85u w=0.47u l=0.16u
X1700 cml_tlatch_68.xmux.xn.S1 cml_tlatch_69.OUTP A3_8_N VSS sg13_lv_nmos ad=63.19999f pd=0.74u as=63.19999f ps=0.74u w=0.26u l=0.38u
X1701 MOT28_P MOT28_N cml_tlatch_44.xmux.xp.S1 VSS sg13_lv_nmos ad=56.9f pd=0.74u as=56.9f ps=0.74u w=0.17u l=0.17u
X1702 cml_tlatch_80.xmux.xp.S1 CKHB2_N cml_tlatch_80.xtail.S1 VSS sg13_lv_nmos ad=0.1598p pd=1.62u as=89.3f ps=0.85u w=0.47u l=0.16u
X1703 cml_tlatch_26.xtail.S1 CKHA0_N cml_tlatch_26.xmux.xp.S1 VSS sg13_lv_nmos ad=89.3f pd=0.85u as=89.3f ps=0.85u w=0.47u l=0.16u
X1704 cml_tlatch_83.xtail.S1 CKB2_P cml_tlatch_83.xmux.xp.S1 VSS sg13_lv_nmos ad=89.3f pd=0.85u as=89.3f ps=0.85u w=0.47u l=0.16u
X1705 cml_tlatch_30.OUTN B0_2_P cml_tlatch_30.xmux.xn.S1 VSS sg13_lv_nmos ad=63.19999f pd=0.74u as=63.19999f ps=0.74u w=0.26u l=0.38u
X1706 cml_tlatch_93.xmux.xp.S1 CLK_W_P CLK_W_N VSS sg13_lv_nmos ad=56.9f pd=0.74u as=56.9f ps=0.74u w=0.17u l=0.17u
X1707 cml_tlatch_70.xtail.S1 CKA3_P cml_tlatch_70.xmux.xp.S1 VSS sg13_lv_nmos ad=89.3f pd=0.85u as=89.3f ps=0.85u w=0.47u l=0.16u
X1708 MOT17_P MOT17_N cml_tlatch_77.xmux.xp.S1 VSS sg13_lv_nmos ad=56.9f pd=0.74u as=56.9f ps=0.74u w=0.17u l=0.17u
X1709 cml_tlatch_23.xmux.xn.S1 CKA0_N cml_tlatch_23.xtail.S1 VSS sg13_lv_nmos ad=0.1598p pd=1.62u as=89.3f ps=0.85u w=0.47u l=0.16u
X1710 cml_tlatch_94.xmux.xn.S1 CKJ_N cml_tlatch_94.xtail.S1 VSS sg13_lv_nmos ad=0.1598p pd=1.62u as=89.3f ps=0.85u w=0.47u l=0.16u
X1711 cml_tlatch_43.xmux.xn.S1 CKHA1_P cml_tlatch_43.xtail.S1 VSS sg13_lv_nmos ad=89.3f pd=0.85u as=89.3f ps=0.85u w=0.47u l=0.16u
X1712 cml_tlatch_61.xmux.xp.S1 cml_tlatch_61.OUTP cml_tlatch_61.OUTN VSS sg13_lv_nmos ad=0.1019p pd=1.34u as=56.9f ps=0.74u w=0.17u l=0.17u
X1713 J2_N J2_P cml_tlatch_94.xmux.xp.S1 VSS sg13_lv_nmos ad=56.9f pd=0.74u as=56.9f ps=0.74u w=0.17u l=0.17u
X1714 cml_tlatch_80.xmux.xp.S1 MOT23_P MOT23_N VSS sg13_lv_nmos ad=56.9f pd=0.74u as=56.9f ps=0.74u w=0.17u l=0.17u
X1715 cml_tlatch_74.xtail.S1 CKHB3_P cml_tlatch_74.xmux.xn.S1 VSS sg13_lv_nmos ad=89.3f pd=0.85u as=89.3f ps=0.85u w=0.47u l=0.16u
X1716 cml_tlatch_40.xmux.xp.S1 A1_2_P A1_2_N VSS sg13_lv_nmos ad=56.9f pd=0.74u as=56.9f ps=0.74u w=0.17u l=0.17u
X1717 cml_tlatch_87.OUTP cml_tlatch_87.INN cml_tlatch_87.xmux.xn.S1 VSS sg13_lv_nmos ad=63.19999f pd=0.74u as=63.19999f ps=0.74u w=0.26u l=0.38u
X1718 cml_tlatch_91.INP cml_tlatch_91.INN cml_tlatch_59.xmux.xp.S1 VSS sg13_lv_nmos ad=56.9f pd=0.74u as=56.9f ps=0.74u w=0.17u l=0.17u
X1719 MOT4_N MOT4_P cml_tlatch_28.xmux.xp.S1 VSS sg13_lv_nmos ad=56.9f pd=0.74u as=0.1019p ps=1.34u w=0.17u l=0.17u
X1720 stub_bi_62.BOTN stub_bi_63.BOTP cml_tlatch_82.xmux.xn.S1 VSS sg13_lv_nmos ad=63.19999f pd=0.74u as=63.19999f ps=0.74u w=0.26u l=0.38u
X1721 cml_tlatch_33.xmux.xp.S1 cml_tlatch_33.OUTP cml_tlatch_33.OUTN VSS sg13_lv_nmos ad=56.9f pd=0.74u as=56.9f ps=0.74u w=0.17u l=0.17u
X1722 cml_tlatch_21.xmux.xn.S1 cml_tlatch_22.OUTP cml_tlatch_43.INN VSS sg13_lv_nmos ad=63.19999f pd=0.74u as=63.19999f ps=0.74u w=0.26u l=0.38u
X1723 ENB1_P ENB_N cml_drv_0.xrtail.R1 VSS sg13_lv_nmos ad=0.1012p pd=1.34u as=56.2f ps=0.74u w=0.16u l=0.19u
X1724 cml_tlatch_80.xmux.xp.S1 MOT23_N MOT23_P VSS sg13_lv_nmos ad=56.9f pd=0.74u as=56.9f ps=0.74u w=0.17u l=0.17u
X1725 cml_tlatch_2.OUTN cml_tlatch_2.OUTP cml_tlatch_2.xmux.xp.S1 VSS sg13_lv_nmos ad=56.9f pd=0.74u as=56.9f ps=0.74u w=0.17u l=0.17u
X1726 cml_tlatch_65.OUTP cml_tlatch_65.OUTN cml_tlatch_65.xmux.xp.S1 VSS sg13_lv_nmos ad=56.9f pd=0.74u as=56.9f ps=0.74u w=0.17u l=0.17u
X1727 cml_tlatch_14.xmux.xp.S1 MOT1_N MOT1_P VSS sg13_lv_nmos ad=56.9f pd=0.74u as=56.9f ps=0.74u w=0.17u l=0.17u
X1728 cml_tlatch_37.xmux.xp.S1 stub_bi_31.BOTP stub_bi_31.BOTN VSS sg13_lv_nmos ad=56.9f pd=0.74u as=56.9f ps=0.74u w=0.17u l=0.17u
X1729 cml_tlatch_13.xtail.S1 POLN VSS VSS sg13_lv_nmos ad=1.5637p pd=8.61u as=1.5637p ps=8.61u w=8.23u l=0.13u
X1730 cml_tlatch_34.xmux.xp.S1 A0_2_P A0_2_N VSS sg13_lv_nmos ad=56.9f pd=0.74u as=56.9f ps=0.74u w=0.17u l=0.17u
X1731 cml_gate2_4.xamp.xn.S1 ENA1_P GA3_N VSS sg13_lv_nmos ad=0.1007p pd=0.91u as=0.1007p ps=0.91u w=0.53u l=0.13u
X1732 cml_tlatch_52.xmux.xp.S1 MOT16_N MOT16_P VSS sg13_lv_nmos ad=56.9f pd=0.74u as=56.9f ps=0.74u w=0.17u l=0.17u
X1733 cml_tlatch_3.xmux.xn.S1 B1_8_N MOT9_P VSS sg13_lv_nmos ad=63.19999f pd=0.74u as=63.19999f ps=0.74u w=0.26u l=0.38u
X1734 A3_2_P cml_tlatch_58.OUTN cml_tlatch_57.xmux.xn.S1 VSS sg13_lv_nmos ad=63.19999f pd=0.74u as=63.19999f ps=0.74u w=0.26u l=0.38u
X1735 cml_tlatch_94.xmux.xn.S1 J1_P J2_N VSS sg13_lv_nmos ad=63.19999f pd=0.74u as=63.19999f ps=0.74u w=0.26u l=0.38u
X1736 cml_tlatch_51.xmux.xn.S1 CKB3_P cml_tlatch_51.xtail.S1 VSS sg13_lv_nmos ad=89.3f pd=0.85u as=89.3f ps=0.85u w=0.47u l=0.16u
X1737 cml_tlatch_23.xmux.xp.S1 cml_tlatch_23.OUTN cml_tlatch_23.OUTP VSS sg13_lv_nmos ad=56.9f pd=0.74u as=56.9f ps=0.74u w=0.17u l=0.17u
X1738 cml_tlatch_3.xmux.xp.S1 MOT9_P MOT9_N VSS sg13_lv_nmos ad=56.9f pd=0.74u as=56.9f ps=0.74u w=0.17u l=0.17u
X1739 cml_tlatch_27.xmux.xp.S1 MOT2_P MOT2_N VSS sg13_lv_nmos ad=56.9f pd=0.74u as=56.9f ps=0.74u w=0.17u l=0.17u
X1740 cml_tlatch_53.xmux.xn.S1 CKHA2_P cml_tlatch_53.xtail.S1 VSS sg13_lv_nmos ad=89.3f pd=0.85u as=89.3f ps=0.85u w=0.47u l=0.16u
X1741 MOT21_P MOT21_N cml_tlatch_79.xmux.xp.S1 VSS sg13_lv_nmos ad=56.9f pd=0.74u as=56.9f ps=0.74u w=0.17u l=0.17u
X1742 cml_tlatch_74.xmux.xp.S1 MOT29_N MOT29_P VSS sg13_lv_nmos ad=56.9f pd=0.74u as=56.9f ps=0.74u w=0.17u l=0.17u
X1743 cml_tlatch_79.xtail.S1 POLN VSS VSS sg13_lv_nmos ad=1.5637p pd=8.61u as=1.5637p ps=8.61u w=8.23u l=0.13u
X1744 cml_tlatch_62.xmux.xp.S1 MOT24_P MOT24_N VSS sg13_lv_nmos ad=56.9f pd=0.74u as=56.9f ps=0.74u w=0.17u l=0.17u
X1745 cml_tlatch_47.xmux.xp.S1 CKB2_P cml_tlatch_47.xtail.S1 VSS sg13_lv_nmos ad=89.3f pd=0.85u as=89.3f ps=0.85u w=0.47u l=0.16u
X1746 cml_tlatch_86.xmux.xp.S1 cml_tlatch_86.OUTP cml_tlatch_86.OUTN VSS sg13_lv_nmos ad=56.9f pd=0.74u as=56.9f ps=0.74u w=0.17u l=0.17u
X1747 CKHA0_N GA0_P cml_drvb_3.xrtail.R2 VSS sg13_lv_nmos ad=0.2618p pd=2.22u as=0.1463p ps=1.15u w=0.77u l=0.21u
X1748 cml_tlatch_43.xtail.S1 CKHA1_N cml_tlatch_43.xmux.xp.S1 VSS sg13_lv_nmos ad=0.1598p pd=1.62u as=89.3f ps=0.85u w=0.47u l=0.16u
X1749 cml_tlatch_97.xmux.xp.S1 CKA1_P cml_tlatch_97.xtail.S1 VSS sg13_lv_nmos ad=89.3f pd=0.85u as=89.3f ps=0.85u w=0.47u l=0.16u
X1750 cml_tlatch_57.xmux.xp.S1 CKA3_P cml_tlatch_57.xtail.S1 VSS sg13_lv_nmos ad=89.3f pd=0.85u as=89.3f ps=0.85u w=0.47u l=0.16u
X1751 MOT7_P MOT7_N cml_tlatch_17.xmux.xp.S1 VSS sg13_lv_nmos ad=56.9f pd=0.74u as=56.9f ps=0.74u w=0.17u l=0.17u
X1752 MOT26_P cml_tlatch_63.INN cml_tlatch_63.xmux.xn.S1 VSS sg13_lv_nmos ad=63.19999f pd=0.74u as=63.19999f ps=0.74u w=0.26u l=0.38u
X1753 MOT12_P MOT12_N cml_tlatch_24.xmux.xp.S1 VSS sg13_lv_nmos ad=56.9f pd=0.74u as=56.9f ps=0.74u w=0.17u l=0.17u
X1754 cml_tlatch_19.xtail.S1 CKA1_N cml_tlatch_19.xmux.xn.S1 VSS sg13_lv_nmos ad=89.3f pd=0.85u as=89.3f ps=0.85u w=0.47u l=0.16u
X1755 cml_tlatch_44.INN cml_tlatch_44.INP cml_tlatch_89.xmux.xp.S1 VSS sg13_lv_nmos ad=56.9f pd=0.74u as=56.9f ps=0.74u w=0.17u l=0.17u
X1756 cml_tlatch_38.OUTP cml_tlatch_38.OUTN cml_tlatch_38.xmux.xp.S1 VSS sg13_lv_nmos ad=56.9f pd=0.74u as=0.1019p ps=1.34u w=0.17u l=0.17u
X1757 MOT7_P B0_2_N cml_tlatch_17.xmux.xn.S1 VSS sg13_lv_nmos ad=63.19999f pd=0.74u as=0.1082p ps=1.34u w=0.26u l=0.38u
X1758 cml_tlatch_25.xtail.S1 CKHA1_N cml_tlatch_25.xmux.xp.S1 VSS sg13_lv_nmos ad=89.3f pd=0.85u as=89.3f ps=0.85u w=0.47u l=0.16u
X1759 cml_tlatch_63.xmux.xn.S1 CKHA3_P cml_tlatch_63.xtail.S1 VSS sg13_lv_nmos ad=89.3f pd=0.85u as=89.3f ps=0.85u w=0.47u l=0.16u
X1760 cml_tlatch_73.xmux.xp.S1 CKHB3_N cml_tlatch_73.xtail.S1 VSS sg13_lv_nmos ad=89.3f pd=0.85u as=89.3f ps=0.85u w=0.47u l=0.16u
X1761 cml_tlatch_77.xmux.xp.S1 CKHB2_N cml_tlatch_77.xtail.S1 VSS sg13_lv_nmos ad=0.1598p pd=1.62u as=89.3f ps=0.85u w=0.47u l=0.16u
X1762 VSS hs_to_clk_7.sg13_lv_nmos_2HGZLP_0.G VSS VSS sg13_lv_nmos ad=2.071p pd=11.28u as=0 ps=0 w=10.9u l=1.38u
X1763 cml_tlatch_16.xmux.xp.S1 MOT5_P MOT5_N VSS sg13_lv_nmos ad=56.9f pd=0.74u as=56.9f ps=0.74u w=0.17u l=0.17u
X1764 A1_2_P A1_2_N cml_tlatch_40.xmux.xp.S1 VSS sg13_lv_nmos ad=56.9f pd=0.74u as=56.9f ps=0.74u w=0.17u l=0.17u
X1765 VDD A3_8_N VSS rppd l=5.17u w=1u
X1766 cml_tlatch_58.xtail.S1 CKA3_N cml_tlatch_58.xmux.xp.S1 VSS sg13_lv_nmos ad=89.3f pd=0.85u as=89.3f ps=0.85u w=0.47u l=0.16u
X1767 stub_bi_55.BOTN stub_bi_55.BOTP cml_tlatch_90.xmux.xp.S1 VSS sg13_lv_nmos ad=56.9f pd=0.74u as=56.9f ps=0.74u w=0.17u l=0.17u
X1768 cml_tlatch_17.xmux.xn.S1 B0_2_P MOT7_N VSS sg13_lv_nmos ad=63.19999f pd=0.74u as=63.19999f ps=0.74u w=0.26u l=0.38u
X1769 cml_tlatch_72.xmux.xp.S1 MOT25_P MOT25_N VSS sg13_lv_nmos ad=56.9f pd=0.74u as=56.9f ps=0.74u w=0.17u l=0.17u
X1770 MOT0_N A0_8_P cml_tlatch_26.xmux.xn.S1 VSS sg13_lv_nmos ad=0.1082p pd=1.34u as=63.19999f ps=0.74u w=0.26u l=0.38u
X1771 cml_tlatch_76.xmux.xn.S1 CKA2_P cml_tlatch_76.xtail.S1 VSS sg13_lv_nmos ad=89.3f pd=0.85u as=89.3f ps=0.85u w=0.47u l=0.16u
X1772 cml_tlatch_10.xtail.S1 CKB1_N cml_tlatch_10.xmux.xn.S1 VSS sg13_lv_nmos ad=89.3f pd=0.85u as=89.3f ps=0.85u w=0.47u l=0.16u
X1773 cml_tlatch_31.xmux.xp.S1 B0_2_N B0_2_P VSS sg13_lv_nmos ad=56.9f pd=0.74u as=56.9f ps=0.74u w=0.17u l=0.17u
X1774 cml_tlatch_97.xmux.xn.S1 cml_tlatch_97.INP cml_tlatch_24.INN VSS sg13_lv_nmos ad=63.19999f pd=0.74u as=63.19999f ps=0.74u w=0.26u l=0.38u
X1775 cml_tlatch_33.OUTP cml_tlatch_33.OUTN cml_tlatch_33.xmux.xp.S1 VSS sg13_lv_nmos ad=56.9f pd=0.74u as=56.9f ps=0.74u w=0.17u l=0.17u
X1776 cml_tlatch_67.xmux.xn.S1 cml_tlatch_74.INN cml_tlatch_67.OUTP VSS sg13_lv_nmos ad=63.19999f pd=0.74u as=63.19999f ps=0.74u w=0.26u l=0.38u
X1777 cml_tlatch_81.xmux.xp.S1 B2_8_P B2_8_N VSS sg13_lv_nmos ad=0.1019p pd=1.34u as=56.9f ps=0.74u w=0.17u l=0.17u
X1778 cml_gate2_1.xrtail.R1 CKA0_N GB0_P VSS sg13_lv_nmos ad=0.1007p pd=0.91u as=0.1007p ps=0.91u w=0.53u l=0.13u
X1779 stub_bi_49.BOTN stub_bi_49.BOTP cml_tlatch_84.xmux.xp.S1 VSS sg13_lv_nmos ad=56.9f pd=0.74u as=56.9f ps=0.74u w=0.17u l=0.17u
X1780 cml_gate2_8.xamp.xn.S1 J2_N ENB_P VSS sg13_lv_nmos ad=0.1007p pd=0.91u as=0.1007p ps=0.91u w=0.53u l=0.13u
X1781 cml_tlatch_82.xmux.xp.S1 stub_bi_62.BOTP stub_bi_62.BOTN VSS sg13_lv_nmos ad=56.9f pd=0.74u as=56.9f ps=0.74u w=0.17u l=0.17u
X1782 cml_tlatch_19.xmux.xn.S1 cml_tlatch_20.OUTN A1_8_P VSS sg13_lv_nmos ad=63.19999f pd=0.74u as=63.19999f ps=0.74u w=0.26u l=0.38u
X1783 VDD MOT17_P VSS rppd l=5.17u w=1u
X1784 MOT17_P MOT17_N cml_tlatch_77.xmux.xp.S1 VSS sg13_lv_nmos ad=56.9f pd=0.74u as=56.9f ps=0.74u w=0.17u l=0.17u
X1785 cml_tlatch_97.xmux.xp.S1 cml_tlatch_24.INP cml_tlatch_24.INN VSS sg13_lv_nmos ad=56.9f pd=0.74u as=56.9f ps=0.74u w=0.17u l=0.17u
X1786 cml_tlatch_36.xmux.xn.S1 stub_bi_31.BOTN B1_2_N VSS sg13_lv_nmos ad=0.1082p pd=1.34u as=63.19999f ps=0.74u w=0.26u l=0.38u
X1787 cml_tlatch_85.xmux.xp.S1 A2_8_N A2_8_P VSS sg13_lv_nmos ad=56.9f pd=0.74u as=56.9f ps=0.74u w=0.17u l=0.17u
X1788 cml_tlatch_51.OUTP cml_tlatch_51.OUTN cml_tlatch_51.xmux.xp.S1 VSS sg13_lv_nmos ad=56.9f pd=0.74u as=56.9f ps=0.74u w=0.17u l=0.17u
X1789 cml_tlatch_72.xmux.xp.S1 MOT25_N MOT25_P VSS sg13_lv_nmos ad=56.9f pd=0.74u as=56.9f ps=0.74u w=0.17u l=0.17u
X1790 cml_tlatch_6.xmux.xn.S1 B1_2_N MOT15_P VSS sg13_lv_nmos ad=0.1082p pd=1.34u as=63.19999f ps=0.74u w=0.26u l=0.38u
X1791 A3_2_P A3_2_N cml_tlatch_57.xmux.xp.S1 VSS sg13_lv_nmos ad=56.9f pd=0.74u as=56.9f ps=0.74u w=0.17u l=0.17u
X1792 MOT31_N MOT31_P cml_tlatch_75.xmux.xp.S1 VSS sg13_lv_nmos ad=56.9f pd=0.74u as=56.9f ps=0.74u w=0.17u l=0.17u
X1793 cml_tlatch_32.xmux.xp.S1 cml_tlatch_32.OUTP cml_tlatch_32.OUTN VSS sg13_lv_nmos ad=0.1019p pd=1.34u as=56.9f ps=0.74u w=0.17u l=0.17u
X1794 cml_tlatch_49.xmux.xn.S1 CKB3_P cml_tlatch_49.xtail.S1 VSS sg13_lv_nmos ad=89.3f pd=0.85u as=89.3f ps=0.85u w=0.47u l=0.16u
X1795 cml_tlatch_74.xtail.S1 CKHB3_N cml_tlatch_74.xmux.xp.S1 VSS sg13_lv_nmos ad=0.1598p pd=1.62u as=89.3f ps=0.85u w=0.47u l=0.16u
X1796 cml_tlatch_28.xmux.xn.S1 CKHA0_P cml_tlatch_28.xtail.S1 VSS sg13_lv_nmos ad=89.3f pd=0.85u as=89.3f ps=0.85u w=0.47u l=0.16u
X1797 cml_tlatch_22.OUTN cml_tlatch_22.OUTP cml_tlatch_22.xmux.xp.S1 VSS sg13_lv_nmos ad=56.9f pd=0.74u as=56.9f ps=0.74u w=0.17u l=0.17u
X1798 MOT4_N MOT4_P cml_tlatch_28.xmux.xp.S1 VSS sg13_lv_nmos ad=56.9f pd=0.74u as=56.9f ps=0.74u w=0.17u l=0.17u
X1799 cml_tlatch_46.xmux.xp.S1 stub_bi_38.BOTP stub_bi_38.BOTN VSS sg13_lv_nmos ad=0.1019p pd=1.34u as=56.9f ps=0.74u w=0.17u l=0.17u
X1800 stub_bi_63.BOTP stub_bi_63.BOTN cml_tlatch_83.xmux.xp.S1 VSS sg13_lv_nmos ad=56.9f pd=0.74u as=56.9f ps=0.74u w=0.17u l=0.17u
X1801 cml_tlatch_58.OUTN D3_P cml_tlatch_58.xmux.xn.S1 VSS sg13_lv_nmos ad=63.19999f pd=0.74u as=63.19999f ps=0.74u w=0.26u l=0.38u
X1802 cml_tlatch_67.OUTN cml_tlatch_74.INP cml_tlatch_67.xmux.xn.S1 VSS sg13_lv_nmos ad=63.19999f pd=0.74u as=63.19999f ps=0.74u w=0.26u l=0.38u
X1803 cml_tlatch_62.xmux.xn.S1 A3_8_N MOT24_P VSS sg13_lv_nmos ad=63.19999f pd=0.74u as=63.19999f ps=0.74u w=0.26u l=0.38u
X1804 cml_tlatch_8.OUTP cml_tlatch_8.OUTN cml_tlatch_8.xmux.xp.S1 VSS sg13_lv_nmos ad=56.9f pd=0.74u as=56.9f ps=0.74u w=0.17u l=0.17u
X1805 cml_tlatch_55.xtail.S1 CKHA2_N cml_tlatch_55.xmux.xp.S1 VSS sg13_lv_nmos ad=89.3f pd=0.85u as=89.3f ps=0.85u w=0.47u l=0.16u
X1806 cml_tlatch_30.OUTN cml_tlatch_30.OUTP cml_tlatch_30.xmux.xp.S1 VSS sg13_lv_nmos ad=56.9f pd=0.74u as=0.1019p ps=1.34u w=0.17u l=0.17u
X1807 cml_tlatch_20.OUTN cml_tlatch_20.OUTP cml_tlatch_20.xmux.xp.S1 VSS sg13_lv_nmos ad=56.9f pd=0.74u as=56.9f ps=0.74u w=0.17u l=0.17u
X1808 cml_tlatch_62.xmux.xn.S1 A3_8_N MOT24_P VSS sg13_lv_nmos ad=63.19999f pd=0.74u as=63.19999f ps=0.74u w=0.26u l=0.38u
X1809 cml_tlatch_80.xmux.xp.S1 MOT23_N MOT23_P VSS sg13_lv_nmos ad=56.9f pd=0.74u as=56.9f ps=0.74u w=0.17u l=0.17u
X1810 VDD cml_tlatch_18.OUTP VSS rppd l=5.17u w=1u
X1811 cml_tlatch_0.xmux.xp.S1 cml_tlatch_0.OUTP cml_tlatch_0.OUTN VSS sg13_lv_nmos ad=56.9f pd=0.74u as=56.9f ps=0.74u w=0.17u l=0.17u
X1812 stub_bi_15.BOTP cml_tlatch_4.INP cml_tlatch_11.xmux.xn.S1 VSS sg13_lv_nmos ad=63.19999f pd=0.74u as=63.19999f ps=0.74u w=0.26u l=0.38u
X1813 cml_tlatch_40.xtail.S1 CKA1_N cml_tlatch_40.xmux.xn.S1 VSS sg13_lv_nmos ad=89.3f pd=0.85u as=89.3f ps=0.85u w=0.47u l=0.16u
X1814 cml_tlatch_40.xmux.xp.S1 A1_2_N A1_2_P VSS sg13_lv_nmos ad=0.1019p pd=1.34u as=56.9f ps=0.74u w=0.17u l=0.17u
X1815 cml_tlatch_98.OUTP cml_tlatch_98.OUTN cml_tlatch_98.xmux.xp.S1 VSS sg13_lv_nmos ad=56.9f pd=0.74u as=56.9f ps=0.74u w=0.17u l=0.17u
X1816 cml_tlatch_5.xtail.S1 CKHB1_N cml_tlatch_5.xmux.xp.S1 VSS sg13_lv_nmos ad=89.3f pd=0.85u as=89.3f ps=0.85u w=0.47u l=0.16u
X1817 cml_tlatch_85.xmux.xn.S1 CKA2_N cml_tlatch_85.xtail.S1 VSS sg13_lv_nmos ad=89.3f pd=0.85u as=89.3f ps=0.85u w=0.47u l=0.16u
X1818 cml_tlatch_59.xmux.xp.S1 cml_tlatch_91.INP cml_tlatch_91.INN VSS sg13_lv_nmos ad=56.9f pd=0.74u as=56.9f ps=0.74u w=0.17u l=0.17u
X1819 cml_gate2_6.xrtail.R1 CKA3_P cml_gate2_6.xamp.xn.S1 VSS sg13_lv_nmos ad=0.1007p pd=0.91u as=0.1007p ps=0.91u w=0.53u l=0.13u
X1820 cml_tlatch_91.INP A2_2_N cml_tlatch_59.xmux.xn.S1 VSS sg13_lv_nmos ad=63.19999f pd=0.74u as=0.1082p ps=1.34u w=0.26u l=0.38u
X1821 cml_tlatch_28.xmux.xn.S1 cml_tlatch_99.OUTN MOT4_P VSS sg13_lv_nmos ad=63.19999f pd=0.74u as=63.19999f ps=0.74u w=0.26u l=0.38u
X1822 cml_tlatch_6.xmux.xp.S1 MOT15_N MOT15_P VSS sg13_lv_nmos ad=56.9f pd=0.74u as=56.9f ps=0.74u w=0.17u l=0.17u
X1823 cml_tlatch_98.xtail.S1 CKB0_P cml_tlatch_98.xmux.xp.S1 VSS sg13_lv_nmos ad=89.3f pd=0.85u as=89.3f ps=0.85u w=0.47u l=0.16u
X1824 GB2_P ENB0_N cml_gate2_7.xamp.xn.S1 VSS sg13_lv_nmos ad=0.1007p pd=0.91u as=0.1007p ps=0.91u w=0.53u l=0.13u
X1825 cml_tlatch_41.OUTN cml_tlatch_41.OUTP cml_tlatch_41.xmux.xp.S1 VSS sg13_lv_nmos ad=56.9f pd=0.74u as=56.9f ps=0.74u w=0.17u l=0.17u
X1826 cml_tlatch_82.xmux.xp.S1 stub_bi_62.BOTP stub_bi_62.BOTN VSS sg13_lv_nmos ad=56.9f pd=0.74u as=56.9f ps=0.74u w=0.17u l=0.17u
X1827 cml_tlatch_23.xmux.xp.S1 cml_tlatch_23.OUTN cml_tlatch_23.OUTP VSS sg13_lv_nmos ad=0.1019p pd=1.34u as=56.9f ps=0.74u w=0.17u l=0.17u
X1828 cml_tlatch_37.xmux.xp.S1 stub_bi_31.BOTN stub_bi_31.BOTP VSS sg13_lv_nmos ad=56.9f pd=0.74u as=56.9f ps=0.74u w=0.17u l=0.17u
X1829 cml_tlatch_28.xmux.xn.S1 cml_tlatch_99.OUTN MOT4_P VSS sg13_lv_nmos ad=63.19999f pd=0.74u as=63.19999f ps=0.74u w=0.26u l=0.38u
X1830 cml_tlatch_89.xmux.xp.S1 cml_tlatch_44.INN cml_tlatch_44.INP VSS sg13_lv_nmos ad=56.9f pd=0.74u as=56.9f ps=0.74u w=0.17u l=0.17u
X1831 GA0_P CKB0_N cml_gate2_3.xrtail.R1 VSS sg13_lv_nmos ad=0.1007p pd=0.91u as=0.1007p ps=0.91u w=0.53u l=0.13u
X1832 cml_tlatch_53.xmux.xp.S1 CKHA2_N cml_tlatch_53.xtail.S1 VSS sg13_lv_nmos ad=89.3f pd=0.85u as=89.3f ps=0.85u w=0.47u l=0.16u
X1833 cml_gate2_5.xamp.xn.S1 ENA1_P GA2_N VSS sg13_lv_nmos ad=0.1007p pd=0.91u as=0.1007p ps=0.91u w=0.53u l=0.13u
X1834 cml_tlatch_98.OUTN cml_tlatch_30.OUTP cml_tlatch_98.xmux.xn.S1 VSS sg13_lv_nmos ad=63.19999f pd=0.74u as=63.19999f ps=0.74u w=0.26u l=0.38u
X1835 cml_tlatch_1.xtail.S1 CKB0_P cml_tlatch_1.xmux.xp.S1 VSS sg13_lv_nmos ad=89.3f pd=0.85u as=89.3f ps=0.85u w=0.47u l=0.16u
X1836 cml_tlatch_38.OUTP D0_N cml_tlatch_38.xmux.xn.S1 VSS sg13_lv_nmos ad=63.19999f pd=0.74u as=63.19999f ps=0.74u w=0.26u l=0.38u
X1837 cml_tlatch_5.xtail.S1 POLN VSS VSS sg13_lv_nmos ad=1.5637p pd=8.61u as=2.7982p ps=17.14u w=8.23u l=0.13u
X1838 cml_tlatch_20.xmux.xp.S1 CKA1_N cml_tlatch_20.xtail.S1 VSS sg13_lv_nmos ad=89.3f pd=0.85u as=89.3f ps=0.85u w=0.47u l=0.16u
X1839 cml_tlatch_36.xtail.S1 CKB1_N cml_tlatch_36.xmux.xn.S1 VSS sg13_lv_nmos ad=89.3f pd=0.85u as=89.3f ps=0.85u w=0.47u l=0.16u
X1840 cml_tlatch_45.xmux.xn.S1 A3_2_N MOT30_P VSS sg13_lv_nmos ad=63.19999f pd=0.74u as=0.1082p ps=1.34u w=0.26u l=0.38u
X1841 MOT30_N A3_2_P cml_tlatch_45.xmux.xn.S1 VSS sg13_lv_nmos ad=63.19999f pd=0.74u as=63.19999f ps=0.74u w=0.26u l=0.38u
X1842 cml_tlatch_81.xmux.xp.S1 B2_8_N B2_8_P VSS sg13_lv_nmos ad=56.9f pd=0.74u as=56.9f ps=0.74u w=0.17u l=0.17u
X1843 cml_tlatch_48.xmux.xp.S1 stub_bi_43.BOTP stub_bi_43.BOTN VSS sg13_lv_nmos ad=56.9f pd=0.74u as=56.9f ps=0.74u w=0.17u l=0.17u
X1844 cml_tlatch_24.INP cml_tlatch_24.INN cml_tlatch_97.xmux.xp.S1 VSS sg13_lv_nmos ad=56.9f pd=0.74u as=56.9f ps=0.74u w=0.17u l=0.17u
X1845 cml_tlatch_29.xmux.xp.S1 MOT6_N MOT6_P VSS sg13_lv_nmos ad=56.9f pd=0.74u as=56.9f ps=0.74u w=0.17u l=0.17u
X1846 cml_tlatch_30.xmux.xp.S1 cml_tlatch_30.OUTN cml_tlatch_30.OUTP VSS sg13_lv_nmos ad=56.9f pd=0.74u as=56.9f ps=0.74u w=0.17u l=0.17u
X1847 A0_8_N cml_tlatch_18.OUTP cml_tlatch_9.xmux.xn.S1 VSS sg13_lv_nmos ad=0.1082p pd=1.34u as=63.19999f ps=0.74u w=0.26u l=0.38u
X1848 cml_tlatch_42.xtail.S1 CKHA1_P cml_tlatch_42.xmux.xn.S1 VSS sg13_lv_nmos ad=89.3f pd=0.85u as=89.3f ps=0.85u w=0.47u l=0.16u
X1849 cml_tlatch_30.OUTN cml_tlatch_30.OUTP cml_tlatch_30.xmux.xp.S1 VSS sg13_lv_nmos ad=56.9f pd=0.74u as=56.9f ps=0.74u w=0.17u l=0.17u
X1850 cml_tlatch_30.xtail.S1 CKB0_N cml_tlatch_30.xmux.xp.S1 VSS sg13_lv_nmos ad=89.3f pd=0.85u as=89.3f ps=0.85u w=0.47u l=0.16u
X1851 cml_tlatch_16.xmux.xp.S1 MOT5_P MOT5_N VSS sg13_lv_nmos ad=56.9f pd=0.74u as=56.9f ps=0.74u w=0.17u l=0.17u
X1852 cml_tlatch_21.xmux.xn.S1 CKA1_N cml_tlatch_21.xtail.S1 VSS sg13_lv_nmos ad=89.3f pd=0.85u as=89.3f ps=0.85u w=0.47u l=0.16u
X1853 cml_tlatch_52.xmux.xp.S1 CKHA2_N cml_tlatch_52.xtail.S1 VSS sg13_lv_nmos ad=89.3f pd=0.85u as=89.3f ps=0.85u w=0.47u l=0.16u
X1854 cml_tlatch_9.xtail.S1 POLN VSS VSS sg13_lv_nmos ad=1.5637p pd=8.61u as=2.7982p ps=17.14u w=8.23u l=0.13u
X1855 A0_8_N cml_tlatch_18.OUTP cml_tlatch_9.xmux.xn.S1 VSS sg13_lv_nmos ad=63.19999f pd=0.74u as=63.19999f ps=0.74u w=0.26u l=0.38u
X1856 cml_tlatch_32.xmux.xp.S1 CKB0_N cml_tlatch_32.xtail.S1 VSS sg13_lv_nmos ad=89.3f pd=0.85u as=89.3f ps=0.85u w=0.47u l=0.16u
X1857 cml_tlatch_8.xmux.xn.S1 CKB0_P cml_tlatch_8.xtail.S1 VSS sg13_lv_nmos ad=89.3f pd=0.85u as=89.3f ps=0.85u w=0.47u l=0.16u
X1858 cml_tlatch_23.xtail.S1 POLN VSS VSS sg13_lv_nmos ad=1.5637p pd=8.61u as=1.5637p ps=8.61u w=8.23u l=0.13u
X1859 cml_tlatch_24.INP cml_tlatch_24.INN cml_tlatch_97.xmux.xp.S1 VSS sg13_lv_nmos ad=56.9f pd=0.74u as=56.9f ps=0.74u w=0.17u l=0.17u
X1860 cml_drvb_6.xrtail.R2 VSS VSS rppd l=2.72u w=1u
X1861 cml_gate2_0.xamp.xn.S1 ENB1_N GB1_P VSS sg13_lv_nmos ad=0.1007p pd=0.91u as=0.1007p ps=0.91u w=0.53u l=0.13u
X1862 cml_tlatch_69.xmux.xp.S1 cml_tlatch_69.OUTP cml_tlatch_69.OUTN VSS sg13_lv_nmos ad=56.9f pd=0.74u as=56.9f ps=0.74u w=0.17u l=0.17u
X1863 MOT19_N MOT19_P cml_tlatch_78.xmux.xp.S1 VSS sg13_lv_nmos ad=56.9f pd=0.74u as=56.9f ps=0.74u w=0.17u l=0.17u
X1864 cml_tlatch_51.xtail.S1 CKB3_P cml_tlatch_51.xmux.xn.S1 VSS sg13_lv_nmos ad=89.3f pd=0.85u as=89.3f ps=0.85u w=0.47u l=0.16u
X1865 cml_tlatch_67.xmux.xp.S1 cml_tlatch_67.OUTP cml_tlatch_67.OUTN VSS sg13_lv_nmos ad=56.9f pd=0.74u as=56.9f ps=0.74u w=0.17u l=0.17u
X1866 cml_tlatch_73.xmux.xp.S1 MOT27_P MOT27_N VSS sg13_lv_nmos ad=56.9f pd=0.74u as=56.9f ps=0.74u w=0.17u l=0.17u
X1867 CKA2_P CK_P hs_to_clk_7.D2 VSS sg13_lv_nmos ad=0.228p pd=1.58u as=0.408p ps=3.08u w=1.2u l=0.2u
X1868 VSS POLN hs_to_clk_3.D2 VSS sg13_lv_nmos ad=1.9p pd=10.38u as=3.4p ps=20.68u w=10u l=0.13u
X1869 cml_tlatch_56.xmux.xp.S1 CKA3_N cml_tlatch_56.xtail.S1 VSS sg13_lv_nmos ad=89.3f pd=0.85u as=89.3f ps=0.85u w=0.47u l=0.16u
X1870 cml_gate2_4.xamp.xn.S1 CKB3_P cml_gate2_4.xrtail.R1 VSS sg13_lv_nmos ad=0.1007p pd=0.91u as=0.1007p ps=0.91u w=0.53u l=0.13u
X1871 GA1_N ENA0_P cml_gate2_2.xamp.xn.S1 VSS sg13_lv_nmos ad=0.1802p pd=1.74u as=0.1007p ps=0.91u w=0.53u l=0.13u
X1872 GB1_P ENB1_N cml_gate2_0.xamp.xn.S1 VSS sg13_lv_nmos ad=0.1007p pd=0.91u as=0.1007p ps=0.91u w=0.53u l=0.13u
X1873 cml_tlatch_43.xmux.xp.S1 CKHA1_N cml_tlatch_43.xtail.S1 VSS sg13_lv_nmos ad=89.3f pd=0.85u as=89.3f ps=0.85u w=0.47u l=0.16u
X1874 cml_tlatch_11.xmux.xp.S1 stub_bi_15.BOTN stub_bi_15.BOTP VSS sg13_lv_nmos ad=56.9f pd=0.74u as=56.9f ps=0.74u w=0.17u l=0.17u
X1875 cml_tlatch_60.xmux.xn.S1 CKA2_N cml_tlatch_60.xtail.S1 VSS sg13_lv_nmos ad=89.3f pd=0.85u as=89.3f ps=0.85u w=0.47u l=0.16u
X1876 MOT2_P cml_tlatch_23.OUTN cml_tlatch_27.xmux.xn.S1 VSS sg13_lv_nmos ad=63.19999f pd=0.74u as=63.19999f ps=0.74u w=0.26u l=0.38u
X1877 cml_tlatch_84.xmux.xp.S1 CKB2_N cml_tlatch_84.xtail.S1 VSS sg13_lv_nmos ad=89.3f pd=0.85u as=89.3f ps=0.85u w=0.47u l=0.16u
X1878 MOT6_N MOT6_P cml_tlatch_29.xmux.xp.S1 VSS sg13_lv_nmos ad=56.9f pd=0.74u as=56.9f ps=0.74u w=0.17u l=0.17u
X1879 cml_tlatch_66.xmux.xn.S1 cml_tlatch_67.OUTN cml_tlatch_73.INP VSS sg13_lv_nmos ad=0.1082p pd=1.34u as=63.19999f ps=0.74u w=0.26u l=0.38u
X1880 cml_tlatch_44.xtail.S1 CKHA3_N cml_tlatch_44.xmux.xp.S1 VSS sg13_lv_nmos ad=89.3f pd=0.85u as=89.3f ps=0.85u w=0.47u l=0.16u
X1881 cml_tlatch_48.xmux.xp.S1 stub_bi_43.BOTP stub_bi_43.BOTN VSS sg13_lv_nmos ad=56.9f pd=0.74u as=56.9f ps=0.74u w=0.17u l=0.17u
X1882 cml_tlatch_66.xmux.xn.S1 cml_tlatch_67.OUTN cml_tlatch_73.INP VSS sg13_lv_nmos ad=63.19999f pd=0.74u as=63.19999f ps=0.74u w=0.26u l=0.38u
X1883 cml_tlatch_8.OUTP cml_tlatch_8.OUTN cml_tlatch_8.xmux.xp.S1 VSS sg13_lv_nmos ad=56.9f pd=0.74u as=56.9f ps=0.74u w=0.17u l=0.17u
X1884 cml_tlatch_23.OUTN cml_tlatch_23.OUTP cml_tlatch_23.xmux.xp.S1 VSS sg13_lv_nmos ad=56.9f pd=0.74u as=56.9f ps=0.74u w=0.17u l=0.17u
X1885 cml_tlatch_55.xtail.S1 POLN VSS VSS sg13_lv_nmos ad=1.5637p pd=8.61u as=1.5637p ps=8.61u w=8.23u l=0.13u
X1886 cml_tlatch_32.xmux.xp.S1 cml_tlatch_32.OUTN cml_tlatch_32.OUTP VSS sg13_lv_nmos ad=56.9f pd=0.74u as=56.9f ps=0.74u w=0.17u l=0.17u
X1887 cml_tlatch_21.xmux.xn.S1 cml_tlatch_22.OUTN cml_tlatch_43.INP VSS sg13_lv_nmos ad=63.19999f pd=0.74u as=63.19999f ps=0.74u w=0.26u l=0.38u
X1888 cml_tlatch_53.xmux.xp.S1 MOT18_P MOT18_N VSS sg13_lv_nmos ad=56.9f pd=0.74u as=56.9f ps=0.74u w=0.17u l=0.17u
X1889 cml_tlatch_94.xmux.xp.S1 J2_N J2_P VSS sg13_lv_nmos ad=56.9f pd=0.74u as=56.9f ps=0.74u w=0.17u l=0.17u
X1890 MOT26_N MOT26_P cml_tlatch_63.xmux.xp.S1 VSS sg13_lv_nmos ad=56.9f pd=0.74u as=56.9f ps=0.74u w=0.17u l=0.17u
X1891 stub_bi_63.BOTP stub_bi_49.BOTN cml_tlatch_83.xmux.xn.S1 VSS sg13_lv_nmos ad=63.19999f pd=0.74u as=63.19999f ps=0.74u w=0.26u l=0.38u
X1892 A2_2_N A2_2_P cml_tlatch_60.xmux.xp.S1 VSS sg13_lv_nmos ad=56.9f pd=0.74u as=56.9f ps=0.74u w=0.17u l=0.17u
X1893 cml_tlatch_47.xmux.xp.S1 B2_2_P B2_2_N VSS sg13_lv_nmos ad=56.9f pd=0.74u as=56.9f ps=0.74u w=0.17u l=0.17u
X1894 cml_gate2_9.xamp.xn.S1 NM1_P cml_gate2_9.xrtail.R1 VSS sg13_lv_nmos ad=0.1007p pd=0.91u as=0.1007p ps=0.91u w=0.53u l=0.13u
X1895 B0_8_P B0_8_N cml_tlatch_1.xmux.xp.S1 VSS sg13_lv_nmos ad=56.9f pd=0.74u as=56.9f ps=0.74u w=0.17u l=0.17u
X1896 cml_tlatch_96.xmux.xn.S1 stub_bi_29.BOTP cml_tlatch_5.INP VSS sg13_lv_nmos ad=0.1082p pd=1.34u as=63.19999f ps=0.74u w=0.26u l=0.38u
X1897 cml_tlatch_35.xmux.xp.S1 CKB1_N cml_tlatch_35.xtail.S1 VSS sg13_lv_nmos ad=89.3f pd=0.85u as=89.3f ps=0.85u w=0.47u l=0.16u
X1898 cml_tlatch_4.xtail.S1 CKHB1_P cml_tlatch_4.xmux.xn.S1 VSS sg13_lv_nmos ad=89.3f pd=0.85u as=0.1598p ps=1.62u w=0.47u l=0.16u
X1899 cml_tlatch_37.xmux.xp.S1 stub_bi_31.BOTN stub_bi_31.BOTP VSS sg13_lv_nmos ad=56.9f pd=0.74u as=56.9f ps=0.74u w=0.17u l=0.17u
X1900 cml_tlatch_20.OUTP cml_tlatch_43.INN cml_tlatch_20.xmux.xn.S1 VSS sg13_lv_nmos ad=63.19999f pd=0.74u as=63.19999f ps=0.74u w=0.26u l=0.38u
X1901 cml_tlatch_89.xmux.xp.S1 cml_tlatch_44.INN cml_tlatch_44.INP VSS sg13_lv_nmos ad=56.9f pd=0.74u as=56.9f ps=0.74u w=0.17u l=0.17u
X1902 MOT29_N MOT29_P cml_tlatch_74.xmux.xp.S1 VSS sg13_lv_nmos ad=56.9f pd=0.74u as=56.9f ps=0.74u w=0.17u l=0.17u
X1903 cml_tlatch_74.INP cml_tlatch_74.INN cml_tlatch_88.xmux.xp.S1 VSS sg13_lv_nmos ad=56.9f pd=0.74u as=56.9f ps=0.74u w=0.17u l=0.17u
X1904 cml_gate2_6.xamp.xn.S1 ENB0_P GB3_N VSS sg13_lv_nmos ad=0.1007p pd=0.91u as=0.1007p ps=0.91u w=0.53u l=0.13u
X1905 A0_8_N A0_8_P cml_tlatch_9.xmux.xp.S1 VSS sg13_lv_nmos ad=56.9f pd=0.74u as=56.9f ps=0.74u w=0.17u l=0.17u
X1906 cml_tlatch_32.xtail.S1 CKB0_P cml_tlatch_32.xmux.xn.S1 VSS sg13_lv_nmos ad=89.3f pd=0.85u as=89.3f ps=0.85u w=0.47u l=0.16u
X1907 cml_tlatch_47.xmux.xp.S1 CKB2_P cml_tlatch_47.xtail.S1 VSS sg13_lv_nmos ad=89.3f pd=0.85u as=89.3f ps=0.85u w=0.47u l=0.16u
X1908 MOT1_N B0_8_P cml_tlatch_14.xmux.xn.S1 VSS sg13_lv_nmos ad=63.19999f pd=0.74u as=63.19999f ps=0.74u w=0.26u l=0.38u
X1909 A1_8_P A1_8_N cml_tlatch_19.xmux.xp.S1 VSS sg13_lv_nmos ad=56.9f pd=0.74u as=56.9f ps=0.74u w=0.17u l=0.17u
X1910 cml_tlatch_4.INP cml_tlatch_4.INN cml_tlatch_12.xmux.xp.S1 VSS sg13_lv_nmos ad=56.9f pd=0.74u as=56.9f ps=0.74u w=0.17u l=0.17u
X1911 cml_tlatch_29.xmux.xp.S1 MOT6_N MOT6_P VSS sg13_lv_nmos ad=0.1019p pd=1.34u as=56.9f ps=0.74u w=0.17u l=0.17u
X1912 cml_tlatch_96.xmux.xp.S1 cml_tlatch_5.INN cml_tlatch_5.INP VSS sg13_lv_nmos ad=56.9f pd=0.74u as=56.9f ps=0.74u w=0.17u l=0.17u
X1913 J1_N J1_P cml_tlatch_95.xmux.xp.S1 VSS sg13_lv_nmos ad=56.9f pd=0.74u as=56.9f ps=0.74u w=0.17u l=0.17u
X1914 cml_tlatch_69.xtail.S1 CKA3_N cml_tlatch_69.xmux.xp.S1 VSS sg13_lv_nmos ad=89.3f pd=0.85u as=89.3f ps=0.85u w=0.47u l=0.16u
X1915 cml_tlatch_91.xmux.xn.S1 CKA2_N cml_tlatch_91.xtail.S1 VSS sg13_lv_nmos ad=89.3f pd=0.85u as=89.3f ps=0.85u w=0.47u l=0.16u
X1916 cml_tlatch_55.xmux.xp.S1 MOT22_P MOT22_N VSS sg13_lv_nmos ad=56.9f pd=0.74u as=56.9f ps=0.74u w=0.17u l=0.17u
X1917 stub_bi_31.BOTP D1_P cml_tlatch_37.xmux.xn.S1 VSS sg13_lv_nmos ad=63.19999f pd=0.74u as=63.19999f ps=0.74u w=0.26u l=0.38u
X1918 cml_tlatch_69.OUTP cml_tlatch_69.OUTN cml_tlatch_69.xmux.xp.S1 VSS sg13_lv_nmos ad=56.9f pd=0.74u as=56.9f ps=0.74u w=0.17u l=0.17u
X1919 MOT30_N MOT30_P cml_tlatch_45.xmux.xp.S1 VSS sg13_lv_nmos ad=56.9f pd=0.74u as=56.9f ps=0.74u w=0.17u l=0.17u
X1920 cml_tlatch_58.xtail.S1 CKA3_N cml_tlatch_58.xmux.xp.S1 VSS sg13_lv_nmos ad=89.3f pd=0.85u as=89.3f ps=0.85u w=0.47u l=0.16u
X1921 CKHB0_N GB0_P cml_drvb_1.xrtail.R2 VSS sg13_lv_nmos ad=0.2618p pd=2.22u as=0.1463p ps=1.15u w=0.77u l=0.21u
X1922 cml_tlatch_95.xmux.xp.S1 CKJ_N cml_tlatch_95.xtail.S1 VSS sg13_lv_nmos ad=89.3f pd=0.85u as=89.3f ps=0.85u w=0.47u l=0.16u
X1923 VSS POLN cml_tlatch_76.xtail.S1 VSS sg13_lv_nmos ad=2.7982p pd=17.14u as=1.5637p ps=8.61u w=8.23u l=0.13u
X1924 cml_gate2_8.xrtail.R1 NS1_N ENB_P VSS sg13_lv_nmos ad=0.1007p pd=0.91u as=0.1007p ps=0.91u w=0.53u l=0.13u
X1925 cml_tlatch_6.xtail.S1 CKHB1_N cml_tlatch_6.xmux.xp.S1 VSS sg13_lv_nmos ad=89.3f pd=0.85u as=89.3f ps=0.85u w=0.47u l=0.16u
X1926 cml_tlatch_25.xmux.xp.S1 MOT14_P MOT14_N VSS sg13_lv_nmos ad=56.9f pd=0.74u as=56.9f ps=0.74u w=0.17u l=0.17u
X1927 cml_tlatch_20.xmux.xp.S1 cml_tlatch_20.OUTN cml_tlatch_20.OUTP VSS sg13_lv_nmos ad=56.9f pd=0.74u as=56.9f ps=0.74u w=0.17u l=0.17u
X1928 cml_tlatch_13.xmux.xn.S1 cml_tlatch_5.INP stub_bi_17.BOTP VSS sg13_lv_nmos ad=63.19999f pd=0.74u as=63.19999f ps=0.74u w=0.26u l=0.38u
X1929 ENA_N J1_P cml_gate2_9.xamp.xn.S1 VSS sg13_lv_nmos ad=0.1007p pd=0.91u as=0.1007p ps=0.91u w=0.53u l=0.13u
X1930 cml_tlatch_76.xmux.xn.S1 CKA2_P cml_tlatch_76.xtail.S1 VSS sg13_lv_nmos ad=89.3f pd=0.85u as=89.3f ps=0.85u w=0.47u l=0.16u
X1931 cml_tlatch_87.INN cml_tlatch_87.INP cml_tlatch_76.xmux.xp.S1 VSS sg13_lv_nmos ad=56.9f pd=0.74u as=56.9f ps=0.74u w=0.17u l=0.17u
X1932 cml_tlatch_98.xmux.xn.S1 cml_tlatch_30.OUTN cml_tlatch_98.OUTP VSS sg13_lv_nmos ad=63.19999f pd=0.74u as=63.19999f ps=0.74u w=0.26u l=0.38u
X1933 stub_bi_15.BOTN stub_bi_15.BOTP cml_tlatch_11.xmux.xp.S1 VSS sg13_lv_nmos ad=56.9f pd=0.74u as=56.9f ps=0.74u w=0.17u l=0.17u
X1934 cml_tlatch_70.xmux.xp.S1 cml_tlatch_63.INP cml_tlatch_63.INN VSS sg13_lv_nmos ad=56.9f pd=0.74u as=56.9f ps=0.74u w=0.17u l=0.17u
X1935 cml_tlatch_44.xmux.xp.S1 MOT28_P MOT28_N VSS sg13_lv_nmos ad=0.1019p pd=1.34u as=56.9f ps=0.74u w=0.17u l=0.17u
X1936 cml_tlatch_73.xmux.xp.S1 MOT27_P MOT27_N VSS sg13_lv_nmos ad=56.9f pd=0.74u as=56.9f ps=0.74u w=0.17u l=0.17u
X1937 cml_tlatch_73.INN cml_tlatch_73.INP cml_tlatch_66.xmux.xp.S1 VSS sg13_lv_nmos ad=56.9f pd=0.74u as=56.9f ps=0.74u w=0.17u l=0.17u
X1938 cml_tlatch_54.xtail.S1 CKHA2_P cml_tlatch_54.xmux.xn.S1 VSS sg13_lv_nmos ad=89.3f pd=0.85u as=89.3f ps=0.85u w=0.47u l=0.16u
X1939 cml_tlatch_73.INP cml_tlatch_73.INN cml_tlatch_66.xmux.xp.S1 VSS sg13_lv_nmos ad=56.9f pd=0.74u as=56.9f ps=0.74u w=0.17u l=0.17u
X1940 cml_tlatch_26.xmux.xp.S1 MOT0_N MOT0_P VSS sg13_lv_nmos ad=56.9f pd=0.74u as=56.9f ps=0.74u w=0.17u l=0.17u
X1941 stub_bi_55.BOTP stub_bi_38.BOTN cml_tlatch_90.xmux.xn.S1 VSS sg13_lv_nmos ad=63.19999f pd=0.74u as=63.19999f ps=0.74u w=0.26u l=0.38u
X1942 cml_tlatch_98.xmux.xn.S1 cml_tlatch_30.OUTN cml_tlatch_98.OUTP VSS sg13_lv_nmos ad=63.19999f pd=0.74u as=63.19999f ps=0.74u w=0.26u l=0.38u
X1943 MOT7_N MOT7_P cml_tlatch_17.xmux.xp.S1 VSS sg13_lv_nmos ad=56.9f pd=0.74u as=56.9f ps=0.74u w=0.17u l=0.17u
X1944 cml_tlatch_51.xtail.S1 CKB3_N cml_tlatch_51.xmux.xp.S1 VSS sg13_lv_nmos ad=0.1598p pd=1.62u as=89.3f ps=0.85u w=0.47u l=0.16u
X1945 MOT11_N MOT11_P cml_tlatch_4.xmux.xp.S1 VSS sg13_lv_nmos ad=56.9f pd=0.74u as=56.9f ps=0.74u w=0.17u l=0.17u
X1946 cml_tlatch_58.OUTP D3_N cml_tlatch_58.xmux.xn.S1 VSS sg13_lv_nmos ad=63.19999f pd=0.74u as=63.19999f ps=0.74u w=0.26u l=0.38u
X1947 cml_tlatch_91.xmux.xp.S1 CKA2_P cml_tlatch_91.xtail.S1 VSS sg13_lv_nmos ad=89.3f pd=0.85u as=0.1598p ps=1.62u w=0.47u l=0.16u
X1948 MOT5_P MOT5_N cml_tlatch_16.xmux.xp.S1 VSS sg13_lv_nmos ad=56.9f pd=0.74u as=56.9f ps=0.74u w=0.17u l=0.17u
X1949 MOT8_N VDD VSS rppd l=5.17u w=1u
X1950 cml_tlatch_64.xmux.xp.S1 CKB3_P cml_tlatch_64.xtail.S1 VSS sg13_lv_nmos ad=89.3f pd=0.85u as=89.3f ps=0.85u w=0.47u l=0.16u
X1951 cml_tlatch_9.xmux.xn.S1 cml_tlatch_18.OUTN A0_8_P VSS sg13_lv_nmos ad=63.19999f pd=0.74u as=63.19999f ps=0.74u w=0.26u l=0.38u
X1952 B3_8_N B3_8_P cml_tlatch_64.xmux.xp.S1 VSS sg13_lv_nmos ad=56.9f pd=0.74u as=56.9f ps=0.74u w=0.17u l=0.17u
X1953 CKB2_P CK_N hs_to_clk_4.D2 VSS sg13_lv_nmos ad=0.228p pd=1.58u as=0.228p ps=1.58u w=1.2u l=0.2u
X1954 cml_tlatch_85.xmux.xp.S1 A2_8_P A2_8_N VSS sg13_lv_nmos ad=56.9f pd=0.74u as=56.9f ps=0.74u w=0.17u l=0.17u
X1955 cml_gate2_5.xamp.xn.S1 CKB2_P cml_gate2_5.xrtail.R1 VSS sg13_lv_nmos ad=0.1007p pd=0.91u as=0.1007p ps=0.91u w=0.53u l=0.13u
X1956 cml_tlatch_39.xmux.xn.S1 CKA1_P cml_tlatch_39.xtail.S1 VSS sg13_lv_nmos ad=89.3f pd=0.85u as=89.3f ps=0.85u w=0.47u l=0.16u
X1957 cml_tlatch_32.xmux.xp.S1 cml_tlatch_32.OUTN cml_tlatch_32.OUTP VSS sg13_lv_nmos ad=56.9f pd=0.74u as=56.9f ps=0.74u w=0.17u l=0.17u
X1958 cml_tlatch_76.xmux.xn.S1 cml_tlatch_91.OUTN cml_tlatch_87.INP VSS sg13_lv_nmos ad=63.19999f pd=0.74u as=63.19999f ps=0.74u w=0.26u l=0.38u
X1959 MOT14_P A1_2_N cml_tlatch_25.xmux.xn.S1 VSS sg13_lv_nmos ad=63.19999f pd=0.74u as=63.19999f ps=0.74u w=0.26u l=0.38u
X1960 cml_tlatch_25.xtail.S1 POLN VSS VSS sg13_lv_nmos ad=1.5637p pd=8.61u as=2.7982p ps=17.14u w=8.23u l=0.13u
X1961 cml_tlatch_61.OUTN cml_tlatch_61.OUTP cml_tlatch_61.xmux.xp.S1 VSS sg13_lv_nmos ad=56.9f pd=0.74u as=56.9f ps=0.74u w=0.17u l=0.17u
X1962 cml_tlatch_94.xmux.xp.S1 J2_P J2_N VSS sg13_lv_nmos ad=56.9f pd=0.74u as=56.9f ps=0.74u w=0.17u l=0.17u
X1963 cml_tlatch_76.xmux.xn.S1 cml_tlatch_91.OUTN cml_tlatch_87.INP VSS sg13_lv_nmos ad=63.19999f pd=0.74u as=63.19999f ps=0.74u w=0.26u l=0.38u
X1964 cml_tlatch_32.OUTN cml_tlatch_32.OUTP cml_tlatch_32.xmux.xp.S1 VSS sg13_lv_nmos ad=56.9f pd=0.74u as=56.9f ps=0.74u w=0.17u l=0.17u
X1965 cml_tlatch_66.xmux.xp.S1 cml_tlatch_73.INN cml_tlatch_73.INP VSS sg13_lv_nmos ad=56.9f pd=0.74u as=56.9f ps=0.74u w=0.17u l=0.17u
X1966 MOT14_P A1_2_N cml_tlatch_25.xmux.xn.S1 VSS sg13_lv_nmos ad=63.19999f pd=0.74u as=63.19999f ps=0.74u w=0.26u l=0.38u
X1967 stub_bi_29.BOTN B1_2_N cml_tlatch_35.xmux.xn.S1 VSS sg13_lv_nmos ad=63.19999f pd=0.74u as=63.19999f ps=0.74u w=0.26u l=0.38u
X1968 cml_tlatch_47.xmux.xp.S1 B2_2_P B2_2_N VSS sg13_lv_nmos ad=56.9f pd=0.74u as=56.9f ps=0.74u w=0.17u l=0.17u
X1969 B0_8_P B0_8_N cml_tlatch_1.xmux.xp.S1 VSS sg13_lv_nmos ad=56.9f pd=0.74u as=56.9f ps=0.74u w=0.17u l=0.17u
X1970 cml_tlatch_59.xmux.xp.S1 cml_tlatch_91.INN cml_tlatch_91.INP VSS sg13_lv_nmos ad=56.9f pd=0.74u as=56.9f ps=0.74u w=0.17u l=0.17u
X1971 cml_tlatch_49.OUTP cml_tlatch_49.OUTN cml_tlatch_49.xmux.xp.S1 VSS sg13_lv_nmos ad=56.9f pd=0.74u as=56.9f ps=0.74u w=0.17u l=0.17u
X1972 VSS POLN cml_tlatch_56.xtail.S1 VSS sg13_lv_nmos ad=1.5637p pd=8.61u as=1.5637p ps=8.61u w=8.23u l=0.13u
X1973 cml_tlatch_2.xmux.xn.S1 cml_tlatch_7.OUTP cml_tlatch_2.OUTN VSS sg13_lv_nmos ad=63.19999f pd=0.74u as=0.1082p ps=1.34u w=0.26u l=0.38u
X1974 cml_tlatch_80.xtail.S1 CKHB2_N cml_tlatch_80.xmux.xp.S1 VSS sg13_lv_nmos ad=89.3f pd=0.85u as=89.3f ps=0.85u w=0.47u l=0.16u
X1975 cml_tlatch_35.xmux.xn.S1 CKB1_P cml_tlatch_35.xtail.S1 VSS sg13_lv_nmos ad=89.3f pd=0.85u as=89.3f ps=0.85u w=0.47u l=0.16u
X1976 cml_tlatch_49.xmux.xn.S1 B3_2_N cml_tlatch_49.OUTP VSS sg13_lv_nmos ad=63.19999f pd=0.74u as=63.19999f ps=0.74u w=0.26u l=0.38u
X1977 cml_tlatch_33.OUTN cml_tlatch_33.OUTP cml_tlatch_33.xmux.xp.S1 VSS sg13_lv_nmos ad=56.9f pd=0.74u as=0.1019p ps=1.34u w=0.17u l=0.17u
X1978 cml_tlatch_64.xmux.xp.S1 B3_8_N B3_8_P VSS sg13_lv_nmos ad=56.9f pd=0.74u as=56.9f ps=0.74u w=0.17u l=0.17u
X1979 cml_tlatch_58.OUTP cml_tlatch_58.OUTN cml_tlatch_58.xmux.xp.S1 VSS sg13_lv_nmos ad=56.9f pd=0.74u as=56.9f ps=0.74u w=0.17u l=0.17u
X1980 cml_tlatch_87.INN cml_tlatch_91.OUTP cml_tlatch_76.xmux.xn.S1 VSS sg13_lv_nmos ad=63.19999f pd=0.74u as=63.19999f ps=0.74u w=0.26u l=0.38u
X1981 cml_tlatch_52.xmux.xp.S1 MOT16_P MOT16_N VSS sg13_lv_nmos ad=56.9f pd=0.74u as=56.9f ps=0.74u w=0.17u l=0.17u
X1982 cml_tlatch_23.xtail.S1 CKA0_N cml_tlatch_23.xmux.xn.S1 VSS sg13_lv_nmos ad=89.3f pd=0.85u as=89.3f ps=0.85u w=0.47u l=0.16u
X1983 cml_tlatch_15.xmux.xp.S1 MOT3_N MOT3_P VSS sg13_lv_nmos ad=56.9f pd=0.74u as=56.9f ps=0.74u w=0.17u l=0.17u
X1984 stub_bi_62.BOTP stub_bi_63.BOTN cml_tlatch_82.xmux.xn.S1 VSS sg13_lv_nmos ad=63.19999f pd=0.74u as=63.19999f ps=0.74u w=0.26u l=0.38u
X1985 cml_tlatch_35.xmux.xn.S1 B1_2_P stub_bi_29.BOTP VSS sg13_lv_nmos ad=63.19999f pd=0.74u as=63.19999f ps=0.74u w=0.26u l=0.38u
X1986 cml_tlatch_53.xmux.xn.S1 cml_tlatch_87.OUTP MOT18_N VSS sg13_lv_nmos ad=63.19999f pd=0.74u as=63.19999f ps=0.74u w=0.26u l=0.38u
X1987 A2_2_P A2_2_N cml_tlatch_60.xmux.xp.S1 VSS sg13_lv_nmos ad=56.9f pd=0.74u as=56.9f ps=0.74u w=0.17u l=0.17u
X1988 cml_drv_3.xrtail.R1 ENA_P ENA0_N VSS sg13_lv_nmos ad=56.2f pd=0.74u as=56.2f ps=0.74u w=0.16u l=0.19u
X1989 stub_bi_49.BOTP stub_bi_49.BOTN cml_tlatch_84.xmux.xp.S1 VSS sg13_lv_nmos ad=56.9f pd=0.74u as=56.9f ps=0.74u w=0.17u l=0.17u
X1990 cml_tlatch_2.xmux.xp.S1 cml_tlatch_2.OUTP cml_tlatch_2.OUTN VSS sg13_lv_nmos ad=56.9f pd=0.74u as=56.9f ps=0.74u w=0.17u l=0.17u
X1991 MOT1_P MOT1_N cml_tlatch_14.xmux.xp.S1 VSS sg13_lv_nmos ad=56.9f pd=0.74u as=56.9f ps=0.74u w=0.17u l=0.17u
X1992 cml_tlatch_41.xmux.xp.S1 cml_tlatch_41.OUTN cml_tlatch_41.OUTP VSS sg13_lv_nmos ad=56.9f pd=0.74u as=56.9f ps=0.74u w=0.17u l=0.17u
X1993 cml_tlatch_35.xmux.xn.S1 B1_2_P stub_bi_29.BOTP VSS sg13_lv_nmos ad=63.19999f pd=0.74u as=63.19999f ps=0.74u w=0.26u l=0.38u
X1994 cml_gate2_2.xrtail.R1 CKB1_P cml_gate2_2.xamp.xn.S1 VSS sg13_lv_nmos ad=0.1007p pd=0.91u as=0.1007p ps=0.91u w=0.53u l=0.13u
X1995 stub_bi_31.BOTN stub_bi_31.BOTP cml_tlatch_37.xmux.xp.S1 VSS sg13_lv_nmos ad=56.9f pd=0.74u as=56.9f ps=0.74u w=0.17u l=0.17u
X1996 MOT18_P MOT18_N cml_tlatch_53.xmux.xp.S1 VSS sg13_lv_nmos ad=56.9f pd=0.74u as=56.9f ps=0.74u w=0.17u l=0.17u
X1997 MOT16_P MOT16_N cml_tlatch_52.xmux.xp.S1 VSS sg13_lv_nmos ad=56.9f pd=0.74u as=56.9f ps=0.74u w=0.17u l=0.17u
X1998 A0_2_N A0_2_P cml_tlatch_34.xmux.xp.S1 VSS sg13_lv_nmos ad=56.9f pd=0.74u as=56.9f ps=0.74u w=0.17u l=0.17u
X1999 cml_tlatch_92.xmux.xp.S1 CKJ_P cml_tlatch_92.xtail.S1 VSS sg13_lv_nmos ad=89.3f pd=0.85u as=89.3f ps=0.85u w=0.47u l=0.16u
X2000 cml_tlatch_4.INN cml_tlatch_4.INP cml_tlatch_12.xmux.xp.S1 VSS sg13_lv_nmos ad=56.9f pd=0.74u as=56.9f ps=0.74u w=0.17u l=0.17u
X2001 cml_tlatch_78.xtail.S1 POLN VSS VSS sg13_lv_nmos ad=1.5637p pd=8.61u as=2.7982p ps=17.14u w=8.23u l=0.13u
X2002 cml_tlatch_5.xmux.xp.S1 MOT13_P MOT13_N VSS sg13_lv_nmos ad=56.9f pd=0.74u as=56.9f ps=0.74u w=0.17u l=0.17u
X2003 cml_tlatch_21.xtail.S1 CKA1_P cml_tlatch_21.xmux.xp.S1 VSS sg13_lv_nmos ad=89.3f pd=0.85u as=89.3f ps=0.85u w=0.47u l=0.16u
X2004 cml_tlatch_3.xtail.S1 CKHB1_N cml_tlatch_3.xmux.xp.S1 VSS sg13_lv_nmos ad=89.3f pd=0.85u as=89.3f ps=0.85u w=0.47u l=0.16u
X2005 cml_tlatch_23.OUTP cml_tlatch_23.OUTN cml_tlatch_23.xmux.xp.S1 VSS sg13_lv_nmos ad=56.9f pd=0.74u as=56.9f ps=0.74u w=0.17u l=0.17u
X2006 GB0_P CKA0_N cml_gate2_1.xrtail.R1 VSS sg13_lv_nmos ad=0.1007p pd=0.91u as=0.1007p ps=0.91u w=0.53u l=0.13u
X2007 cml_gate2_7.xamp.xn.S1 ENB0_P GB2_N VSS sg13_lv_nmos ad=0.1007p pd=0.91u as=0.1007p ps=0.91u w=0.53u l=0.13u
X2008 cml_tlatch_75.xmux.xn.S1 B3_2_N MOT31_P VSS sg13_lv_nmos ad=63.19999f pd=0.74u as=0.1082p ps=1.34u w=0.26u l=0.38u
X2009 cml_tlatch_30.xtail.S1 CKB0_N cml_tlatch_30.xmux.xp.S1 VSS sg13_lv_nmos ad=89.3f pd=0.85u as=89.3f ps=0.85u w=0.47u l=0.16u
X2010 cml_tlatch_95.xmux.xn.S1 CKJ_P cml_tlatch_95.xtail.S1 VSS sg13_lv_nmos ad=89.3f pd=0.85u as=89.3f ps=0.85u w=0.47u l=0.16u
X2011 cml_tlatch_65.xmux.xp.S1 cml_tlatch_65.OUTN cml_tlatch_65.OUTP VSS sg13_lv_nmos ad=56.9f pd=0.74u as=56.9f ps=0.74u w=0.17u l=0.17u
X2012 cml_tlatch_89.xtail.S1 CKA3_P cml_tlatch_89.xmux.xp.S1 VSS sg13_lv_nmos ad=89.3f pd=0.85u as=89.3f ps=0.85u w=0.47u l=0.16u
X2013 cml_tlatch_22.xmux.xp.S1 CKA1_N cml_tlatch_22.xtail.S1 VSS sg13_lv_nmos ad=89.3f pd=0.85u as=89.3f ps=0.85u w=0.47u l=0.16u
X2014 MOT31_N B3_2_P cml_tlatch_75.xmux.xn.S1 VSS sg13_lv_nmos ad=63.19999f pd=0.74u as=63.19999f ps=0.74u w=0.26u l=0.38u
X2015 cml_tlatch_86.OUTN cml_tlatch_86.OUTP cml_tlatch_86.xmux.xp.S1 VSS sg13_lv_nmos ad=56.9f pd=0.74u as=56.9f ps=0.74u w=0.17u l=0.17u
X2016 cml_tlatch_17.xmux.xp.S1 MOT7_N MOT7_P VSS sg13_lv_nmos ad=56.9f pd=0.74u as=56.9f ps=0.74u w=0.17u l=0.17u
X2017 cml_tlatch_24.xmux.xn.S1 CKHA1_P cml_tlatch_24.xtail.S1 VSS sg13_lv_nmos ad=89.3f pd=0.85u as=89.3f ps=0.85u w=0.47u l=0.16u
X2018 cml_tlatch_76.xmux.xp.S1 CKA2_N cml_tlatch_76.xtail.S1 VSS sg13_lv_nmos ad=0.1598p pd=1.62u as=89.3f ps=0.85u w=0.47u l=0.16u
X2019 VDD A1_8_P VSS rppd l=5.17u w=1u
X2020 stub_bi_15.BOTN stub_bi_15.BOTP cml_tlatch_11.xmux.xp.S1 VSS sg13_lv_nmos ad=56.9f pd=0.74u as=56.9f ps=0.74u w=0.17u l=0.17u
X2021 cml_tlatch_45.xmux.xp.S1 CKHA3_N cml_tlatch_45.xtail.S1 VSS sg13_lv_nmos ad=89.3f pd=0.85u as=89.3f ps=0.85u w=0.47u l=0.16u
X2022 cml_tlatch_26.xmux.xp.S1 MOT0_N MOT0_P VSS sg13_lv_nmos ad=56.9f pd=0.74u as=56.9f ps=0.74u w=0.17u l=0.17u
X2023 cml_tlatch_59.xmux.xn.S1 A2_2_N cml_tlatch_91.INP VSS sg13_lv_nmos ad=63.19999f pd=0.74u as=63.19999f ps=0.74u w=0.26u l=0.38u
X2024 cml_tlatch_41.xtail.S1 CKA1_P cml_tlatch_41.xmux.xn.S1 VSS sg13_lv_nmos ad=89.3f pd=0.85u as=89.3f ps=0.85u w=0.47u l=0.16u
X2025 cml_tlatch_43.INN cml_tlatch_22.OUTP cml_tlatch_21.xmux.xn.S1 VSS sg13_lv_nmos ad=0.1082p pd=1.34u as=63.19999f ps=0.74u w=0.26u l=0.38u
X2026 cml_tlatch_47.xtail.S1 CKB2_P cml_tlatch_47.xmux.xp.S1 VSS sg13_lv_nmos ad=89.3f pd=0.85u as=0.1598p ps=1.62u w=0.47u l=0.16u
X2027 cml_tlatch_43.xmux.xp.S1 CKHA1_N cml_tlatch_43.xtail.S1 VSS sg13_lv_nmos ad=89.3f pd=0.85u as=89.3f ps=0.85u w=0.47u l=0.16u
X2028 VDD cml_tlatch_58.OUTN VSS rppd l=5.17u w=1u
X2029 A3_2_N A3_2_P cml_tlatch_57.xmux.xp.S1 VSS sg13_lv_nmos ad=56.9f pd=0.74u as=56.9f ps=0.74u w=0.17u l=0.17u
X2030 cml_tlatch_7.OUTN cml_tlatch_7.OUTP cml_tlatch_7.xmux.xp.S1 VSS sg13_lv_nmos ad=56.9f pd=0.74u as=56.9f ps=0.74u w=0.17u l=0.17u
X2031 cml_tlatch_99.xmux.xp.S1 cml_tlatch_99.OUTP cml_tlatch_99.OUTN VSS sg13_lv_nmos ad=56.9f pd=0.74u as=56.9f ps=0.74u w=0.17u l=0.17u
X2032 cml_tlatch_85.xmux.xp.S1 A2_8_P A2_8_N VSS sg13_lv_nmos ad=56.9f pd=0.74u as=56.9f ps=0.74u w=0.17u l=0.17u
X2033 cml_tlatch_98.xmux.xn.S1 cml_tlatch_30.OUTP cml_tlatch_98.OUTN VSS sg13_lv_nmos ad=63.19999f pd=0.74u as=63.19999f ps=0.74u w=0.26u l=0.38u
X2034 cml_tlatch_33.xmux.xp.S1 cml_tlatch_33.OUTN cml_tlatch_33.OUTP VSS sg13_lv_nmos ad=56.9f pd=0.74u as=56.9f ps=0.74u w=0.17u l=0.17u
X2035 GB1_N ENB1_P cml_gate2_0.xamp.xn.S1 VSS sg13_lv_nmos ad=0.1802p pd=1.74u as=0.1007p ps=0.91u w=0.53u l=0.13u
X2036 cml_gate2_6.xamp.xn.S1 CKA3_P cml_gate2_6.xrtail.R1 VSS sg13_lv_nmos ad=0.1007p pd=0.91u as=0.1007p ps=0.91u w=0.53u l=0.13u
X2037 cml_tlatch_84.xmux.xp.S1 stub_bi_49.BOTP stub_bi_49.BOTN VSS sg13_lv_nmos ad=56.9f pd=0.74u as=56.9f ps=0.74u w=0.17u l=0.17u
X2038 cml_tlatch_49.xmux.xp.S1 CKB3_N cml_tlatch_49.xtail.S1 VSS sg13_lv_nmos ad=89.3f pd=0.85u as=89.3f ps=0.85u w=0.47u l=0.16u
X2039 cml_tlatch_77.xtail.S1 CKHB2_N cml_tlatch_77.xmux.xp.S1 VSS sg13_lv_nmos ad=89.3f pd=0.85u as=89.3f ps=0.85u w=0.47u l=0.16u
X2040 cml_tlatch_64.xmux.xp.S1 B3_8_N B3_8_P VSS sg13_lv_nmos ad=56.9f pd=0.74u as=56.9f ps=0.74u w=0.17u l=0.17u
X2041 CKA3_P CK_P hs_to_clk_6.D2 VSS sg13_lv_nmos ad=0.228p pd=1.58u as=0.408p ps=3.08u w=1.2u l=0.2u
X2042 cml_tlatch_77.xmux.xp.S1 MOT17_N MOT17_P VSS sg13_lv_nmos ad=56.9f pd=0.74u as=56.9f ps=0.74u w=0.17u l=0.17u
X2043 cml_tlatch_37.xtail.S1 CKB1_P cml_tlatch_37.xmux.xn.S1 VSS sg13_lv_nmos ad=89.3f pd=0.85u as=89.3f ps=0.85u w=0.47u l=0.16u
X2044 A2_8_P A2_8_N cml_tlatch_85.xmux.xp.S1 VSS sg13_lv_nmos ad=56.9f pd=0.74u as=56.9f ps=0.74u w=0.17u l=0.17u
X2045 cml_tlatch_87.xmux.xn.S1 CKA2_N cml_tlatch_87.xtail.S1 VSS sg13_lv_nmos ad=89.3f pd=0.85u as=0.1598p ps=1.62u w=0.47u l=0.16u
X2046 cml_tlatch_90.xmux.xp.S1 stub_bi_55.BOTN stub_bi_55.BOTP VSS sg13_lv_nmos ad=56.9f pd=0.74u as=56.9f ps=0.74u w=0.17u l=0.17u
X2047 cml_tlatch_4.xmux.xn.S1 cml_tlatch_4.INN MOT11_P VSS sg13_lv_nmos ad=63.19999f pd=0.74u as=63.19999f ps=0.74u w=0.26u l=0.38u
X2048 cml_tlatch_24.INN cml_tlatch_24.INP cml_tlatch_97.xmux.xp.S1 VSS sg13_lv_nmos ad=56.9f pd=0.74u as=56.9f ps=0.74u w=0.17u l=0.17u
X2049 cml_gate2_4.xrtail.R1 CKB3_N GA3_P VSS sg13_lv_nmos ad=0.1007p pd=0.91u as=0.1007p ps=0.91u w=0.53u l=0.13u
X2050 cml_tlatch_48.xmux.xp.S1 stub_bi_43.BOTN stub_bi_43.BOTP VSS sg13_lv_nmos ad=0.1019p pd=1.34u as=56.9f ps=0.74u w=0.17u l=0.17u
X2051 cml_tlatch_95.xmux.xn.S1 J4_N J1_N VSS sg13_lv_nmos ad=63.19999f pd=0.74u as=63.19999f ps=0.74u w=0.26u l=0.38u
X2052 cml_tlatch_32.OUTN cml_tlatch_32.OUTP cml_tlatch_32.xmux.xp.S1 VSS sg13_lv_nmos ad=56.9f pd=0.74u as=56.9f ps=0.74u w=0.17u l=0.17u
X2053 cml_tlatch_50.xtail.S1 CKB3_P cml_tlatch_50.xmux.xp.S1 VSS sg13_lv_nmos ad=89.3f pd=0.85u as=89.3f ps=0.85u w=0.47u l=0.16u
X2054 cml_tlatch_40.xmux.xp.S1 CKA1_P cml_tlatch_40.xtail.S1 VSS sg13_lv_nmos ad=0.1598p pd=1.62u as=89.3f ps=0.85u w=0.47u l=0.16u
X2055 cml_tlatch_59.xmux.xp.S1 cml_tlatch_91.INN cml_tlatch_91.INP VSS sg13_lv_nmos ad=56.9f pd=0.74u as=56.9f ps=0.74u w=0.17u l=0.17u
X2056 cml_tlatch_28.xmux.xp.S1 MOT4_P MOT4_N VSS sg13_lv_nmos ad=56.9f pd=0.74u as=56.9f ps=0.74u w=0.17u l=0.17u
X2057 cml_tlatch_54.xmux.xn.S1 CKHA2_P cml_tlatch_54.xtail.S1 VSS sg13_lv_nmos ad=89.3f pd=0.85u as=89.3f ps=0.85u w=0.47u l=0.16u
X2058 cml_tlatch_30.xmux.xn.S1 B0_2_P cml_tlatch_30.OUTN VSS sg13_lv_nmos ad=63.19999f pd=0.74u as=63.19999f ps=0.74u w=0.26u l=0.38u
X2059 A3_8_N cml_tlatch_69.OUTP cml_tlatch_68.xmux.xn.S1 VSS sg13_lv_nmos ad=63.19999f pd=0.74u as=0.1082p ps=1.34u w=0.26u l=0.38u
X2060 cml_tlatch_43.xmux.xp.S1 MOT10_N MOT10_P VSS sg13_lv_nmos ad=56.9f pd=0.74u as=56.9f ps=0.74u w=0.17u l=0.17u
X2061 VSS POLN cml_tlatch_44.xtail.S1 VSS sg13_lv_nmos ad=2.7982p pd=17.14u as=1.5637p ps=8.61u w=8.23u l=0.13u
X2062 cml_tlatch_80.xtail.S1 POLN VSS VSS sg13_lv_nmos ad=1.5637p pd=8.61u as=1.5637p ps=8.61u w=8.23u l=0.13u
X2063 cml_tlatch_87.xmux.xp.S1 cml_tlatch_87.OUTN cml_tlatch_87.OUTP VSS sg13_lv_nmos ad=0.1019p pd=1.34u as=56.9f ps=0.74u w=0.17u l=0.17u
X2064 cml_tlatch_30.xmux.xn.S1 B0_2_P cml_tlatch_30.OUTN VSS sg13_lv_nmos ad=63.19999f pd=0.74u as=63.19999f ps=0.74u w=0.26u l=0.38u
X2065 cml_tlatch_24.xtail.S1 CKHA1_N cml_tlatch_24.xmux.xp.S1 VSS sg13_lv_nmos ad=0.1598p pd=1.62u as=89.3f ps=0.85u w=0.47u l=0.16u
X2066 cml_tlatch_62.xtail.S1 CKHA3_N cml_tlatch_62.xmux.xp.S1 VSS sg13_lv_nmos ad=89.3f pd=0.85u as=89.3f ps=0.85u w=0.47u l=0.16u
X2067 cml_tlatch_91.OUTP cml_tlatch_91.OUTN cml_tlatch_91.xmux.xp.S1 VSS sg13_lv_nmos ad=56.9f pd=0.74u as=56.9f ps=0.74u w=0.17u l=0.17u
X2068 cml_tlatch_51.xmux.xp.S1 cml_tlatch_51.OUTN cml_tlatch_51.OUTP VSS sg13_lv_nmos ad=56.9f pd=0.74u as=56.9f ps=0.74u w=0.17u l=0.17u
X2069 cml_tlatch_94.xtail.S1 CKJ_P cml_tlatch_94.xmux.xp.S1 VSS sg13_lv_nmos ad=89.3f pd=0.85u as=89.3f ps=0.85u w=0.47u l=0.16u
X2070 cml_tlatch_87.xmux.xn.S1 cml_tlatch_87.INN cml_tlatch_87.OUTP VSS sg13_lv_nmos ad=63.19999f pd=0.74u as=63.19999f ps=0.74u w=0.26u l=0.38u
X2071 VSS hs_to_clk_6.sg13_lv_nmos_2HGZLP_0.G VSS VSS sg13_lv_nmos ad=2.071p pd=11.28u as=0 ps=0 w=10.9u l=1.38u
X2072 MOT28_P cml_tlatch_44.INN cml_tlatch_44.xmux.xn.S1 VSS sg13_lv_nmos ad=63.19999f pd=0.74u as=63.19999f ps=0.74u w=0.26u l=0.38u
X2073 cml_tlatch_0.OUTN cml_tlatch_0.OUTP cml_tlatch_0.xmux.xp.S1 VSS sg13_lv_nmos ad=56.9f pd=0.74u as=56.9f ps=0.74u w=0.17u l=0.17u
X2074 MOT1_P MOT1_N cml_tlatch_14.xmux.xp.S1 VSS sg13_lv_nmos ad=56.9f pd=0.74u as=56.9f ps=0.74u w=0.17u l=0.17u
X2075 cml_tlatch_44.xmux.xn.S1 CKHA3_P cml_tlatch_44.xtail.S1 VSS sg13_lv_nmos ad=89.3f pd=0.85u as=89.3f ps=0.85u w=0.47u l=0.16u
X2076 cml_tlatch_74.xmux.xp.S1 CKHB3_N cml_tlatch_74.xtail.S1 VSS sg13_lv_nmos ad=89.3f pd=0.85u as=89.3f ps=0.85u w=0.47u l=0.16u
X2077 stub_bi_31.BOTN stub_bi_31.BOTP cml_tlatch_37.xmux.xp.S1 VSS sg13_lv_nmos ad=56.9f pd=0.74u as=56.9f ps=0.74u w=0.17u l=0.17u
X2078 A1_2_P A1_2_N cml_tlatch_40.xmux.xp.S1 VSS sg13_lv_nmos ad=56.9f pd=0.74u as=56.9f ps=0.74u w=0.17u l=0.17u
X2079 VDD A1_2_P VSS rppd l=5.17u w=1u
X2080 cml_tlatch_98.xmux.xp.S1 cml_tlatch_98.OUTN cml_tlatch_98.OUTP VSS sg13_lv_nmos ad=56.9f pd=0.74u as=56.9f ps=0.74u w=0.17u l=0.17u
X2081 cml_tlatch_99.xmux.xn.S1 CKA0_N cml_tlatch_99.xtail.S1 VSS sg13_lv_nmos ad=89.3f pd=0.85u as=89.3f ps=0.85u w=0.47u l=0.16u
X2082 MOT2_N cml_tlatch_23.OUTP cml_tlatch_27.xmux.xn.S1 VSS sg13_lv_nmos ad=0.1082p pd=1.34u as=63.19999f ps=0.74u w=0.26u l=0.38u
X2083 cml_tlatch_92.xmux.xn.S1 CKJ_N cml_tlatch_92.xtail.S1 VSS sg13_lv_nmos ad=0.1598p pd=1.62u as=89.3f ps=0.85u w=0.47u l=0.16u
X2084 cml_tlatch_86.xmux.xp.S1 cml_tlatch_86.OUTN cml_tlatch_86.OUTP VSS sg13_lv_nmos ad=56.9f pd=0.74u as=56.9f ps=0.74u w=0.17u l=0.17u
X2085 cml_tlatch_23.OUTP cml_tlatch_23.OUTN cml_tlatch_23.xmux.xp.S1 VSS sg13_lv_nmos ad=56.9f pd=0.74u as=56.9f ps=0.74u w=0.17u l=0.17u
X2086 cml_tlatch_61.xmux.xn.S1 CKA2_P cml_tlatch_61.xtail.S1 VSS sg13_lv_nmos ad=89.3f pd=0.85u as=89.3f ps=0.85u w=0.47u l=0.16u
X2087 cml_gate2_9.xamp.xn.S1 J1_N ENA_P VSS sg13_lv_nmos ad=0.1007p pd=0.91u as=0.1007p ps=0.91u w=0.53u l=0.13u
X2088 cml_tlatch_7.xmux.xp.S1 CKB0_P cml_tlatch_7.xtail.S1 VSS sg13_lv_nmos ad=89.3f pd=0.85u as=89.3f ps=0.85u w=0.47u l=0.16u
X2089 cml_tlatch_69.xtail.S1 CKA3_N cml_tlatch_69.xmux.xp.S1 VSS sg13_lv_nmos ad=89.3f pd=0.85u as=89.3f ps=0.85u w=0.47u l=0.16u
X2090 MOT23_N MOT23_P cml_tlatch_80.xmux.xp.S1 VSS sg13_lv_nmos ad=56.9f pd=0.74u as=56.9f ps=0.74u w=0.17u l=0.17u
X2091 cml_tlatch_91.xmux.xn.S1 CKA2_N cml_tlatch_91.xtail.S1 VSS sg13_lv_nmos ad=89.3f pd=0.85u as=89.3f ps=0.85u w=0.47u l=0.16u
X2092 cml_tlatch_57.xmux.xn.S1 cml_tlatch_58.OUTN A3_2_P VSS sg13_lv_nmos ad=63.19999f pd=0.74u as=63.19999f ps=0.74u w=0.26u l=0.38u
X2093 cml_tlatch_75.xmux.xp.S1 MOT31_P MOT31_N VSS sg13_lv_nmos ad=56.9f pd=0.74u as=56.9f ps=0.74u w=0.17u l=0.17u
X2094 VDD MOT19_P VSS rppd l=5.17u w=1u
X2095 cml_tlatch_49.xmux.xp.S1 cml_tlatch_49.OUTP cml_tlatch_49.OUTN VSS sg13_lv_nmos ad=56.9f pd=0.74u as=56.9f ps=0.74u w=0.17u l=0.17u
X2096 cml_tlatch_17.xmux.xp.S1 MOT7_N MOT7_P VSS sg13_lv_nmos ad=0.1019p pd=1.34u as=56.9f ps=0.74u w=0.17u l=0.17u
X2097 cml_gate2_8.xrtail.R1 NS1_P cml_gate2_8.xamp.xn.S1 VSS sg13_lv_nmos ad=0.1007p pd=0.91u as=0.1007p ps=0.91u w=0.53u l=0.13u
X2098 B2_8_P B2_8_N cml_tlatch_81.xmux.xp.S1 VSS sg13_lv_nmos ad=56.9f pd=0.74u as=0.1019p ps=1.34u w=0.17u l=0.17u
X2099 cml_tlatch_50.xmux.xp.S1 B3_2_P B3_2_N VSS sg13_lv_nmos ad=56.9f pd=0.74u as=56.9f ps=0.74u w=0.17u l=0.17u
X2100 MOT6_P MOT6_N cml_tlatch_29.xmux.xp.S1 VSS sg13_lv_nmos ad=56.9f pd=0.74u as=56.9f ps=0.74u w=0.17u l=0.17u
X2101 cml_tlatch_70.xtail.S1 CKA3_N cml_tlatch_70.xmux.xn.S1 VSS sg13_lv_nmos ad=89.3f pd=0.85u as=89.3f ps=0.85u w=0.47u l=0.16u
X2102 cml_tlatch_30.xmux.xp.S1 cml_tlatch_30.OUTP cml_tlatch_30.OUTN VSS sg13_lv_nmos ad=56.9f pd=0.74u as=56.9f ps=0.74u w=0.17u l=0.17u
X2103 stub_bi_43.BOTP D2_P cml_tlatch_48.xmux.xn.S1 VSS sg13_lv_nmos ad=63.19999f pd=0.74u as=63.19999f ps=0.74u w=0.26u l=0.38u
X2104 cml_tlatch_65.xtail.S1 CKB3_N cml_tlatch_65.xmux.xp.S1 VSS sg13_lv_nmos ad=0.1598p pd=1.62u as=89.3f ps=0.85u w=0.47u l=0.16u
X2105 MOT11_P MOT11_N cml_tlatch_4.xmux.xp.S1 VSS sg13_lv_nmos ad=56.9f pd=0.74u as=56.9f ps=0.74u w=0.17u l=0.17u
X2106 MOT9_P MOT9_N cml_tlatch_3.xmux.xp.S1 VSS sg13_lv_nmos ad=56.9f pd=0.74u as=0.1019p ps=1.34u w=0.17u l=0.17u
X2107 cml_tlatch_30.xtail.S1 CKB0_P cml_tlatch_30.xmux.xn.S1 VSS sg13_lv_nmos ad=89.3f pd=0.85u as=89.3f ps=0.85u w=0.47u l=0.16u
X2108 GA0_N ENA0_P cml_gate2_3.xamp.xn.S1 VSS sg13_lv_nmos ad=0.1007p pd=0.91u as=0.1007p ps=0.91u w=0.53u l=0.13u
X2109 cml_tlatch_63.xmux.xn.S1 cml_tlatch_63.INN MOT26_P VSS sg13_lv_nmos ad=63.19999f pd=0.74u as=63.19999f ps=0.74u w=0.26u l=0.38u
X2110 cml_tlatch_81.xtail.S1 CKB2_N cml_tlatch_81.xmux.xn.S1 VSS sg13_lv_nmos ad=89.3f pd=0.85u as=89.3f ps=0.85u w=0.47u l=0.16u
X2111 cml_tlatch_97.xmux.xp.S1 cml_tlatch_24.INN cml_tlatch_24.INP VSS sg13_lv_nmos ad=56.9f pd=0.74u as=56.9f ps=0.74u w=0.17u l=0.17u
X2112 cml_tlatch_50.xmux.xp.S1 B3_2_P B3_2_N VSS sg13_lv_nmos ad=0.1019p pd=1.34u as=56.9f ps=0.74u w=0.17u l=0.17u
X2113 cml_tlatch_63.xmux.xn.S1 cml_tlatch_63.INN MOT26_P VSS sg13_lv_nmos ad=63.19999f pd=0.74u as=63.19999f ps=0.74u w=0.26u l=0.38u
X2114 cml_tlatch_33.xmux.xp.S1 cml_tlatch_33.OUTN cml_tlatch_33.OUTP VSS sg13_lv_nmos ad=56.9f pd=0.74u as=56.9f ps=0.74u w=0.17u l=0.17u
X2115 cml_tlatch_77.xtail.S1 POLN VSS VSS sg13_lv_nmos ad=1.5637p pd=8.61u as=1.5637p ps=8.61u w=8.23u l=0.13u
X2116 cml_tlatch_22.OUTP cml_tlatch_22.OUTN cml_tlatch_22.xmux.xp.S1 VSS sg13_lv_nmos ad=56.9f pd=0.74u as=0.1019p ps=1.34u w=0.17u l=0.17u
X2117 cml_tlatch_26.xmux.xn.S1 A0_8_P MOT0_N VSS sg13_lv_nmos ad=63.19999f pd=0.74u as=63.19999f ps=0.74u w=0.26u l=0.38u
X2118 cml_tlatch_19.xmux.xp.S1 CKA1_P cml_tlatch_19.xtail.S1 VSS sg13_lv_nmos ad=89.3f pd=0.85u as=0.1598p ps=1.62u w=0.47u l=0.16u
X2119 B1_2_N B1_2_P cml_tlatch_36.xmux.xp.S1 VSS sg13_lv_nmos ad=56.9f pd=0.74u as=56.9f ps=0.74u w=0.17u l=0.17u
X2120 cml_tlatch_34.xmux.xp.S1 CKA0_P cml_tlatch_34.xtail.S1 VSS sg13_lv_nmos ad=0.1598p pd=1.62u as=89.3f ps=0.85u w=0.47u l=0.16u
X2121 MOT27_P MOT27_N cml_tlatch_73.xmux.xp.S1 VSS sg13_lv_nmos ad=56.9f pd=0.74u as=56.9f ps=0.74u w=0.17u l=0.17u
X2122 cml_tlatch_26.xmux.xn.S1 A0_8_P MOT0_N VSS sg13_lv_nmos ad=63.19999f pd=0.74u as=63.19999f ps=0.74u w=0.26u l=0.38u
X2123 cml_tlatch_24.INN cml_tlatch_97.INP cml_tlatch_97.xmux.xn.S1 VSS sg13_lv_nmos ad=63.19999f pd=0.74u as=63.19999f ps=0.74u w=0.26u l=0.38u
X2124 hs_to_clk_8.D2 POLN VSS VSS sg13_lv_nmos ad=1.9p pd=10.38u as=1.9p ps=10.38u w=10u l=0.13u
X2125 cml_tlatch_2.xtail.S1 CKB0_N cml_tlatch_2.xmux.xp.S1 VSS sg13_lv_nmos ad=89.3f pd=0.85u as=89.3f ps=0.85u w=0.47u l=0.16u
X2126 cml_tlatch_29.xmux.xp.S1 MOT6_P MOT6_N VSS sg13_lv_nmos ad=56.9f pd=0.74u as=56.9f ps=0.74u w=0.17u l=0.17u
X2127 cml_gate2_7.xamp.xn.S1 CKA2_P cml_gate2_7.xrtail.R1 VSS sg13_lv_nmos ad=0.1007p pd=0.91u as=0.1007p ps=0.91u w=0.53u l=0.13u
X2128 cml_tlatch_61.xmux.xp.S1 cml_tlatch_61.OUTN cml_tlatch_61.OUTP VSS sg13_lv_nmos ad=56.9f pd=0.74u as=56.9f ps=0.74u w=0.17u l=0.17u
X2129 cml_tlatch_67.OUTP cml_tlatch_74.INN cml_tlatch_67.xmux.xn.S1 VSS sg13_lv_nmos ad=63.19999f pd=0.74u as=63.19999f ps=0.74u w=0.26u l=0.38u
X2130 cml_tlatch_54.xmux.xp.S1 CKHA2_N cml_tlatch_54.xtail.S1 VSS sg13_lv_nmos ad=89.3f pd=0.85u as=89.3f ps=0.85u w=0.47u l=0.16u
X2131 A1_8_P cml_tlatch_20.OUTN cml_tlatch_19.xmux.xn.S1 VSS sg13_lv_nmos ad=63.19999f pd=0.74u as=63.19999f ps=0.74u w=0.26u l=0.38u
X2132 cml_tlatch_66.xtail.S1 POLN VSS VSS sg13_lv_nmos ad=1.5637p pd=8.61u as=1.5637p ps=8.61u w=8.23u l=0.13u
X2133 cml_tlatch_55.xmux.xn.S1 CKHA2_P cml_tlatch_55.xtail.S1 VSS sg13_lv_nmos ad=89.3f pd=0.85u as=0.1598p ps=1.62u w=0.47u l=0.16u
X2134 MOT15_P B1_2_N cml_tlatch_6.xmux.xn.S1 VSS sg13_lv_nmos ad=63.19999f pd=0.74u as=63.19999f ps=0.74u w=0.26u l=0.38u
X2135 cml_tlatch_6.xtail.S1 POLN VSS VSS sg13_lv_nmos ad=1.5637p pd=8.61u as=2.7982p ps=17.14u w=8.23u l=0.13u
X2136 cml_tlatch_8.xmux.xp.S1 cml_tlatch_8.OUTN cml_tlatch_8.OUTP VSS sg13_lv_nmos ad=56.9f pd=0.74u as=56.9f ps=0.74u w=0.17u l=0.17u
X2137 MOT5_P cml_tlatch_98.OUTN cml_tlatch_16.xmux.xn.S1 VSS sg13_lv_nmos ad=63.19999f pd=0.74u as=63.19999f ps=0.74u w=0.26u l=0.38u
X2138 cml_tlatch_26.xmux.xp.S1 CKHA0_N cml_tlatch_26.xtail.S1 VSS sg13_lv_nmos ad=89.3f pd=0.85u as=89.3f ps=0.85u w=0.47u l=0.16u
X2139 cml_tlatch_18.OUTP cml_tlatch_18.OUTN cml_tlatch_18.xmux.xp.S1 VSS sg13_lv_nmos ad=56.9f pd=0.74u as=56.9f ps=0.74u w=0.17u l=0.17u
X2140 MOT3_N MOT3_P cml_tlatch_15.xmux.xp.S1 VSS sg13_lv_nmos ad=56.9f pd=0.74u as=56.9f ps=0.74u w=0.17u l=0.17u
X2141 cml_tlatch_20.xmux.xp.S1 cml_tlatch_20.OUTP cml_tlatch_20.OUTN VSS sg13_lv_nmos ad=56.9f pd=0.74u as=56.9f ps=0.74u w=0.17u l=0.17u
X2142 B1_2_N stub_bi_31.BOTN cml_tlatch_36.xmux.xn.S1 VSS sg13_lv_nmos ad=63.19999f pd=0.74u as=63.19999f ps=0.74u w=0.26u l=0.38u
X2143 ENA1_P ENA_N cml_drv_1.xrtail.R1 VSS sg13_lv_nmos ad=56.2f pd=0.74u as=56.2f ps=0.74u w=0.16u l=0.19u
X2144 MOT15_P B1_2_N cml_tlatch_6.xmux.xn.S1 VSS sg13_lv_nmos ad=63.19999f pd=0.74u as=63.19999f ps=0.74u w=0.26u l=0.38u
X2145 cml_tlatch_13.xmux.xp.S1 stub_bi_17.BOTN stub_bi_17.BOTP VSS sg13_lv_nmos ad=56.9f pd=0.74u as=56.9f ps=0.74u w=0.17u l=0.17u
X2146 MOT18_N MOT18_P cml_tlatch_53.xmux.xp.S1 VSS sg13_lv_nmos ad=56.9f pd=0.74u as=56.9f ps=0.74u w=0.17u l=0.17u
X2147 cml_tlatch_42.xmux.xn.S1 A1_8_N MOT8_P VSS sg13_lv_nmos ad=63.19999f pd=0.74u as=63.19999f ps=0.74u w=0.26u l=0.38u
X2148 cml_tlatch_43.xtail.S1 CKHA1_P cml_tlatch_43.xmux.xn.S1 VSS sg13_lv_nmos ad=89.3f pd=0.85u as=89.3f ps=0.85u w=0.47u l=0.16u
X2149 cml_tlatch_63.xmux.xp.S1 MOT26_P MOT26_N VSS sg13_lv_nmos ad=56.9f pd=0.74u as=56.9f ps=0.74u w=0.17u l=0.17u
X2150 cml_tlatch_67.xmux.xn.S1 cml_tlatch_74.INP cml_tlatch_67.OUTN VSS sg13_lv_nmos ad=63.19999f pd=0.74u as=0.1082p ps=1.34u w=0.26u l=0.38u
X2151 cml_tlatch_98.OUTP VDD VSS rppd l=5.17u w=1u
X2152 cml_tlatch_84.xtail.S1 CKB2_P cml_tlatch_84.xmux.xn.S1 VSS sg13_lv_nmos ad=89.3f pd=0.85u as=89.3f ps=0.85u w=0.47u l=0.16u
X2153 cml_tlatch_98.xmux.xp.S1 cml_tlatch_98.OUTN cml_tlatch_98.OUTP VSS sg13_lv_nmos ad=56.9f pd=0.74u as=56.9f ps=0.74u w=0.17u l=0.17u
X2154 ENB_P NS1_N cml_gate2_8.xrtail.R1 VSS sg13_lv_nmos ad=0.1007p pd=0.91u as=0.1007p ps=0.91u w=0.53u l=0.13u
X2155 cml_tlatch_45.xmux.xn.S1 CKHA3_P cml_tlatch_45.xtail.S1 VSS sg13_lv_nmos ad=89.3f pd=0.85u as=89.3f ps=0.85u w=0.47u l=0.16u
X2156 cml_tlatch_49.xtail.S1 CKB3_N cml_tlatch_49.xmux.xp.S1 VSS sg13_lv_nmos ad=89.3f pd=0.85u as=89.3f ps=0.85u w=0.47u l=0.16u
X2157 MOT24_P A3_8_N cml_tlatch_62.xmux.xn.S1 VSS sg13_lv_nmos ad=63.19999f pd=0.74u as=63.19999f ps=0.74u w=0.26u l=0.38u
X2158 stub_bi_62.BOTN stub_bi_62.BOTP cml_tlatch_82.xmux.xp.S1 VSS sg13_lv_nmos ad=56.9f pd=0.74u as=56.9f ps=0.74u w=0.17u l=0.17u
X2159 cml_tlatch_47.xtail.S1 CKB2_N cml_tlatch_47.xmux.xn.S1 VSS sg13_lv_nmos ad=89.3f pd=0.85u as=89.3f ps=0.85u w=0.47u l=0.16u
X2160 cml_tlatch_44.INP cml_tlatch_44.INN cml_tlatch_89.xmux.xp.S1 VSS sg13_lv_nmos ad=56.9f pd=0.74u as=56.9f ps=0.74u w=0.17u l=0.17u
X2161 MOT21_N MOT21_P cml_tlatch_79.xmux.xp.S1 VSS sg13_lv_nmos ad=56.9f pd=0.74u as=56.9f ps=0.74u w=0.17u l=0.17u
X2162 cml_gate2_0.xrtail.R1 CKA1_P cml_gate2_0.xamp.xn.S1 VSS sg13_lv_nmos ad=0.1007p pd=0.91u as=0.1007p ps=0.91u w=0.53u l=0.13u
X2163 B3_2_P B3_2_N cml_tlatch_50.xmux.xp.S1 VSS sg13_lv_nmos ad=56.9f pd=0.74u as=56.9f ps=0.74u w=0.17u l=0.17u
X2164 cml_tlatch_74.xmux.xp.S1 MOT29_P MOT29_N VSS sg13_lv_nmos ad=56.9f pd=0.74u as=56.9f ps=0.74u w=0.17u l=0.17u
X2165 cml_tlatch_89.xtail.S1 POLN VSS VSS sg13_lv_nmos ad=1.5637p pd=8.61u as=1.5637p ps=8.61u w=8.23u l=0.13u
X2166 MOT21_N stub_bi_55.BOTN cml_tlatch_79.xmux.xn.S1 VSS sg13_lv_nmos ad=63.19999f pd=0.74u as=63.19999f ps=0.74u w=0.26u l=0.38u
X2167 cml_tlatch_43.INN cml_tlatch_43.INP cml_tlatch_21.xmux.xp.S1 VSS sg13_lv_nmos ad=56.9f pd=0.74u as=56.9f ps=0.74u w=0.17u l=0.17u
X2168 cml_tlatch_43.INP cml_tlatch_43.INN cml_tlatch_21.xmux.xp.S1 VSS sg13_lv_nmos ad=56.9f pd=0.74u as=56.9f ps=0.74u w=0.17u l=0.17u
X2169 cml_tlatch_24.xmux.xp.S1 CKHA1_N cml_tlatch_24.xtail.S1 VSS sg13_lv_nmos ad=89.3f pd=0.85u as=89.3f ps=0.85u w=0.47u l=0.16u
X2170 cml_tlatch_97.xmux.xp.S1 cml_tlatch_24.INN cml_tlatch_24.INP VSS sg13_lv_nmos ad=56.9f pd=0.74u as=56.9f ps=0.74u w=0.17u l=0.17u
X2171 B3_8_P cml_tlatch_65.OUTN cml_tlatch_64.xmux.xn.S1 VSS sg13_lv_nmos ad=63.19999f pd=0.74u as=63.19999f ps=0.74u w=0.26u l=0.38u
X2172 MOT4_P cml_tlatch_99.OUTN cml_tlatch_28.xmux.xn.S1 VSS sg13_lv_nmos ad=63.19999f pd=0.74u as=63.19999f ps=0.74u w=0.26u l=0.38u
X2173 cml_tlatch_12.xmux.xp.S1 cml_tlatch_4.INN cml_tlatch_4.INP VSS sg13_lv_nmos ad=56.9f pd=0.74u as=56.9f ps=0.74u w=0.17u l=0.17u
X2174 cml_tlatch_5.INP cml_tlatch_5.INN cml_tlatch_96.xmux.xp.S1 VSS sg13_lv_nmos ad=56.9f pd=0.74u as=56.9f ps=0.74u w=0.17u l=0.17u
X2175 cml_tlatch_95.xmux.xp.S1 J1_P J1_N VSS sg13_lv_nmos ad=56.9f pd=0.74u as=56.9f ps=0.74u w=0.17u l=0.17u
X2176 cml_tlatch_68.xmux.xp.S1 A3_8_P A3_8_N VSS sg13_lv_nmos ad=0.1019p pd=1.34u as=56.9f ps=0.74u w=0.17u l=0.17u
X2177 cml_tlatch_30.xmux.xp.S1 cml_tlatch_30.OUTP cml_tlatch_30.OUTN VSS sg13_lv_nmos ad=56.9f pd=0.74u as=56.9f ps=0.74u w=0.17u l=0.17u
X2178 cml_tlatch_85.xtail.S1 CKA2_P cml_tlatch_85.xmux.xp.S1 VSS sg13_lv_nmos ad=89.3f pd=0.85u as=89.3f ps=0.85u w=0.47u l=0.16u
X2179 cml_tlatch_71.OUTP cml_tlatch_71.OUTN cml_tlatch_71.xmux.xp.S1 VSS sg13_lv_nmos ad=56.9f pd=0.74u as=56.9f ps=0.74u w=0.17u l=0.17u
X2180 MOT22_N MOT22_P cml_tlatch_55.xmux.xp.S1 VSS sg13_lv_nmos ad=56.9f pd=0.74u as=0.1019p ps=1.34u w=0.17u l=0.17u
X2181 cml_tlatch_34.xmux.xp.S1 A0_2_N A0_2_P VSS sg13_lv_nmos ad=56.9f pd=0.74u as=56.9f ps=0.74u w=0.17u l=0.17u
X2182 cml_tlatch_69.xmux.xp.S1 cml_tlatch_69.OUTN cml_tlatch_69.OUTP VSS sg13_lv_nmos ad=56.9f pd=0.74u as=56.9f ps=0.74u w=0.17u l=0.17u
X2183 cml_tlatch_18.xmux.xp.S1 cml_tlatch_18.OUTP cml_tlatch_18.OUTN VSS sg13_lv_nmos ad=56.9f pd=0.74u as=56.9f ps=0.74u w=0.17u l=0.17u
X2184 cml_tlatch_38.xmux.xn.S1 D0_N cml_tlatch_38.OUTP VSS sg13_lv_nmos ad=63.19999f pd=0.74u as=63.19999f ps=0.74u w=0.26u l=0.38u
X2185 cml_tlatch_88.xmux.xp.S1 cml_tlatch_74.INP cml_tlatch_74.INN VSS sg13_lv_nmos ad=56.9f pd=0.74u as=56.9f ps=0.74u w=0.17u l=0.17u
X2186 cml_tlatch_45.xmux.xn.S1 A3_2_P MOT30_N VSS sg13_lv_nmos ad=63.19999f pd=0.74u as=63.19999f ps=0.74u w=0.26u l=0.38u
X2187 cml_tlatch_88.xtail.S1 CKB3_P cml_tlatch_88.xmux.xp.S1 VSS sg13_lv_nmos ad=89.3f pd=0.85u as=89.3f ps=0.85u w=0.47u l=0.16u
X2188 cml_tlatch_82.xmux.xn.S1 stub_bi_63.BOTN stub_bi_62.BOTP VSS sg13_lv_nmos ad=63.19999f pd=0.74u as=63.19999f ps=0.74u w=0.26u l=0.38u
X2189 cml_gate2_3.xamp.xn.S1 ENA0_N GA0_P VSS sg13_lv_nmos ad=0.1007p pd=0.91u as=0.1007p ps=0.91u w=0.53u l=0.13u
X2190 cml_tlatch_75.xmux.xp.S1 CKHB3_N cml_tlatch_75.xtail.S1 VSS sg13_lv_nmos ad=89.3f pd=0.85u as=89.3f ps=0.85u w=0.47u l=0.16u
X2191 cml_tlatch_36.xmux.xp.S1 B1_2_N B1_2_P VSS sg13_lv_nmos ad=0.1019p pd=1.34u as=56.9f ps=0.74u w=0.17u l=0.17u
X2192 cml_tlatch_54.xmux.xp.S1 MOT20_P MOT20_N VSS sg13_lv_nmos ad=56.9f pd=0.74u as=56.9f ps=0.74u w=0.17u l=0.17u
X2193 cml_tlatch_78.xmux.xp.S1 MOT19_P MOT19_N VSS sg13_lv_nmos ad=56.9f pd=0.74u as=56.9f ps=0.74u w=0.17u l=0.17u
X2194 cml_tlatch_95.xmux.xp.S1 J1_N J1_P VSS sg13_lv_nmos ad=56.9f pd=0.74u as=56.9f ps=0.74u w=0.17u l=0.17u
X2195 cml_tlatch_67.OUTN cml_tlatch_67.OUTP cml_tlatch_67.xmux.xp.S1 VSS sg13_lv_nmos ad=56.9f pd=0.74u as=56.9f ps=0.74u w=0.17u l=0.17u
X2196 cml_tlatch_56.xmux.xp.S1 cml_tlatch_56.OUTN cml_tlatch_56.OUTP VSS sg13_lv_nmos ad=0.1019p pd=1.34u as=56.9f ps=0.74u w=0.17u l=0.17u
X2197 cml_tlatch_63.INN cml_tlatch_63.INP cml_tlatch_70.xmux.xp.S1 VSS sg13_lv_nmos ad=56.9f pd=0.74u as=56.9f ps=0.74u w=0.17u l=0.17u
X2198 MOT27_N MOT27_P cml_tlatch_73.xmux.xp.S1 VSS sg13_lv_nmos ad=56.9f pd=0.74u as=56.9f ps=0.74u w=0.17u l=0.17u
X2199 CKA0_N CK_N hs_to_clk_0.D2 VSS sg13_lv_nmos ad=0.228p pd=1.58u as=0.408p ps=3.08u w=1.2u l=0.2u
X2200 MOT28_N MOT28_P cml_tlatch_44.xmux.xp.S1 VSS sg13_lv_nmos ad=56.9f pd=0.74u as=56.9f ps=0.74u w=0.17u l=0.17u
X2201 cml_tlatch_9.xmux.xn.S1 cml_tlatch_18.OUTP A0_8_N VSS sg13_lv_nmos ad=63.19999f pd=0.74u as=63.19999f ps=0.74u w=0.26u l=0.38u
X2202 MOT0_P MOT0_N cml_tlatch_26.xmux.xp.S1 VSS sg13_lv_nmos ad=56.9f pd=0.74u as=0.1019p ps=1.34u w=0.17u l=0.17u
X2203 cml_tlatch_86.xtail.S1 CKA2_P cml_tlatch_86.xmux.xn.S1 VSS sg13_lv_nmos ad=89.3f pd=0.85u as=89.3f ps=0.85u w=0.47u l=0.16u
X2204 cml_tlatch_3.xtail.S1 POLN VSS VSS sg13_lv_nmos ad=1.5637p pd=8.61u as=2.7982p ps=17.14u w=8.23u l=0.13u
X2205 cml_tlatch_92.xmux.xp.S1 J4_N J4_P VSS sg13_lv_nmos ad=56.9f pd=0.74u as=56.9f ps=0.74u w=0.17u l=0.17u
X2206 cml_tlatch_25.xmux.xp.S1 CKHA1_N cml_tlatch_25.xtail.S1 VSS sg13_lv_nmos ad=89.3f pd=0.85u as=89.3f ps=0.85u w=0.47u l=0.16u
X2207 VSS POLN cml_tlatch_83.xtail.S1 VSS sg13_lv_nmos ad=2.7982p pd=17.14u as=1.5637p ps=8.61u w=8.23u l=0.13u
X2208 cml_tlatch_4.xmux.xp.S1 MOT11_P MOT11_N VSS sg13_lv_nmos ad=56.9f pd=0.74u as=56.9f ps=0.74u w=0.17u l=0.17u
X2209 B2_8_N stub_bi_62.BOTN cml_tlatch_81.xmux.xn.S1 VSS sg13_lv_nmos ad=63.19999f pd=0.74u as=63.19999f ps=0.74u w=0.26u l=0.38u
X2210 cml_tlatch_5.xtail.S1 CKHB1_P cml_tlatch_5.xmux.xn.S1 VSS sg13_lv_nmos ad=89.3f pd=0.85u as=0.1598p ps=1.62u w=0.47u l=0.16u
X2211 cml_tlatch_20.xmux.xn.S1 cml_tlatch_43.INN cml_tlatch_20.OUTP VSS sg13_lv_nmos ad=63.19999f pd=0.74u as=63.19999f ps=0.74u w=0.26u l=0.38u
X2212 A2_8_P cml_tlatch_86.OUTN cml_tlatch_85.xmux.xn.S1 VSS sg13_lv_nmos ad=0.1082p pd=1.34u as=63.19999f ps=0.74u w=0.26u l=0.38u
X2213 cml_tlatch_64.xmux.xp.S1 B3_8_P B3_8_N VSS sg13_lv_nmos ad=56.9f pd=0.74u as=56.9f ps=0.74u w=0.17u l=0.17u
X2214 cml_tlatch_56.OUTN A3_2_P cml_tlatch_56.xmux.xn.S1 VSS sg13_lv_nmos ad=63.19999f pd=0.74u as=63.19999f ps=0.74u w=0.26u l=0.38u
X2215 cml_tlatch_56.xtail.S1 CKA3_P cml_tlatch_56.xmux.xn.S1 VSS sg13_lv_nmos ad=89.3f pd=0.85u as=89.3f ps=0.85u w=0.47u l=0.16u
X2216 stub_bi_43.BOTN stub_bi_43.BOTP cml_tlatch_48.xmux.xp.S1 VSS sg13_lv_nmos ad=56.9f pd=0.74u as=56.9f ps=0.74u w=0.17u l=0.17u
X2217 cml_tlatch_82.xtail.S1 CKB2_P cml_tlatch_82.xmux.xn.S1 VSS sg13_lv_nmos ad=89.3f pd=0.85u as=89.3f ps=0.85u w=0.47u l=0.16u
X2218 cml_tlatch_40.xtail.S1 CKA1_P cml_tlatch_40.xmux.xp.S1 VSS sg13_lv_nmos ad=89.3f pd=0.85u as=89.3f ps=0.85u w=0.47u l=0.16u
X2219 cml_tlatch_8.OUTN cml_tlatch_8.OUTP cml_tlatch_8.xmux.xp.S1 VSS sg13_lv_nmos ad=56.9f pd=0.74u as=56.9f ps=0.74u w=0.17u l=0.17u
X2220 cml_gate2_6.xrtail.R1 CKA3_N GB3_P VSS sg13_lv_nmos ad=0.1007p pd=0.91u as=0.1007p ps=0.91u w=0.53u l=0.13u
X2221 cml_tlatch_12.xtail.S1 CKB1_P cml_tlatch_12.xmux.xp.S1 VSS sg13_lv_nmos ad=0.1598p pd=1.62u as=89.3f ps=0.85u w=0.47u l=0.16u
X2222 cml_tlatch_69.xtail.S1 CKA3_P cml_tlatch_69.xmux.xn.S1 VSS sg13_lv_nmos ad=89.3f pd=0.85u as=89.3f ps=0.85u w=0.47u l=0.16u
X2223 MOT22_N MOT22_P cml_tlatch_55.xmux.xp.S1 VSS sg13_lv_nmos ad=56.9f pd=0.74u as=56.9f ps=0.74u w=0.17u l=0.17u
X2224 MOT3_N cml_tlatch_7.OUTP cml_tlatch_15.xmux.xn.S1 VSS sg13_lv_nmos ad=63.19999f pd=0.74u as=63.19999f ps=0.74u w=0.26u l=0.38u
X2225 cml_tlatch_51.xmux.xp.S1 CKB3_N cml_tlatch_51.xtail.S1 VSS sg13_lv_nmos ad=89.3f pd=0.85u as=89.3f ps=0.85u w=0.47u l=0.16u
X2226 cml_tlatch_69.xmux.xp.S1 cml_tlatch_69.OUTN cml_tlatch_69.OUTP VSS sg13_lv_nmos ad=56.9f pd=0.74u as=56.9f ps=0.74u w=0.17u l=0.17u
X2227 cml_tlatch_21.xmux.xp.S1 cml_tlatch_43.INP cml_tlatch_43.INN VSS sg13_lv_nmos ad=0.1019p pd=1.34u as=56.9f ps=0.74u w=0.17u l=0.17u
X2228 cml_tlatch_61.xmux.xp.S1 cml_tlatch_61.OUTP cml_tlatch_61.OUTN VSS sg13_lv_nmos ad=56.9f pd=0.74u as=56.9f ps=0.74u w=0.17u l=0.17u
X2229 cml_tlatch_51.OUTN cml_tlatch_51.OUTP cml_tlatch_51.xmux.xp.S1 VSS sg13_lv_nmos ad=56.9f pd=0.74u as=56.9f ps=0.74u w=0.17u l=0.17u
X2230 CKA0_P CK_P hs_to_clk_0.D2 VSS sg13_lv_nmos ad=0.228p pd=1.58u as=0.408p ps=3.08u w=1.2u l=0.2u
X2231 B2_2_N B2_2_P cml_tlatch_47.xmux.xp.S1 VSS sg13_lv_nmos ad=56.9f pd=0.74u as=56.9f ps=0.74u w=0.17u l=0.17u
X2232 cml_tlatch_73.INP cml_tlatch_67.OUTN cml_tlatch_66.xmux.xn.S1 VSS sg13_lv_nmos ad=63.19999f pd=0.74u as=63.19999f ps=0.74u w=0.26u l=0.38u
X2233 cml_tlatch_49.xmux.xp.S1 cml_tlatch_49.OUTN cml_tlatch_49.OUTP VSS sg13_lv_nmos ad=56.9f pd=0.74u as=56.9f ps=0.74u w=0.17u l=0.17u
X2234 cml_tlatch_98.OUTN cml_tlatch_98.OUTP cml_tlatch_98.xmux.xp.S1 VSS sg13_lv_nmos ad=56.9f pd=0.74u as=56.9f ps=0.74u w=0.17u l=0.17u
X2235 cml_gate2_3.xrtail.R1 CKB0_P cml_gate2_3.xamp.xn.S1 VSS sg13_lv_nmos ad=0.1007p pd=0.91u as=0.1007p ps=0.91u w=0.53u l=0.13u
X2236 cml_tlatch_68.xmux.xp.S1 A3_8_N A3_8_P VSS sg13_lv_nmos ad=56.9f pd=0.74u as=56.9f ps=0.74u w=0.17u l=0.17u
X2237 cml_tlatch_58.xmux.xp.S1 cml_tlatch_58.OUTN cml_tlatch_58.OUTP VSS sg13_lv_nmos ad=56.9f pd=0.74u as=56.9f ps=0.74u w=0.17u l=0.17u
X2238 cml_tlatch_99.xmux.xn.S1 CKA0_N cml_tlatch_99.xtail.S1 VSS sg13_lv_nmos ad=89.3f pd=0.85u as=89.3f ps=0.85u w=0.47u l=0.16u
X2239 MOT22_P MOT22_N cml_tlatch_55.xmux.xp.S1 VSS sg13_lv_nmos ad=56.9f pd=0.74u as=56.9f ps=0.74u w=0.17u l=0.17u
X2240 cml_tlatch_83.xmux.xn.S1 stub_bi_49.BOTN stub_bi_63.BOTP VSS sg13_lv_nmos ad=63.19999f pd=0.74u as=63.19999f ps=0.74u w=0.26u l=0.38u
X2241 MOT16_N MOT16_P cml_tlatch_52.xmux.xp.S1 VSS sg13_lv_nmos ad=56.9f pd=0.74u as=56.9f ps=0.74u w=0.17u l=0.17u
X2242 cml_tlatch_74.xmux.xp.S1 MOT29_P MOT29_N VSS sg13_lv_nmos ad=56.9f pd=0.74u as=56.9f ps=0.74u w=0.17u l=0.17u
X2243 stub_bi_38.BOTP stub_bi_38.BOTN cml_tlatch_46.xmux.xp.S1 VSS sg13_lv_nmos ad=56.9f pd=0.74u as=56.9f ps=0.74u w=0.17u l=0.17u
X2244 ENA_P NM1_N cml_gate2_9.xrtail.R1 VSS sg13_lv_nmos ad=0.1007p pd=0.91u as=0.1007p ps=0.91u w=0.53u l=0.13u
X2245 cml_tlatch_84.xmux.xp.S1 stub_bi_49.BOTN stub_bi_49.BOTP VSS sg13_lv_nmos ad=56.9f pd=0.74u as=56.9f ps=0.74u w=0.17u l=0.17u
X2246 cml_tlatch_96.xtail.S1 POLN VSS VSS sg13_lv_nmos ad=1.5637p pd=8.61u as=2.7982p ps=17.14u w=8.23u l=0.13u
X2247 cml_tlatch_14.xmux.xp.S1 MOT1_N MOT1_P VSS sg13_lv_nmos ad=56.9f pd=0.74u as=56.9f ps=0.74u w=0.17u l=0.17u
X2248 cml_tlatch_10.xmux.xp.S1 B1_8_N B1_8_P VSS sg13_lv_nmos ad=56.9f pd=0.74u as=56.9f ps=0.74u w=0.17u l=0.17u
X2249 MOT14_P MOT14_N cml_tlatch_25.xmux.xp.S1 VSS sg13_lv_nmos ad=56.9f pd=0.74u as=56.9f ps=0.74u w=0.17u l=0.17u
X2250 cml_tlatch_38.OUTN D0_P cml_tlatch_38.xmux.xn.S1 VSS sg13_lv_nmos ad=0.1082p pd=1.34u as=63.19999f ps=0.74u w=0.26u l=0.38u
X2251 cml_tlatch_59.xtail.S1 POLN VSS VSS sg13_lv_nmos ad=1.5637p pd=8.61u as=2.7982p ps=17.14u w=8.23u l=0.13u
X2252 MOT13_N MOT13_P cml_tlatch_5.xmux.xp.S1 VSS sg13_lv_nmos ad=56.9f pd=0.74u as=56.9f ps=0.74u w=0.17u l=0.17u
X2253 cml_tlatch_12.xmux.xp.S1 cml_tlatch_4.INN cml_tlatch_4.INP VSS sg13_lv_nmos ad=56.9f pd=0.74u as=56.9f ps=0.74u w=0.17u l=0.17u
X2254 cml_tlatch_5.INP stub_bi_29.BOTP cml_tlatch_96.xmux.xn.S1 VSS sg13_lv_nmos ad=63.19999f pd=0.74u as=63.19999f ps=0.74u w=0.26u l=0.38u
X2255 cml_tlatch_72.xmux.xp.S1 CKHB3_N cml_tlatch_72.xtail.S1 VSS sg13_lv_nmos ad=89.3f pd=0.85u as=89.3f ps=0.85u w=0.47u l=0.16u
X2256 cml_tlatch_95.xmux.xp.S1 J1_P J1_N VSS sg13_lv_nmos ad=56.9f pd=0.74u as=56.9f ps=0.74u w=0.17u l=0.17u
X2257 cml_tlatch_38.OUTN D0_P cml_tlatch_38.xmux.xn.S1 VSS sg13_lv_nmos ad=63.19999f pd=0.74u as=63.19999f ps=0.74u w=0.26u l=0.38u
X2258 MOT10_N VDD VSS rppd l=5.17u w=1u
X2259 cml_gate2_5.xamp.xn.S1 ENA1_P GA2_N VSS sg13_lv_nmos ad=0.1007p pd=0.91u as=0.1007p ps=0.91u w=0.53u l=0.13u
X2260 cml_tlatch_84.xmux.xn.S1 CKB2_P cml_tlatch_84.xtail.S1 VSS sg13_lv_nmos ad=89.3f pd=0.85u as=89.3f ps=0.85u w=0.47u l=0.16u
X2261 cml_tlatch_86.xmux.xp.S1 cml_tlatch_86.OUTP cml_tlatch_86.OUTN VSS sg13_lv_nmos ad=56.9f pd=0.74u as=56.9f ps=0.74u w=0.17u l=0.17u
X2262 cml_tlatch_30.xtail.S1 CKB0_P cml_tlatch_30.xmux.xn.S1 VSS sg13_lv_nmos ad=89.3f pd=0.85u as=89.3f ps=0.85u w=0.47u l=0.16u
X2263 cml_tlatch_30.xmux.xp.S1 cml_tlatch_30.OUTN cml_tlatch_30.OUTP VSS sg13_lv_nmos ad=0.1019p pd=1.34u as=56.9f ps=0.74u w=0.17u l=0.17u
X2264 cml_tlatch_71.xmux.xn.S1 CKA3_P cml_tlatch_71.xtail.S1 VSS sg13_lv_nmos ad=89.3f pd=0.85u as=0.1598p ps=1.62u w=0.47u l=0.16u
X2265 cml_tlatch_14.xmux.xn.S1 B0_8_P MOT1_N VSS sg13_lv_nmos ad=63.19999f pd=0.74u as=63.19999f ps=0.74u w=0.26u l=0.38u
X2266 MOT7_P MOT7_N cml_tlatch_17.xmux.xp.S1 VSS sg13_lv_nmos ad=56.9f pd=0.74u as=56.9f ps=0.74u w=0.17u l=0.17u
X2267 cml_tlatch_13.xmux.xn.S1 cml_tlatch_5.INN stub_bi_17.BOTN VSS sg13_lv_nmos ad=63.19999f pd=0.74u as=63.19999f ps=0.74u w=0.26u l=0.38u
X2268 cml_tlatch_11.xmux.xp.S1 stub_bi_15.BOTP stub_bi_15.BOTN VSS sg13_lv_nmos ad=56.9f pd=0.74u as=56.9f ps=0.74u w=0.17u l=0.17u
X2269 cml_tlatch_58.xmux.xp.S1 cml_tlatch_58.OUTN cml_tlatch_58.OUTP VSS sg13_lv_nmos ad=56.9f pd=0.74u as=56.9f ps=0.74u w=0.17u l=0.17u
X2270 cml_tlatch_9.xtail.S1 POLN VSS VSS sg13_lv_nmos ad=1.5637p pd=8.61u as=1.5637p ps=8.61u w=8.23u l=0.13u
X2271 cml_tlatch_66.xtail.S1 CKB3_N cml_tlatch_66.xmux.xn.S1 VSS sg13_lv_nmos ad=89.3f pd=0.85u as=89.3f ps=0.85u w=0.47u l=0.16u
X2272 MOT3_P MOT3_N cml_tlatch_15.xmux.xp.S1 VSS sg13_lv_nmos ad=56.9f pd=0.74u as=56.9f ps=0.74u w=0.17u l=0.17u
X2273 GB0_N ENB1_P cml_gate2_1.xamp.xn.S1 VSS sg13_lv_nmos ad=0.1007p pd=0.91u as=0.1007p ps=0.91u w=0.53u l=0.13u
X2274 MOT0_P MOT0_N cml_tlatch_26.xmux.xp.S1 VSS sg13_lv_nmos ad=56.9f pd=0.74u as=56.9f ps=0.74u w=0.17u l=0.17u
X2275 cml_tlatch_63.xtail.S1 CKHA3_N cml_tlatch_63.xmux.xp.S1 VSS sg13_lv_nmos ad=89.3f pd=0.85u as=0.1598p ps=1.62u w=0.47u l=0.16u
X2276 cml_tlatch_52.xtail.S1 CKHA2_N cml_tlatch_52.xmux.xp.S1 VSS sg13_lv_nmos ad=89.3f pd=0.85u as=89.3f ps=0.85u w=0.47u l=0.16u
X2277 VDD cml_tlatch_41.OUTP VSS rppd l=5.17u w=1u
X2278 cml_tlatch_84.xmux.xp.S1 stub_bi_49.BOTN stub_bi_49.BOTP VSS sg13_lv_nmos ad=56.9f pd=0.74u as=56.9f ps=0.74u w=0.17u l=0.17u
X2279 cml_tlatch_16.xmux.xp.S1 MOT5_N MOT5_P VSS sg13_lv_nmos ad=56.9f pd=0.74u as=56.9f ps=0.74u w=0.17u l=0.17u
X2280 cml_tlatch_57.xmux.xp.S1 A3_2_P A3_2_N VSS sg13_lv_nmos ad=56.9f pd=0.74u as=56.9f ps=0.74u w=0.17u l=0.17u
X2281 cml_tlatch_31.xtail.S1 CKB0_N cml_tlatch_31.xmux.xn.S1 VSS sg13_lv_nmos ad=89.3f pd=0.85u as=89.3f ps=0.85u w=0.47u l=0.16u
X2282 cml_tlatch_2.xtail.S1 CKB0_N cml_tlatch_2.xmux.xp.S1 VSS sg13_lv_nmos ad=89.3f pd=0.85u as=89.3f ps=0.85u w=0.47u l=0.16u
X2283 cml_tlatch_7.xmux.xp.S1 cml_tlatch_7.OUTP cml_tlatch_7.OUTN VSS sg13_lv_nmos ad=56.9f pd=0.74u as=56.9f ps=0.74u w=0.17u l=0.17u
X2284 cml_tlatch_99.xtail.S1 CKA0_P cml_tlatch_99.xmux.xp.S1 VSS sg13_lv_nmos ad=89.3f pd=0.85u as=89.3f ps=0.85u w=0.47u l=0.16u
X2285 cml_tlatch_98.OUTP cml_tlatch_30.OUTN cml_tlatch_98.xmux.xn.S1 VSS sg13_lv_nmos ad=63.19999f pd=0.74u as=63.19999f ps=0.74u w=0.26u l=0.38u
X2286 cml_tlatch_90.xmux.xn.S1 stub_bi_38.BOTN stub_bi_55.BOTP VSS sg13_lv_nmos ad=63.19999f pd=0.74u as=0.1082p ps=1.34u w=0.26u l=0.38u
X2287 cml_tlatch_76.xtail.S1 CKA2_N cml_tlatch_76.xmux.xp.S1 VSS sg13_lv_nmos ad=89.3f pd=0.85u as=89.3f ps=0.85u w=0.47u l=0.16u
X2288 hs_to_clk_8.D2 CK_N CKJ_N VSS sg13_lv_nmos ad=0.228p pd=1.58u as=0.228p ps=1.58u w=1.2u l=0.2u
X2289 GB1_P ENB1_N cml_gate2_0.xamp.xn.S1 VSS sg13_lv_nmos ad=0.1007p pd=0.91u as=0.1007p ps=0.91u w=0.53u l=0.13u
X2290 stub_bi_49.BOTN stub_bi_49.BOTP cml_tlatch_84.xmux.xp.S1 VSS sg13_lv_nmos ad=56.9f pd=0.74u as=56.9f ps=0.74u w=0.17u l=0.17u
X2291 MOT20_P MOT20_N cml_tlatch_54.xmux.xp.S1 VSS sg13_lv_nmos ad=56.9f pd=0.74u as=56.9f ps=0.74u w=0.17u l=0.17u
X2292 A1_2_N A1_2_P cml_tlatch_40.xmux.xp.S1 VSS sg13_lv_nmos ad=56.9f pd=0.74u as=56.9f ps=0.74u w=0.17u l=0.17u
X2293 NS1_P VDD VSS rppd l=13.09u w=1u
X2294 cml_tlatch_58.xmux.xn.S1 D3_N cml_tlatch_58.OUTP VSS sg13_lv_nmos ad=63.19999f pd=0.74u as=63.19999f ps=0.74u w=0.26u l=0.38u
X2295 stub_bi_55.BOTP stub_bi_55.BOTN cml_tlatch_90.xmux.xp.S1 VSS sg13_lv_nmos ad=56.9f pd=0.74u as=56.9f ps=0.74u w=0.17u l=0.17u
X2296 cml_tlatch_9.xtail.S1 CKA0_P cml_tlatch_9.xmux.xp.S1 VSS sg13_lv_nmos ad=89.3f pd=0.85u as=89.3f ps=0.85u w=0.47u l=0.16u
X2297 cml_tlatch_88.xmux.xp.S1 CKB3_P cml_tlatch_88.xtail.S1 VSS sg13_lv_nmos ad=89.3f pd=0.85u as=89.3f ps=0.85u w=0.47u l=0.16u
X2298 cml_tlatch_90.xtail.S1 CKB2_N cml_tlatch_90.xmux.xn.S1 VSS sg13_lv_nmos ad=89.3f pd=0.85u as=89.3f ps=0.85u w=0.47u l=0.16u
X2299 cml_tlatch_61.xmux.xp.S1 cml_tlatch_61.OUTP cml_tlatch_61.OUTN VSS sg13_lv_nmos ad=56.9f pd=0.74u as=56.9f ps=0.74u w=0.17u l=0.17u
X2300 cml_tlatch_32.xmux.xp.S1 cml_tlatch_32.OUTP cml_tlatch_32.OUTN VSS sg13_lv_nmos ad=56.9f pd=0.74u as=56.9f ps=0.74u w=0.17u l=0.17u
X2301 A0_8_P cml_tlatch_18.OUTN cml_tlatch_9.xmux.xn.S1 VSS sg13_lv_nmos ad=63.19999f pd=0.74u as=63.19999f ps=0.74u w=0.26u l=0.38u
X2302 cml_tlatch_48.xmux.xn.S1 D2_P stub_bi_43.BOTP VSS sg13_lv_nmos ad=63.19999f pd=0.74u as=63.19999f ps=0.74u w=0.26u l=0.38u
X2303 CKHA3_N GA3_P cml_drvb_4.xrtail.R2 VSS sg13_lv_nmos ad=0.2618p pd=2.22u as=0.1463p ps=1.15u w=0.77u l=0.21u
X2304 cml_tlatch_80.xmux.xn.S1 CKHB2_P cml_tlatch_80.xtail.S1 VSS sg13_lv_nmos ad=89.3f pd=0.85u as=0.1598p ps=1.62u w=0.47u l=0.16u
X2305 cml_tlatch_84.xtail.S1 CKB2_N cml_tlatch_84.xmux.xp.S1 VSS sg13_lv_nmos ad=89.3f pd=0.85u as=89.3f ps=0.85u w=0.47u l=0.16u
X2306 MOT10_P MOT10_N cml_tlatch_43.xmux.xp.S1 VSS sg13_lv_nmos ad=56.9f pd=0.74u as=56.9f ps=0.74u w=0.17u l=0.17u
X2307 ENA1_N ENA_P cml_drv_1.xrtail.R1 VSS sg13_lv_nmos ad=56.2f pd=0.74u as=56.2f ps=0.74u w=0.16u l=0.19u
X2308 GB3_P ENB0_N cml_gate2_6.xamp.xn.S1 VSS sg13_lv_nmos ad=0.1007p pd=0.91u as=0.1007p ps=0.91u w=0.53u l=0.13u
X2309 cml_tlatch_87.OUTP cml_tlatch_87.OUTN cml_tlatch_87.xmux.xp.S1 VSS sg13_lv_nmos ad=56.9f pd=0.74u as=56.9f ps=0.74u w=0.17u l=0.17u
X2310 B3_8_P B3_8_N cml_tlatch_64.xmux.xp.S1 VSS sg13_lv_nmos ad=56.9f pd=0.74u as=56.9f ps=0.74u w=0.17u l=0.17u
X2311 cml_tlatch_91.xmux.xp.S1 cml_tlatch_91.OUTN cml_tlatch_91.OUTP VSS sg13_lv_nmos ad=56.9f pd=0.74u as=56.9f ps=0.74u w=0.17u l=0.17u
X2312 A1_2_N A1_2_P cml_tlatch_40.xmux.xp.S1 VSS sg13_lv_nmos ad=56.9f pd=0.74u as=56.9f ps=0.74u w=0.17u l=0.17u
X2313 cml_tlatch_87.INP cml_tlatch_91.OUTN cml_tlatch_76.xmux.xn.S1 VSS sg13_lv_nmos ad=63.19999f pd=0.74u as=63.19999f ps=0.74u w=0.26u l=0.38u
X2314 VSS POLN cml_tlatch_50.xtail.S1 VSS sg13_lv_nmos ad=1.5637p pd=8.61u as=1.5637p ps=8.61u w=8.23u l=0.13u
X2315 cml_tlatch_23.xmux.xn.S1 cml_tlatch_0.OUTN cml_tlatch_23.OUTP VSS sg13_lv_nmos ad=63.19999f pd=0.74u as=63.19999f ps=0.74u w=0.26u l=0.38u
X2316 cml_tlatch_25.xmux.xn.S1 A1_2_N MOT14_P VSS sg13_lv_nmos ad=63.19999f pd=0.74u as=63.19999f ps=0.74u w=0.26u l=0.38u
X2317 cml_tlatch_35.xmux.xn.S1 B1_2_N stub_bi_29.BOTN VSS sg13_lv_nmos ad=63.19999f pd=0.74u as=63.19999f ps=0.74u w=0.26u l=0.38u
X2318 cml_tlatch_62.xmux.xp.S1 MOT24_P MOT24_N VSS sg13_lv_nmos ad=56.9f pd=0.74u as=56.9f ps=0.74u w=0.17u l=0.17u
X2319 VSS POLN cml_tlatch_39.xtail.S1 VSS sg13_lv_nmos ad=1.5637p pd=8.61u as=1.5637p ps=8.61u w=8.23u l=0.13u
X2320 cml_tlatch_39.xtail.S1 CKA1_N cml_tlatch_39.xmux.xp.S1 VSS sg13_lv_nmos ad=89.3f pd=0.85u as=89.3f ps=0.85u w=0.47u l=0.16u
X2321 cml_gate2_9.xamp.xn.S1 NM1_P cml_gate2_9.xrtail.R1 VSS sg13_lv_nmos ad=0.1802p pd=1.74u as=0.1007p ps=0.91u w=0.53u l=0.13u
X2322 CKA2_N CK_N hs_to_clk_7.D2 VSS sg13_lv_nmos ad=0.408p pd=3.08u as=0.228p ps=1.58u w=1.2u l=0.2u
X2323 cml_tlatch_35.xmux.xn.S1 B1_2_N stub_bi_29.BOTN VSS sg13_lv_nmos ad=63.19999f pd=0.74u as=63.19999f ps=0.74u w=0.26u l=0.38u
X2324 VSS POLN cml_tlatch_65.xtail.S1 VSS sg13_lv_nmos ad=2.7982p pd=17.14u as=1.5637p ps=8.61u w=8.23u l=0.13u
X2325 cml_tlatch_75.xmux.xn.S1 CKHB3_P cml_tlatch_75.xtail.S1 VSS sg13_lv_nmos ad=89.3f pd=0.85u as=89.3f ps=0.85u w=0.47u l=0.16u
X2326 cml_tlatch_14.xmux.xp.S1 MOT1_N MOT1_P VSS sg13_lv_nmos ad=56.9f pd=0.74u as=56.9f ps=0.74u w=0.17u l=0.17u
X2327 cml_tlatch_10.xmux.xp.S1 B1_8_N B1_8_P VSS sg13_lv_nmos ad=56.9f pd=0.74u as=56.9f ps=0.74u w=0.17u l=0.17u
X2328 cml_tlatch_37.xmux.xp.S1 stub_bi_31.BOTP stub_bi_31.BOTN VSS sg13_lv_nmos ad=56.9f pd=0.74u as=56.9f ps=0.74u w=0.17u l=0.17u
X2329 MOT14_P MOT14_N cml_tlatch_25.xmux.xp.S1 VSS sg13_lv_nmos ad=56.9f pd=0.74u as=56.9f ps=0.74u w=0.17u l=0.17u
X2330 MOT8_N MOT8_P cml_tlatch_42.xmux.xp.S1 VSS sg13_lv_nmos ad=56.9f pd=0.74u as=56.9f ps=0.74u w=0.17u l=0.17u
X2331 cml_tlatch_0.xmux.xp.S1 cml_tlatch_0.OUTN cml_tlatch_0.OUTP VSS sg13_lv_nmos ad=56.9f pd=0.74u as=56.9f ps=0.74u w=0.17u l=0.17u
X2332 cml_tlatch_24.xmux.xp.S1 CKHA1_N cml_tlatch_24.xtail.S1 VSS sg13_lv_nmos ad=89.3f pd=0.85u as=89.3f ps=0.85u w=0.47u l=0.16u
X2333 cml_tlatch_86.OUTP cml_tlatch_86.OUTN cml_tlatch_86.xmux.xp.S1 VSS sg13_lv_nmos ad=56.9f pd=0.74u as=56.9f ps=0.74u w=0.17u l=0.17u
X2334 VSS hs_to_clk_1.sg13_lv_nmos_2HGZLP_0.G VSS VSS sg13_lv_nmos ad=2.071p pd=11.28u as=0 ps=0 w=10.9u l=1.38u
X2335 cml_tlatch_23.xmux.xp.S1 cml_tlatch_23.OUTN cml_tlatch_23.OUTP VSS sg13_lv_nmos ad=56.9f pd=0.74u as=56.9f ps=0.74u w=0.17u l=0.17u
X2336 stub_bi_29.BOTP B1_2_P cml_tlatch_35.xmux.xn.S1 VSS sg13_lv_nmos ad=63.19999f pd=0.74u as=63.19999f ps=0.74u w=0.26u l=0.38u
X2337 cml_tlatch_35.xtail.S1 CKB1_N cml_tlatch_35.xmux.xp.S1 VSS sg13_lv_nmos ad=89.3f pd=0.85u as=89.3f ps=0.85u w=0.47u l=0.16u
X2338 cml_tlatch_80.xmux.xp.S1 MOT23_P MOT23_N VSS sg13_lv_nmos ad=56.9f pd=0.74u as=56.9f ps=0.74u w=0.17u l=0.17u
X2339 VDD MOT7_P VSS rppd l=5.17u w=1u
X2340 MOT2_N MOT2_P cml_tlatch_27.xmux.xp.S1 VSS sg13_lv_nmos ad=56.9f pd=0.74u as=56.9f ps=0.74u w=0.17u l=0.17u
X2341 MOT24_N MOT24_P cml_tlatch_62.xmux.xp.S1 VSS sg13_lv_nmos ad=56.9f pd=0.74u as=56.9f ps=0.74u w=0.17u l=0.17u
X2342 cml_tlatch_75.xmux.xn.S1 B3_2_P MOT31_N VSS sg13_lv_nmos ad=63.19999f pd=0.74u as=63.19999f ps=0.74u w=0.26u l=0.38u
X2343 cml_tlatch_4.xmux.xp.S1 MOT11_N MOT11_P VSS sg13_lv_nmos ad=56.9f pd=0.74u as=56.9f ps=0.74u w=0.17u l=0.17u
X2344 cml_tlatch_24.xmux.xp.S1 MOT12_N MOT12_P VSS sg13_lv_nmos ad=56.9f pd=0.74u as=56.9f ps=0.74u w=0.17u l=0.17u
X2345 cml_tlatch_18.xtail.S1 POLN VSS VSS sg13_lv_nmos ad=1.5637p pd=8.61u as=2.7982p ps=17.14u w=8.23u l=0.13u
X2346 cml_tlatch_9.xmux.xn.S1 CKA0_N cml_tlatch_9.xtail.S1 VSS sg13_lv_nmos ad=89.3f pd=0.85u as=89.3f ps=0.85u w=0.47u l=0.16u
X2347 MOT24_N A3_8_P cml_tlatch_62.xmux.xn.S1 VSS sg13_lv_nmos ad=63.19999f pd=0.74u as=63.19999f ps=0.74u w=0.26u l=0.38u
X2348 cml_tlatch_63.xmux.xp.S1 MOT26_N MOT26_P VSS sg13_lv_nmos ad=56.9f pd=0.74u as=56.9f ps=0.74u w=0.17u l=0.17u
X2349 cml_tlatch_38.xmux.xp.S1 cml_tlatch_38.OUTN cml_tlatch_38.OUTP VSS sg13_lv_nmos ad=56.9f pd=0.74u as=56.9f ps=0.74u w=0.17u l=0.17u
X2350 cml_tlatch_57.xmux.xp.S1 A3_2_P A3_2_N VSS sg13_lv_nmos ad=56.9f pd=0.74u as=56.9f ps=0.74u w=0.17u l=0.17u
X2351 cml_tlatch_90.xmux.xp.S1 stub_bi_55.BOTP stub_bi_55.BOTN VSS sg13_lv_nmos ad=56.9f pd=0.74u as=56.9f ps=0.74u w=0.17u l=0.17u
X2352 cml_tlatch_7.xmux.xp.S1 cml_tlatch_7.OUTP cml_tlatch_7.OUTN VSS sg13_lv_nmos ad=56.9f pd=0.74u as=56.9f ps=0.74u w=0.17u l=0.17u
X2353 cml_tlatch_95.xtail.S1 CKJ_N cml_tlatch_95.xmux.xp.S1 VSS sg13_lv_nmos ad=89.3f pd=0.85u as=89.3f ps=0.85u w=0.47u l=0.16u
X2354 B3_2_N B3_2_P cml_tlatch_50.xmux.xp.S1 VSS sg13_lv_nmos ad=56.9f pd=0.74u as=56.9f ps=0.74u w=0.17u l=0.17u
X2355 cml_tlatch_79.xmux.xn.S1 stub_bi_55.BOTN MOT21_N VSS sg13_lv_nmos ad=63.19999f pd=0.74u as=63.19999f ps=0.74u w=0.26u l=0.38u
X2356 cml_tlatch_77.xmux.xn.S1 CKHB2_P cml_tlatch_77.xtail.S1 VSS sg13_lv_nmos ad=89.3f pd=0.85u as=0.1598p ps=1.62u w=0.47u l=0.16u
X2357 cml_drvb_1.xrtail.R2 GB0_N CKHB0_P VSS sg13_lv_nmos ad=0.1463p pd=1.15u as=0.2618p ps=2.22u w=0.77u l=0.21u
X2358 cml_tlatch_6.xmux.xp.S1 CKHB1_N cml_tlatch_6.xtail.S1 VSS sg13_lv_nmos ad=89.3f pd=0.85u as=89.3f ps=0.85u w=0.47u l=0.16u
X2359 cml_tlatch_48.xtail.S1 CKB2_P cml_tlatch_48.xmux.xn.S1 VSS sg13_lv_nmos ad=89.3f pd=0.85u as=89.3f ps=0.85u w=0.47u l=0.16u
X2360 cml_tlatch_3.xmux.xp.S1 MOT9_P MOT9_N VSS sg13_lv_nmos ad=56.9f pd=0.74u as=56.9f ps=0.74u w=0.17u l=0.17u
X2361 cml_tlatch_20.xmux.xn.S1 cml_tlatch_43.INP cml_tlatch_20.OUTN VSS sg13_lv_nmos ad=63.19999f pd=0.74u as=63.19999f ps=0.74u w=0.26u l=0.38u
X2362 cml_tlatch_64.xmux.xn.S1 cml_tlatch_65.OUTN B3_8_P VSS sg13_lv_nmos ad=63.19999f pd=0.74u as=63.19999f ps=0.74u w=0.26u l=0.38u
X2363 cml_tlatch_59.xmux.xp.S1 CKA2_N cml_tlatch_59.xtail.S1 VSS sg13_lv_nmos ad=89.3f pd=0.85u as=89.3f ps=0.85u w=0.47u l=0.16u
X2364 cml_tlatch_65.xmux.xp.S1 CKB3_N cml_tlatch_65.xtail.S1 VSS sg13_lv_nmos ad=89.3f pd=0.85u as=89.3f ps=0.85u w=0.47u l=0.16u
X2365 cml_tlatch_36.xmux.xp.S1 B1_2_P B1_2_N VSS sg13_lv_nmos ad=56.9f pd=0.74u as=56.9f ps=0.74u w=0.17u l=0.17u
X2366 B0_2_P B0_2_N cml_tlatch_31.xmux.xp.S1 VSS sg13_lv_nmos ad=56.9f pd=0.74u as=56.9f ps=0.74u w=0.17u l=0.17u
X2367 cml_tlatch_12.xtail.S1 CKB1_P cml_tlatch_12.xmux.xp.S1 VSS sg13_lv_nmos ad=89.3f pd=0.85u as=89.3f ps=0.85u w=0.47u l=0.16u
X2368 VSS cml_gate2_8.xrtail.R1 VSS rppd l=4.86u w=1u
X2369 cml_tlatch_73.xmux.xp.S1 MOT27_N MOT27_P VSS sg13_lv_nmos ad=56.9f pd=0.74u as=56.9f ps=0.74u w=0.17u l=0.17u
X2370 cml_gate2_5.xamp.xn.S1 CKB2_P cml_gate2_5.xrtail.R1 VSS sg13_lv_nmos ad=0.1007p pd=0.91u as=0.1007p ps=0.91u w=0.53u l=0.13u
X2371 cml_tlatch_8.xmux.xp.S1 CKB0_N cml_tlatch_8.xtail.S1 VSS sg13_lv_nmos ad=89.3f pd=0.85u as=89.3f ps=0.85u w=0.47u l=0.16u
X2372 cml_tlatch_71.OUTN cml_tlatch_71.OUTP cml_tlatch_71.xmux.xp.S1 VSS sg13_lv_nmos ad=56.9f pd=0.74u as=56.9f ps=0.74u w=0.17u l=0.17u
X2373 cml_tlatch_47.xtail.S1 POLN VSS VSS sg13_lv_nmos ad=1.5637p pd=8.61u as=1.5637p ps=8.61u w=8.23u l=0.13u
X2374 cml_tlatch_41.xmux.xp.S1 CKA1_N cml_tlatch_41.xtail.S1 VSS sg13_lv_nmos ad=89.3f pd=0.85u as=0.1598p ps=1.62u w=0.47u l=0.16u
X2375 cml_tlatch_72.xmux.xn.S1 CKHB3_P cml_tlatch_72.xtail.S1 VSS sg13_lv_nmos ad=89.3f pd=0.85u as=89.3f ps=0.85u w=0.47u l=0.16u
X2376 MOT25_P MOT25_N cml_tlatch_72.xmux.xp.S1 VSS sg13_lv_nmos ad=56.9f pd=0.74u as=56.9f ps=0.74u w=0.17u l=0.17u
X2377 cml_tlatch_61.OUTP cml_tlatch_61.OUTN cml_tlatch_61.xmux.xp.S1 VSS sg13_lv_nmos ad=56.9f pd=0.74u as=56.9f ps=0.74u w=0.17u l=0.17u
X2378 cml_tlatch_66.xmux.xn.S1 CKB3_N cml_tlatch_66.xtail.S1 VSS sg13_lv_nmos ad=89.3f pd=0.85u as=89.3f ps=0.85u w=0.47u l=0.16u
X2379 cml_gate2_9.xrtail.R1 NM1_P cml_gate2_9.xamp.xn.S1 VSS sg13_lv_nmos ad=0.1007p pd=0.91u as=0.1007p ps=0.91u w=0.53u l=0.13u
X2380 cml_tlatch_87.OUTN cml_tlatch_87.OUTP cml_tlatch_87.xmux.xp.S1 VSS sg13_lv_nmos ad=56.9f pd=0.74u as=56.9f ps=0.74u w=0.17u l=0.17u
X2381 A1_8_N cml_tlatch_20.OUTP cml_tlatch_19.xmux.xn.S1 VSS sg13_lv_nmos ad=63.19999f pd=0.74u as=63.19999f ps=0.74u w=0.26u l=0.38u
X2382 cml_tlatch_83.xmux.xp.S1 stub_bi_63.BOTP stub_bi_63.BOTN VSS sg13_lv_nmos ad=0.1019p pd=1.34u as=56.9f ps=0.74u w=0.17u l=0.17u
X2383 VDD MOT21_P VSS rppd l=5.17u w=1u
X2384 cml_tlatch_22.xmux.xp.S1 cml_tlatch_22.OUTP cml_tlatch_22.OUTN VSS sg13_lv_nmos ad=56.9f pd=0.74u as=56.9f ps=0.74u w=0.17u l=0.17u
X2385 cml_tlatch_18.xmux.xp.S1 cml_tlatch_18.OUTN cml_tlatch_18.OUTP VSS sg13_lv_nmos ad=56.9f pd=0.74u as=56.9f ps=0.74u w=0.17u l=0.17u
X2386 cml_tlatch_15.xmux.xp.S1 MOT3_P MOT3_N VSS sg13_lv_nmos ad=56.9f pd=0.74u as=56.9f ps=0.74u w=0.17u l=0.17u
X2387 stub_bi_17.BOTP stub_bi_17.BOTN cml_tlatch_13.xmux.xp.S1 VSS sg13_lv_nmos ad=56.9f pd=0.74u as=56.9f ps=0.74u w=0.17u l=0.17u
X2388 cml_tlatch_34.xtail.S1 CKA0_P cml_tlatch_34.xmux.xp.S1 VSS sg13_lv_nmos ad=89.3f pd=0.85u as=89.3f ps=0.85u w=0.47u l=0.16u
X2389 VSS hs_to_clk_6.sg13_lv_nmos_2HGZLP_0.G VSS VSS sg13_lv_nmos ad=2.071p pd=11.28u as=0 ps=0 w=10.9u l=1.38u
X2390 cml_gate2_1.xrtail.R1 CKA0_P cml_gate2_1.xamp.xn.S1 VSS sg13_lv_nmos ad=0.1007p pd=0.91u as=0.1007p ps=0.91u w=0.53u l=0.13u
X2391 cml_tlatch_30.OUTN B0_2_P cml_tlatch_30.xmux.xn.S1 VSS sg13_lv_nmos ad=63.19999f pd=0.74u as=63.19999f ps=0.74u w=0.26u l=0.38u
X2392 cml_tlatch_98.OUTP cml_tlatch_98.OUTN cml_tlatch_98.xmux.xp.S1 VSS sg13_lv_nmos ad=56.9f pd=0.74u as=56.9f ps=0.74u w=0.17u l=0.17u
X2393 MOT13_P MOT13_N cml_tlatch_5.xmux.xp.S1 VSS sg13_lv_nmos ad=56.9f pd=0.74u as=56.9f ps=0.74u w=0.17u l=0.17u
X2394 cml_tlatch_44.xmux.xn.S1 cml_tlatch_44.INN MOT28_P VSS sg13_lv_nmos ad=63.19999f pd=0.74u as=63.19999f ps=0.74u w=0.26u l=0.38u
X2395 MOT23_P MOT23_N cml_tlatch_80.xmux.xp.S1 VSS sg13_lv_nmos ad=56.9f pd=0.74u as=56.9f ps=0.74u w=0.17u l=0.17u
X2396 cml_tlatch_18.xmux.xn.S1 cml_tlatch_23.OUTN cml_tlatch_18.OUTP VSS sg13_lv_nmos ad=63.19999f pd=0.74u as=63.19999f ps=0.74u w=0.26u l=0.38u
X2397 cml_tlatch_90.xmux.xn.S1 CKB2_N cml_tlatch_90.xtail.S1 VSS sg13_lv_nmos ad=89.3f pd=0.85u as=89.3f ps=0.85u w=0.47u l=0.16u
X2398 cml_tlatch_86.OUTP cml_tlatch_86.OUTN cml_tlatch_86.xmux.xp.S1 VSS sg13_lv_nmos ad=56.9f pd=0.74u as=56.9f ps=0.74u w=0.17u l=0.17u
X2399 cml_tlatch_82.xmux.xp.S1 stub_bi_62.BOTP stub_bi_62.BOTN VSS sg13_lv_nmos ad=56.9f pd=0.74u as=56.9f ps=0.74u w=0.17u l=0.17u
X2400 cml_tlatch_15.xmux.xp.S1 CKHB0_N cml_tlatch_15.xtail.S1 VSS sg13_lv_nmos ad=89.3f pd=0.85u as=89.3f ps=0.85u w=0.47u l=0.16u
X2401 cml_tlatch_87.OUTP cml_tlatch_87.INN cml_tlatch_87.xmux.xn.S1 VSS sg13_lv_nmos ad=63.19999f pd=0.74u as=0.1082p ps=1.34u w=0.26u l=0.38u
X2402 cml_tlatch_89.xmux.xn.S1 CKA3_N cml_tlatch_89.xtail.S1 VSS sg13_lv_nmos ad=89.3f pd=0.85u as=0.1598p ps=1.62u w=0.47u l=0.16u
X2403 cml_tlatch_44.xmux.xn.S1 cml_tlatch_44.INN MOT28_P VSS sg13_lv_nmos ad=63.19999f pd=0.74u as=63.19999f ps=0.74u w=0.26u l=0.38u
X2404 cml_tlatch_70.xtail.S1 CKA3_P cml_tlatch_70.xmux.xp.S1 VSS sg13_lv_nmos ad=89.3f pd=0.85u as=89.3f ps=0.85u w=0.47u l=0.16u
X2405 cml_tlatch_62.xmux.xp.S1 MOT24_N MOT24_P VSS sg13_lv_nmos ad=0.1019p pd=1.34u as=56.9f ps=0.74u w=0.17u l=0.17u
X2406 MOT15_P MOT15_N cml_tlatch_6.xmux.xp.S1 VSS sg13_lv_nmos ad=56.9f pd=0.74u as=56.9f ps=0.74u w=0.17u l=0.17u
X2407 cml_tlatch_78.xtail.S1 POLN VSS VSS sg13_lv_nmos ad=1.5637p pd=8.61u as=1.5637p ps=8.61u w=8.23u l=0.13u
X2408 VDD cml_tlatch_86.OUTP VSS rppd l=5.17u w=1u
X2409 cml_tlatch_27.xmux.xn.S1 cml_tlatch_23.OUTP MOT2_N VSS sg13_lv_nmos ad=63.19999f pd=0.74u as=63.19999f ps=0.74u w=0.26u l=0.38u
X2410 cml_drv_3.xrtail.R1 ENA_N ENA0_P VSS sg13_lv_nmos ad=56.2f pd=0.74u as=56.2f ps=0.74u w=0.16u l=0.19u
X2411 cml_gate2_2.xamp.xn.S1 CKB1_P cml_gate2_2.xrtail.R1 VSS sg13_lv_nmos ad=0.1007p pd=0.91u as=0.1007p ps=0.91u w=0.53u l=0.13u
X2412 MOT29_P MOT29_N cml_tlatch_74.xmux.xp.S1 VSS sg13_lv_nmos ad=56.9f pd=0.74u as=56.9f ps=0.74u w=0.17u l=0.17u
X2413 cml_gate2_7.xamp.xn.S1 ENB0_P GB2_N VSS sg13_lv_nmos ad=0.1007p pd=0.91u as=0.1007p ps=0.91u w=0.53u l=0.13u
X2414 cml_tlatch_27.xmux.xn.S1 cml_tlatch_23.OUTP MOT2_N VSS sg13_lv_nmos ad=63.19999f pd=0.74u as=63.19999f ps=0.74u w=0.26u l=0.38u
X2415 cml_tlatch_92.xtail.S1 CKJ_P cml_tlatch_92.xmux.xp.S1 VSS sg13_lv_nmos ad=89.3f pd=0.85u as=89.3f ps=0.85u w=0.47u l=0.16u
X2416 cml_tlatch_8.OUTN VDD VSS rppd l=5.17u w=1u
X2417 cml_tlatch_71.xmux.xp.S1 cml_tlatch_71.OUTN cml_tlatch_71.OUTP VSS sg13_lv_nmos ad=56.9f pd=0.74u as=56.9f ps=0.74u w=0.17u l=0.17u
X2418 cml_tlatch_0.OUTP cml_tlatch_99.OUTN cml_tlatch_0.xmux.xn.S1 VSS sg13_lv_nmos ad=63.19999f pd=0.74u as=0.1082p ps=1.34u w=0.26u l=0.38u
X2419 cml_tlatch_3.xmux.xp.S1 CKHB1_N cml_tlatch_3.xtail.S1 VSS sg13_lv_nmos ad=89.3f pd=0.85u as=89.3f ps=0.85u w=0.47u l=0.16u
X2420 cml_tlatch_89.xmux.xp.S1 cml_tlatch_44.INP cml_tlatch_44.INN VSS sg13_lv_nmos ad=56.9f pd=0.74u as=56.9f ps=0.74u w=0.17u l=0.17u
X2421 VSS POLN cml_tlatch_91.xtail.S1 VSS sg13_lv_nmos ad=1.5637p pd=8.61u as=1.5637p ps=8.61u w=8.23u l=0.13u
X2422 cml_tlatch_74.INN cml_tlatch_74.INP cml_tlatch_88.xmux.xp.S1 VSS sg13_lv_nmos ad=56.9f pd=0.74u as=56.9f ps=0.74u w=0.17u l=0.17u
X2423 A3_2_P cml_tlatch_58.OUTN cml_tlatch_57.xmux.xn.S1 VSS sg13_lv_nmos ad=63.19999f pd=0.74u as=0.1082p ps=1.34u w=0.26u l=0.38u
X2424 cml_tlatch_58.xmux.xp.S1 cml_tlatch_58.OUTP cml_tlatch_58.OUTN VSS sg13_lv_nmos ad=0.1019p pd=1.34u as=56.9f ps=0.74u w=0.17u l=0.17u
X2425 cml_tlatch_61.xtail.S1 CKA2_N cml_tlatch_61.xmux.xp.S1 VSS sg13_lv_nmos ad=89.3f pd=0.85u as=89.3f ps=0.85u w=0.47u l=0.16u
X2426 cml_tlatch_30.OUTP cml_tlatch_30.OUTN cml_tlatch_30.xmux.xp.S1 VSS sg13_lv_nmos ad=56.9f pd=0.74u as=56.9f ps=0.74u w=0.17u l=0.17u
X2427 MOT5_N MOT5_P cml_tlatch_16.xmux.xp.S1 VSS sg13_lv_nmos ad=56.9f pd=0.74u as=56.9f ps=0.74u w=0.17u l=0.17u
X2428 cml_tlatch_24.INP cml_tlatch_24.INN cml_tlatch_97.xmux.xp.S1 VSS sg13_lv_nmos ad=56.9f pd=0.74u as=56.9f ps=0.74u w=0.17u l=0.17u
X2429 B1_2_P B1_2_N cml_tlatch_36.xmux.xp.S1 VSS sg13_lv_nmos ad=56.9f pd=0.74u as=56.9f ps=0.74u w=0.17u l=0.17u
X2430 MOT19_N MOT19_P cml_tlatch_78.xmux.xp.S1 VSS sg13_lv_nmos ad=56.9f pd=0.74u as=0.1019p ps=1.34u w=0.17u l=0.17u
X2431 cml_tlatch_25.xtail.S1 CKHA1_P cml_tlatch_25.xmux.xn.S1 VSS sg13_lv_nmos ad=89.3f pd=0.85u as=89.3f ps=0.85u w=0.47u l=0.16u
X2432 MOT20_N MOT20_P cml_tlatch_54.xmux.xp.S1 VSS sg13_lv_nmos ad=56.9f pd=0.74u as=56.9f ps=0.74u w=0.17u l=0.17u
X2433 cml_tlatch_31.xtail.S1 CKB0_N cml_tlatch_31.xmux.xn.S1 VSS sg13_lv_nmos ad=89.3f pd=0.85u as=89.3f ps=0.85u w=0.47u l=0.16u
X2434 cml_tlatch_24.xtail.S1 CKHA1_P cml_tlatch_24.xmux.xn.S1 VSS sg13_lv_nmos ad=89.3f pd=0.85u as=89.3f ps=0.85u w=0.47u l=0.16u
X2435 cml_tlatch_44.xmux.xp.S1 MOT28_P MOT28_N VSS sg13_lv_nmos ad=56.9f pd=0.74u as=56.9f ps=0.74u w=0.17u l=0.17u
X2436 cml_tlatch_43.xmux.xn.S1 cml_tlatch_43.INN MOT10_P VSS sg13_lv_nmos ad=63.19999f pd=0.74u as=63.19999f ps=0.74u w=0.26u l=0.38u
X2437 cml_tlatch_22.xmux.xn.S1 CKA1_P cml_tlatch_22.xtail.S1 VSS sg13_lv_nmos ad=89.3f pd=0.85u as=89.3f ps=0.85u w=0.47u l=0.16u
X2438 cml_gate2_3.xrtail.R1 VSS VSS rppd l=4.86u w=1u
X2439 MOT26_P cml_tlatch_63.INN cml_tlatch_63.xmux.xn.S1 VSS sg13_lv_nmos ad=63.19999f pd=0.74u as=63.19999f ps=0.74u w=0.26u l=0.38u
X2440 GA2_P ENA1_N cml_gate2_5.xamp.xn.S1 VSS sg13_lv_nmos ad=0.1007p pd=0.91u as=0.1007p ps=0.91u w=0.53u l=0.13u
X2441 cml_tlatch_97.xmux.xp.S1 CKA1_P cml_tlatch_97.xtail.S1 VSS sg13_lv_nmos ad=89.3f pd=0.85u as=89.3f ps=0.85u w=0.47u l=0.16u
X2442 cml_tlatch_67.xmux.xp.S1 cml_tlatch_67.OUTP cml_tlatch_67.OUTN VSS sg13_lv_nmos ad=56.9f pd=0.74u as=56.9f ps=0.74u w=0.17u l=0.17u
X2443 cml_tlatch_81.xmux.xp.S1 B2_8_N B2_8_P VSS sg13_lv_nmos ad=56.9f pd=0.74u as=56.9f ps=0.74u w=0.17u l=0.17u
X2444 cml_tlatch_61.OUTP cml_tlatch_61.OUTN cml_tlatch_61.xmux.xp.S1 VSS sg13_lv_nmos ad=56.9f pd=0.74u as=56.9f ps=0.74u w=0.17u l=0.17u
X2445 MOT8_P VDD VSS rppd l=5.17u w=1u
X2446 cml_tlatch_48.xmux.xp.S1 stub_bi_43.BOTP stub_bi_43.BOTN VSS sg13_lv_nmos ad=56.9f pd=0.74u as=56.9f ps=0.74u w=0.17u l=0.17u
X2447 B3_2_P B3_2_N cml_tlatch_50.xmux.xp.S1 VSS sg13_lv_nmos ad=56.9f pd=0.74u as=56.9f ps=0.74u w=0.17u l=0.17u
X2448 cml_tlatch_57.xmux.xp.S1 CKA3_P cml_tlatch_57.xtail.S1 VSS sg13_lv_nmos ad=89.3f pd=0.85u as=89.3f ps=0.85u w=0.47u l=0.16u
X2449 cml_tlatch_81.xmux.xp.S1 CKB2_P cml_tlatch_81.xtail.S1 VSS sg13_lv_nmos ad=89.3f pd=0.85u as=89.3f ps=0.85u w=0.47u l=0.16u
X2450 cml_tlatch_26.xtail.S1 CKHA0_P cml_tlatch_26.xmux.xn.S1 VSS sg13_lv_nmos ad=89.3f pd=0.85u as=89.3f ps=0.85u w=0.47u l=0.16u
X2451 cml_tlatch_8.xmux.xp.S1 cml_tlatch_8.OUTP cml_tlatch_8.OUTN VSS sg13_lv_nmos ad=56.9f pd=0.74u as=56.9f ps=0.74u w=0.17u l=0.17u
X2452 cml_tlatch_33.xtail.S1 CKA0_N cml_tlatch_33.xmux.xp.S1 VSS sg13_lv_nmos ad=89.3f pd=0.85u as=89.3f ps=0.85u w=0.47u l=0.16u
X2453 cml_gate2_4.xrtail.R1 CKB3_N GA3_P VSS sg13_lv_nmos ad=0.1007p pd=0.91u as=0.1007p ps=0.91u w=0.53u l=0.13u
X2454 MOT0_N A0_8_P cml_tlatch_26.xmux.xn.S1 VSS sg13_lv_nmos ad=63.19999f pd=0.74u as=63.19999f ps=0.74u w=0.26u l=0.38u
X2455 cml_tlatch_18.OUTN cml_tlatch_18.OUTP cml_tlatch_18.xmux.xp.S1 VSS sg13_lv_nmos ad=56.9f pd=0.74u as=56.9f ps=0.74u w=0.17u l=0.17u
X2456 cml_tlatch_43.INN cml_tlatch_43.INP cml_tlatch_21.xmux.xp.S1 VSS sg13_lv_nmos ad=56.9f pd=0.74u as=56.9f ps=0.74u w=0.17u l=0.17u
X2457 stub_bi_17.BOTP stub_bi_17.BOTN cml_tlatch_13.xmux.xp.S1 VSS sg13_lv_nmos ad=56.9f pd=0.74u as=56.9f ps=0.74u w=0.17u l=0.17u
X2458 cml_tlatch_51.xmux.xp.S1 cml_tlatch_51.OUTP cml_tlatch_51.OUTN VSS sg13_lv_nmos ad=56.9f pd=0.74u as=56.9f ps=0.74u w=0.17u l=0.17u
X2459 CKHB3_N GB3_P cml_drvb_6.xrtail.R2 VSS sg13_lv_nmos ad=0.2618p pd=2.22u as=0.1463p ps=1.15u w=0.77u l=0.21u
X2460 cml_tlatch_2.OUTP cml_tlatch_2.OUTN cml_tlatch_2.xmux.xp.S1 VSS sg13_lv_nmos ad=56.9f pd=0.74u as=0.1019p ps=1.34u w=0.17u l=0.17u
X2461 cml_tlatch_0.xmux.xp.S1 CKA0_N cml_tlatch_0.xtail.S1 VSS sg13_lv_nmos ad=89.3f pd=0.85u as=0.1598p ps=1.62u w=0.47u l=0.16u
X2462 cml_tlatch_3.xmux.xp.S1 MOT9_N MOT9_P VSS sg13_lv_nmos ad=56.9f pd=0.74u as=56.9f ps=0.74u w=0.17u l=0.17u
X2463 cml_tlatch_67.xmux.xn.S1 cml_tlatch_74.INN cml_tlatch_67.OUTP VSS sg13_lv_nmos ad=63.19999f pd=0.74u as=0.1082p ps=1.34u w=0.26u l=0.38u
X2464 cml_tlatch_0.xmux.xn.S1 CKA0_P cml_tlatch_0.xtail.S1 VSS sg13_lv_nmos ad=89.3f pd=0.85u as=89.3f ps=0.85u w=0.47u l=0.16u
X2465 cml_tlatch_23.OUTN cml_tlatch_0.OUTP cml_tlatch_23.xmux.xn.S1 VSS sg13_lv_nmos ad=0.1082p pd=1.34u as=63.19999f ps=0.74u w=0.26u l=0.38u
X2466 cml_tlatch_96.xmux.xp.S1 CKB1_P cml_tlatch_96.xtail.S1 VSS sg13_lv_nmos ad=89.3f pd=0.85u as=89.3f ps=0.85u w=0.47u l=0.16u
X2467 cml_tlatch_50.xmux.xp.S1 CKB3_P cml_tlatch_50.xtail.S1 VSS sg13_lv_nmos ad=89.3f pd=0.85u as=89.3f ps=0.85u w=0.47u l=0.16u
X2468 MOT19_N MOT19_P cml_tlatch_78.xmux.xp.S1 VSS sg13_lv_nmos ad=56.9f pd=0.74u as=56.9f ps=0.74u w=0.17u l=0.17u
X2469 cml_tlatch_98.xmux.xp.S1 cml_tlatch_98.OUTP cml_tlatch_98.OUTN VSS sg13_lv_nmos ad=56.9f pd=0.74u as=56.9f ps=0.74u w=0.17u l=0.17u
X2470 B0_8_N VDD VSS rppd l=5.17u w=1u
X2471 cml_tlatch_23.OUTN cml_tlatch_0.OUTP cml_tlatch_23.xmux.xn.S1 VSS sg13_lv_nmos ad=63.19999f pd=0.74u as=63.19999f ps=0.74u w=0.26u l=0.38u
X2472 cml_tlatch_6.xmux.xn.S1 B1_2_N MOT15_P VSS sg13_lv_nmos ad=63.19999f pd=0.74u as=63.19999f ps=0.74u w=0.26u l=0.38u
X2473 A3_8_P A3_8_N cml_tlatch_68.xmux.xp.S1 VSS sg13_lv_nmos ad=56.9f pd=0.74u as=0.1019p ps=1.34u w=0.17u l=0.17u
X2474 cml_tlatch_41.xmux.xn.S1 D1_P cml_tlatch_41.OUTN VSS sg13_lv_nmos ad=63.19999f pd=0.74u as=63.19999f ps=0.74u w=0.26u l=0.38u
X2475 hs_to_clk_3.D2 CK_P CKA1_P VSS sg13_lv_nmos ad=0.228p pd=1.58u as=0.228p ps=1.58u w=1.2u l=0.2u
X2476 cml_tlatch_12.xmux.xp.S1 CKB1_P cml_tlatch_12.xtail.S1 VSS sg13_lv_nmos ad=89.3f pd=0.85u as=89.3f ps=0.85u w=0.47u l=0.16u
X2477 cml_tlatch_55.xmux.xp.S1 MOT22_N MOT22_P VSS sg13_lv_nmos ad=56.9f pd=0.74u as=56.9f ps=0.74u w=0.17u l=0.17u
X2478 cml_tlatch_52.xmux.xp.S1 MOT16_P MOT16_N VSS sg13_lv_nmos ad=56.9f pd=0.74u as=56.9f ps=0.74u w=0.17u l=0.17u
X2479 MOT8_P A1_8_N cml_tlatch_42.xmux.xn.S1 VSS sg13_lv_nmos ad=63.19999f pd=0.74u as=63.19999f ps=0.74u w=0.26u l=0.38u
X2480 cml_tlatch_10.xmux.xp.S1 B1_8_P B1_8_N VSS sg13_lv_nmos ad=56.9f pd=0.74u as=56.9f ps=0.74u w=0.17u l=0.17u
X2481 cml_tlatch_79.xmux.xp.S1 MOT21_P MOT21_N VSS sg13_lv_nmos ad=56.9f pd=0.74u as=56.9f ps=0.74u w=0.17u l=0.17u
X2482 cml_tlatch_38.xmux.xp.S1 cml_tlatch_38.OUTP cml_tlatch_38.OUTN VSS sg13_lv_nmos ad=56.9f pd=0.74u as=56.9f ps=0.74u w=0.17u l=0.17u
X2483 VSS POLN cml_tlatch_31.xtail.S1 VSS sg13_lv_nmos ad=1.5637p pd=8.61u as=1.5637p ps=8.61u w=8.23u l=0.13u
X2484 cml_tlatch_5.INN cml_tlatch_5.INP cml_tlatch_96.xmux.xp.S1 VSS sg13_lv_nmos ad=56.9f pd=0.74u as=56.9f ps=0.74u w=0.17u l=0.17u
X2485 cml_tlatch_50.xmux.xp.S1 B3_2_N B3_2_P VSS sg13_lv_nmos ad=56.9f pd=0.74u as=56.9f ps=0.74u w=0.17u l=0.17u
X2486 MOT29_N MOT29_P cml_tlatch_74.xmux.xp.S1 VSS sg13_lv_nmos ad=56.9f pd=0.74u as=56.9f ps=0.74u w=0.17u l=0.17u
X2487 cml_tlatch_46.xmux.xp.S1 stub_bi_38.BOTN stub_bi_38.BOTP VSS sg13_lv_nmos ad=56.9f pd=0.74u as=56.9f ps=0.74u w=0.17u l=0.17u
X2488 MOT6_N A0_2_P cml_tlatch_29.xmux.xn.S1 VSS sg13_lv_nmos ad=63.19999f pd=0.74u as=0.1082p ps=1.34u w=0.26u l=0.38u
X2489 MOT15_P MOT15_N cml_tlatch_6.xmux.xp.S1 VSS sg13_lv_nmos ad=56.9f pd=0.74u as=56.9f ps=0.74u w=0.17u l=0.17u
X2490 cml_tlatch_4.xtail.S1 POLN VSS VSS sg13_lv_nmos ad=1.5637p pd=8.61u as=2.7982p ps=17.14u w=8.23u l=0.13u
X2491 cml_tlatch_25.xmux.xp.S1 MOT14_N MOT14_P VSS sg13_lv_nmos ad=56.9f pd=0.74u as=56.9f ps=0.74u w=0.17u l=0.17u
X2492 cml_tlatch_5.xmux.xp.S1 MOT13_P MOT13_N VSS sg13_lv_nmos ad=56.9f pd=0.74u as=56.9f ps=0.74u w=0.17u l=0.17u
X2493 cml_tlatch_88.xmux.xp.S1 cml_tlatch_74.INN cml_tlatch_74.INP VSS sg13_lv_nmos ad=56.9f pd=0.74u as=56.9f ps=0.74u w=0.17u l=0.17u
X2494 hs_to_clk_1.D2 POLN VSS VSS sg13_lv_nmos ad=1.9p pd=10.38u as=1.9p ps=10.38u w=10u l=0.13u
X2495 cml_tlatch_97.xtail.S1 POLN VSS VSS sg13_lv_nmos ad=1.5637p pd=8.61u as=1.5637p ps=8.61u w=8.23u l=0.13u
X2496 J1_N J1_P cml_tlatch_95.xmux.xp.S1 VSS sg13_lv_nmos ad=56.9f pd=0.74u as=56.9f ps=0.74u w=0.17u l=0.17u
X2497 cml_tlatch_35.xmux.xp.S1 stub_bi_29.BOTP stub_bi_29.BOTN VSS sg13_lv_nmos ad=56.9f pd=0.74u as=56.9f ps=0.74u w=0.17u l=0.17u
X2498 cml_tlatch_71.xmux.xn.S1 cml_tlatch_44.INP cml_tlatch_71.OUTN VSS sg13_lv_nmos ad=63.19999f pd=0.74u as=63.19999f ps=0.74u w=0.26u l=0.38u
X2499 cml_tlatch_20.xtail.S1 CKA1_P cml_tlatch_20.xmux.xn.S1 VSS sg13_lv_nmos ad=89.3f pd=0.85u as=89.3f ps=0.85u w=0.47u l=0.16u
X2500 stub_bi_38.BOTP B2_2_P cml_tlatch_46.xmux.xn.S1 VSS sg13_lv_nmos ad=63.19999f pd=0.74u as=63.19999f ps=0.74u w=0.26u l=0.38u
X2501 cml_tlatch_2.OUTP cml_tlatch_2.OUTN cml_tlatch_2.xmux.xp.S1 VSS sg13_lv_nmos ad=56.9f pd=0.74u as=56.9f ps=0.74u w=0.17u l=0.17u
X2502 cml_tlatch_42.xmux.xp.S1 CKHA1_N cml_tlatch_42.xtail.S1 VSS sg13_lv_nmos ad=89.3f pd=0.85u as=89.3f ps=0.85u w=0.47u l=0.16u
X2503 cml_tlatch_94.xmux.xp.S1 J2_N J2_P VSS sg13_lv_nmos ad=56.9f pd=0.74u as=56.9f ps=0.74u w=0.17u l=0.17u
X2504 A2_2_N A2_2_P cml_tlatch_60.xmux.xp.S1 VSS sg13_lv_nmos ad=56.9f pd=0.74u as=56.9f ps=0.74u w=0.17u l=0.17u
X2505 MOT0_N MOT0_P cml_tlatch_26.xmux.xp.S1 VSS sg13_lv_nmos ad=56.9f pd=0.74u as=56.9f ps=0.74u w=0.17u l=0.17u
X2506 cml_tlatch_30.OUTP cml_tlatch_30.OUTN cml_tlatch_30.xmux.xp.S1 VSS sg13_lv_nmos ad=56.9f pd=0.74u as=56.9f ps=0.74u w=0.17u l=0.17u
X2507 cml_tlatch_9.xmux.xn.S1 CKA0_N cml_tlatch_9.xtail.S1 VSS sg13_lv_nmos ad=89.3f pd=0.85u as=89.3f ps=0.85u w=0.47u l=0.16u
X2508 cml_tlatch_25.xmux.xn.S1 A1_2_P MOT14_N VSS sg13_lv_nmos ad=0.1082p pd=1.34u as=63.19999f ps=0.74u w=0.26u l=0.38u
X2509 cml_tlatch_45.xmux.xp.S1 MOT30_P MOT30_N VSS sg13_lv_nmos ad=56.9f pd=0.74u as=56.9f ps=0.74u w=0.17u l=0.17u
X2510 cml_tlatch_85.xmux.xn.S1 CKA2_N cml_tlatch_85.xtail.S1 VSS sg13_lv_nmos ad=89.3f pd=0.85u as=89.3f ps=0.85u w=0.47u l=0.16u
X2511 GA0_N ENA0_P cml_gate2_3.xamp.xn.S1 VSS sg13_lv_nmos ad=0.1802p pd=1.74u as=0.1007p ps=0.91u w=0.53u l=0.13u
X2512 cml_tlatch_26.xmux.xp.S1 MOT0_N MOT0_P VSS sg13_lv_nmos ad=56.9f pd=0.74u as=56.9f ps=0.74u w=0.17u l=0.17u
X2513 cml_tlatch_76.xmux.xp.S1 cml_tlatch_87.INP cml_tlatch_87.INN VSS sg13_lv_nmos ad=56.9f pd=0.74u as=56.9f ps=0.74u w=0.17u l=0.17u
X2514 cml_tlatch_65.xmux.xp.S1 cml_tlatch_65.OUTP cml_tlatch_65.OUTN VSS sg13_lv_nmos ad=56.9f pd=0.74u as=56.9f ps=0.74u w=0.17u l=0.17u
X2515 stub_bi_62.BOTP stub_bi_63.BOTN cml_tlatch_82.xmux.xn.S1 VSS sg13_lv_nmos ad=63.19999f pd=0.74u as=63.19999f ps=0.74u w=0.26u l=0.38u
X2516 A0_8_N A0_8_P cml_tlatch_9.xmux.xp.S1 VSS sg13_lv_nmos ad=56.9f pd=0.74u as=56.9f ps=0.74u w=0.17u l=0.17u
X2517 cml_tlatch_38.xtail.S1 CKA0_P cml_tlatch_38.xmux.xn.S1 VSS sg13_lv_nmos ad=89.3f pd=0.85u as=89.3f ps=0.85u w=0.47u l=0.16u
X2518 cml_tlatch_71.xtail.S1 CKA3_P cml_tlatch_71.xmux.xn.S1 VSS sg13_lv_nmos ad=89.3f pd=0.85u as=89.3f ps=0.85u w=0.47u l=0.16u
X2519 cml_tlatch_20.xmux.xp.S1 CKA1_N cml_tlatch_20.xtail.S1 VSS sg13_lv_nmos ad=89.3f pd=0.85u as=0.1598p ps=1.62u w=0.47u l=0.16u
X2520 cml_tlatch_36.xtail.S1 CKB1_P cml_tlatch_36.xmux.xp.S1 VSS sg13_lv_nmos ad=89.3f pd=0.85u as=89.3f ps=0.85u w=0.47u l=0.16u
X2521 MOT22_P A2_2_N cml_tlatch_55.xmux.xn.S1 VSS sg13_lv_nmos ad=63.19999f pd=0.74u as=0.1082p ps=1.34u w=0.26u l=0.38u
X2522 cml_tlatch_81.xmux.xn.S1 CKB2_N cml_tlatch_81.xtail.S1 VSS sg13_lv_nmos ad=89.3f pd=0.85u as=89.3f ps=0.85u w=0.47u l=0.16u
X2523 cml_tlatch_17.xmux.xp.S1 MOT7_P MOT7_N VSS sg13_lv_nmos ad=56.9f pd=0.74u as=56.9f ps=0.74u w=0.17u l=0.17u
X2524 cml_tlatch_56.OUTP A3_2_N cml_tlatch_56.xmux.xn.S1 VSS sg13_lv_nmos ad=63.19999f pd=0.74u as=63.19999f ps=0.74u w=0.26u l=0.38u
X2525 cml_tlatch_8.xmux.xp.S1 CKB0_N cml_tlatch_8.xtail.S1 VSS sg13_lv_nmos ad=89.3f pd=0.85u as=89.3f ps=0.85u w=0.47u l=0.16u
X2526 cml_tlatch_68.xmux.xn.S1 CKA3_N cml_tlatch_68.xtail.S1 VSS sg13_lv_nmos ad=89.3f pd=0.85u as=89.3f ps=0.85u w=0.47u l=0.16u
X2527 cml_tlatch_8.xmux.xp.S1 cml_tlatch_8.OUTP cml_tlatch_8.OUTN VSS sg13_lv_nmos ad=56.9f pd=0.74u as=56.9f ps=0.74u w=0.17u l=0.17u
X2528 cml_tlatch_93.xtail.S1 CKJ_N cml_tlatch_93.xmux.xp.S1 VSS sg13_lv_nmos ad=89.3f pd=0.85u as=89.3f ps=0.85u w=0.47u l=0.16u
X2529 cml_drv_2.xrtail.R1 ENB_P ENB0_N VSS sg13_lv_nmos ad=56.2f pd=0.74u as=56.2f ps=0.74u w=0.16u l=0.19u
X2530 cml_tlatch_69.OUTP cml_tlatch_69.OUTN cml_tlatch_69.xmux.xp.S1 VSS sg13_lv_nmos ad=56.9f pd=0.74u as=56.9f ps=0.74u w=0.17u l=0.17u
X2531 cml_gate2_7.xamp.xn.S1 CKA2_P cml_gate2_7.xrtail.R1 VSS sg13_lv_nmos ad=0.1007p pd=0.91u as=0.1007p ps=0.91u w=0.53u l=0.13u
X2532 cml_tlatch_21.xmux.xn.S1 CKA1_N cml_tlatch_21.xtail.S1 VSS sg13_lv_nmos ad=89.3f pd=0.85u as=89.3f ps=0.85u w=0.47u l=0.16u
X2533 cml_tlatch_20.OUTP cml_tlatch_43.INN cml_tlatch_20.xmux.xn.S1 VSS sg13_lv_nmos ad=63.19999f pd=0.74u as=63.19999f ps=0.74u w=0.26u l=0.38u
X2534 cml_tlatch_85.xmux.xn.S1 cml_tlatch_86.OUTN A2_8_P VSS sg13_lv_nmos ad=63.19999f pd=0.74u as=63.19999f ps=0.74u w=0.26u l=0.38u
X2535 cml_tlatch_93.xmux.xp.S1 CLK_W_P CLK_W_N VSS sg13_lv_nmos ad=56.9f pd=0.74u as=56.9f ps=0.74u w=0.17u l=0.17u
X2536 cml_tlatch_32.OUTP cml_tlatch_32.OUTN cml_tlatch_32.xmux.xp.S1 VSS sg13_lv_nmos ad=56.9f pd=0.74u as=56.9f ps=0.74u w=0.17u l=0.17u
X2537 MOT4_N cml_tlatch_99.OUTP cml_tlatch_28.xmux.xn.S1 VSS sg13_lv_nmos ad=63.19999f pd=0.74u as=63.19999f ps=0.74u w=0.26u l=0.38u
X2538 cml_gate2_5.xrtail.R1 CKB2_N GA2_P VSS sg13_lv_nmos ad=0.1007p pd=0.91u as=0.1007p ps=0.91u w=0.53u l=0.13u
X2539 cml_tlatch_85.xmux.xn.S1 cml_tlatch_86.OUTN A2_8_P VSS sg13_lv_nmos ad=63.19999f pd=0.74u as=63.19999f ps=0.74u w=0.26u l=0.38u
X2540 cml_tlatch_4.INP stub_bi_17.BOTP cml_tlatch_12.xmux.xn.S1 VSS sg13_lv_nmos ad=63.19999f pd=0.74u as=63.19999f ps=0.74u w=0.26u l=0.38u
X2541 cml_tlatch_73.INP cml_tlatch_73.INN cml_tlatch_66.xmux.xp.S1 VSS sg13_lv_nmos ad=56.9f pd=0.74u as=56.9f ps=0.74u w=0.17u l=0.17u
X2542 cml_tlatch_73.INN cml_tlatch_73.INP cml_tlatch_66.xmux.xp.S1 VSS sg13_lv_nmos ad=56.9f pd=0.74u as=56.9f ps=0.74u w=0.17u l=0.17u
X2543 cml_tlatch_40.xmux.xp.S1 A1_2_P A1_2_N VSS sg13_lv_nmos ad=56.9f pd=0.74u as=56.9f ps=0.74u w=0.17u l=0.17u
X2544 cml_tlatch_87.xmux.xp.S1 cml_tlatch_87.OUTN cml_tlatch_87.OUTP VSS sg13_lv_nmos ad=56.9f pd=0.74u as=56.9f ps=0.74u w=0.17u l=0.17u
X2545 cml_tlatch_88.xmux.xp.S1 cml_tlatch_74.INN cml_tlatch_74.INP VSS sg13_lv_nmos ad=56.9f pd=0.74u as=56.9f ps=0.74u w=0.17u l=0.17u
X2546 cml_tlatch_91.OUTP cml_tlatch_91.OUTN cml_tlatch_91.xmux.xp.S1 VSS sg13_lv_nmos ad=56.9f pd=0.74u as=56.9f ps=0.74u w=0.17u l=0.17u
X2547 MOT30_P MOT30_N cml_tlatch_45.xmux.xp.S1 VSS sg13_lv_nmos ad=56.9f pd=0.74u as=56.9f ps=0.74u w=0.17u l=0.17u
X2548 cml_tlatch_52.xmux.xp.S1 MOT16_P MOT16_N VSS sg13_lv_nmos ad=56.9f pd=0.74u as=56.9f ps=0.74u w=0.17u l=0.17u
X2549 cml_tlatch_15.xmux.xn.S1 cml_tlatch_7.OUTP MOT3_N VSS sg13_lv_nmos ad=63.19999f pd=0.74u as=63.19999f ps=0.74u w=0.26u l=0.38u
X2550 cml_tlatch_12.xmux.xn.S1 CKB1_N cml_tlatch_12.xtail.S1 VSS sg13_lv_nmos ad=89.3f pd=0.85u as=89.3f ps=0.85u w=0.47u l=0.16u
X2551 VDD NM1_P VSS rppd l=13.09u w=1u
X2552 cml_tlatch_66.xmux.xn.S1 cml_tlatch_67.OUTN cml_tlatch_73.INP VSS sg13_lv_nmos ad=63.19999f pd=0.74u as=63.19999f ps=0.74u w=0.26u l=0.38u
X2553 cml_tlatch_15.xmux.xp.S1 CKHB0_N cml_tlatch_15.xtail.S1 VSS sg13_lv_nmos ad=89.3f pd=0.85u as=89.3f ps=0.85u w=0.47u l=0.16u
X2554 cml_tlatch_97.INN cml_tlatch_97.INP cml_tlatch_39.xmux.xp.S1 VSS sg13_lv_nmos ad=56.9f pd=0.74u as=0.1019p ps=1.34u w=0.17u l=0.17u
X2555 cml_tlatch_33.xmux.xp.S1 cml_tlatch_33.OUTP cml_tlatch_33.OUTN VSS sg13_lv_nmos ad=56.9f pd=0.74u as=56.9f ps=0.74u w=0.17u l=0.17u
X2556 B1_8_P B1_8_N cml_tlatch_10.xmux.xp.S1 VSS sg13_lv_nmos ad=56.9f pd=0.74u as=56.9f ps=0.74u w=0.17u l=0.17u
X2557 MOT5_P MOT5_N cml_tlatch_16.xmux.xp.S1 VSS sg13_lv_nmos ad=56.9f pd=0.74u as=56.9f ps=0.74u w=0.17u l=0.17u
X2558 cml_tlatch_25.xmux.xp.S1 MOT14_N MOT14_P VSS sg13_lv_nmos ad=56.9f pd=0.74u as=56.9f ps=0.74u w=0.17u l=0.17u
X2559 cml_tlatch_60.xmux.xn.S1 CKA2_N cml_tlatch_60.xtail.S1 VSS sg13_lv_nmos ad=89.3f pd=0.85u as=89.3f ps=0.85u w=0.47u l=0.16u
X2560 cml_tlatch_26.xmux.xn.S1 CKHA0_P cml_tlatch_26.xtail.S1 VSS sg13_lv_nmos ad=89.3f pd=0.85u as=89.3f ps=0.85u w=0.47u l=0.16u
X2561 cml_tlatch_42.xmux.xp.S1 MOT8_P MOT8_N VSS sg13_lv_nmos ad=56.9f pd=0.74u as=56.9f ps=0.74u w=0.17u l=0.17u
X2562 cml_tlatch_44.xtail.S1 CKHA3_N cml_tlatch_44.xmux.xp.S1 VSS sg13_lv_nmos ad=89.3f pd=0.85u as=0.1598p ps=1.62u w=0.47u l=0.16u
X2563 cml_tlatch_60.xmux.xp.S1 A2_2_N A2_2_P VSS sg13_lv_nmos ad=0.1019p pd=1.34u as=56.9f ps=0.74u w=0.17u l=0.17u
X2564 cml_tlatch_45.xtail.S1 CKHA3_P cml_tlatch_45.xmux.xn.S1 VSS sg13_lv_nmos ad=0.1598p pd=1.62u as=89.3f ps=0.85u w=0.47u l=0.16u
X2565 hs_to_clk_2.D2 CK_N CKB1_P VSS sg13_lv_nmos ad=0.408p pd=3.08u as=0.228p ps=1.58u w=1.2u l=0.2u
X2566 cml_tlatch_65.OUTP cml_tlatch_65.OUTN cml_tlatch_65.xmux.xp.S1 VSS sg13_lv_nmos ad=56.9f pd=0.74u as=0.1019p ps=1.34u w=0.17u l=0.17u
X2567 B2_2_P stub_bi_43.BOTP cml_tlatch_47.xmux.xn.S1 VSS sg13_lv_nmos ad=63.19999f pd=0.74u as=63.19999f ps=0.74u w=0.26u l=0.38u
X2568 cml_tlatch_53.xmux.xp.S1 MOT18_N MOT18_P VSS sg13_lv_nmos ad=56.9f pd=0.74u as=56.9f ps=0.74u w=0.17u l=0.17u
X2569 MOT17_P B2_8_N cml_tlatch_77.xmux.xn.S1 VSS sg13_lv_nmos ad=63.19999f pd=0.74u as=63.19999f ps=0.74u w=0.26u l=0.38u
X2570 cml_tlatch_34.xmux.xp.S1 A0_2_P A0_2_N VSS sg13_lv_nmos ad=56.9f pd=0.74u as=56.9f ps=0.74u w=0.17u l=0.17u
X2571 cml_tlatch_49.xtail.S1 POLN VSS VSS sg13_lv_nmos ad=1.5637p pd=8.61u as=2.7982p ps=17.14u w=8.23u l=0.13u
X2572 cml_tlatch_65.OUTP cml_tlatch_73.INN cml_tlatch_65.xmux.xn.S1 VSS sg13_lv_nmos ad=63.19999f pd=0.74u as=63.19999f ps=0.74u w=0.26u l=0.38u
X2573 MOT23_N MOT23_P cml_tlatch_80.xmux.xp.S1 VSS sg13_lv_nmos ad=56.9f pd=0.74u as=56.9f ps=0.74u w=0.17u l=0.17u
X2574 cml_tlatch_12.xmux.xp.S1 cml_tlatch_4.INP cml_tlatch_4.INN VSS sg13_lv_nmos ad=0.1019p pd=1.34u as=56.9f ps=0.74u w=0.17u l=0.17u
X2575 cml_tlatch_47.xmux.xn.S1 CKB2_N cml_tlatch_47.xtail.S1 VSS sg13_lv_nmos ad=89.3f pd=0.85u as=89.3f ps=0.85u w=0.47u l=0.16u
X2576 cml_tlatch_97.xmux.xn.S1 CKA1_N cml_tlatch_97.xtail.S1 VSS sg13_lv_nmos ad=89.3f pd=0.85u as=89.3f ps=0.85u w=0.47u l=0.16u
X2577 cml_tlatch_86.xtail.S1 CKA2_N cml_tlatch_86.xmux.xp.S1 VSS sg13_lv_nmos ad=89.3f pd=0.85u as=89.3f ps=0.85u w=0.47u l=0.16u
X2578 cml_tlatch_57.xmux.xn.S1 CKA3_N cml_tlatch_57.xtail.S1 VSS sg13_lv_nmos ad=89.3f pd=0.85u as=89.3f ps=0.85u w=0.47u l=0.16u
X2579 cml_tlatch_38.xmux.xn.S1 D0_P cml_tlatch_38.OUTN VSS sg13_lv_nmos ad=63.19999f pd=0.74u as=63.19999f ps=0.74u w=0.26u l=0.38u
X2580 cml_gate2_0.xamp.xn.S1 CKA1_P cml_gate2_0.xrtail.R1 VSS sg13_lv_nmos ad=0.1007p pd=0.91u as=0.1007p ps=0.91u w=0.53u l=0.13u
X2581 cml_tlatch_19.xmux.xp.S1 CKA1_P cml_tlatch_19.xtail.S1 VSS sg13_lv_nmos ad=89.3f pd=0.85u as=89.3f ps=0.85u w=0.47u l=0.16u
X2582 cml_tlatch_58.OUTP cml_tlatch_58.OUTN cml_tlatch_58.xmux.xp.S1 VSS sg13_lv_nmos ad=56.9f pd=0.74u as=56.9f ps=0.74u w=0.17u l=0.17u
X2583 cml_tlatch_2.xmux.xn.S1 CKB0_P cml_tlatch_2.xtail.S1 VSS sg13_lv_nmos ad=89.3f pd=0.85u as=89.3f ps=0.85u w=0.47u l=0.16u
X2584 cml_tlatch_25.xtail.S1 CKHA1_P cml_tlatch_25.xmux.xn.S1 VSS sg13_lv_nmos ad=89.3f pd=0.85u as=89.3f ps=0.85u w=0.47u l=0.16u
X2585 cml_tlatch_68.xtail.S1 POLN VSS VSS sg13_lv_nmos ad=1.5637p pd=8.61u as=1.5637p ps=8.61u w=8.23u l=0.13u
X2586 cml_gate2_3.xamp.xn.S1 ENA0_N GA0_P VSS sg13_lv_nmos ad=0.1007p pd=0.91u as=0.1007p ps=0.91u w=0.53u l=0.13u
X2587 MOT12_P MOT12_N cml_tlatch_24.xmux.xp.S1 VSS sg13_lv_nmos ad=56.9f pd=0.74u as=56.9f ps=0.74u w=0.17u l=0.17u
X2588 cml_tlatch_85.xmux.xp.S1 CKA2_P cml_tlatch_85.xtail.S1 VSS sg13_lv_nmos ad=0.1598p pd=1.62u as=89.3f ps=0.85u w=0.47u l=0.16u
X2589 stub_bi_49.BOTP stub_bi_49.BOTN cml_tlatch_84.xmux.xp.S1 VSS sg13_lv_nmos ad=56.9f pd=0.74u as=56.9f ps=0.74u w=0.17u l=0.17u
X2590 cml_tlatch_87.xmux.xn.S1 cml_tlatch_87.INN cml_tlatch_87.OUTP VSS sg13_lv_nmos ad=63.19999f pd=0.74u as=63.19999f ps=0.74u w=0.26u l=0.38u
X2591 cml_tlatch_6.xtail.S1 CKHB1_P cml_tlatch_6.xmux.xn.S1 VSS sg13_lv_nmos ad=89.3f pd=0.85u as=89.3f ps=0.85u w=0.47u l=0.16u
X2592 A3_2_N A3_2_P cml_tlatch_57.xmux.xp.S1 VSS sg13_lv_nmos ad=56.9f pd=0.74u as=56.9f ps=0.74u w=0.17u l=0.17u
X2593 stub_bi_55.BOTN stub_bi_55.BOTP cml_tlatch_90.xmux.xp.S1 VSS sg13_lv_nmos ad=56.9f pd=0.74u as=0.1019p ps=1.34u w=0.17u l=0.17u
X2594 cml_tlatch_7.OUTN cml_tlatch_7.OUTP cml_tlatch_7.xmux.xp.S1 VSS sg13_lv_nmos ad=56.9f pd=0.74u as=56.9f ps=0.74u w=0.17u l=0.17u
X2595 cml_tlatch_0.OUTP cml_tlatch_0.OUTN cml_tlatch_0.xmux.xp.S1 VSS sg13_lv_nmos ad=56.9f pd=0.74u as=56.9f ps=0.74u w=0.17u l=0.17u
X2596 cml_tlatch_17.xmux.xp.S1 MOT7_P MOT7_N VSS sg13_lv_nmos ad=56.9f pd=0.74u as=56.9f ps=0.74u w=0.17u l=0.17u
X2597 hs_to_clk_3.sg13_lv_nmos_2HGZLP_0.G CKA1_N VSS rppd l=4.25u w=1u
X2598 cml_tlatch_43.INN cml_tlatch_22.OUTP cml_tlatch_21.xmux.xn.S1 VSS sg13_lv_nmos ad=63.19999f pd=0.74u as=0.1082p ps=1.34u w=0.26u l=0.38u
X2599 cml_tlatch_40.xmux.xp.S1 A1_2_P A1_2_N VSS sg13_lv_nmos ad=56.9f pd=0.74u as=56.9f ps=0.74u w=0.17u l=0.17u
X2600 cml_tlatch_86.OUTP cml_tlatch_87.OUTN cml_tlatch_86.xmux.xn.S1 VSS sg13_lv_nmos ad=0.1082p pd=1.34u as=63.19999f ps=0.74u w=0.26u l=0.38u
X2601 cml_tlatch_31.xmux.xp.S1 B0_2_N B0_2_P VSS sg13_lv_nmos ad=56.9f pd=0.74u as=56.9f ps=0.74u w=0.17u l=0.17u
X2602 B1_2_N B1_2_P cml_tlatch_36.xmux.xp.S1 VSS sg13_lv_nmos ad=56.9f pd=0.74u as=56.9f ps=0.74u w=0.17u l=0.17u
X2603 cml_tlatch_7.xmux.xn.S1 CKB0_N cml_tlatch_7.xtail.S1 VSS sg13_lv_nmos ad=89.3f pd=0.85u as=89.3f ps=0.85u w=0.47u l=0.16u
X2604 cml_tlatch_56.OUTN cml_tlatch_56.OUTP cml_tlatch_56.xmux.xp.S1 VSS sg13_lv_nmos ad=56.9f pd=0.74u as=56.9f ps=0.74u w=0.17u l=0.17u
X2605 cml_tlatch_67.xtail.S1 CKB3_N cml_tlatch_67.xmux.xp.S1 VSS sg13_lv_nmos ad=89.3f pd=0.85u as=89.3f ps=0.85u w=0.47u l=0.16u
X2606 cml_tlatch_71.xmux.xp.S1 cml_tlatch_71.OUTP cml_tlatch_71.OUTN VSS sg13_lv_nmos ad=56.9f pd=0.74u as=56.9f ps=0.74u w=0.17u l=0.17u
X2607 MOT17_P MOT17_N cml_tlatch_77.xmux.xp.S1 VSS sg13_lv_nmos ad=56.9f pd=0.74u as=56.9f ps=0.74u w=0.17u l=0.17u
X2608 cml_tlatch_85.xmux.xp.S1 A2_8_N A2_8_P VSS sg13_lv_nmos ad=56.9f pd=0.74u as=56.9f ps=0.74u w=0.17u l=0.17u
X2609 cml_tlatch_51.OUTP cml_tlatch_51.OUTN cml_tlatch_51.xmux.xp.S1 VSS sg13_lv_nmos ad=56.9f pd=0.74u as=0.1019p ps=1.34u w=0.17u l=0.17u
X2610 cml_tlatch_72.xmux.xp.S1 MOT25_N MOT25_P VSS sg13_lv_nmos ad=56.9f pd=0.74u as=56.9f ps=0.74u w=0.17u l=0.17u
X2611 CLK_W_N J2_N cml_tlatch_93.xmux.xn.S1 VSS sg13_lv_nmos ad=63.19999f pd=0.74u as=63.19999f ps=0.74u w=0.26u l=0.38u
X2612 cml_gate2_6.xrtail.R1 CKA3_N GB3_P VSS sg13_lv_nmos ad=0.1007p pd=0.91u as=0.1007p ps=0.91u w=0.53u l=0.13u
X2613 cml_tlatch_3.xmux.xn.S1 B1_8_P MOT9_N VSS sg13_lv_nmos ad=63.19999f pd=0.74u as=63.19999f ps=0.74u w=0.26u l=0.38u
X2614 A3_2_N cml_tlatch_58.OUTP cml_tlatch_57.xmux.xn.S1 VSS sg13_lv_nmos ad=63.19999f pd=0.74u as=63.19999f ps=0.74u w=0.26u l=0.38u
X2615 cml_tlatch_87.xmux.xp.S1 cml_tlatch_87.OUTN cml_tlatch_87.OUTP VSS sg13_lv_nmos ad=56.9f pd=0.74u as=56.9f ps=0.74u w=0.17u l=0.17u
X2616 cml_tlatch_18.OUTP cml_tlatch_18.OUTN cml_tlatch_18.xmux.xp.S1 VSS sg13_lv_nmos ad=56.9f pd=0.74u as=0.1019p ps=1.34u w=0.17u l=0.17u
X2617 MOT4_N MOT4_P cml_tlatch_28.xmux.xp.S1 VSS sg13_lv_nmos ad=56.9f pd=0.74u as=56.9f ps=0.74u w=0.17u l=0.17u
X2618 VSS hs_to_clk_6.sg13_lv_nmos_2HGZLP_0.G VSS VSS sg13_lv_nmos ad=2.071p pd=11.28u as=0 ps=0 w=10.9u l=1.38u
X2619 cml_tlatch_58.OUTP D3_N cml_tlatch_58.xmux.xn.S1 VSS sg13_lv_nmos ad=63.19999f pd=0.74u as=0.1082p ps=1.34u w=0.26u l=0.38u
X2620 hs_to_clk_5.D2 POLN VSS VSS sg13_lv_nmos ad=1.9p pd=10.38u as=1.9p ps=10.38u w=10u l=0.13u
X2621 cml_tlatch_34.xmux.xn.S1 cml_tlatch_38.OUTP A0_2_N VSS sg13_lv_nmos ad=63.19999f pd=0.74u as=63.19999f ps=0.74u w=0.26u l=0.38u
X2622 cml_tlatch_9.xmux.xn.S1 cml_tlatch_18.OUTN A0_8_P VSS sg13_lv_nmos ad=63.19999f pd=0.74u as=63.19999f ps=0.74u w=0.26u l=0.38u
X2623 stub_bi_43.BOTP D2_P cml_tlatch_48.xmux.xn.S1 VSS sg13_lv_nmos ad=63.19999f pd=0.74u as=63.19999f ps=0.74u w=0.26u l=0.38u
X2624 cml_gate2_3.xrtail.R1 CKB0_P cml_gate2_3.xamp.xn.S1 VSS sg13_lv_nmos ad=0.1007p pd=0.91u as=0.1007p ps=0.91u w=0.53u l=0.13u
X2625 cml_tlatch_8.xtail.S1 CKB0_N cml_tlatch_8.xmux.xp.S1 VSS sg13_lv_nmos ad=89.3f pd=0.85u as=0.1598p ps=1.62u w=0.47u l=0.16u
X2626 VDD CKHA2_P VSS rppd l=13.09u w=1u
X2627 cml_tlatch_84.xmux.xn.S1 stub_bi_55.BOTN stub_bi_49.BOTP VSS sg13_lv_nmos ad=0.1082p pd=1.34u as=63.19999f ps=0.74u w=0.26u l=0.38u
X2628 cml_drv_0.xrtail.R1 ENB_P ENB1_N VSS sg13_lv_nmos ad=56.2f pd=0.74u as=56.2f ps=0.74u w=0.16u l=0.19u
X2629 cml_tlatch_5.xmux.xp.S1 MOT13_N MOT13_P VSS sg13_lv_nmos ad=56.9f pd=0.74u as=56.9f ps=0.74u w=0.17u l=0.17u
X2630 cml_tlatch_80.xmux.xp.S1 MOT23_N MOT23_P VSS sg13_lv_nmos ad=56.9f pd=0.74u as=56.9f ps=0.74u w=0.17u l=0.17u
X2631 MOT26_N cml_tlatch_63.INP cml_tlatch_63.xmux.xn.S1 VSS sg13_lv_nmos ad=63.19999f pd=0.74u as=63.19999f ps=0.74u w=0.26u l=0.38u
X2632 cml_tlatch_44.xmux.xp.S1 MOT28_N MOT28_P VSS sg13_lv_nmos ad=56.9f pd=0.74u as=56.9f ps=0.74u w=0.17u l=0.17u
X2633 cml_tlatch_29.xmux.xp.S1 CKHA0_N cml_tlatch_29.xtail.S1 VSS sg13_lv_nmos ad=0.1598p pd=1.62u as=89.3f ps=0.85u w=0.47u l=0.16u
X2634 cml_tlatch_86.xmux.xp.S1 cml_tlatch_86.OUTN cml_tlatch_86.OUTP VSS sg13_lv_nmos ad=56.9f pd=0.74u as=56.9f ps=0.74u w=0.17u l=0.17u
X2635 cml_tlatch_46.xtail.S1 CKB2_N cml_tlatch_46.xmux.xp.S1 VSS sg13_lv_nmos ad=89.3f pd=0.85u as=89.3f ps=0.85u w=0.47u l=0.16u
X2636 MOT7_N B0_2_P cml_tlatch_17.xmux.xn.S1 VSS sg13_lv_nmos ad=63.19999f pd=0.74u as=0.1082p ps=1.34u w=0.26u l=0.38u
X2637 stub_bi_29.BOTN B1_2_N cml_tlatch_35.xmux.xn.S1 VSS sg13_lv_nmos ad=63.19999f pd=0.74u as=63.19999f ps=0.74u w=0.26u l=0.38u
X2638 cml_tlatch_24.INN cml_tlatch_24.INP cml_tlatch_97.xmux.xp.S1 VSS sg13_lv_nmos ad=56.9f pd=0.74u as=56.9f ps=0.74u w=0.17u l=0.17u
X2639 cml_tlatch_52.xmux.xp.S1 MOT16_N MOT16_P VSS sg13_lv_nmos ad=56.9f pd=0.74u as=56.9f ps=0.74u w=0.17u l=0.17u
X2640 cml_tlatch_34.xmux.xp.S1 A0_2_P A0_2_N VSS sg13_lv_nmos ad=0.1019p pd=1.34u as=56.9f ps=0.74u w=0.17u l=0.17u
X2641 MOT24_P MOT24_N cml_tlatch_62.xmux.xp.S1 VSS sg13_lv_nmos ad=56.9f pd=0.74u as=56.9f ps=0.74u w=0.17u l=0.17u
X2642 cml_tlatch_78.xmux.xn.S1 CKHB2_P cml_tlatch_78.xtail.S1 VSS sg13_lv_nmos ad=89.3f pd=0.85u as=0.1598p ps=1.62u w=0.47u l=0.16u
X2643 cml_tlatch_6.xmux.xp.S1 MOT15_N MOT15_P VSS sg13_lv_nmos ad=56.9f pd=0.74u as=56.9f ps=0.74u w=0.17u l=0.17u
X2644 cml_tlatch_71.xmux.xp.S1 cml_tlatch_71.OUTP cml_tlatch_71.OUTN VSS sg13_lv_nmos ad=56.9f pd=0.74u as=56.9f ps=0.74u w=0.17u l=0.17u
X2645 cml_tlatch_27.xmux.xp.S1 MOT2_P MOT2_N VSS sg13_lv_nmos ad=56.9f pd=0.74u as=56.9f ps=0.74u w=0.17u l=0.17u
X2646 cml_tlatch_3.xtail.S1 CKHB1_P cml_tlatch_3.xmux.xn.S1 VSS sg13_lv_nmos ad=89.3f pd=0.85u as=89.3f ps=0.85u w=0.47u l=0.16u
X2647 cml_tlatch_74.xmux.xp.S1 MOT29_N MOT29_P VSS sg13_lv_nmos ad=56.9f pd=0.74u as=56.9f ps=0.74u w=0.17u l=0.17u
X2648 hs_to_clk_0.D2 POLN VSS VSS sg13_lv_nmos ad=1.9p pd=10.38u as=1.9p ps=10.38u w=10u l=0.13u
X2649 stub_bi_62.BOTP stub_bi_62.BOTN cml_tlatch_82.xmux.xp.S1 VSS sg13_lv_nmos ad=56.9f pd=0.74u as=56.9f ps=0.74u w=0.17u l=0.17u
X2650 cml_tlatch_89.xtail.S1 CKA3_N cml_tlatch_89.xmux.xn.S1 VSS sg13_lv_nmos ad=89.3f pd=0.85u as=89.3f ps=0.85u w=0.47u l=0.16u
X2651 cml_tlatch_71.OUTP cml_tlatch_71.OUTN cml_tlatch_71.xmux.xp.S1 VSS sg13_lv_nmos ad=56.9f pd=0.74u as=56.9f ps=0.74u w=0.17u l=0.17u
X2652 cml_tlatch_73.xmux.xn.S1 CKHB3_P cml_tlatch_73.xtail.S1 VSS sg13_lv_nmos ad=89.3f pd=0.85u as=89.3f ps=0.85u w=0.47u l=0.16u
X2653 cml_tlatch_10.xtail.S1 POLN VSS VSS sg13_lv_nmos ad=1.5637p pd=8.61u as=2.7982p ps=17.14u w=8.23u l=0.13u
X2654 cml_tlatch_19.xmux.xn.S1 cml_tlatch_20.OUTP A1_8_N VSS sg13_lv_nmos ad=63.19999f pd=0.74u as=63.19999f ps=0.74u w=0.26u l=0.38u
X2655 cml_tlatch_44.INN cml_tlatch_44.INP cml_tlatch_89.xmux.xp.S1 VSS sg13_lv_nmos ad=56.9f pd=0.74u as=56.9f ps=0.74u w=0.17u l=0.17u
X2656 cml_tlatch_6.xmux.xn.S1 B1_2_P MOT15_N VSS sg13_lv_nmos ad=0.1082p pd=1.34u as=63.19999f ps=0.74u w=0.26u l=0.38u
X2657 cml_tlatch_16.xmux.xp.S1 MOT5_P MOT5_N VSS sg13_lv_nmos ad=56.9f pd=0.74u as=56.9f ps=0.74u w=0.17u l=0.17u
X2658 A1_2_P A1_2_N cml_tlatch_40.xmux.xp.S1 VSS sg13_lv_nmos ad=56.9f pd=0.74u as=56.9f ps=0.74u w=0.17u l=0.17u
X2659 cml_tlatch_18.xmux.xn.S1 CKA0_P cml_tlatch_18.xtail.S1 VSS sg13_lv_nmos ad=89.3f pd=0.85u as=0.1598p ps=1.62u w=0.47u l=0.16u
X2660 cml_tlatch_36.xmux.xp.S1 B1_2_N B1_2_P VSS sg13_lv_nmos ad=56.9f pd=0.74u as=56.9f ps=0.74u w=0.17u l=0.17u
X2661 cml_tlatch_71.xtail.S1 CKA3_P cml_tlatch_71.xmux.xn.S1 VSS sg13_lv_nmos ad=89.3f pd=0.85u as=89.3f ps=0.85u w=0.47u l=0.16u
X2662 GB0_N ENB1_P cml_gate2_1.xamp.xn.S1 VSS sg13_lv_nmos ad=0.1802p pd=1.74u as=0.1007p ps=0.91u w=0.53u l=0.13u
X2663 cml_tlatch_0.xmux.xn.S1 cml_tlatch_99.OUTP cml_tlatch_0.OUTN VSS sg13_lv_nmos ad=63.19999f pd=0.74u as=63.19999f ps=0.74u w=0.26u l=0.38u
X2664 cml_tlatch_62.xmux.xn.S1 A3_8_P MOT24_N VSS sg13_lv_nmos ad=63.19999f pd=0.74u as=63.19999f ps=0.74u w=0.26u l=0.38u
X2665 cml_tlatch_93.xtail.S1 CKJ_N cml_tlatch_93.xmux.xp.S1 VSS sg13_lv_nmos ad=89.3f pd=0.85u as=89.3f ps=0.85u w=0.47u l=0.16u
X2666 cml_tlatch_62.xmux.xn.S1 A3_8_P MOT24_N VSS sg13_lv_nmos ad=63.19999f pd=0.74u as=63.19999f ps=0.74u w=0.26u l=0.38u
X2667 cml_tlatch_46.xmux.xn.S1 B2_2_P stub_bi_38.BOTP VSS sg13_lv_nmos ad=63.19999f pd=0.74u as=63.19999f ps=0.74u w=0.26u l=0.38u
X2668 MOT23_P B2_2_N cml_tlatch_80.xmux.xn.S1 VSS sg13_lv_nmos ad=63.19999f pd=0.74u as=0.1082p ps=1.34u w=0.26u l=0.38u
X2669 cml_tlatch_89.xtail.S1 CKA3_P cml_tlatch_89.xmux.xp.S1 VSS sg13_lv_nmos ad=89.3f pd=0.85u as=89.3f ps=0.85u w=0.47u l=0.16u
X2670 cml_tlatch_16.xmux.xp.S1 CKHB0_N cml_tlatch_16.xtail.S1 VSS sg13_lv_nmos ad=89.3f pd=0.85u as=89.3f ps=0.85u w=0.47u l=0.16u
X2671 cml_tlatch_22.xmux.xp.S1 cml_tlatch_22.OUTN cml_tlatch_22.OUTP VSS sg13_lv_nmos ad=56.9f pd=0.74u as=56.9f ps=0.74u w=0.17u l=0.17u
X2672 cml_tlatch_78.xtail.S1 CKHB2_N cml_tlatch_78.xmux.xp.S1 VSS sg13_lv_nmos ad=89.3f pd=0.85u as=89.3f ps=0.85u w=0.47u l=0.16u
X2673 cml_tlatch_67.xtail.S1 CKB3_P cml_tlatch_67.xmux.xn.S1 VSS sg13_lv_nmos ad=0.1598p pd=1.62u as=89.3f ps=0.85u w=0.47u l=0.16u
X2674 MOT21_N stub_bi_55.BOTN cml_tlatch_79.xmux.xn.S1 VSS sg13_lv_nmos ad=63.19999f pd=0.74u as=63.19999f ps=0.74u w=0.26u l=0.38u
X2675 cml_tlatch_85.xmux.xp.S1 A2_8_N A2_8_P VSS sg13_lv_nmos ad=56.9f pd=0.74u as=56.9f ps=0.74u w=0.17u l=0.17u
X2676 cml_tlatch_61.xmux.xp.S1 cml_tlatch_61.OUTN cml_tlatch_61.OUTP VSS sg13_lv_nmos ad=56.9f pd=0.74u as=56.9f ps=0.74u w=0.17u l=0.17u
X2677 cml_tlatch_20.OUTN cml_tlatch_43.INP cml_tlatch_20.xmux.xn.S1 VSS sg13_lv_nmos ad=63.19999f pd=0.74u as=63.19999f ps=0.74u w=0.26u l=0.38u
X2678 cml_tlatch_97.xmux.xp.S1 cml_tlatch_24.INP cml_tlatch_24.INN VSS sg13_lv_nmos ad=0.1019p pd=1.34u as=56.9f ps=0.74u w=0.17u l=0.17u
X2679 cml_tlatch_72.xmux.xp.S1 MOT25_N MOT25_P VSS sg13_lv_nmos ad=56.9f pd=0.74u as=56.9f ps=0.74u w=0.17u l=0.17u
X2680 B2_8_P B2_8_N cml_tlatch_81.xmux.xp.S1 VSS sg13_lv_nmos ad=56.9f pd=0.74u as=56.9f ps=0.74u w=0.17u l=0.17u
X2681 cml_tlatch_33.OUTP A0_2_N cml_tlatch_33.xmux.xn.S1 VSS sg13_lv_nmos ad=0.1082p pd=1.34u as=63.19999f ps=0.74u w=0.26u l=0.38u
X2682 VSS POLN hs_to_clk_4.D2 VSS sg13_lv_nmos ad=1.9p pd=10.38u as=1.9p ps=10.38u w=10u l=0.13u
X2683 cml_tlatch_99.xmux.xp.S1 CKA0_P cml_tlatch_99.xtail.S1 VSS sg13_lv_nmos ad=0.1598p pd=1.62u as=89.3f ps=0.85u w=0.47u l=0.16u
X2684 cml_tlatch_52.xtail.S1 CKHA2_P cml_tlatch_52.xmux.xn.S1 VSS sg13_lv_nmos ad=89.3f pd=0.85u as=89.3f ps=0.85u w=0.47u l=0.16u
X2685 cml_tlatch_59.xtail.S1 CKA2_P cml_tlatch_59.xmux.xn.S1 VSS sg13_lv_nmos ad=89.3f pd=0.85u as=89.3f ps=0.85u w=0.47u l=0.16u
X2686 cml_drv_1.xrtail.R1 ENA_P ENA1_N VSS sg13_lv_nmos ad=56.2f pd=0.74u as=56.2f ps=0.74u w=0.16u l=0.19u
X2687 cml_tlatch_33.OUTP A0_2_N cml_tlatch_33.xmux.xn.S1 VSS sg13_lv_nmos ad=63.19999f pd=0.74u as=63.19999f ps=0.74u w=0.26u l=0.38u
X2688 cml_tlatch_11.xtail.S1 CKB1_P cml_tlatch_11.xmux.xn.S1 VSS sg13_lv_nmos ad=0.1598p pd=1.62u as=89.3f ps=0.85u w=0.47u l=0.16u
X2689 B3_8_P cml_tlatch_65.OUTN cml_tlatch_64.xmux.xn.S1 VSS sg13_lv_nmos ad=63.19999f pd=0.74u as=63.19999f ps=0.74u w=0.26u l=0.38u
X2690 cml_tlatch_13.xmux.xp.S1 stub_bi_17.BOTN stub_bi_17.BOTP VSS sg13_lv_nmos ad=56.9f pd=0.74u as=56.9f ps=0.74u w=0.17u l=0.17u
X2691 MOT9_P MOT9_N cml_tlatch_3.xmux.xp.S1 VSS sg13_lv_nmos ad=56.9f pd=0.74u as=56.9f ps=0.74u w=0.17u l=0.17u
X2692 cml_tlatch_33.xtail.S1 CKA0_P cml_tlatch_33.xmux.xn.S1 VSS sg13_lv_nmos ad=89.3f pd=0.85u as=89.3f ps=0.85u w=0.47u l=0.16u
X2693 cml_tlatch_48.xmux.xp.S1 CKB2_N cml_tlatch_48.xtail.S1 VSS sg13_lv_nmos ad=89.3f pd=0.85u as=89.3f ps=0.85u w=0.47u l=0.16u
X2694 cml_tlatch_9.xmux.xp.S1 CKA0_P cml_tlatch_9.xtail.S1 VSS sg13_lv_nmos ad=89.3f pd=0.85u as=89.3f ps=0.85u w=0.47u l=0.16u
X2695 cml_gate2_7.xrtail.R1 CKA2_N GB2_P VSS sg13_lv_nmos ad=0.1007p pd=0.91u as=0.1007p ps=0.91u w=0.53u l=0.13u
X2696 GB3_P ENB0_N cml_gate2_6.xamp.xn.S1 VSS sg13_lv_nmos ad=0.1802p pd=1.74u as=0.1007p ps=0.91u w=0.53u l=0.13u
X2697 cml_tlatch_45.xmux.xn.S1 A3_2_P MOT30_N VSS sg13_lv_nmos ad=63.19999f pd=0.74u as=0.1082p ps=1.34u w=0.26u l=0.38u
X2698 cml_tlatch_98.OUTN cml_tlatch_98.OUTP cml_tlatch_98.xmux.xp.S1 VSS sg13_lv_nmos ad=56.9f pd=0.74u as=56.9f ps=0.74u w=0.17u l=0.17u
X2699 cml_tlatch_46.xtail.S1 CKB2_P cml_tlatch_46.xmux.xn.S1 VSS sg13_lv_nmos ad=89.3f pd=0.85u as=89.3f ps=0.85u w=0.47u l=0.16u
X2700 cml_tlatch_66.xtail.S1 CKB3_P cml_tlatch_66.xmux.xp.S1 VSS sg13_lv_nmos ad=89.3f pd=0.85u as=0.1598p ps=1.62u w=0.47u l=0.16u
X2701 MOT31_P MOT31_N cml_tlatch_75.xmux.xp.S1 VSS sg13_lv_nmos ad=56.9f pd=0.74u as=56.9f ps=0.74u w=0.17u l=0.17u
X2702 VSS POLN cml_tlatch_39.xtail.S1 VSS sg13_lv_nmos ad=2.7982p pd=17.14u as=1.5637p ps=8.61u w=8.23u l=0.13u
X2703 cml_tlatch_56.xtail.S1 CKA3_P cml_tlatch_56.xmux.xn.S1 VSS sg13_lv_nmos ad=89.3f pd=0.85u as=89.3f ps=0.85u w=0.47u l=0.16u
X2704 cml_gate2_3.xamp.xn.S1 ENA0_P GA0_N VSS sg13_lv_nmos ad=0.1007p pd=0.91u as=0.1007p ps=0.91u w=0.53u l=0.13u
X2705 B1_8_N B1_8_P cml_tlatch_10.xmux.xp.S1 VSS sg13_lv_nmos ad=56.9f pd=0.74u as=0.1019p ps=1.34u w=0.17u l=0.17u
X2706 MOT21_N MOT21_P cml_tlatch_79.xmux.xp.S1 VSS sg13_lv_nmos ad=56.9f pd=0.74u as=0.1019p ps=1.34u w=0.17u l=0.17u
X2707 cml_tlatch_24.xmux.xn.S1 cml_tlatch_24.INN MOT12_P VSS sg13_lv_nmos ad=63.19999f pd=0.74u as=63.19999f ps=0.74u w=0.26u l=0.38u
X2708 stub_bi_38.BOTP stub_bi_38.BOTN cml_tlatch_46.xmux.xp.S1 VSS sg13_lv_nmos ad=56.9f pd=0.74u as=56.9f ps=0.74u w=0.17u l=0.17u
X2709 cml_tlatch_18.xtail.S1 CKA0_N cml_tlatch_18.xmux.xp.S1 VSS sg13_lv_nmos ad=89.3f pd=0.85u as=89.3f ps=0.85u w=0.47u l=0.16u
X2710 cml_tlatch_6.xmux.xp.S1 MOT15_N MOT15_P VSS sg13_lv_nmos ad=56.9f pd=0.74u as=56.9f ps=0.74u w=0.17u l=0.17u
X2711 cml_tlatch_29.xmux.xp.S1 MOT6_P MOT6_N VSS sg13_lv_nmos ad=56.9f pd=0.74u as=56.9f ps=0.74u w=0.17u l=0.17u
X2712 cml_tlatch_18.OUTP cml_tlatch_23.OUTN cml_tlatch_18.xmux.xn.S1 VSS sg13_lv_nmos ad=63.19999f pd=0.74u as=63.19999f ps=0.74u w=0.26u l=0.38u
X2713 cml_tlatch_44.INP cml_tlatch_56.OUTN cml_tlatch_89.xmux.xn.S1 VSS sg13_lv_nmos ad=63.19999f pd=0.74u as=63.19999f ps=0.74u w=0.26u l=0.38u
X2714 cml_tlatch_20.OUTP cml_tlatch_20.OUTN cml_tlatch_20.xmux.xp.S1 VSS sg13_lv_nmos ad=56.9f pd=0.74u as=56.9f ps=0.74u w=0.17u l=0.17u
X2715 cml_tlatch_37.xmux.xp.S1 stub_bi_31.BOTN stub_bi_31.BOTP VSS sg13_lv_nmos ad=56.9f pd=0.74u as=56.9f ps=0.74u w=0.17u l=0.17u
X2716 cml_tlatch_75.xtail.S1 CKHB3_P cml_tlatch_75.xmux.xn.S1 VSS sg13_lv_nmos ad=0.1598p pd=1.62u as=89.3f ps=0.85u w=0.47u l=0.16u
X2717 cml_tlatch_89.xmux.xp.S1 cml_tlatch_44.INN cml_tlatch_44.INP VSS sg13_lv_nmos ad=56.9f pd=0.74u as=56.9f ps=0.74u w=0.17u l=0.17u
X2718 MOT28_P cml_tlatch_44.INN cml_tlatch_44.xmux.xn.S1 VSS sg13_lv_nmos ad=63.19999f pd=0.74u as=63.19999f ps=0.74u w=0.26u l=0.38u
X2719 cml_tlatch_32.OUTP D0_N cml_tlatch_32.xmux.xn.S1 VSS sg13_lv_nmos ad=63.19999f pd=0.74u as=63.19999f ps=0.74u w=0.26u l=0.38u
X2720 stub_bi_29.BOTN stub_bi_29.BOTP cml_tlatch_35.xmux.xp.S1 VSS sg13_lv_nmos ad=56.9f pd=0.74u as=0.1019p ps=1.34u w=0.17u l=0.17u
X2721 cml_tlatch_2.xmux.xn.S1 CKB0_P cml_tlatch_2.xtail.S1 VSS sg13_lv_nmos ad=89.3f pd=0.85u as=89.3f ps=0.85u w=0.47u l=0.16u
X2722 MOT10_P VDD VSS rppd l=5.17u w=1u
X2723 cml_tlatch_62.xtail.S1 CKHA3_N cml_tlatch_62.xmux.xp.S1 VSS sg13_lv_nmos ad=89.3f pd=0.85u as=89.3f ps=0.85u w=0.47u l=0.16u
X2724 cml_tlatch_2.xmux.xp.S1 cml_tlatch_2.OUTN cml_tlatch_2.OUTP VSS sg13_lv_nmos ad=56.9f pd=0.74u as=56.9f ps=0.74u w=0.17u l=0.17u
X2725 cml_tlatch_87.xtail.S1 CKA2_P cml_tlatch_87.xmux.xp.S1 VSS sg13_lv_nmos ad=89.3f pd=0.85u as=89.3f ps=0.85u w=0.47u l=0.16u
X2726 J2_P J2_N cml_tlatch_94.xmux.xp.S1 VSS sg13_lv_nmos ad=56.9f pd=0.74u as=56.9f ps=0.74u w=0.17u l=0.17u
X2727 cml_tlatch_60.xmux.xp.S1 A2_2_P A2_2_N VSS sg13_lv_nmos ad=56.9f pd=0.74u as=56.9f ps=0.74u w=0.17u l=0.17u
X2728 cml_tlatch_27.xtail.S1 CKHA0_P cml_tlatch_27.xmux.xn.S1 VSS sg13_lv_nmos ad=89.3f pd=0.85u as=89.3f ps=0.85u w=0.47u l=0.16u
X2729 cml_tlatch_26.xmux.xp.S1 MOT0_P MOT0_N VSS sg13_lv_nmos ad=56.9f pd=0.74u as=56.9f ps=0.74u w=0.17u l=0.17u
X2730 cml_tlatch_29.xmux.xp.S1 MOT6_N MOT6_P VSS sg13_lv_nmos ad=56.9f pd=0.74u as=56.9f ps=0.74u w=0.17u l=0.17u
X2731 cml_tlatch_96.xmux.xp.S1 cml_tlatch_5.INN cml_tlatch_5.INP VSS sg13_lv_nmos ad=56.9f pd=0.74u as=56.9f ps=0.74u w=0.17u l=0.17u
X2732 B0_8_N cml_tlatch_2.OUTP cml_tlatch_1.xmux.xn.S1 VSS sg13_lv_nmos ad=63.19999f pd=0.74u as=63.19999f ps=0.74u w=0.26u l=0.38u
X2733 cml_tlatch_30.xmux.xp.S1 cml_tlatch_30.OUTN cml_tlatch_30.OUTP VSS sg13_lv_nmos ad=56.9f pd=0.74u as=56.9f ps=0.74u w=0.17u l=0.17u
X2734 cml_tlatch_30.OUTN cml_tlatch_30.OUTP cml_tlatch_30.xmux.xp.S1 VSS sg13_lv_nmos ad=56.9f pd=0.74u as=56.9f ps=0.74u w=0.17u l=0.17u
X2735 MOT2_N cml_tlatch_23.OUTP cml_tlatch_27.xmux.xn.S1 VSS sg13_lv_nmos ad=63.19999f pd=0.74u as=63.19999f ps=0.74u w=0.26u l=0.38u
X2736 A1_2_P cml_tlatch_41.OUTN cml_tlatch_40.xmux.xn.S1 VSS sg13_lv_nmos ad=63.19999f pd=0.74u as=63.19999f ps=0.74u w=0.26u l=0.38u
X2737 cml_tlatch_55.xmux.xp.S1 MOT22_P MOT22_N VSS sg13_lv_nmos ad=56.9f pd=0.74u as=56.9f ps=0.74u w=0.17u l=0.17u
X2738 cml_tlatch_36.xmux.xp.S1 B1_2_N B1_2_P VSS sg13_lv_nmos ad=56.9f pd=0.74u as=56.9f ps=0.74u w=0.17u l=0.17u
X2739 cml_tlatch_6.xtail.S1 CKHB1_P cml_tlatch_6.xmux.xn.S1 VSS sg13_lv_nmos ad=89.3f pd=0.85u as=89.3f ps=0.85u w=0.47u l=0.16u
X2740 cml_tlatch_18.xtail.S1 POLN VSS VSS sg13_lv_nmos ad=1.5637p pd=8.61u as=1.5637p ps=8.61u w=8.23u l=0.13u
X2741 B1_8_N B1_8_P cml_tlatch_10.xmux.xp.S1 VSS sg13_lv_nmos ad=56.9f pd=0.74u as=56.9f ps=0.74u w=0.17u l=0.17u
X2742 cml_tlatch_70.xmux.xp.S1 cml_tlatch_63.INN cml_tlatch_63.INP VSS sg13_lv_nmos ad=0.1019p pd=1.34u as=56.9f ps=0.74u w=0.17u l=0.17u
X2743 cml_tlatch_38.OUTN cml_tlatch_38.OUTP cml_tlatch_38.xmux.xp.S1 VSS sg13_lv_nmos ad=56.9f pd=0.74u as=56.9f ps=0.74u w=0.17u l=0.17u
X2744 MOT21_N MOT21_P cml_tlatch_79.xmux.xp.S1 VSS sg13_lv_nmos ad=56.9f pd=0.74u as=56.9f ps=0.74u w=0.17u l=0.17u
X2745 cml_tlatch_87.INN cml_tlatch_87.INP cml_tlatch_76.xmux.xp.S1 VSS sg13_lv_nmos ad=56.9f pd=0.74u as=56.9f ps=0.74u w=0.17u l=0.17u
X2746 cml_tlatch_61.xmux.xn.S1 CKA2_P cml_tlatch_61.xtail.S1 VSS sg13_lv_nmos ad=89.3f pd=0.85u as=89.3f ps=0.85u w=0.47u l=0.16u
X2747 cml_tlatch_73.xmux.xp.S1 MOT27_P MOT27_N VSS sg13_lv_nmos ad=56.9f pd=0.74u as=56.9f ps=0.74u w=0.17u l=0.17u
X2748 cml_tlatch_4.xmux.xp.S1 CKHB1_N cml_tlatch_4.xtail.S1 VSS sg13_lv_nmos ad=89.3f pd=0.85u as=89.3f ps=0.85u w=0.47u l=0.16u
X2749 cml_tlatch_9.xmux.xp.S1 A0_8_P A0_8_N VSS sg13_lv_nmos ad=56.9f pd=0.74u as=56.9f ps=0.74u w=0.17u l=0.17u
X2750 cml_tlatch_77.xmux.xn.S1 B2_8_N MOT17_P VSS sg13_lv_nmos ad=63.19999f pd=0.74u as=63.19999f ps=0.74u w=0.26u l=0.38u
X2751 MOT10_P cml_tlatch_43.INN cml_tlatch_43.xmux.xn.S1 VSS sg13_lv_nmos ad=63.19999f pd=0.74u as=63.19999f ps=0.74u w=0.26u l=0.38u
X2752 cml_tlatch_65.xmux.xn.S1 cml_tlatch_73.INN cml_tlatch_65.OUTP VSS sg13_lv_nmos ad=63.19999f pd=0.74u as=63.19999f ps=0.74u w=0.26u l=0.38u
X2753 J4_P J4_N cml_tlatch_92.xmux.xp.S1 VSS sg13_lv_nmos ad=56.9f pd=0.74u as=56.9f ps=0.74u w=0.17u l=0.17u
X2754 MOT7_N MOT7_P cml_tlatch_17.xmux.xp.S1 VSS sg13_lv_nmos ad=56.9f pd=0.74u as=0.1019p ps=1.34u w=0.17u l=0.17u
X2755 MOT10_N MOT10_P cml_tlatch_43.xmux.xp.S1 VSS sg13_lv_nmos ad=56.9f pd=0.74u as=56.9f ps=0.74u w=0.17u l=0.17u
X2756 stub_bi_43.BOTN D2_N cml_tlatch_48.xmux.xn.S1 VSS sg13_lv_nmos ad=63.19999f pd=0.74u as=63.19999f ps=0.74u w=0.26u l=0.38u
X2757 stub_bi_29.BOTN stub_bi_29.BOTP cml_tlatch_35.xmux.xp.S1 VSS sg13_lv_nmos ad=56.9f pd=0.74u as=56.9f ps=0.74u w=0.17u l=0.17u
X2758 cml_tlatch_96.xmux.xn.S1 stub_bi_29.BOTN cml_tlatch_5.INN VSS sg13_lv_nmos ad=0.1082p pd=1.34u as=63.19999f ps=0.74u w=0.26u l=0.38u
X2759 cml_tlatch_8.OUTN cml_tlatch_8.OUTP cml_tlatch_8.xmux.xp.S1 VSS sg13_lv_nmos ad=56.9f pd=0.74u as=56.9f ps=0.74u w=0.17u l=0.17u
X2760 cml_tlatch_22.xtail.S1 CKA1_N cml_tlatch_22.xmux.xp.S1 VSS sg13_lv_nmos ad=89.3f pd=0.85u as=89.3f ps=0.85u w=0.47u l=0.16u
X2761 cml_tlatch_70.xtail.S1 CKA3_N cml_tlatch_70.xmux.xn.S1 VSS sg13_lv_nmos ad=89.3f pd=0.85u as=89.3f ps=0.85u w=0.47u l=0.16u
X2762 cml_tlatch_69.xmux.xp.S1 cml_tlatch_69.OUTN cml_tlatch_69.OUTP VSS sg13_lv_nmos ad=56.9f pd=0.74u as=56.9f ps=0.74u w=0.17u l=0.17u
X2763 cml_tlatch_48.xmux.xn.S1 CKB2_P cml_tlatch_48.xtail.S1 VSS sg13_lv_nmos ad=89.3f pd=0.85u as=89.3f ps=0.85u w=0.47u l=0.16u
X2764 cml_tlatch_18.xmux.xp.S1 cml_tlatch_18.OUTP cml_tlatch_18.OUTN VSS sg13_lv_nmos ad=56.9f pd=0.74u as=56.9f ps=0.74u w=0.17u l=0.17u
X2765 B3_8_N B3_8_P cml_tlatch_64.xmux.xp.S1 VSS sg13_lv_nmos ad=56.9f pd=0.74u as=56.9f ps=0.74u w=0.17u l=0.17u
X2766 cml_tlatch_41.OUTP cml_tlatch_41.OUTN cml_tlatch_41.xmux.xp.S1 VSS sg13_lv_nmos ad=56.9f pd=0.74u as=56.9f ps=0.74u w=0.17u l=0.17u
X2767 cml_gate2_9.xamp.xn.S1 J1_N ENA_P VSS sg13_lv_nmos ad=0.1007p pd=0.91u as=0.1007p ps=0.91u w=0.53u l=0.13u
X2768 cml_tlatch_58.xmux.xn.S1 CKA3_P cml_tlatch_58.xtail.S1 VSS sg13_lv_nmos ad=89.3f pd=0.85u as=89.3f ps=0.85u w=0.47u l=0.16u
X2769 cml_tlatch_32.xmux.xp.S1 cml_tlatch_32.OUTN cml_tlatch_32.OUTP VSS sg13_lv_nmos ad=56.9f pd=0.74u as=56.9f ps=0.74u w=0.17u l=0.17u
X2770 cml_tlatch_98.OUTN cml_tlatch_98.OUTP cml_tlatch_98.xmux.xp.S1 VSS sg13_lv_nmos ad=56.9f pd=0.74u as=56.9f ps=0.74u w=0.17u l=0.17u
X2771 cml_tlatch_95.xmux.xp.S1 J1_N J1_P VSS sg13_lv_nmos ad=56.9f pd=0.74u as=56.9f ps=0.74u w=0.17u l=0.17u
X2772 cml_tlatch_94.xmux.xp.S1 J2_P J2_N VSS sg13_lv_nmos ad=56.9f pd=0.74u as=56.9f ps=0.74u w=0.17u l=0.17u
X2773 cml_tlatch_13.xtail.S1 CKB1_N cml_tlatch_13.xmux.xp.S1 VSS sg13_lv_nmos ad=89.3f pd=0.85u as=89.3f ps=0.85u w=0.47u l=0.16u
X2774 cml_tlatch_94.xmux.xp.S1 J2_N J2_P VSS sg13_lv_nmos ad=56.9f pd=0.74u as=56.9f ps=0.74u w=0.17u l=0.17u
X2775 cml_tlatch_66.xmux.xp.S1 cml_tlatch_73.INN cml_tlatch_73.INP VSS sg13_lv_nmos ad=56.9f pd=0.74u as=56.9f ps=0.74u w=0.17u l=0.17u
X2776 MOT26_N MOT26_P cml_tlatch_63.xmux.xp.S1 VSS sg13_lv_nmos ad=56.9f pd=0.74u as=56.9f ps=0.74u w=0.17u l=0.17u
X2777 cml_tlatch_72.xtail.S1 CKHB3_P cml_tlatch_72.xmux.xn.S1 VSS sg13_lv_nmos ad=0.1598p pd=1.62u as=89.3f ps=0.85u w=0.47u l=0.16u
X2778 VSS POLN cml_tlatch_67.xtail.S1 VSS sg13_lv_nmos ad=2.7982p pd=17.14u as=1.5637p ps=8.61u w=8.23u l=0.13u
X2779 cml_tlatch_47.xmux.xp.S1 B2_2_P B2_2_N VSS sg13_lv_nmos ad=56.9f pd=0.74u as=56.9f ps=0.74u w=0.17u l=0.17u
X2780 cml_tlatch_93.xmux.xp.S1 CKJ_N cml_tlatch_93.xtail.S1 VSS sg13_lv_nmos ad=89.3f pd=0.85u as=0.1598p ps=1.62u w=0.47u l=0.16u
X2781 cml_tlatch_76.xtail.S1 CKA2_N cml_tlatch_76.xmux.xp.S1 VSS sg13_lv_nmos ad=89.3f pd=0.85u as=89.3f ps=0.85u w=0.47u l=0.16u
X2782 cml_tlatch_49.OUTP cml_tlatch_49.OUTN cml_tlatch_49.xmux.xp.S1 VSS sg13_lv_nmos ad=56.9f pd=0.74u as=56.9f ps=0.74u w=0.17u l=0.17u
X2783 B0_8_P B0_8_N cml_tlatch_1.xmux.xp.S1 VSS sg13_lv_nmos ad=56.9f pd=0.74u as=56.9f ps=0.74u w=0.17u l=0.17u
X2784 cml_tlatch_29.xmux.xp.S1 CKHA0_N cml_tlatch_29.xtail.S1 VSS sg13_lv_nmos ad=89.3f pd=0.85u as=89.3f ps=0.85u w=0.47u l=0.16u
X2785 cml_gate2_1.xrtail.R1 CKA0_P cml_gate2_1.xamp.xn.S1 VSS sg13_lv_nmos ad=0.1007p pd=0.91u as=0.1007p ps=0.91u w=0.53u l=0.13u
X2786 cml_tlatch_78.xmux.xp.S1 CKHB2_N cml_tlatch_78.xtail.S1 VSS sg13_lv_nmos ad=89.3f pd=0.85u as=89.3f ps=0.85u w=0.47u l=0.16u
X2787 cml_tlatch_23.xmux.xn.S1 cml_tlatch_0.OUTP cml_tlatch_23.OUTN VSS sg13_lv_nmos ad=63.19999f pd=0.74u as=63.19999f ps=0.74u w=0.26u l=0.38u
X2788 MOT14_P MOT14_N cml_tlatch_25.xmux.xp.S1 VSS sg13_lv_nmos ad=56.9f pd=0.74u as=56.9f ps=0.74u w=0.17u l=0.17u
X2789 cml_tlatch_41.OUTN D1_P cml_tlatch_41.xmux.xn.S1 VSS sg13_lv_nmos ad=63.19999f pd=0.74u as=63.19999f ps=0.74u w=0.26u l=0.38u
X2790 stub_bi_62.BOTN VDD VSS rppd l=5.17u w=1u
X2791 cml_tlatch_17.xmux.xp.S1 CKHB0_N cml_tlatch_17.xtail.S1 VSS sg13_lv_nmos ad=0.1598p pd=1.62u as=89.3f ps=0.85u w=0.47u l=0.16u
X2792 A2_2_P A2_2_N cml_tlatch_60.xmux.xp.S1 VSS sg13_lv_nmos ad=56.9f pd=0.74u as=56.9f ps=0.74u w=0.17u l=0.17u
X2793 cml_tlatch_74.INP cml_tlatch_74.INN cml_tlatch_88.xmux.xp.S1 VSS sg13_lv_nmos ad=56.9f pd=0.74u as=56.9f ps=0.74u w=0.17u l=0.17u
X2794 cml_tlatch_71.xmux.xn.S1 cml_tlatch_44.INN cml_tlatch_71.OUTP VSS sg13_lv_nmos ad=63.19999f pd=0.74u as=63.19999f ps=0.74u w=0.26u l=0.38u
X2795 cml_tlatch_3.xtail.S1 CKHB1_P cml_tlatch_3.xmux.xn.S1 VSS sg13_lv_nmos ad=89.3f pd=0.85u as=89.3f ps=0.85u w=0.47u l=0.16u
X2796 stub_bi_38.BOTN B2_2_N cml_tlatch_46.xmux.xn.S1 VSS sg13_lv_nmos ad=63.19999f pd=0.74u as=63.19999f ps=0.74u w=0.26u l=0.38u
X2797 cml_tlatch_42.xmux.xn.S1 A1_8_N MOT8_P VSS sg13_lv_nmos ad=63.19999f pd=0.74u as=0.1082p ps=1.34u w=0.26u l=0.38u
X2798 MOT18_P MOT18_N cml_tlatch_53.xmux.xp.S1 VSS sg13_lv_nmos ad=56.9f pd=0.74u as=56.9f ps=0.74u w=0.17u l=0.17u
X2799 A0_2_N A0_2_P cml_tlatch_34.xmux.xp.S1 VSS sg13_lv_nmos ad=56.9f pd=0.74u as=56.9f ps=0.74u w=0.17u l=0.17u
X2800 cml_tlatch_22.xmux.xn.S1 cml_tlatch_24.INP cml_tlatch_22.OUTN VSS sg13_lv_nmos ad=63.19999f pd=0.74u as=63.19999f ps=0.74u w=0.26u l=0.38u
X2801 cml_tlatch_73.xmux.xp.S1 CKHB3_N cml_tlatch_73.xtail.S1 VSS sg13_lv_nmos ad=89.3f pd=0.85u as=89.3f ps=0.85u w=0.47u l=0.16u
X2802 cml_tlatch_2.xmux.xp.S1 cml_tlatch_2.OUTN cml_tlatch_2.OUTP VSS sg13_lv_nmos ad=56.9f pd=0.74u as=56.9f ps=0.74u w=0.17u l=0.17u
X2803 cml_gate2_2.xamp.xn.S1 ENA0_P GA1_N VSS sg13_lv_nmos ad=0.1007p pd=0.91u as=0.1007p ps=0.91u w=0.53u l=0.13u
X2804 cml_tlatch_4.INN cml_tlatch_4.INP cml_tlatch_12.xmux.xp.S1 VSS sg13_lv_nmos ad=56.9f pd=0.74u as=56.9f ps=0.74u w=0.17u l=0.17u
X2805 J2_P J2_N cml_tlatch_94.xmux.xp.S1 VSS sg13_lv_nmos ad=56.9f pd=0.74u as=56.9f ps=0.74u w=0.17u l=0.17u
X2806 cml_tlatch_89.xtail.S1 CKA3_N cml_tlatch_89.xmux.xn.S1 VSS sg13_lv_nmos ad=89.3f pd=0.85u as=89.3f ps=0.85u w=0.47u l=0.16u
X2807 cml_tlatch_96.xmux.xp.S1 cml_tlatch_5.INN cml_tlatch_5.INP VSS sg13_lv_nmos ad=56.9f pd=0.74u as=56.9f ps=0.74u w=0.17u l=0.17u
X2808 cml_tlatch_26.xmux.xp.S1 MOT0_P MOT0_N VSS sg13_lv_nmos ad=0.1019p pd=1.34u as=56.9f ps=0.74u w=0.17u l=0.17u
X2809 ENB_N J2_P cml_gate2_8.xamp.xn.S1 VSS sg13_lv_nmos ad=0.1802p pd=1.74u as=0.1007p ps=0.91u w=0.53u l=0.13u
X2810 MOT30_N MOT30_P cml_tlatch_45.xmux.xp.S1 VSS sg13_lv_nmos ad=56.9f pd=0.74u as=56.9f ps=0.74u w=0.17u l=0.17u
X2811 cml_tlatch_45.xmux.xn.S1 CKHA3_P cml_tlatch_45.xtail.S1 VSS sg13_lv_nmos ad=89.3f pd=0.85u as=89.3f ps=0.85u w=0.47u l=0.16u
X2812 cml_tlatch_58.xmux.xp.S1 cml_tlatch_58.OUTN cml_tlatch_58.OUTP VSS sg13_lv_nmos ad=56.9f pd=0.74u as=56.9f ps=0.74u w=0.17u l=0.17u
X2813 cml_tlatch_68.xmux.xp.S1 A3_8_N A3_8_P VSS sg13_lv_nmos ad=56.9f pd=0.74u as=56.9f ps=0.74u w=0.17u l=0.17u
X2814 cml_tlatch_10.xmux.xn.S1 stub_bi_15.BOTP B1_8_P VSS sg13_lv_nmos ad=63.19999f pd=0.74u as=63.19999f ps=0.74u w=0.26u l=0.38u
X2815 VSS POLN cml_tlatch_14.xtail.S1 VSS sg13_lv_nmos ad=2.7982p pd=17.14u as=1.5637p ps=8.61u w=8.23u l=0.13u
X2816 cml_tlatch_41.xmux.xp.S1 CKA1_N cml_tlatch_41.xtail.S1 VSS sg13_lv_nmos ad=89.3f pd=0.85u as=89.3f ps=0.85u w=0.47u l=0.16u
X2817 cml_tlatch_88.xtail.S1 CKB3_N cml_tlatch_88.xmux.xn.S1 VSS sg13_lv_nmos ad=0.1598p pd=1.62u as=89.3f ps=0.85u w=0.47u l=0.16u
X2818 MOT14_N A1_2_P cml_tlatch_25.xmux.xn.S1 VSS sg13_lv_nmos ad=63.19999f pd=0.74u as=63.19999f ps=0.74u w=0.26u l=0.38u
X2819 cml_tlatch_87.INN cml_tlatch_87.INP cml_tlatch_76.xmux.xp.S1 VSS sg13_lv_nmos ad=56.9f pd=0.74u as=56.9f ps=0.74u w=0.17u l=0.17u
X2820 stub_bi_15.BOTN stub_bi_15.BOTP cml_tlatch_11.xmux.xp.S1 VSS sg13_lv_nmos ad=56.9f pd=0.74u as=56.9f ps=0.74u w=0.17u l=0.17u
X2821 cml_tlatch_84.xmux.xp.S1 stub_bi_49.BOTN stub_bi_49.BOTP VSS sg13_lv_nmos ad=56.9f pd=0.74u as=56.9f ps=0.74u w=0.17u l=0.17u
X2822 cml_tlatch_73.INN cml_tlatch_73.INP cml_tlatch_66.xmux.xp.S1 VSS sg13_lv_nmos ad=56.9f pd=0.74u as=56.9f ps=0.74u w=0.17u l=0.17u
X2823 cml_tlatch_64.xmux.xn.S1 CKB3_N cml_tlatch_64.xtail.S1 VSS sg13_lv_nmos ad=89.3f pd=0.85u as=89.3f ps=0.85u w=0.47u l=0.16u
X2824 cml_gate2_3.xamp.xn.S1 CKB0_P cml_gate2_3.xrtail.R1 VSS sg13_lv_nmos ad=0.1007p pd=0.91u as=0.1007p ps=0.91u w=0.53u l=0.13u
X2825 cml_tlatch_58.xtail.S1 POLN VSS VSS sg13_lv_nmos ad=1.5637p pd=8.61u as=1.5637p ps=8.61u w=8.23u l=0.13u
X2826 B0_8_N B0_8_P cml_tlatch_1.xmux.xp.S1 VSS sg13_lv_nmos ad=56.9f pd=0.74u as=0.1019p ps=1.34u w=0.17u l=0.17u
X2827 MOT14_N A1_2_P cml_tlatch_25.xmux.xn.S1 VSS sg13_lv_nmos ad=63.19999f pd=0.74u as=63.19999f ps=0.74u w=0.26u l=0.38u
X2828 cml_tlatch_61.xmux.xp.S1 CKA2_N cml_tlatch_61.xtail.S1 VSS sg13_lv_nmos ad=0.1598p pd=1.62u as=89.3f ps=0.85u w=0.47u l=0.16u
X2829 MOT7_N MOT7_P cml_tlatch_17.xmux.xp.S1 VSS sg13_lv_nmos ad=56.9f pd=0.74u as=56.9f ps=0.74u w=0.17u l=0.17u
X2830 cml_tlatch_16.xmux.xp.S1 CKHB0_N cml_tlatch_16.xtail.S1 VSS sg13_lv_nmos ad=89.3f pd=0.85u as=89.3f ps=0.85u w=0.47u l=0.16u
X2831 cml_tlatch_2.xtail.S1 CKB0_P cml_tlatch_2.xmux.xn.S1 VSS sg13_lv_nmos ad=89.3f pd=0.85u as=0.1598p ps=1.62u w=0.47u l=0.16u
X2832 cml_tlatch_27.xmux.xn.S1 CKHA0_P cml_tlatch_27.xtail.S1 VSS sg13_lv_nmos ad=89.3f pd=0.85u as=89.3f ps=0.85u w=0.47u l=0.16u
X2833 VDD MOT20_N VSS rppd l=5.17u w=1u
X2834 cml_tlatch_82.xmux.xn.S1 stub_bi_63.BOTN stub_bi_62.BOTP VSS sg13_lv_nmos ad=63.19999f pd=0.74u as=0.1082p ps=1.34u w=0.26u l=0.38u
X2835 VSS POLN cml_tlatch_85.xtail.S1 VSS sg13_lv_nmos ad=1.5637p pd=8.61u as=1.5637p ps=8.61u w=8.23u l=0.13u
X2836 cml_tlatch_85.xtail.S1 CKA2_P cml_tlatch_85.xmux.xp.S1 VSS sg13_lv_nmos ad=89.3f pd=0.85u as=89.3f ps=0.85u w=0.47u l=0.16u
X2837 cml_tlatch_98.xtail.S1 CKB0_N cml_tlatch_98.xmux.xn.S1 VSS sg13_lv_nmos ad=89.3f pd=0.85u as=89.3f ps=0.85u w=0.47u l=0.16u
X2838 B0_2_P B0_2_N cml_tlatch_31.xmux.xp.S1 VSS sg13_lv_nmos ad=56.9f pd=0.74u as=56.9f ps=0.74u w=0.17u l=0.17u
X2839 GA2_P ENA1_N cml_gate2_5.xamp.xn.S1 VSS sg13_lv_nmos ad=0.1007p pd=0.91u as=0.1007p ps=0.91u w=0.53u l=0.13u
X2840 cml_tlatch_82.xmux.xp.S1 CKB2_N cml_tlatch_82.xtail.S1 VSS sg13_lv_nmos ad=89.3f pd=0.85u as=89.3f ps=0.85u w=0.47u l=0.16u
X2841 cml_tlatch_11.xtail.S1 CKB1_P cml_tlatch_11.xmux.xn.S1 VSS sg13_lv_nmos ad=89.3f pd=0.85u as=89.3f ps=0.85u w=0.47u l=0.16u
X2842 cml_tlatch_85.xmux.xp.S1 A2_8_P A2_8_N VSS sg13_lv_nmos ad=56.9f pd=0.74u as=56.9f ps=0.74u w=0.17u l=0.17u
X2843 cml_tlatch_91.OUTN cml_tlatch_91.OUTP cml_tlatch_91.xmux.xp.S1 VSS sg13_lv_nmos ad=56.9f pd=0.74u as=56.9f ps=0.74u w=0.17u l=0.17u
X2844 cml_tlatch_99.xmux.xp.S1 cml_tlatch_99.OUTN cml_tlatch_99.OUTP VSS sg13_lv_nmos ad=56.9f pd=0.74u as=56.9f ps=0.74u w=0.17u l=0.17u
X2845 cml_tlatch_56.xmux.xp.S1 cml_tlatch_56.OUTP cml_tlatch_56.OUTN VSS sg13_lv_nmos ad=56.9f pd=0.74u as=56.9f ps=0.74u w=0.17u l=0.17u
X2846 cml_tlatch_54.xmux.xp.S1 MOT20_N MOT20_P VSS sg13_lv_nmos ad=56.9f pd=0.74u as=56.9f ps=0.74u w=0.17u l=0.17u
X2847 MOT19_P stub_bi_63.BOTP cml_tlatch_78.xmux.xn.S1 VSS sg13_lv_nmos ad=63.19999f pd=0.74u as=63.19999f ps=0.74u w=0.26u l=0.38u
X2848 cml_tlatch_39.xmux.xn.S1 A1_2_P cml_tlatch_97.INN VSS sg13_lv_nmos ad=63.19999f pd=0.74u as=63.19999f ps=0.74u w=0.26u l=0.38u
X2849 cml_tlatch_66.xmux.xp.S1 cml_tlatch_73.INP cml_tlatch_73.INN VSS sg13_lv_nmos ad=56.9f pd=0.74u as=56.9f ps=0.74u w=0.17u l=0.17u
X2850 cml_tlatch_14.xmux.xp.S1 CKHB0_N cml_tlatch_14.xtail.S1 VSS sg13_lv_nmos ad=0.1598p pd=1.62u as=89.3f ps=0.85u w=0.47u l=0.16u
X2851 A1_2_N A1_2_P cml_tlatch_40.xmux.xp.S1 VSS sg13_lv_nmos ad=56.9f pd=0.74u as=56.9f ps=0.74u w=0.17u l=0.17u
X2852 cml_tlatch_62.xtail.S1 CKHA3_P cml_tlatch_62.xmux.xn.S1 VSS sg13_lv_nmos ad=89.3f pd=0.85u as=89.3f ps=0.85u w=0.47u l=0.16u
X2853 cml_tlatch_81.xtail.S1 CKB2_P cml_tlatch_81.xmux.xp.S1 VSS sg13_lv_nmos ad=89.3f pd=0.85u as=89.3f ps=0.85u w=0.47u l=0.16u
X2854 A0_2_P cml_tlatch_38.OUTN cml_tlatch_34.xmux.xn.S1 VSS sg13_lv_nmos ad=0.1082p pd=1.34u as=63.19999f ps=0.74u w=0.26u l=0.38u
X2855 cml_tlatch_59.xmux.xp.S1 cml_tlatch_91.INN cml_tlatch_91.INP VSS sg13_lv_nmos ad=56.9f pd=0.74u as=56.9f ps=0.74u w=0.17u l=0.17u
X2856 cml_tlatch_33.xmux.xp.S1 CKA0_N cml_tlatch_33.xtail.S1 VSS sg13_lv_nmos ad=0.1598p pd=1.62u as=89.3f ps=0.85u w=0.47u l=0.16u
X2857 cml_tlatch_32.OUTP D0_N cml_tlatch_32.xmux.xn.S1 VSS sg13_lv_nmos ad=63.19999f pd=0.74u as=63.19999f ps=0.74u w=0.26u l=0.38u
X2858 A2_8_P cml_tlatch_86.OUTN cml_tlatch_85.xmux.xn.S1 VSS sg13_lv_nmos ad=63.19999f pd=0.74u as=63.19999f ps=0.74u w=0.26u l=0.38u
X2859 cml_tlatch_75.xmux.xn.S1 B3_2_P MOT31_N VSS sg13_lv_nmos ad=63.19999f pd=0.74u as=0.1082p ps=1.34u w=0.26u l=0.38u
X2860 A0_2_P cml_tlatch_38.OUTN cml_tlatch_34.xmux.xn.S1 VSS sg13_lv_nmos ad=63.19999f pd=0.74u as=63.19999f ps=0.74u w=0.26u l=0.38u
X2861 cml_tlatch_12.xmux.xn.S1 stub_bi_17.BOTP cml_tlatch_4.INP VSS sg13_lv_nmos ad=63.19999f pd=0.74u as=63.19999f ps=0.74u w=0.26u l=0.38u
X2862 cml_tlatch_28.xmux.xn.S1 cml_tlatch_99.OUTP MOT4_N VSS sg13_lv_nmos ad=63.19999f pd=0.74u as=63.19999f ps=0.74u w=0.26u l=0.38u
X2863 cml_tlatch_1.xtail.S1 CKB0_P cml_tlatch_1.xmux.xp.S1 VSS sg13_lv_nmos ad=89.3f pd=0.85u as=89.3f ps=0.85u w=0.47u l=0.16u
X2864 B0_8_N B0_8_P cml_tlatch_1.xmux.xp.S1 VSS sg13_lv_nmos ad=56.9f pd=0.74u as=56.9f ps=0.74u w=0.17u l=0.17u
X2865 cml_tlatch_0.xtail.S1 CKA0_P cml_tlatch_0.xmux.xn.S1 VSS sg13_lv_nmos ad=89.3f pd=0.85u as=89.3f ps=0.85u w=0.47u l=0.16u
X2866 cml_tlatch_34.xtail.S1 CKA0_N cml_tlatch_34.xmux.xn.S1 VSS sg13_lv_nmos ad=89.3f pd=0.85u as=89.3f ps=0.85u w=0.47u l=0.16u
X2867 cml_drvb_6.xrtail.R2 GB3_N CKHB3_P VSS sg13_lv_nmos ad=0.1463p pd=1.15u as=0.2618p ps=2.22u w=0.77u l=0.21u
X2868 cml_tlatch_12.xmux.xn.S1 stub_bi_17.BOTP cml_tlatch_4.INP VSS sg13_lv_nmos ad=63.19999f pd=0.74u as=63.19999f ps=0.74u w=0.26u l=0.38u
X2869 cml_gate2_1.xamp.xn.S1 ENB1_P GB0_N VSS sg13_lv_nmos ad=0.1007p pd=0.91u as=0.1007p ps=0.91u w=0.53u l=0.13u
X2870 cml_tlatch_47.xmux.xp.S1 B2_2_N B2_2_P VSS sg13_lv_nmos ad=0.1019p pd=1.34u as=56.9f ps=0.74u w=0.17u l=0.17u
X2871 VSS POLN cml_tlatch_31.xtail.S1 VSS sg13_lv_nmos ad=2.7982p pd=17.14u as=1.5637p ps=8.61u w=8.23u l=0.13u
X2872 MOT1_P MOT1_N cml_tlatch_14.xmux.xp.S1 VSS sg13_lv_nmos ad=56.9f pd=0.74u as=56.9f ps=0.74u w=0.17u l=0.17u
X2873 cml_gate2_2.xamp.xn.S1 ENA0_N GA1_P VSS sg13_lv_nmos ad=0.1007p pd=0.91u as=0.1007p ps=0.91u w=0.53u l=0.13u
X2874 stub_bi_31.BOTN stub_bi_31.BOTP cml_tlatch_37.xmux.xp.S1 VSS sg13_lv_nmos ad=56.9f pd=0.74u as=56.9f ps=0.74u w=0.17u l=0.17u
X2875 A0_2_N A0_2_P cml_tlatch_34.xmux.xp.S1 VSS sg13_lv_nmos ad=56.9f pd=0.74u as=56.9f ps=0.74u w=0.17u l=0.17u
X2876 cml_tlatch_50.xmux.xn.S1 CKB3_N cml_tlatch_50.xtail.S1 VSS sg13_lv_nmos ad=89.3f pd=0.85u as=89.3f ps=0.85u w=0.47u l=0.16u
X2877 cml_tlatch_63.xmux.xp.S1 MOT26_N MOT26_P VSS sg13_lv_nmos ad=56.9f pd=0.74u as=56.9f ps=0.74u w=0.17u l=0.17u
X2878 MOT16_P MOT16_N cml_tlatch_52.xmux.xp.S1 VSS sg13_lv_nmos ad=56.9f pd=0.74u as=56.9f ps=0.74u w=0.17u l=0.17u
X2879 cml_tlatch_69.xtail.S1 CKA3_P cml_tlatch_69.xmux.xn.S1 VSS sg13_lv_nmos ad=89.3f pd=0.85u as=89.3f ps=0.85u w=0.47u l=0.16u
X2880 cml_tlatch_62.xmux.xp.S1 MOT24_N MOT24_P VSS sg13_lv_nmos ad=56.9f pd=0.74u as=56.9f ps=0.74u w=0.17u l=0.17u
X2881 cml_tlatch_27.xtail.S1 CKHA0_N cml_tlatch_27.xmux.xp.S1 VSS sg13_lv_nmos ad=89.3f pd=0.85u as=89.3f ps=0.85u w=0.47u l=0.16u
X2882 cml_tlatch_87.xtail.S1 CKA2_P cml_tlatch_87.xmux.xp.S1 VSS sg13_lv_nmos ad=89.3f pd=0.85u as=89.3f ps=0.85u w=0.47u l=0.16u
X2883 cml_tlatch_32.xmux.xp.S1 CKB0_N cml_tlatch_32.xtail.S1 VSS sg13_lv_nmos ad=89.3f pd=0.85u as=89.3f ps=0.85u w=0.47u l=0.16u
X2884 cml_tlatch_23.OUTP cml_tlatch_23.OUTN cml_tlatch_23.xmux.xp.S1 VSS sg13_lv_nmos ad=56.9f pd=0.74u as=56.9f ps=0.74u w=0.17u l=0.17u
X2885 hs_to_clk_1.D2 POLN VSS VSS sg13_lv_nmos ad=3.4p pd=20.68u as=1.9p ps=10.38u w=10u l=0.13u
X2886 GA1_P ENA0_N cml_gate2_2.xamp.xn.S1 VSS sg13_lv_nmos ad=0.1007p pd=0.91u as=0.1007p ps=0.91u w=0.53u l=0.13u
X2887 MOT10_P MOT10_N cml_tlatch_43.xmux.xp.S1 VSS sg13_lv_nmos ad=56.9f pd=0.74u as=56.9f ps=0.74u w=0.17u l=0.17u
X2888 cml_tlatch_29.xtail.S1 CKHA0_N cml_tlatch_29.xmux.xp.S1 VSS sg13_lv_nmos ad=89.3f pd=0.85u as=89.3f ps=0.85u w=0.47u l=0.16u
X2889 cml_tlatch_82.xmux.xp.S1 stub_bi_62.BOTN stub_bi_62.BOTP VSS sg13_lv_nmos ad=56.9f pd=0.74u as=56.9f ps=0.74u w=0.17u l=0.17u
X2890 cml_tlatch_17.xmux.xp.S1 MOT7_N MOT7_P VSS sg13_lv_nmos ad=56.9f pd=0.74u as=56.9f ps=0.74u w=0.17u l=0.17u
X2891 J2_P J1_N cml_tlatch_94.xmux.xn.S1 VSS sg13_lv_nmos ad=63.19999f pd=0.74u as=63.19999f ps=0.74u w=0.26u l=0.38u
X2892 hs_to_clk_6.D2 POLN VSS VSS sg13_lv_nmos ad=1.9p pd=10.38u as=1.9p ps=10.38u w=10u l=0.13u
X2893 cml_tlatch_83.xtail.S1 CKB2_P cml_tlatch_83.xmux.xp.S1 VSS sg13_lv_nmos ad=0.1598p pd=1.62u as=89.3f ps=0.85u w=0.47u l=0.16u
X2894 cml_tlatch_4.xmux.xn.S1 cml_tlatch_4.INP MOT11_N VSS sg13_lv_nmos ad=63.19999f pd=0.74u as=63.19999f ps=0.74u w=0.26u l=0.38u
X2895 VDD cml_tlatch_91.INP VSS rppd l=5.17u w=1u
X2896 cml_tlatch_99.xmux.xn.S1 cml_tlatch_33.OUTN cml_tlatch_99.OUTP VSS sg13_lv_nmos ad=63.19999f pd=0.74u as=63.19999f ps=0.74u w=0.26u l=0.38u
X2897 cml_tlatch_19.xtail.S1 POLN VSS VSS sg13_lv_nmos ad=1.5637p pd=8.61u as=1.5637p ps=8.61u w=8.23u l=0.13u
X2898 cml_gate2_6.xamp.xn.S1 ENB0_N GB3_P VSS sg13_lv_nmos ad=0.1007p pd=0.91u as=0.1007p ps=0.91u w=0.53u l=0.13u
X2899 cml_tlatch_0.xmux.xp.S1 cml_tlatch_0.OUTN cml_tlatch_0.OUTP VSS sg13_lv_nmos ad=56.9f pd=0.74u as=56.9f ps=0.74u w=0.17u l=0.17u
X2900 cml_tlatch_37.xtail.S1 POLN VSS VSS sg13_lv_nmos ad=1.5637p pd=8.61u as=2.7982p ps=17.14u w=8.23u l=0.13u
X2901 cml_tlatch_93.xmux.xn.S1 CKJ_P cml_tlatch_93.xtail.S1 VSS sg13_lv_nmos ad=89.3f pd=0.85u as=89.3f ps=0.85u w=0.47u l=0.16u
X2902 MOT26_P MOT26_N cml_tlatch_63.xmux.xp.S1 VSS sg13_lv_nmos ad=56.9f pd=0.74u as=56.9f ps=0.74u w=0.17u l=0.17u
X2903 cml_drv_1.xrtail.R1 ENA_P ENA1_N VSS sg13_lv_nmos ad=56.2f pd=0.74u as=56.2f ps=0.74u w=0.16u l=0.19u
X2904 cml_tlatch_50.xmux.xp.S1 B3_2_P B3_2_N VSS sg13_lv_nmos ad=56.9f pd=0.74u as=56.9f ps=0.74u w=0.17u l=0.17u
X2905 B0_2_P B0_2_N cml_tlatch_31.xmux.xp.S1 VSS sg13_lv_nmos ad=56.9f pd=0.74u as=56.9f ps=0.74u w=0.17u l=0.17u
X2906 cml_tlatch_33.xmux.xp.S1 cml_tlatch_33.OUTN cml_tlatch_33.OUTP VSS sg13_lv_nmos ad=56.9f pd=0.74u as=56.9f ps=0.74u w=0.17u l=0.17u
X2907 B2_8_N B2_8_P cml_tlatch_81.xmux.xp.S1 VSS sg13_lv_nmos ad=56.9f pd=0.74u as=56.9f ps=0.74u w=0.17u l=0.17u
X2908 cml_tlatch_55.xtail.S1 CKHA2_N cml_tlatch_55.xmux.xp.S1 VSS sg13_lv_nmos ad=89.3f pd=0.85u as=89.3f ps=0.85u w=0.47u l=0.16u
X2909 cml_tlatch_84.xmux.xp.S1 stub_bi_49.BOTP stub_bi_49.BOTN VSS sg13_lv_nmos ad=56.9f pd=0.74u as=56.9f ps=0.74u w=0.17u l=0.17u
X2910 cml_tlatch_22.OUTP cml_tlatch_22.OUTN cml_tlatch_22.xmux.xp.S1 VSS sg13_lv_nmos ad=56.9f pd=0.74u as=56.9f ps=0.74u w=0.17u l=0.17u
X2911 cml_tlatch_77.xmux.xp.S1 MOT17_N MOT17_P VSS sg13_lv_nmos ad=56.9f pd=0.74u as=56.9f ps=0.74u w=0.17u l=0.17u
X2912 MOT2_N MOT2_P cml_tlatch_27.xmux.xp.S1 VSS sg13_lv_nmos ad=56.9f pd=0.74u as=56.9f ps=0.74u w=0.17u l=0.17u
X2913 MOT9_N MOT9_P cml_tlatch_3.xmux.xp.S1 VSS sg13_lv_nmos ad=56.9f pd=0.74u as=56.9f ps=0.74u w=0.17u l=0.17u
X2914 A2_8_P A2_8_N cml_tlatch_85.xmux.xp.S1 VSS sg13_lv_nmos ad=56.9f pd=0.74u as=56.9f ps=0.74u w=0.17u l=0.17u
X2915 MOT25_P MOT25_N cml_tlatch_72.xmux.xp.S1 VSS sg13_lv_nmos ad=56.9f pd=0.74u as=56.9f ps=0.74u w=0.17u l=0.17u
X2916 cml_tlatch_81.xmux.xp.S1 B2_8_N B2_8_P VSS sg13_lv_nmos ad=56.9f pd=0.74u as=56.9f ps=0.74u w=0.17u l=0.17u
X2917 cml_tlatch_24.INN cml_tlatch_24.INP cml_tlatch_97.xmux.xp.S1 VSS sg13_lv_nmos ad=56.9f pd=0.74u as=56.9f ps=0.74u w=0.17u l=0.17u
X2918 cml_tlatch_36.xmux.xp.S1 CKB1_P cml_tlatch_36.xtail.S1 VSS sg13_lv_nmos ad=89.3f pd=0.85u as=89.3f ps=0.85u w=0.47u l=0.16u
X2919 cml_tlatch_79.xmux.xn.S1 CKHB2_P cml_tlatch_79.xtail.S1 VSS sg13_lv_nmos ad=89.3f pd=0.85u as=0.1598p ps=1.62u w=0.47u l=0.16u
X2920 cml_tlatch_16.xtail.S1 POLN VSS VSS sg13_lv_nmos ad=1.5637p pd=8.61u as=2.7982p ps=17.14u w=8.23u l=0.13u
X2921 cml_tlatch_86.xmux.xn.S1 cml_tlatch_87.OUTN cml_tlatch_86.OUTP VSS sg13_lv_nmos ad=63.19999f pd=0.74u as=63.19999f ps=0.74u w=0.26u l=0.38u
X2922 cml_tlatch_60.xmux.xp.S1 CKA2_P cml_tlatch_60.xtail.S1 VSS sg13_lv_nmos ad=89.3f pd=0.85u as=89.3f ps=0.85u w=0.47u l=0.16u
X2923 cml_tlatch_13.xtail.S1 CKB1_N cml_tlatch_13.xmux.xp.S1 VSS sg13_lv_nmos ad=89.3f pd=0.85u as=89.3f ps=0.85u w=0.47u l=0.16u
X2924 cml_tlatch_28.xmux.xp.S1 MOT4_P MOT4_N VSS sg13_lv_nmos ad=56.9f pd=0.74u as=56.9f ps=0.74u w=0.17u l=0.17u
X2925 cml_tlatch_4.xmux.xp.S1 MOT11_N MOT11_P VSS sg13_lv_nmos ad=56.9f pd=0.74u as=56.9f ps=0.74u w=0.17u l=0.17u
X2926 cml_tlatch_86.xmux.xn.S1 cml_tlatch_87.OUTN cml_tlatch_86.OUTP VSS sg13_lv_nmos ad=63.19999f pd=0.74u as=63.19999f ps=0.74u w=0.26u l=0.38u
X2927 stub_bi_38.BOTN stub_bi_38.BOTP cml_tlatch_46.xmux.xp.S1 VSS sg13_lv_nmos ad=56.9f pd=0.74u as=56.9f ps=0.74u w=0.17u l=0.17u
X2928 cml_tlatch_3.xmux.xp.S1 MOT9_N MOT9_P VSS sg13_lv_nmos ad=56.9f pd=0.74u as=56.9f ps=0.74u w=0.17u l=0.17u
X2929 cml_tlatch_4.xtail.S1 CKHB1_P cml_tlatch_4.xmux.xn.S1 VSS sg13_lv_nmos ad=89.3f pd=0.85u as=89.3f ps=0.85u w=0.47u l=0.16u
X2930 cml_tlatch_41.OUTP D1_N cml_tlatch_41.xmux.xn.S1 VSS sg13_lv_nmos ad=63.19999f pd=0.74u as=63.19999f ps=0.74u w=0.26u l=0.38u
X2931 cml_tlatch_93.xmux.xn.S1 J2_N CLK_W_N VSS sg13_lv_nmos ad=63.19999f pd=0.74u as=63.19999f ps=0.74u w=0.26u l=0.38u
X2932 VSS hs_to_clk_6.sg13_lv_nmos_2HGZLP_0.G VSS VSS sg13_lv_nmos ad=2.071p pd=11.28u as=0 ps=0 w=10.9u l=1.38u
X2933 cml_tlatch_87.xmux.xp.S1 cml_tlatch_87.OUTP cml_tlatch_87.OUTN VSS sg13_lv_nmos ad=0.1019p pd=1.34u as=56.9f ps=0.74u w=0.17u l=0.17u
X2934 cml_tlatch_84.xmux.xn.S1 stub_bi_55.BOTP stub_bi_49.BOTN VSS sg13_lv_nmos ad=0.1082p pd=1.34u as=63.19999f ps=0.74u w=0.26u l=0.38u
X2935 cml_tlatch_67.xmux.xn.S1 CKB3_P cml_tlatch_67.xtail.S1 VSS sg13_lv_nmos ad=89.3f pd=0.85u as=89.3f ps=0.85u w=0.47u l=0.16u
X2936 cml_tlatch_57.xmux.xn.S1 cml_tlatch_58.OUTP A3_2_N VSS sg13_lv_nmos ad=63.19999f pd=0.74u as=63.19999f ps=0.74u w=0.26u l=0.38u
X2937 cml_tlatch_90.xmux.xp.S1 stub_bi_55.BOTP stub_bi_55.BOTN VSS sg13_lv_nmos ad=56.9f pd=0.74u as=56.9f ps=0.74u w=0.17u l=0.17u
X2938 cml_tlatch_74.xmux.xn.S1 CKHB3_P cml_tlatch_74.xtail.S1 VSS sg13_lv_nmos ad=89.3f pd=0.85u as=89.3f ps=0.85u w=0.47u l=0.16u
X2939 MOT25_N MOT25_P cml_tlatch_72.xmux.xp.S1 VSS sg13_lv_nmos ad=56.9f pd=0.74u as=56.9f ps=0.74u w=0.17u l=0.17u
X2940 cml_tlatch_99.xtail.S1 CKA0_P cml_tlatch_99.xmux.xp.S1 VSS sg13_lv_nmos ad=89.3f pd=0.85u as=89.3f ps=0.85u w=0.47u l=0.16u
X2941 MOT16_P A2_8_N cml_tlatch_52.xmux.xn.S1 VSS sg13_lv_nmos ad=0.1082p pd=1.34u as=63.19999f ps=0.74u w=0.26u l=0.38u
X2942 cml_tlatch_17.xmux.xp.S1 CKHB0_N cml_tlatch_17.xtail.S1 VSS sg13_lv_nmos ad=89.3f pd=0.85u as=89.3f ps=0.85u w=0.47u l=0.16u
X2943 A0_2_N cml_tlatch_38.OUTP cml_tlatch_34.xmux.xn.S1 VSS sg13_lv_nmos ad=63.19999f pd=0.74u as=63.19999f ps=0.74u w=0.26u l=0.38u
X2944 cml_tlatch_11.xmux.xn.S1 CKB1_P cml_tlatch_11.xtail.S1 VSS sg13_lv_nmos ad=89.3f pd=0.85u as=89.3f ps=0.85u w=0.47u l=0.16u
X2945 J4_N J4_P cml_tlatch_92.xmux.xp.S1 VSS sg13_lv_nmos ad=56.9f pd=0.74u as=56.9f ps=0.74u w=0.17u l=0.17u
X2946 cml_tlatch_48.xmux.xn.S1 D2_P stub_bi_43.BOTP VSS sg13_lv_nmos ad=63.19999f pd=0.74u as=0.1082p ps=1.34u w=0.26u l=0.38u
X2947 cml_tlatch_98.xmux.xp.S1 cml_tlatch_98.OUTN cml_tlatch_98.OUTP VSS sg13_lv_nmos ad=56.9f pd=0.74u as=56.9f ps=0.74u w=0.17u l=0.17u
X2948 cml_tlatch_74.xmux.xn.S1 cml_tlatch_74.INN MOT29_P VSS sg13_lv_nmos ad=0.1082p pd=1.34u as=63.19999f ps=0.74u w=0.26u l=0.38u
X2949 MOT15_P MOT15_N cml_tlatch_6.xmux.xp.S1 VSS sg13_lv_nmos ad=56.9f pd=0.74u as=56.9f ps=0.74u w=0.17u l=0.17u
X2950 cml_tlatch_25.xtail.S1 CKHA1_N cml_tlatch_25.xmux.xp.S1 VSS sg13_lv_nmos ad=89.3f pd=0.85u as=89.3f ps=0.85u w=0.47u l=0.16u
X2951 MOT6_N MOT6_P cml_tlatch_29.xmux.xp.S1 VSS sg13_lv_nmos ad=56.9f pd=0.74u as=56.9f ps=0.74u w=0.17u l=0.17u
X2952 cml_tlatch_71.OUTN cml_tlatch_71.OUTP cml_tlatch_71.xmux.xp.S1 VSS sg13_lv_nmos ad=56.9f pd=0.74u as=56.9f ps=0.74u w=0.17u l=0.17u
X2953 cml_tlatch_63.xmux.xn.S1 cml_tlatch_63.INP MOT26_N VSS sg13_lv_nmos ad=63.19999f pd=0.74u as=63.19999f ps=0.74u w=0.26u l=0.38u
X2954 stub_bi_62.BOTN stub_bi_62.BOTP cml_tlatch_82.xmux.xp.S1 VSS sg13_lv_nmos ad=56.9f pd=0.74u as=56.9f ps=0.74u w=0.17u l=0.17u
X2955 cml_tlatch_20.xmux.xp.S1 cml_tlatch_20.OUTN cml_tlatch_20.OUTP VSS sg13_lv_nmos ad=56.9f pd=0.74u as=56.9f ps=0.74u w=0.17u l=0.17u
X2956 stub_bi_49.BOTP stub_bi_55.BOTN cml_tlatch_84.xmux.xn.S1 VSS sg13_lv_nmos ad=63.19999f pd=0.74u as=63.19999f ps=0.74u w=0.26u l=0.38u
X2957 stub_bi_31.BOTP stub_bi_31.BOTN cml_tlatch_37.xmux.xp.S1 VSS sg13_lv_nmos ad=56.9f pd=0.74u as=0.1019p ps=1.34u w=0.17u l=0.17u
X2958 VSS POLN hs_to_clk_7.D2 VSS sg13_lv_nmos ad=1.9p pd=10.38u as=1.9p ps=10.38u w=10u l=0.13u
X2959 cml_tlatch_44.INP cml_tlatch_44.INN cml_tlatch_89.xmux.xp.S1 VSS sg13_lv_nmos ad=56.9f pd=0.74u as=0.1019p ps=1.34u w=0.17u l=0.17u
X2960 cml_tlatch_63.xmux.xn.S1 cml_tlatch_63.INP MOT26_N VSS sg13_lv_nmos ad=63.19999f pd=0.74u as=63.19999f ps=0.74u w=0.26u l=0.38u
X2961 cml_tlatch_75.xmux.xp.S1 MOT31_P MOT31_N VSS sg13_lv_nmos ad=0.1019p pd=1.34u as=56.9f ps=0.74u w=0.17u l=0.17u
X2962 cml_tlatch_79.xtail.S1 CKHB2_N cml_tlatch_79.xmux.xp.S1 VSS sg13_lv_nmos ad=89.3f pd=0.85u as=89.3f ps=0.85u w=0.47u l=0.16u
X2963 cml_tlatch_15.xmux.xp.S1 MOT3_P MOT3_N VSS sg13_lv_nmos ad=56.9f pd=0.74u as=56.9f ps=0.74u w=0.17u l=0.17u
X2964 cml_gate2_0.xamp.xn.S1 ENB1_P GB1_N VSS sg13_lv_nmos ad=0.1007p pd=0.91u as=0.1007p ps=0.91u w=0.53u l=0.13u
X2965 cml_tlatch_20.OUTN cml_tlatch_20.OUTP cml_tlatch_20.xmux.xp.S1 VSS sg13_lv_nmos ad=56.9f pd=0.74u as=0.1019p ps=1.34u w=0.17u l=0.17u
X2966 cml_tlatch_20.xmux.xp.S1 CKA1_N cml_tlatch_20.xtail.S1 VSS sg13_lv_nmos ad=89.3f pd=0.85u as=89.3f ps=0.85u w=0.47u l=0.16u
X2967 cml_tlatch_38.xmux.xp.S1 CKA0_N cml_tlatch_38.xtail.S1 VSS sg13_lv_nmos ad=89.3f pd=0.85u as=0.1598p ps=1.62u w=0.47u l=0.16u
X2968 cml_tlatch_50.xmux.xp.S1 B3_2_P B3_2_N VSS sg13_lv_nmos ad=56.9f pd=0.74u as=56.9f ps=0.74u w=0.17u l=0.17u
X2969 cml_tlatch_53.xtail.S1 CKHA2_P cml_tlatch_53.xmux.xn.S1 VSS sg13_lv_nmos ad=89.3f pd=0.85u as=89.3f ps=0.85u w=0.47u l=0.16u
X2970 MOT6_P MOT6_N cml_tlatch_29.xmux.xp.S1 VSS sg13_lv_nmos ad=56.9f pd=0.74u as=56.9f ps=0.74u w=0.17u l=0.17u
X2971 A2_2_N A2_2_P cml_tlatch_60.xmux.xp.S1 VSS sg13_lv_nmos ad=56.9f pd=0.74u as=56.9f ps=0.74u w=0.17u l=0.17u
X2972 MOT0_N MOT0_P cml_tlatch_26.xmux.xp.S1 VSS sg13_lv_nmos ad=56.9f pd=0.74u as=56.9f ps=0.74u w=0.17u l=0.17u
X2973 cml_tlatch_30.xmux.xp.S1 cml_tlatch_30.OUTP cml_tlatch_30.OUTN VSS sg13_lv_nmos ad=56.9f pd=0.74u as=56.9f ps=0.74u w=0.17u l=0.17u
X2974 cml_tlatch_2.OUTN VDD VSS rppd l=5.17u w=1u
X2975 cml_tlatch_75.xmux.xn.S1 CKHB3_P cml_tlatch_75.xtail.S1 VSS sg13_lv_nmos ad=89.3f pd=0.85u as=89.3f ps=0.85u w=0.47u l=0.16u
X2976 VDD cml_tlatch_87.OUTN VSS rppd l=5.17u w=1u
X2977 cml_tlatch_86.xmux.xp.S1 CKA2_N cml_tlatch_86.xtail.S1 VSS sg13_lv_nmos ad=0.1598p pd=1.62u as=89.3f ps=0.85u w=0.47u l=0.16u
X2978 cml_tlatch_19.xmux.xn.S1 CKA1_N cml_tlatch_19.xtail.S1 VSS sg13_lv_nmos ad=89.3f pd=0.85u as=89.3f ps=0.85u w=0.47u l=0.16u
X2979 A1_8_N cml_tlatch_20.OUTP cml_tlatch_19.xmux.xn.S1 VSS sg13_lv_nmos ad=63.19999f pd=0.74u as=63.19999f ps=0.74u w=0.26u l=0.38u
X2980 cml_tlatch_39.xtail.S1 CKA1_P cml_tlatch_39.xmux.xn.S1 VSS sg13_lv_nmos ad=89.3f pd=0.85u as=89.3f ps=0.85u w=0.47u l=0.16u
X2981 MOT15_N B1_2_P cml_tlatch_6.xmux.xn.S1 VSS sg13_lv_nmos ad=63.19999f pd=0.74u as=63.19999f ps=0.74u w=0.26u l=0.38u
X2982 VSS POLN cml_tlatch_52.xtail.S1 VSS sg13_lv_nmos ad=1.5637p pd=8.61u as=1.5637p ps=8.61u w=8.23u l=0.13u
X2983 cml_tlatch_78.xmux.xp.S1 MOT19_P MOT19_N VSS sg13_lv_nmos ad=56.9f pd=0.74u as=56.9f ps=0.74u w=0.17u l=0.17u
X2984 cml_gate2_1.xamp.xn.S1 CKA0_P cml_gate2_1.xrtail.R1 VSS sg13_lv_nmos ad=0.1007p pd=0.91u as=0.1007p ps=0.91u w=0.53u l=0.13u
X2985 cml_tlatch_67.OUTN cml_tlatch_67.OUTP cml_tlatch_67.xmux.xp.S1 VSS sg13_lv_nmos ad=56.9f pd=0.74u as=0.1019p ps=1.34u w=0.17u l=0.17u
X2986 cml_tlatch_46.xmux.xn.S1 B2_2_N stub_bi_38.BOTN VSS sg13_lv_nmos ad=63.19999f pd=0.74u as=63.19999f ps=0.74u w=0.26u l=0.38u
X2987 MOT15_N B1_2_P cml_tlatch_6.xmux.xn.S1 VSS sg13_lv_nmos ad=63.19999f pd=0.74u as=63.19999f ps=0.74u w=0.26u l=0.38u
X2988 cml_gate2_7.xamp.xn.S1 ENB0_N GB2_P VSS sg13_lv_nmos ad=0.1007p pd=0.91u as=0.1007p ps=0.91u w=0.53u l=0.13u
X2989 cml_tlatch_98.xtail.S1 CKB0_N cml_tlatch_98.xmux.xn.S1 VSS sg13_lv_nmos ad=89.3f pd=0.85u as=89.3f ps=0.85u w=0.47u l=0.16u
X2990 A0_8_N A0_8_P cml_tlatch_9.xmux.xp.S1 VSS sg13_lv_nmos ad=56.9f pd=0.74u as=0.1019p ps=1.34u w=0.17u l=0.17u
X2991 cml_tlatch_31.xmux.xp.S1 CKB0_P cml_tlatch_31.xtail.S1 VSS sg13_lv_nmos ad=89.3f pd=0.85u as=89.3f ps=0.85u w=0.47u l=0.16u
X2992 stub_bi_31.BOTP stub_bi_31.BOTN cml_tlatch_37.xmux.xp.S1 VSS sg13_lv_nmos ad=56.9f pd=0.74u as=56.9f ps=0.74u w=0.17u l=0.17u
X2993 cml_tlatch_42.xmux.xn.S1 A1_8_P MOT8_N VSS sg13_lv_nmos ad=63.19999f pd=0.74u as=63.19999f ps=0.74u w=0.26u l=0.38u
X2994 cml_tlatch_92.xmux.xp.S1 J4_N J4_P VSS sg13_lv_nmos ad=56.9f pd=0.74u as=56.9f ps=0.74u w=0.17u l=0.17u
X2995 cml_gate2_3.xrtail.R1 CKB0_N GA0_P VSS sg13_lv_nmos ad=0.1007p pd=0.91u as=0.1007p ps=0.91u w=0.53u l=0.13u
X2996 cml_tlatch_0.OUTN cml_tlatch_99.OUTP cml_tlatch_0.xmux.xn.S1 VSS sg13_lv_nmos ad=63.19999f pd=0.74u as=63.19999f ps=0.74u w=0.26u l=0.38u
X2997 cml_tlatch_43.xmux.xp.S1 MOT10_P MOT10_N VSS sg13_lv_nmos ad=56.9f pd=0.74u as=56.9f ps=0.74u w=0.17u l=0.17u
X2998 VSS POLN cml_tlatch_5.xtail.S1 VSS sg13_lv_nmos ad=2.7982p pd=17.14u as=1.5637p ps=8.61u w=8.23u l=0.13u
X2999 cml_tlatch_10.xmux.xn.S1 CKB1_N cml_tlatch_10.xtail.S1 VSS sg13_lv_nmos ad=89.3f pd=0.85u as=89.3f ps=0.85u w=0.47u l=0.16u
X3000 cml_tlatch_71.xmux.xp.S1 CKA3_N cml_tlatch_71.xtail.S1 VSS sg13_lv_nmos ad=89.3f pd=0.85u as=89.3f ps=0.85u w=0.47u l=0.16u
X3001 cml_drvb_8.xrtail.R2 J4_P NS1_P VSS sg13_lv_nmos ad=0.1463p pd=1.15u as=0.2618p ps=2.22u w=0.77u l=0.21u
X3002 MOT24_N A3_8_P cml_tlatch_62.xmux.xn.S1 VSS sg13_lv_nmos ad=63.19999f pd=0.74u as=63.19999f ps=0.74u w=0.26u l=0.38u
X3003 cml_tlatch_18.OUTN cml_tlatch_18.OUTP cml_tlatch_18.xmux.xp.S1 VSS sg13_lv_nmos ad=56.9f pd=0.74u as=56.9f ps=0.74u w=0.17u l=0.17u
X3004 cml_tlatch_14.xmux.xp.S1 CKHB0_N cml_tlatch_14.xtail.S1 VSS sg13_lv_nmos ad=89.3f pd=0.85u as=89.3f ps=0.85u w=0.47u l=0.16u
X3005 cml_tlatch_64.xmux.xp.S1 B3_8_P B3_8_N VSS sg13_lv_nmos ad=56.9f pd=0.74u as=56.9f ps=0.74u w=0.17u l=0.17u
X3006 cml_tlatch_19.xmux.xp.S1 A1_8_N A1_8_P VSS sg13_lv_nmos ad=56.9f pd=0.74u as=56.9f ps=0.74u w=0.17u l=0.17u
X3007 stub_bi_43.BOTN stub_bi_43.BOTP cml_tlatch_48.xmux.xp.S1 VSS sg13_lv_nmos ad=56.9f pd=0.74u as=56.9f ps=0.74u w=0.17u l=0.17u
X3008 cml_tlatch_41.xmux.xp.S1 cml_tlatch_41.OUTN cml_tlatch_41.OUTP VSS sg13_lv_nmos ad=56.9f pd=0.74u as=56.9f ps=0.74u w=0.17u l=0.17u
X3009 cml_tlatch_79.xmux.xn.S1 stub_bi_55.BOTN MOT21_N VSS sg13_lv_nmos ad=63.19999f pd=0.74u as=63.19999f ps=0.74u w=0.26u l=0.38u
X3010 stub_bi_38.BOTP B2_2_P cml_tlatch_46.xmux.xn.S1 VSS sg13_lv_nmos ad=63.19999f pd=0.74u as=63.19999f ps=0.74u w=0.26u l=0.38u
X3011 cml_tlatch_15.xtail.S1 POLN VSS VSS sg13_lv_nmos ad=1.5637p pd=8.61u as=2.7982p ps=17.14u w=8.23u l=0.13u
X3012 cml_tlatch_74.INN cml_tlatch_74.INP cml_tlatch_88.xmux.xp.S1 VSS sg13_lv_nmos ad=56.9f pd=0.74u as=56.9f ps=0.74u w=0.17u l=0.17u
X3013 cml_tlatch_33.xmux.xn.S1 A0_2_P cml_tlatch_33.OUTN VSS sg13_lv_nmos ad=63.19999f pd=0.74u as=63.19999f ps=0.74u w=0.26u l=0.38u
X3014 ENA_P J1_N cml_gate2_9.xamp.xn.S1 VSS sg13_lv_nmos ad=0.1007p pd=0.91u as=0.1007p ps=0.91u w=0.53u l=0.13u
X3015 cml_gate2_8.xamp.xn.S1 J2_P ENB_N VSS sg13_lv_nmos ad=0.1007p pd=0.91u as=0.1007p ps=0.91u w=0.53u l=0.13u
X3016 cml_tlatch_32.OUTP cml_tlatch_32.OUTN cml_tlatch_32.xmux.xp.S1 VSS sg13_lv_nmos ad=56.9f pd=0.74u as=56.9f ps=0.74u w=0.17u l=0.17u
X3017 cml_tlatch_53.xmux.xp.S1 CKHA2_N cml_tlatch_53.xtail.S1 VSS sg13_lv_nmos ad=0.1598p pd=1.62u as=89.3f ps=0.85u w=0.47u l=0.16u
X3018 cml_tlatch_20.xmux.xp.S1 cml_tlatch_20.OUTN cml_tlatch_20.OUTP VSS sg13_lv_nmos ad=56.9f pd=0.74u as=56.9f ps=0.74u w=0.17u l=0.17u
X3019 cml_tlatch_51.OUTN cml_tlatch_51.OUTP cml_tlatch_51.xmux.xp.S1 VSS sg13_lv_nmos ad=56.9f pd=0.74u as=56.9f ps=0.74u w=0.17u l=0.17u
X3020 cml_tlatch_67.xmux.xp.S1 CKB3_N cml_tlatch_67.xtail.S1 VSS sg13_lv_nmos ad=89.3f pd=0.85u as=89.3f ps=0.85u w=0.47u l=0.16u
X3021 cml_tlatch_64.xmux.xn.S1 cml_tlatch_65.OUTN B3_8_P VSS sg13_lv_nmos ad=63.19999f pd=0.74u as=0.1082p ps=1.34u w=0.26u l=0.38u
X3022 cml_tlatch_1.xtail.S1 CKB0_P cml_tlatch_1.xmux.xp.S1 VSS sg13_lv_nmos ad=89.3f pd=0.85u as=89.3f ps=0.85u w=0.47u l=0.16u
X3023 cml_tlatch_33.xmux.xn.S1 A0_2_N cml_tlatch_33.OUTP VSS sg13_lv_nmos ad=63.19999f pd=0.74u as=63.19999f ps=0.74u w=0.26u l=0.38u
X3024 cml_tlatch_28.xtail.S1 CKHA0_P cml_tlatch_28.xmux.xn.S1 VSS sg13_lv_nmos ad=89.3f pd=0.85u as=89.3f ps=0.85u w=0.47u l=0.16u
X3025 J1_P J1_N cml_tlatch_95.xmux.xp.S1 VSS sg13_lv_nmos ad=56.9f pd=0.74u as=56.9f ps=0.74u w=0.17u l=0.17u
X3026 cml_tlatch_40.xmux.xn.S1 cml_tlatch_41.OUTN A1_2_P VSS sg13_lv_nmos ad=63.19999f pd=0.74u as=63.19999f ps=0.74u w=0.26u l=0.38u
X3027 B3_8_N cml_tlatch_65.OUTP cml_tlatch_64.xmux.xn.S1 VSS sg13_lv_nmos ad=63.19999f pd=0.74u as=63.19999f ps=0.74u w=0.26u l=0.38u
X3028 cml_tlatch_63.xmux.xp.S1 MOT26_P MOT26_N VSS sg13_lv_nmos ad=56.9f pd=0.74u as=56.9f ps=0.74u w=0.17u l=0.17u
X3029 B2_2_N B2_2_P cml_tlatch_47.xmux.xp.S1 VSS sg13_lv_nmos ad=56.9f pd=0.74u as=0.1019p ps=1.34u w=0.17u l=0.17u
X3030 cml_tlatch_49.xmux.xp.S1 cml_tlatch_49.OUTN cml_tlatch_49.OUTP VSS sg13_lv_nmos ad=56.9f pd=0.74u as=56.9f ps=0.74u w=0.17u l=0.17u
X3031 GB1_P ENB1_N cml_gate2_0.xamp.xn.S1 VSS sg13_lv_nmos ad=0.1802p pd=1.74u as=0.1007p ps=0.91u w=0.53u l=0.13u
X3032 cml_tlatch_55.xmux.xp.S1 CKHA2_N cml_tlatch_55.xtail.S1 VSS sg13_lv_nmos ad=89.3f pd=0.85u as=89.3f ps=0.85u w=0.47u l=0.16u
X3033 cml_tlatch_69.OUTN cml_tlatch_69.OUTP cml_tlatch_69.xmux.xp.S1 VSS sg13_lv_nmos ad=56.9f pd=0.74u as=56.9f ps=0.74u w=0.17u l=0.17u
X3034 cml_tlatch_42.xtail.S1 CKHA1_P cml_tlatch_42.xmux.xn.S1 VSS sg13_lv_nmos ad=0.1598p pd=1.62u as=89.3f ps=0.85u w=0.47u l=0.16u
X3035 cml_tlatch_59.xmux.xp.S1 CKA2_N cml_tlatch_59.xtail.S1 VSS sg13_lv_nmos ad=89.3f pd=0.85u as=89.3f ps=0.85u w=0.47u l=0.16u
X3036 VDD cml_tlatch_24.INP VSS rppd l=5.17u w=1u
X3037 cml_gate2_4.xrtail.R1 CKB3_P cml_gate2_4.xamp.xn.S1 VSS sg13_lv_nmos ad=0.1007p pd=0.91u as=0.1007p ps=0.91u w=0.53u l=0.13u
X3038 cml_tlatch_20.xmux.xp.S1 cml_tlatch_20.OUTN cml_tlatch_20.OUTP VSS sg13_lv_nmos ad=56.9f pd=0.74u as=56.9f ps=0.74u w=0.17u l=0.17u
X3039 cml_tlatch_8.xmux.xn.S1 cml_tlatch_98.OUTN cml_tlatch_8.OUTP VSS sg13_lv_nmos ad=0.1082p pd=1.34u as=63.19999f ps=0.74u w=0.26u l=0.38u
X3040 cml_tlatch_40.xmux.xn.S1 CKA1_N cml_tlatch_40.xtail.S1 VSS sg13_lv_nmos ad=89.3f pd=0.85u as=89.3f ps=0.85u w=0.47u l=0.16u
X3041 B3_8_N B3_8_P cml_tlatch_64.xmux.xp.S1 VSS sg13_lv_nmos ad=56.9f pd=0.74u as=56.9f ps=0.74u w=0.17u l=0.17u
X3042 cml_tlatch_32.xmux.xp.S1 CKB0_N cml_tlatch_32.xtail.S1 VSS sg13_lv_nmos ad=89.3f pd=0.85u as=89.3f ps=0.85u w=0.47u l=0.16u
X3043 cml_tlatch_5.xmux.xp.S1 CKHB1_N cml_tlatch_5.xtail.S1 VSS sg13_lv_nmos ad=89.3f pd=0.85u as=89.3f ps=0.85u w=0.47u l=0.16u
X3044 cml_tlatch_96.xmux.xp.S1 cml_tlatch_5.INP cml_tlatch_5.INN VSS sg13_lv_nmos ad=0.1019p pd=1.34u as=56.9f ps=0.74u w=0.17u l=0.17u
X3045 B3_2_P B3_2_N cml_tlatch_50.xmux.xp.S1 VSS sg13_lv_nmos ad=56.9f pd=0.74u as=56.9f ps=0.74u w=0.17u l=0.17u
X3046 cml_tlatch_72.xmux.xn.S1 CKHB3_P cml_tlatch_72.xtail.S1 VSS sg13_lv_nmos ad=89.3f pd=0.85u as=89.3f ps=0.85u w=0.47u l=0.16u
X3047 cml_tlatch_74.xmux.xp.S1 MOT29_P MOT29_N VSS sg13_lv_nmos ad=56.9f pd=0.74u as=56.9f ps=0.74u w=0.17u l=0.17u
X3048 cml_tlatch_8.xmux.xn.S1 CKB0_P cml_tlatch_8.xtail.S1 VSS sg13_lv_nmos ad=89.3f pd=0.85u as=89.3f ps=0.85u w=0.47u l=0.16u
X3049 cml_tlatch_60.xmux.xp.S1 A2_2_N A2_2_P VSS sg13_lv_nmos ad=56.9f pd=0.74u as=56.9f ps=0.74u w=0.17u l=0.17u
X3050 cml_tlatch_78.xmux.xn.S1 stub_bi_63.BOTP MOT19_P VSS sg13_lv_nmos ad=63.19999f pd=0.74u as=63.19999f ps=0.74u w=0.26u l=0.38u
X3051 MOT12_P cml_tlatch_24.INN cml_tlatch_24.xmux.xn.S1 VSS sg13_lv_nmos ad=63.19999f pd=0.74u as=63.19999f ps=0.74u w=0.26u l=0.38u
X3052 cml_tlatch_45.xmux.xp.S1 CKHA3_N cml_tlatch_45.xtail.S1 VSS sg13_lv_nmos ad=89.3f pd=0.85u as=89.3f ps=0.85u w=0.47u l=0.16u
X3053 cml_tlatch_53.xmux.xp.S1 MOT18_N MOT18_P VSS sg13_lv_nmos ad=56.9f pd=0.74u as=56.9f ps=0.74u w=0.17u l=0.17u
X3054 cml_tlatch_46.xmux.xp.S1 CKB2_N cml_tlatch_46.xtail.S1 VSS sg13_lv_nmos ad=89.3f pd=0.85u as=89.3f ps=0.85u w=0.47u l=0.16u
X3055 MOT12_N MOT12_P cml_tlatch_24.xmux.xp.S1 VSS sg13_lv_nmos ad=56.9f pd=0.74u as=56.9f ps=0.74u w=0.17u l=0.17u
X3056 cml_tlatch_43.INN cml_tlatch_43.INP cml_tlatch_21.xmux.xp.S1 VSS sg13_lv_nmos ad=56.9f pd=0.74u as=56.9f ps=0.74u w=0.17u l=0.17u
X3057 cml_tlatch_89.xmux.xn.S1 cml_tlatch_56.OUTN cml_tlatch_44.INP VSS sg13_lv_nmos ad=63.19999f pd=0.74u as=63.19999f ps=0.74u w=0.26u l=0.38u
X3058 cml_tlatch_12.xmux.xp.S1 cml_tlatch_4.INP cml_tlatch_4.INN VSS sg13_lv_nmos ad=56.9f pd=0.74u as=56.9f ps=0.74u w=0.17u l=0.17u
X3059 cml_tlatch_12.xmux.xp.S1 cml_tlatch_4.INN cml_tlatch_4.INP VSS sg13_lv_nmos ad=56.9f pd=0.74u as=56.9f ps=0.74u w=0.17u l=0.17u
X3060 cml_tlatch_56.xmux.xp.S1 CKA3_N cml_tlatch_56.xtail.S1 VSS sg13_lv_nmos ad=89.3f pd=0.85u as=89.3f ps=0.85u w=0.47u l=0.16u
X3061 cml_tlatch_23.xmux.xp.S1 cml_tlatch_23.OUTP cml_tlatch_23.OUTN VSS sg13_lv_nmos ad=56.9f pd=0.74u as=56.9f ps=0.74u w=0.17u l=0.17u
X3062 cml_tlatch_5.INP cml_tlatch_5.INN cml_tlatch_96.xmux.xp.S1 VSS sg13_lv_nmos ad=56.9f pd=0.74u as=56.9f ps=0.74u w=0.17u l=0.17u
X3063 cml_tlatch_95.xmux.xp.S1 J1_P J1_N VSS sg13_lv_nmos ad=56.9f pd=0.74u as=56.9f ps=0.74u w=0.17u l=0.17u
X3064 cml_tlatch_18.xmux.xn.S1 cml_tlatch_23.OUTN cml_tlatch_18.OUTP VSS sg13_lv_nmos ad=63.19999f pd=0.74u as=63.19999f ps=0.74u w=0.26u l=0.38u
X3065 cml_tlatch_36.xmux.xn.S1 CKB1_N cml_tlatch_36.xtail.S1 VSS sg13_lv_nmos ad=89.3f pd=0.85u as=89.3f ps=0.85u w=0.47u l=0.16u
X3066 cml_tlatch_49.OUTP cml_tlatch_49.OUTN cml_tlatch_49.xmux.xp.S1 VSS sg13_lv_nmos ad=56.9f pd=0.74u as=56.9f ps=0.74u w=0.17u l=0.17u
X3067 cml_tlatch_32.xmux.xn.S1 D0_N cml_tlatch_32.OUTP VSS sg13_lv_nmos ad=63.19999f pd=0.74u as=63.19999f ps=0.74u w=0.26u l=0.38u
X3068 hs_to_clk_0.D2 POLN VSS VSS sg13_lv_nmos ad=3.4p pd=20.68u as=1.9p ps=10.38u w=10u l=0.13u
X3069 cml_tlatch_17.xtail.S1 CKHB0_N cml_tlatch_17.xmux.xp.S1 VSS sg13_lv_nmos ad=89.3f pd=0.85u as=89.3f ps=0.85u w=0.47u l=0.16u
X3070 cml_tlatch_67.xmux.xp.S1 cml_tlatch_67.OUTN cml_tlatch_67.OUTP VSS sg13_lv_nmos ad=56.9f pd=0.74u as=56.9f ps=0.74u w=0.17u l=0.17u
X3071 VSS hs_to_clk_0.sg13_lv_nmos_2HGZLP_0.G VSS VSS sg13_lv_nmos ad=2.071p pd=11.28u as=0 ps=0 w=10.9u l=1.38u
X3072 A2_8_N cml_tlatch_86.OUTP cml_tlatch_85.xmux.xn.S1 VSS sg13_lv_nmos ad=0.1082p pd=1.34u as=63.19999f ps=0.74u w=0.26u l=0.38u
X3073 A3_8_P A3_8_N cml_tlatch_68.xmux.xp.S1 VSS sg13_lv_nmos ad=56.9f pd=0.74u as=56.9f ps=0.74u w=0.17u l=0.17u
X3074 cml_tlatch_55.xmux.xp.S1 MOT22_N MOT22_P VSS sg13_lv_nmos ad=56.9f pd=0.74u as=56.9f ps=0.74u w=0.17u l=0.17u
X3075 cml_tlatch_1.xmux.xp.S1 B0_8_N B0_8_P VSS sg13_lv_nmos ad=56.9f pd=0.74u as=56.9f ps=0.74u w=0.17u l=0.17u
X3076 cml_tlatch_10.xmux.xp.S1 B1_8_P B1_8_N VSS sg13_lv_nmos ad=56.9f pd=0.74u as=56.9f ps=0.74u w=0.17u l=0.17u
X3077 cml_tlatch_1.xmux.xn.S1 cml_tlatch_2.OUTP B0_8_N VSS sg13_lv_nmos ad=63.19999f pd=0.74u as=63.19999f ps=0.74u w=0.26u l=0.38u
X3078 cml_tlatch_38.xmux.xp.S1 cml_tlatch_38.OUTP cml_tlatch_38.OUTN VSS sg13_lv_nmos ad=56.9f pd=0.74u as=56.9f ps=0.74u w=0.17u l=0.17u
X3079 cml_tlatch_95.xmux.xp.S1 J1_N J1_P VSS sg13_lv_nmos ad=56.9f pd=0.74u as=56.9f ps=0.74u w=0.17u l=0.17u
X3080 cml_tlatch_76.xmux.xp.S1 cml_tlatch_87.INP cml_tlatch_87.INN VSS sg13_lv_nmos ad=56.9f pd=0.74u as=56.9f ps=0.74u w=0.17u l=0.17u
X3081 cml_tlatch_73.xtail.S1 CKHB3_P cml_tlatch_73.xmux.xn.S1 VSS sg13_lv_nmos ad=0.1598p pd=1.62u as=89.3f ps=0.85u w=0.47u l=0.16u
X3082 MOT27_N MOT27_P cml_tlatch_73.xmux.xp.S1 VSS sg13_lv_nmos ad=56.9f pd=0.74u as=56.9f ps=0.74u w=0.17u l=0.17u
X3083 MOT28_N MOT28_P cml_tlatch_44.xmux.xp.S1 VSS sg13_lv_nmos ad=56.9f pd=0.74u as=56.9f ps=0.74u w=0.17u l=0.17u
X3084 cml_tlatch_41.xmux.xp.S1 cml_tlatch_41.OUTN cml_tlatch_41.OUTP VSS sg13_lv_nmos ad=56.9f pd=0.74u as=56.9f ps=0.74u w=0.17u l=0.17u
X3085 cml_tlatch_1.xmux.xn.S1 cml_tlatch_2.OUTP B0_8_N VSS sg13_lv_nmos ad=63.19999f pd=0.74u as=63.19999f ps=0.74u w=0.26u l=0.38u
X3086 MOT2_P MOT2_N cml_tlatch_27.xmux.xp.S1 VSS sg13_lv_nmos ad=56.9f pd=0.74u as=56.9f ps=0.74u w=0.17u l=0.17u
X3087 MOT0_P MOT0_N cml_tlatch_26.xmux.xp.S1 VSS sg13_lv_nmos ad=56.9f pd=0.74u as=56.9f ps=0.74u w=0.17u l=0.17u
X3088 cml_tlatch_92.xmux.xp.S1 J4_N J4_P VSS sg13_lv_nmos ad=56.9f pd=0.74u as=56.9f ps=0.74u w=0.17u l=0.17u
X3089 cml_tlatch_17.xmux.xp.S1 MOT7_P MOT7_N VSS sg13_lv_nmos ad=56.9f pd=0.74u as=56.9f ps=0.74u w=0.17u l=0.17u
X3090 cml_tlatch_79.xmux.xp.S1 CKHB2_N cml_tlatch_79.xtail.S1 VSS sg13_lv_nmos ad=89.3f pd=0.85u as=89.3f ps=0.85u w=0.47u l=0.16u
X3091 cml_tlatch_35.xmux.xp.S1 stub_bi_29.BOTP stub_bi_29.BOTN VSS sg13_lv_nmos ad=56.9f pd=0.74u as=56.9f ps=0.74u w=0.17u l=0.17u
X3092 cml_tlatch_51.xmux.xn.S1 CKB3_P cml_tlatch_51.xtail.S1 VSS sg13_lv_nmos ad=89.3f pd=0.85u as=89.3f ps=0.85u w=0.47u l=0.16u
X3093 cml_tlatch_63.INP cml_tlatch_71.OUTN cml_tlatch_70.xmux.xn.S1 VSS sg13_lv_nmos ad=63.19999f pd=0.74u as=63.19999f ps=0.74u w=0.26u l=0.38u
X3094 cml_tlatch_80.xtail.S1 CKHB2_N cml_tlatch_80.xmux.xp.S1 VSS sg13_lv_nmos ad=89.3f pd=0.85u as=89.3f ps=0.85u w=0.47u l=0.16u
X3095 cml_tlatch_88.xmux.xn.S1 CKB3_N cml_tlatch_88.xtail.S1 VSS sg13_lv_nmos ad=89.3f pd=0.85u as=89.3f ps=0.85u w=0.47u l=0.16u
X3096 A2_8_N A2_8_P cml_tlatch_85.xmux.xp.S1 VSS sg13_lv_nmos ad=56.9f pd=0.74u as=0.1019p ps=1.34u w=0.17u l=0.17u
X3097 cml_tlatch_41.xmux.xp.S1 cml_tlatch_41.OUTN cml_tlatch_41.OUTP VSS sg13_lv_nmos ad=56.9f pd=0.74u as=56.9f ps=0.74u w=0.17u l=0.17u
X3098 cml_tlatch_99.OUTP cml_tlatch_99.OUTN cml_tlatch_99.xmux.xp.S1 VSS sg13_lv_nmos ad=56.9f pd=0.74u as=56.9f ps=0.74u w=0.17u l=0.17u
X3099 MOT17_P B2_8_N cml_tlatch_77.xmux.xn.S1 VSS sg13_lv_nmos ad=63.19999f pd=0.74u as=63.19999f ps=0.74u w=0.26u l=0.38u
X3100 cml_tlatch_4.xtail.S1 CKHB1_P cml_tlatch_4.xmux.xn.S1 VSS sg13_lv_nmos ad=89.3f pd=0.85u as=89.3f ps=0.85u w=0.47u l=0.16u
X3101 cml_tlatch_56.OUTN cml_tlatch_56.OUTP cml_tlatch_56.xmux.xp.S1 VSS sg13_lv_nmos ad=56.9f pd=0.74u as=56.9f ps=0.74u w=0.17u l=0.17u
X3102 cml_tlatch_32.OUTP cml_tlatch_32.OUTN cml_tlatch_32.xmux.xp.S1 VSS sg13_lv_nmos ad=56.9f pd=0.74u as=56.9f ps=0.74u w=0.17u l=0.17u
X3103 cml_tlatch_43.xmux.xn.S1 cml_tlatch_43.INN MOT10_P VSS sg13_lv_nmos ad=63.19999f pd=0.74u as=0.1082p ps=1.34u w=0.26u l=0.38u
X3104 cml_tlatch_22.OUTN cml_tlatch_24.INP cml_tlatch_22.xmux.xn.S1 VSS sg13_lv_nmos ad=0.1082p pd=1.34u as=63.19999f ps=0.74u w=0.26u l=0.38u
X3105 cml_tlatch_65.OUTP cml_tlatch_73.INN cml_tlatch_65.xmux.xn.S1 VSS sg13_lv_nmos ad=63.19999f pd=0.74u as=63.19999f ps=0.74u w=0.26u l=0.38u
X3106 MOT20_P MOT20_N cml_tlatch_54.xmux.xp.S1 VSS sg13_lv_nmos ad=56.9f pd=0.74u as=56.9f ps=0.74u w=0.17u l=0.17u
X3107 VSS POLN cml_tlatch_61.xtail.S1 VSS sg13_lv_nmos ad=1.5637p pd=8.61u as=1.5637p ps=8.61u w=8.23u l=0.13u
X3108 MOT22_N MOT22_P cml_tlatch_55.xmux.xp.S1 VSS sg13_lv_nmos ad=56.9f pd=0.74u as=56.9f ps=0.74u w=0.17u l=0.17u
X3109 cml_tlatch_61.xtail.S1 CKA2_N cml_tlatch_61.xmux.xp.S1 VSS sg13_lv_nmos ad=89.3f pd=0.85u as=89.3f ps=0.85u w=0.47u l=0.16u
X3110 cml_tlatch_45.xmux.xp.S1 MOT30_P MOT30_N VSS sg13_lv_nmos ad=56.9f pd=0.74u as=56.9f ps=0.74u w=0.17u l=0.17u
X3111 cml_tlatch_74.xmux.xp.S1 CKHB3_N cml_tlatch_74.xtail.S1 VSS sg13_lv_nmos ad=89.3f pd=0.85u as=89.3f ps=0.85u w=0.47u l=0.16u
X3112 cml_tlatch_61.xmux.xp.S1 cml_tlatch_61.OUTP cml_tlatch_61.OUTN VSS sg13_lv_nmos ad=56.9f pd=0.74u as=56.9f ps=0.74u w=0.17u l=0.17u
X3113 VDD cml_tlatch_69.OUTN VSS rppd l=5.17u w=1u
X3114 J1_P J1_N cml_tlatch_95.xmux.xp.S1 VSS sg13_lv_nmos ad=56.9f pd=0.74u as=56.9f ps=0.74u w=0.17u l=0.17u
X3115 MOT5_N cml_tlatch_98.OUTP cml_tlatch_16.xmux.xn.S1 VSS sg13_lv_nmos ad=0.1082p pd=1.34u as=63.19999f ps=0.74u w=0.26u l=0.38u
X3116 cml_tlatch_5.INN stub_bi_29.BOTN cml_tlatch_96.xmux.xn.S1 VSS sg13_lv_nmos ad=63.19999f pd=0.74u as=63.19999f ps=0.74u w=0.26u l=0.38u
X3117 cml_tlatch_47.xmux.xp.S1 CKB2_P cml_tlatch_47.xtail.S1 VSS sg13_lv_nmos ad=89.3f pd=0.85u as=89.3f ps=0.85u w=0.47u l=0.16u
X3118 VSS POLN cml_tlatch_29.xtail.S1 VSS sg13_lv_nmos ad=1.5637p pd=8.61u as=1.5637p ps=8.61u w=8.23u l=0.13u
X3119 cml_tlatch_22.xmux.xn.S1 CKA1_P cml_tlatch_22.xtail.S1 VSS sg13_lv_nmos ad=89.3f pd=0.85u as=0.1598p ps=1.62u w=0.47u l=0.16u
X3120 cml_tlatch_52.xmux.xn.S1 CKHA2_P cml_tlatch_52.xtail.S1 VSS sg13_lv_nmos ad=89.3f pd=0.85u as=89.3f ps=0.85u w=0.47u l=0.16u
X3121 cml_tlatch_91.INP cml_tlatch_91.INN cml_tlatch_59.xmux.xp.S1 VSS sg13_lv_nmos ad=56.9f pd=0.74u as=0.1019p ps=1.34u w=0.17u l=0.17u
X3122 cml_tlatch_7.xmux.xp.S1 CKB0_P cml_tlatch_7.xtail.S1 VSS sg13_lv_nmos ad=89.3f pd=0.85u as=89.3f ps=0.85u w=0.47u l=0.16u
X3123 cml_tlatch_33.xmux.xn.S1 CKA0_P cml_tlatch_33.xtail.S1 VSS sg13_lv_nmos ad=89.3f pd=0.85u as=89.3f ps=0.85u w=0.47u l=0.16u
X3124 cml_tlatch_48.xtail.S1 CKB2_N cml_tlatch_48.xmux.xp.S1 VSS sg13_lv_nmos ad=89.3f pd=0.85u as=89.3f ps=0.85u w=0.47u l=0.16u
X3125 cml_tlatch_1.xmux.xp.S1 B0_8_P B0_8_N VSS sg13_lv_nmos ad=56.9f pd=0.74u as=56.9f ps=0.74u w=0.17u l=0.17u
X3126 cml_tlatch_91.xmux.xp.S1 cml_tlatch_91.OUTN cml_tlatch_91.OUTP VSS sg13_lv_nmos ad=56.9f pd=0.74u as=56.9f ps=0.74u w=0.17u l=0.17u
X3127 cml_tlatch_45.xmux.xp.S1 MOT30_N MOT30_P VSS sg13_lv_nmos ad=56.9f pd=0.74u as=56.9f ps=0.74u w=0.17u l=0.17u
X3128 MOT16_N MOT16_P cml_tlatch_52.xmux.xp.S1 VSS sg13_lv_nmos ad=56.9f pd=0.74u as=56.9f ps=0.74u w=0.17u l=0.17u
X3129 MOT28_P VDD VSS rppd l=5.17u w=1u
X3130 cml_tlatch_60.xmux.xp.S1 A2_2_N A2_2_P VSS sg13_lv_nmos ad=56.9f pd=0.74u as=56.9f ps=0.74u w=0.17u l=0.17u
X3131 cml_tlatch_1.xtail.S1 CKB0_N cml_tlatch_1.xmux.xn.S1 VSS sg13_lv_nmos ad=89.3f pd=0.85u as=89.3f ps=0.85u w=0.47u l=0.16u
X3132 cml_tlatch_14.xtail.S1 CKHB0_N cml_tlatch_14.xmux.xp.S1 VSS sg13_lv_nmos ad=89.3f pd=0.85u as=89.3f ps=0.85u w=0.47u l=0.16u
X3133 cml_tlatch_39.xmux.xp.S1 cml_tlatch_97.INP cml_tlatch_97.INN VSS sg13_lv_nmos ad=56.9f pd=0.74u as=56.9f ps=0.74u w=0.17u l=0.17u
X3134 cml_tlatch_14.xmux.xp.S1 MOT1_N MOT1_P VSS sg13_lv_nmos ad=56.9f pd=0.74u as=56.9f ps=0.74u w=0.17u l=0.17u
X3135 cml_tlatch_22.xmux.xn.S1 cml_tlatch_24.INN cml_tlatch_22.OUTP VSS sg13_lv_nmos ad=63.19999f pd=0.74u as=63.19999f ps=0.74u w=0.26u l=0.38u
X3136 cml_tlatch_53.xmux.xp.S1 MOT18_N MOT18_P VSS sg13_lv_nmos ad=56.9f pd=0.74u as=56.9f ps=0.74u w=0.17u l=0.17u
X3137 cml_tlatch_33.xtail.S1 CKA0_N cml_tlatch_33.xmux.xp.S1 VSS sg13_lv_nmos ad=89.3f pd=0.85u as=89.3f ps=0.85u w=0.47u l=0.16u
X3138 cml_tlatch_34.xmux.xp.S1 A0_2_P A0_2_N VSS sg13_lv_nmos ad=56.9f pd=0.74u as=56.9f ps=0.74u w=0.17u l=0.17u
X3139 cml_tlatch_32.OUTN D0_P cml_tlatch_32.xmux.xn.S1 VSS sg13_lv_nmos ad=63.19999f pd=0.74u as=63.19999f ps=0.74u w=0.26u l=0.38u
X3140 cml_tlatch_6.xtail.S1 CKHB1_N cml_tlatch_6.xmux.xp.S1 VSS sg13_lv_nmos ad=89.3f pd=0.85u as=89.3f ps=0.85u w=0.47u l=0.16u
X3141 MOT8_N MOT8_P cml_tlatch_42.xmux.xp.S1 VSS sg13_lv_nmos ad=56.9f pd=0.74u as=56.9f ps=0.74u w=0.17u l=0.17u
X3142 A2_8_N A2_8_P cml_tlatch_85.xmux.xp.S1 VSS sg13_lv_nmos ad=56.9f pd=0.74u as=56.9f ps=0.74u w=0.17u l=0.17u
X3143 cml_tlatch_12.xmux.xp.S1 cml_tlatch_4.INP cml_tlatch_4.INN VSS sg13_lv_nmos ad=56.9f pd=0.74u as=56.9f ps=0.74u w=0.17u l=0.17u
X3144 VSS POLN cml_tlatch_25.xtail.S1 VSS sg13_lv_nmos ad=2.7982p pd=17.14u as=1.5637p ps=8.61u w=8.23u l=0.13u
X3145 cml_tlatch_93.xmux.xp.S1 CLK_W_P CLK_W_N VSS sg13_lv_nmos ad=56.9f pd=0.74u as=56.9f ps=0.74u w=0.17u l=0.17u
X3146 cml_tlatch_18.xmux.xp.S1 CKA0_N cml_tlatch_18.xtail.S1 VSS sg13_lv_nmos ad=89.3f pd=0.85u as=89.3f ps=0.85u w=0.47u l=0.16u
X3147 VSS POLN cml_tlatch_30.xtail.S1 VSS sg13_lv_nmos ad=1.5637p pd=8.61u as=1.5637p ps=8.61u w=8.23u l=0.13u
X3148 cml_tlatch_28.xmux.xn.S1 CKHA0_P cml_tlatch_28.xtail.S1 VSS sg13_lv_nmos ad=89.3f pd=0.85u as=89.3f ps=0.85u w=0.47u l=0.16u
X3149 cml_tlatch_43.xmux.xp.S1 MOT10_N MOT10_P VSS sg13_lv_nmos ad=56.9f pd=0.74u as=56.9f ps=0.74u w=0.17u l=0.17u
X3150 cml_tlatch_42.xmux.xn.S1 CKHA1_P cml_tlatch_42.xtail.S1 VSS sg13_lv_nmos ad=89.3f pd=0.85u as=89.3f ps=0.85u w=0.47u l=0.16u
X3151 stub_bi_62.BOTP stub_bi_62.BOTN cml_tlatch_82.xmux.xp.S1 VSS sg13_lv_nmos ad=56.9f pd=0.74u as=56.9f ps=0.74u w=0.17u l=0.17u
X3152 cml_tlatch_91.INP cml_tlatch_91.INN cml_tlatch_59.xmux.xp.S1 VSS sg13_lv_nmos ad=56.9f pd=0.74u as=56.9f ps=0.74u w=0.17u l=0.17u
X3153 MOT7_P MOT7_N cml_tlatch_17.xmux.xp.S1 VSS sg13_lv_nmos ad=56.9f pd=0.74u as=56.9f ps=0.74u w=0.17u l=0.17u
X3154 cml_tlatch_63.xtail.S1 CKHA3_P cml_tlatch_63.xmux.xn.S1 VSS sg13_lv_nmos ad=89.3f pd=0.85u as=89.3f ps=0.85u w=0.47u l=0.16u
X3155 cml_tlatch_77.xtail.S1 CKHB2_N cml_tlatch_77.xmux.xp.S1 VSS sg13_lv_nmos ad=89.3f pd=0.85u as=89.3f ps=0.85u w=0.47u l=0.16u
X3156 cml_tlatch_32.xtail.S1 CKB0_N cml_tlatch_32.xmux.xp.S1 VSS sg13_lv_nmos ad=89.3f pd=0.85u as=0.1598p ps=1.62u w=0.47u l=0.16u
X3157 VDD GA2_N VSS rppd l=7.42u w=1u
X3158 cml_tlatch_0.OUTP cml_tlatch_0.OUTN cml_tlatch_0.xmux.xp.S1 VSS sg13_lv_nmos ad=56.9f pd=0.74u as=56.9f ps=0.74u w=0.17u l=0.17u
X3159 VSS POLN cml_tlatch_46.xtail.S1 VSS sg13_lv_nmos ad=1.5637p pd=8.61u as=1.5637p ps=8.61u w=8.23u l=0.13u
X3160 cml_tlatch_22.OUTN cml_tlatch_22.OUTP cml_tlatch_22.xmux.xp.S1 VSS sg13_lv_nmos ad=56.9f pd=0.74u as=56.9f ps=0.74u w=0.17u l=0.17u
X3161 cml_tlatch_76.xtail.S1 CKA2_P cml_tlatch_76.xmux.xn.S1 VSS sg13_lv_nmos ad=89.3f pd=0.85u as=89.3f ps=0.85u w=0.47u l=0.16u
X3162 cml_tlatch_23.OUTP cml_tlatch_0.OUTN cml_tlatch_23.xmux.xn.S1 VSS sg13_lv_nmos ad=63.19999f pd=0.74u as=0.1082p ps=1.34u w=0.26u l=0.38u
X3163 cml_tlatch_10.xmux.xn.S1 CKB1_N cml_tlatch_10.xtail.S1 VSS sg13_lv_nmos ad=89.3f pd=0.85u as=89.3f ps=0.85u w=0.47u l=0.16u
X3164 cml_tlatch_41.xtail.S1 POLN VSS VSS sg13_lv_nmos ad=1.5637p pd=8.61u as=1.5637p ps=8.61u w=8.23u l=0.13u
X3165 cml_tlatch_57.xmux.xp.S1 A3_2_P A3_2_N VSS sg13_lv_nmos ad=56.9f pd=0.74u as=56.9f ps=0.74u w=0.17u l=0.17u
X3166 cml_tlatch_7.xmux.xp.S1 cml_tlatch_7.OUTP cml_tlatch_7.OUTN VSS sg13_lv_nmos ad=56.9f pd=0.74u as=56.9f ps=0.74u w=0.17u l=0.17u
X3167 cml_tlatch_25.xmux.xn.S1 A1_2_P MOT14_N VSS sg13_lv_nmos ad=63.19999f pd=0.74u as=63.19999f ps=0.74u w=0.26u l=0.38u
X3168 cml_tlatch_99.OUTP cml_tlatch_99.OUTN cml_tlatch_99.xmux.xp.S1 VSS sg13_lv_nmos ad=56.9f pd=0.74u as=56.9f ps=0.74u w=0.17u l=0.17u
X3169 cml_gate2_1.xrtail.R1 CKA0_N GB0_P VSS sg13_lv_nmos ad=0.1007p pd=0.91u as=0.1007p ps=0.91u w=0.53u l=0.13u
X3170 stub_bi_49.BOTN stub_bi_49.BOTP cml_tlatch_84.xmux.xp.S1 VSS sg13_lv_nmos ad=56.9f pd=0.74u as=56.9f ps=0.74u w=0.17u l=0.17u
X3171 cml_tlatch_4.xtail.S1 CKHB1_N cml_tlatch_4.xmux.xp.S1 VSS sg13_lv_nmos ad=89.3f pd=0.85u as=89.3f ps=0.85u w=0.47u l=0.16u
X3172 cml_tlatch_3.xmux.xp.S1 MOT9_P MOT9_N VSS sg13_lv_nmos ad=56.9f pd=0.74u as=56.9f ps=0.74u w=0.17u l=0.17u
X3173 B3_8_P B3_8_N cml_tlatch_64.xmux.xp.S1 VSS sg13_lv_nmos ad=56.9f pd=0.74u as=56.9f ps=0.74u w=0.17u l=0.17u
X3174 cml_tlatch_44.xmux.xp.S1 MOT28_N MOT28_P VSS sg13_lv_nmos ad=56.9f pd=0.74u as=56.9f ps=0.74u w=0.17u l=0.17u
X3175 MOT17_P MOT17_N cml_tlatch_77.xmux.xp.S1 VSS sg13_lv_nmos ad=56.9f pd=0.74u as=0.1019p ps=1.34u w=0.17u l=0.17u
X3176 cml_drv_3.xrtail.R1 ENA_P ENA0_N VSS sg13_lv_nmos ad=56.2f pd=0.74u as=56.2f ps=0.74u w=0.16u l=0.19u
X3177 cml_tlatch_91.xtail.S1 CKA2_P cml_tlatch_91.xmux.xp.S1 VSS sg13_lv_nmos ad=89.3f pd=0.85u as=89.3f ps=0.85u w=0.47u l=0.16u
X3178 cml_tlatch_36.xmux.xp.S1 B1_2_P B1_2_N VSS sg13_lv_nmos ad=56.9f pd=0.74u as=56.9f ps=0.74u w=0.17u l=0.17u
X3179 stub_bi_43.BOTP stub_bi_43.BOTN cml_tlatch_48.xmux.xp.S1 VSS sg13_lv_nmos ad=56.9f pd=0.74u as=56.9f ps=0.74u w=0.17u l=0.17u
X3180 B0_8_P cml_tlatch_2.OUTN cml_tlatch_1.xmux.xn.S1 VSS sg13_lv_nmos ad=63.19999f pd=0.74u as=63.19999f ps=0.74u w=0.26u l=0.38u
X3181 cml_tlatch_28.xtail.S1 CKHA0_N cml_tlatch_28.xmux.xp.S1 VSS sg13_lv_nmos ad=89.3f pd=0.85u as=89.3f ps=0.85u w=0.47u l=0.16u
X3182 cml_tlatch_39.xmux.xn.S1 A1_2_N cml_tlatch_97.INP VSS sg13_lv_nmos ad=63.19999f pd=0.74u as=63.19999f ps=0.74u w=0.26u l=0.38u
X3183 cml_tlatch_64.xtail.S1 CKB3_P cml_tlatch_64.xmux.xp.S1 VSS sg13_lv_nmos ad=89.3f pd=0.85u as=89.3f ps=0.85u w=0.47u l=0.16u
X3184 ENB_N VDD VSS rppd l=7.42u w=1u
X3185 MOT12_P MOT12_N cml_tlatch_24.xmux.xp.S1 VSS sg13_lv_nmos ad=56.9f pd=0.74u as=56.9f ps=0.74u w=0.17u l=0.17u
X3186 VSS hs_to_clk_6.sg13_lv_nmos_2HGZLP_0.G VSS VSS sg13_lv_nmos ad=2.071p pd=11.28u as=0 ps=0 w=10.9u l=1.38u
X3187 cml_tlatch_3.xtail.S1 CKHB1_N cml_tlatch_3.xmux.xp.S1 VSS sg13_lv_nmos ad=89.3f pd=0.85u as=89.3f ps=0.85u w=0.47u l=0.16u
X3188 cml_tlatch_87.OUTN cml_tlatch_87.OUTP cml_tlatch_87.xmux.xp.S1 VSS sg13_lv_nmos ad=56.9f pd=0.74u as=56.9f ps=0.74u w=0.17u l=0.17u
X3189 cml_tlatch_73.INN cml_tlatch_67.OUTP cml_tlatch_66.xmux.xn.S1 VSS sg13_lv_nmos ad=63.19999f pd=0.74u as=63.19999f ps=0.74u w=0.26u l=0.38u
X3190 cml_tlatch_91.xmux.xp.S1 cml_tlatch_91.OUTN cml_tlatch_91.OUTP VSS sg13_lv_nmos ad=56.9f pd=0.74u as=56.9f ps=0.74u w=0.17u l=0.17u
X3191 cml_tlatch_1.xmux.xp.S1 B0_8_P B0_8_N VSS sg13_lv_nmos ad=56.9f pd=0.74u as=56.9f ps=0.74u w=0.17u l=0.17u
X3192 cml_tlatch_90.xtail.S1 CKB2_P cml_tlatch_90.xmux.xp.S1 VSS sg13_lv_nmos ad=89.3f pd=0.85u as=89.3f ps=0.85u w=0.47u l=0.16u
X3193 cml_tlatch_97.INN A1_2_P cml_tlatch_39.xmux.xn.S1 VSS sg13_lv_nmos ad=63.19999f pd=0.74u as=63.19999f ps=0.74u w=0.26u l=0.38u
X3194 stub_bi_55.BOTN stub_bi_55.BOTP cml_tlatch_90.xmux.xp.S1 VSS sg13_lv_nmos ad=56.9f pd=0.74u as=56.9f ps=0.74u w=0.17u l=0.17u
X3195 cml_tlatch_18.xmux.xp.S1 cml_tlatch_18.OUTN cml_tlatch_18.OUTP VSS sg13_lv_nmos ad=56.9f pd=0.74u as=56.9f ps=0.74u w=0.17u l=0.17u
X3196 cml_tlatch_95.xmux.xn.S1 CKJ_P cml_tlatch_95.xtail.S1 VSS sg13_lv_nmos ad=0.1598p pd=1.62u as=89.3f ps=0.85u w=0.47u l=0.16u
X3197 cml_tlatch_89.xtail.S1 CKA3_P cml_tlatch_89.xmux.xp.S1 VSS sg13_lv_nmos ad=89.3f pd=0.85u as=89.3f ps=0.85u w=0.47u l=0.16u
X3198 cml_tlatch_72.xmux.xp.S1 MOT25_P MOT25_N VSS sg13_lv_nmos ad=56.9f pd=0.74u as=56.9f ps=0.74u w=0.17u l=0.17u
X3199 cml_tlatch_65.xtail.S1 CKB3_P cml_tlatch_65.xmux.xn.S1 VSS sg13_lv_nmos ad=89.3f pd=0.85u as=0.1598p ps=1.62u w=0.47u l=0.16u
X3200 cml_tlatch_80.xmux.xp.S1 CKHB2_N cml_tlatch_80.xtail.S1 VSS sg13_lv_nmos ad=89.3f pd=0.85u as=89.3f ps=0.85u w=0.47u l=0.16u
X3201 cml_tlatch_35.xtail.S1 CKB1_P cml_tlatch_35.xmux.xn.S1 VSS sg13_lv_nmos ad=0.1598p pd=1.62u as=89.3f ps=0.85u w=0.47u l=0.16u
X3202 cml_tlatch_34.xmux.xn.S1 cml_tlatch_38.OUTN A0_2_P VSS sg13_lv_nmos ad=63.19999f pd=0.74u as=63.19999f ps=0.74u w=0.26u l=0.38u
X3203 cml_tlatch_23.xmux.xp.S1 CKA0_P cml_tlatch_23.xtail.S1 VSS sg13_lv_nmos ad=89.3f pd=0.85u as=0.1598p ps=1.62u w=0.47u l=0.16u
X3204 MOT8_N MOT8_P cml_tlatch_42.xmux.xp.S1 VSS sg13_lv_nmos ad=56.9f pd=0.74u as=56.9f ps=0.74u w=0.17u l=0.17u
X3205 cml_tlatch_45.xmux.xp.S1 CKHA3_N cml_tlatch_45.xtail.S1 VSS sg13_lv_nmos ad=89.3f pd=0.85u as=89.3f ps=0.85u w=0.47u l=0.16u
X3206 cml_tlatch_33.OUTP cml_tlatch_33.OUTN cml_tlatch_33.xmux.xp.S1 VSS sg13_lv_nmos ad=56.9f pd=0.74u as=56.9f ps=0.74u w=0.17u l=0.17u
X3207 cml_tlatch_94.xmux.xn.S1 CKJ_N cml_tlatch_94.xtail.S1 VSS sg13_lv_nmos ad=89.3f pd=0.85u as=89.3f ps=0.85u w=0.47u l=0.16u
X3208 cml_gate2_6.xrtail.R1 CKA3_P cml_gate2_6.xamp.xn.S1 VSS sg13_lv_nmos ad=0.1007p pd=0.91u as=0.1007p ps=0.91u w=0.53u l=0.13u
X3209 cml_tlatch_23.xmux.xn.S1 CKA0_N cml_tlatch_23.xtail.S1 VSS sg13_lv_nmos ad=89.3f pd=0.85u as=89.3f ps=0.85u w=0.47u l=0.16u
X3210 MOT28_P MOT28_N cml_tlatch_44.xmux.xp.S1 VSS sg13_lv_nmos ad=56.9f pd=0.74u as=56.9f ps=0.74u w=0.17u l=0.17u
X3211 cml_tlatch_18.OUTN cml_tlatch_23.OUTP cml_tlatch_18.xmux.xn.S1 VSS sg13_lv_nmos ad=0.1082p pd=1.34u as=63.19999f ps=0.74u w=0.26u l=0.38u
X3212 cml_tlatch_4.INP stub_bi_17.BOTP cml_tlatch_12.xmux.xn.S1 VSS sg13_lv_nmos ad=63.19999f pd=0.74u as=63.19999f ps=0.74u w=0.26u l=0.38u
X3213 cml_tlatch_86.OUTP cml_tlatch_86.OUTN cml_tlatch_86.xmux.xp.S1 VSS sg13_lv_nmos ad=56.9f pd=0.74u as=56.9f ps=0.74u w=0.17u l=0.17u
X3214 cml_tlatch_71.xmux.xp.S1 cml_tlatch_71.OUTP cml_tlatch_71.OUTN VSS sg13_lv_nmos ad=56.9f pd=0.74u as=56.9f ps=0.74u w=0.17u l=0.17u
X3215 MOT17_P MOT17_N cml_tlatch_77.xmux.xp.S1 VSS sg13_lv_nmos ad=56.9f pd=0.74u as=56.9f ps=0.74u w=0.17u l=0.17u
X3216 cml_tlatch_82.xmux.xp.S1 stub_bi_62.BOTP stub_bi_62.BOTN VSS sg13_lv_nmos ad=56.9f pd=0.74u as=56.9f ps=0.74u w=0.17u l=0.17u
X3217 cml_tlatch_18.OUTN cml_tlatch_23.OUTP cml_tlatch_18.xmux.xn.S1 VSS sg13_lv_nmos ad=63.19999f pd=0.74u as=63.19999f ps=0.74u w=0.26u l=0.38u
X3218 cml_tlatch_36.xmux.xn.S1 CKB1_N cml_tlatch_36.xtail.S1 VSS sg13_lv_nmos ad=89.3f pd=0.85u as=89.3f ps=0.85u w=0.47u l=0.16u
X3219 cml_tlatch_47.xtail.S1 CKB2_P cml_tlatch_47.xmux.xp.S1 VSS sg13_lv_nmos ad=89.3f pd=0.85u as=89.3f ps=0.85u w=0.47u l=0.16u
X3220 cml_tlatch_75.xmux.xp.S1 CKHB3_N cml_tlatch_75.xtail.S1 VSS sg13_lv_nmos ad=89.3f pd=0.85u as=89.3f ps=0.85u w=0.47u l=0.16u
X3221 cml_tlatch_80.xmux.xp.S1 MOT23_P MOT23_N VSS sg13_lv_nmos ad=56.9f pd=0.74u as=56.9f ps=0.74u w=0.17u l=0.17u
X3222 MOT31_N MOT31_P cml_tlatch_75.xmux.xp.S1 VSS sg13_lv_nmos ad=56.9f pd=0.74u as=56.9f ps=0.74u w=0.17u l=0.17u
X3223 MOT3_N MOT3_P cml_tlatch_15.xmux.xp.S1 VSS sg13_lv_nmos ad=56.9f pd=0.74u as=56.9f ps=0.74u w=0.17u l=0.17u
X3224 MOT4_N MOT4_P cml_tlatch_28.xmux.xp.S1 VSS sg13_lv_nmos ad=56.9f pd=0.74u as=56.9f ps=0.74u w=0.17u l=0.17u
X3225 cml_tlatch_35.xtail.S1 POLN VSS VSS sg13_lv_nmos ad=1.5637p pd=8.61u as=1.5637p ps=8.61u w=8.23u l=0.13u
X3226 cml_tlatch_86.xtail.S1 CKA2_P cml_tlatch_86.xmux.xn.S1 VSS sg13_lv_nmos ad=89.3f pd=0.85u as=89.3f ps=0.85u w=0.47u l=0.16u
X3227 cml_tlatch_64.xmux.xn.S1 cml_tlatch_65.OUTP B3_8_N VSS sg13_lv_nmos ad=63.19999f pd=0.74u as=63.19999f ps=0.74u w=0.26u l=0.38u
X3228 cml_tlatch_11.xmux.xn.S1 cml_tlatch_4.INN stub_bi_15.BOTN VSS sg13_lv_nmos ad=63.19999f pd=0.74u as=63.19999f ps=0.74u w=0.26u l=0.38u
X3229 cml_tlatch_30.OUTN cml_tlatch_30.OUTP cml_tlatch_30.xmux.xp.S1 VSS sg13_lv_nmos ad=56.9f pd=0.74u as=56.9f ps=0.74u w=0.17u l=0.17u
X3230 cml_tlatch_5.xmux.xp.S1 MOT13_N MOT13_P VSS sg13_lv_nmos ad=56.9f pd=0.74u as=56.9f ps=0.74u w=0.17u l=0.17u
X3231 cml_tlatch_5.xtail.S1 CKHB1_P cml_tlatch_5.xmux.xn.S1 VSS sg13_lv_nmos ad=89.3f pd=0.85u as=89.3f ps=0.85u w=0.47u l=0.16u
X3232 cml_tlatch_41.xmux.xn.S1 D1_N cml_tlatch_41.OUTP VSS sg13_lv_nmos ad=63.19999f pd=0.74u as=63.19999f ps=0.74u w=0.26u l=0.38u
X3233 cml_tlatch_80.xmux.xp.S1 MOT23_N MOT23_P VSS sg13_lv_nmos ad=56.9f pd=0.74u as=56.9f ps=0.74u w=0.17u l=0.17u
X3234 cml_tlatch_0.xmux.xp.S1 cml_tlatch_0.OUTP cml_tlatch_0.OUTN VSS sg13_lv_nmos ad=56.9f pd=0.74u as=56.9f ps=0.74u w=0.17u l=0.17u
X3235 cml_tlatch_24.xmux.xn.S1 cml_tlatch_24.INP MOT12_N VSS sg13_lv_nmos ad=63.19999f pd=0.74u as=63.19999f ps=0.74u w=0.26u l=0.38u
X3236 cml_tlatch_94.xmux.xn.S1 J1_N J2_P VSS sg13_lv_nmos ad=63.19999f pd=0.74u as=63.19999f ps=0.74u w=0.26u l=0.38u
X3237 cml_tlatch_19.xmux.xp.S1 A1_8_P A1_8_N VSS sg13_lv_nmos ad=56.9f pd=0.74u as=56.9f ps=0.74u w=0.17u l=0.17u
X3238 MOT30_N VDD VSS rppd l=5.17u w=1u
X3239 B3_2_N B3_2_P cml_tlatch_50.xmux.xp.S1 VSS sg13_lv_nmos ad=56.9f pd=0.74u as=56.9f ps=0.74u w=0.17u l=0.17u
X3240 MOT18_P cml_tlatch_87.OUTN cml_tlatch_53.xmux.xn.S1 VSS sg13_lv_nmos ad=0.1082p pd=1.34u as=63.19999f ps=0.74u w=0.26u l=0.38u
X3241 cml_tlatch_54.xtail.S1 POLN VSS VSS sg13_lv_nmos ad=1.5637p pd=8.61u as=2.7982p ps=17.14u w=8.23u l=0.13u
X3242 cml_tlatch_41.xmux.xn.S1 CKA1_P cml_tlatch_41.xtail.S1 VSS sg13_lv_nmos ad=89.3f pd=0.85u as=89.3f ps=0.85u w=0.47u l=0.16u
X3243 CLK_W_P CLK_W_N cml_tlatch_93.xmux.xp.S1 VSS sg13_lv_nmos ad=56.9f pd=0.74u as=56.9f ps=0.74u w=0.17u l=0.17u
X3244 cml_tlatch_3.xmux.xp.S1 MOT9_P MOT9_N VSS sg13_lv_nmos ad=0.1019p pd=1.34u as=56.9f ps=0.74u w=0.17u l=0.17u
X3245 cml_tlatch_43.xtail.S1 CKHA1_N cml_tlatch_43.xmux.xp.S1 VSS sg13_lv_nmos ad=89.3f pd=0.85u as=89.3f ps=0.85u w=0.47u l=0.16u
X3246 cml_tlatch_97.xmux.xn.S1 CKA1_N cml_tlatch_97.xtail.S1 VSS sg13_lv_nmos ad=89.3f pd=0.85u as=0.1598p ps=1.62u w=0.47u l=0.16u
X3247 cml_tlatch_86.xtail.S1 CKA2_N cml_tlatch_86.xmux.xp.S1 VSS sg13_lv_nmos ad=89.3f pd=0.85u as=89.3f ps=0.85u w=0.47u l=0.16u
X3248 cml_tlatch_64.xtail.S1 CKB3_N cml_tlatch_64.xmux.xn.S1 VSS sg13_lv_nmos ad=89.3f pd=0.85u as=89.3f ps=0.85u w=0.47u l=0.16u
X3249 cml_tlatch_36.xmux.xp.S1 B1_2_P B1_2_N VSS sg13_lv_nmos ad=56.9f pd=0.74u as=56.9f ps=0.74u w=0.17u l=0.17u
X3250 cml_tlatch_39.xmux.xp.S1 cml_tlatch_97.INN cml_tlatch_97.INP VSS sg13_lv_nmos ad=56.9f pd=0.74u as=56.9f ps=0.74u w=0.17u l=0.17u
X3251 VSS POLN cml_tlatch_93.xtail.S1 VSS sg13_lv_nmos ad=1.5637p pd=8.61u as=1.5637p ps=8.61u w=8.23u l=0.13u
X3252 J4_P CLK_W_P cml_tlatch_92.xmux.xn.S1 VSS sg13_lv_nmos ad=63.19999f pd=0.74u as=63.19999f ps=0.74u w=0.26u l=0.38u
X3253 cml_tlatch_57.xmux.xp.S1 A3_2_N A3_2_P VSS sg13_lv_nmos ad=0.1019p pd=1.34u as=56.9f ps=0.74u w=0.17u l=0.17u
X3254 cml_tlatch_77.xmux.xp.S1 CKHB2_N cml_tlatch_77.xtail.S1 VSS sg13_lv_nmos ad=89.3f pd=0.85u as=89.3f ps=0.85u w=0.47u l=0.16u
X3255 cml_tlatch_61.OUTP cml_tlatch_61.OUTN cml_tlatch_61.xmux.xp.S1 VSS sg13_lv_nmos ad=56.9f pd=0.74u as=56.9f ps=0.74u w=0.17u l=0.17u
X3256 GB0_P ENB1_N cml_gate2_1.xamp.xn.S1 VSS sg13_lv_nmos ad=0.1007p pd=0.91u as=0.1007p ps=0.91u w=0.53u l=0.13u
X3257 cml_tlatch_87.xtail.S1 CKA2_N cml_tlatch_87.xmux.xn.S1 VSS sg13_lv_nmos ad=89.3f pd=0.85u as=89.3f ps=0.85u w=0.47u l=0.16u
X3258 cml_tlatch_48.xmux.xp.S1 stub_bi_43.BOTP stub_bi_43.BOTN VSS sg13_lv_nmos ad=56.9f pd=0.74u as=56.9f ps=0.74u w=0.17u l=0.17u
X3259 cml_tlatch_37.xmux.xn.S1 CKB1_P cml_tlatch_37.xtail.S1 VSS sg13_lv_nmos ad=89.3f pd=0.85u as=89.3f ps=0.85u w=0.47u l=0.16u
X3260 cml_tlatch_82.xtail.S1 CKB2_N cml_tlatch_82.xmux.xp.S1 VSS sg13_lv_nmos ad=89.3f pd=0.85u as=89.3f ps=0.85u w=0.47u l=0.16u
X3261 cml_tlatch_83.xmux.xp.S1 stub_bi_63.BOTN stub_bi_63.BOTP VSS sg13_lv_nmos ad=0.1019p pd=1.34u as=56.9f ps=0.74u w=0.17u l=0.17u
X3262 cml_tlatch_16.xmux.xp.S1 MOT5_P MOT5_N VSS sg13_lv_nmos ad=56.9f pd=0.74u as=56.9f ps=0.74u w=0.17u l=0.17u
X3263 cml_tlatch_7.xmux.xp.S1 CKB0_P cml_tlatch_7.xtail.S1 VSS sg13_lv_nmos ad=89.3f pd=0.85u as=89.3f ps=0.85u w=0.47u l=0.16u
X3264 stub_bi_17.BOTP stub_bi_17.BOTN cml_tlatch_13.xmux.xp.S1 VSS sg13_lv_nmos ad=56.9f pd=0.74u as=56.9f ps=0.74u w=0.17u l=0.17u
X3265 cml_tlatch_51.xmux.xp.S1 cml_tlatch_51.OUTP cml_tlatch_51.OUTN VSS sg13_lv_nmos ad=56.9f pd=0.74u as=56.9f ps=0.74u w=0.17u l=0.17u
X3266 GA2_P CKB2_N cml_gate2_5.xrtail.R1 VSS sg13_lv_nmos ad=0.1007p pd=0.91u as=0.1007p ps=0.91u w=0.53u l=0.13u
X3267 cml_tlatch_10.xtail.S1 CKB1_N cml_tlatch_10.xmux.xn.S1 VSS sg13_lv_nmos ad=89.3f pd=0.85u as=0.1598p ps=1.62u w=0.47u l=0.16u
X3268 cml_tlatch_86.OUTP cml_tlatch_87.OUTN cml_tlatch_86.xmux.xn.S1 VSS sg13_lv_nmos ad=63.19999f pd=0.74u as=63.19999f ps=0.74u w=0.26u l=0.38u
X3269 VSS POLN cml_tlatch_88.xtail.S1 VSS sg13_lv_nmos ad=1.5637p pd=8.61u as=1.5637p ps=8.61u w=8.23u l=0.13u
X3270 cml_tlatch_54.xtail.S1 CKHA2_P cml_tlatch_54.xmux.xn.S1 VSS sg13_lv_nmos ad=89.3f pd=0.85u as=89.3f ps=0.85u w=0.47u l=0.16u
X3271 cml_tlatch_73.INP VDD VSS rppd l=5.17u w=1u
X3272 cml_tlatch_1.xtail.S1 CKB0_N cml_tlatch_1.xmux.xn.S1 VSS sg13_lv_nmos ad=89.3f pd=0.85u as=89.3f ps=0.85u w=0.47u l=0.16u
X3273 cml_tlatch_72.xmux.xp.S1 CKHB3_N cml_tlatch_72.xtail.S1 VSS sg13_lv_nmos ad=89.3f pd=0.85u as=89.3f ps=0.85u w=0.47u l=0.16u
X3274 cml_tlatch_83.xtail.S1 CKB2_N cml_tlatch_83.xmux.xn.S1 VSS sg13_lv_nmos ad=89.3f pd=0.85u as=89.3f ps=0.85u w=0.47u l=0.16u
X3275 CKHA2_N GA2_P cml_drvb_5.xrtail.R2 VSS sg13_lv_nmos ad=0.2618p pd=2.22u as=0.1463p ps=1.15u w=0.77u l=0.21u
X3276 cml_tlatch_69.xmux.xp.S1 cml_tlatch_69.OUTP cml_tlatch_69.OUTN VSS sg13_lv_nmos ad=56.9f pd=0.74u as=56.9f ps=0.74u w=0.17u l=0.17u
X3277 cml_tlatch_70.xtail.S1 CKA3_N cml_tlatch_70.xmux.xn.S1 VSS sg13_lv_nmos ad=89.3f pd=0.85u as=89.3f ps=0.85u w=0.47u l=0.16u
X3278 cml_tlatch_75.xmux.xp.S1 MOT31_N MOT31_P VSS sg13_lv_nmos ad=56.9f pd=0.74u as=56.9f ps=0.74u w=0.17u l=0.17u
X3279 cml_tlatch_0.xtail.S1 POLN VSS VSS sg13_lv_nmos ad=1.5637p pd=8.61u as=2.7982p ps=17.14u w=8.23u l=0.13u
X3280 A3_2_N cml_tlatch_58.OUTP cml_tlatch_57.xmux.xn.S1 VSS sg13_lv_nmos ad=63.19999f pd=0.74u as=0.1082p ps=1.34u w=0.26u l=0.38u
X3281 stub_bi_49.BOTN stub_bi_55.BOTP cml_tlatch_84.xmux.xn.S1 VSS sg13_lv_nmos ad=63.19999f pd=0.74u as=63.19999f ps=0.74u w=0.26u l=0.38u
X3282 cml_tlatch_82.xmux.xp.S1 stub_bi_62.BOTP stub_bi_62.BOTN VSS sg13_lv_nmos ad=56.9f pd=0.74u as=56.9f ps=0.74u w=0.17u l=0.17u
X3283 cml_tlatch_53.xtail.S1 CKHA2_N cml_tlatch_53.xmux.xp.S1 VSS sg13_lv_nmos ad=89.3f pd=0.85u as=89.3f ps=0.85u w=0.47u l=0.16u
X3284 VSS POLN cml_tlatch_53.xtail.S1 VSS sg13_lv_nmos ad=1.5637p pd=8.61u as=1.5637p ps=8.61u w=8.23u l=0.13u
X3285 VSS hs_to_clk_6.sg13_lv_nmos_2HGZLP_0.G VSS VSS sg13_lv_nmos ad=3.706p pd=22.48u as=0 ps=0 w=10.9u l=1.38u
X3286 cml_tlatch_30.xtail.S1 CKB0_P cml_tlatch_30.xmux.xn.S1 VSS sg13_lv_nmos ad=89.3f pd=0.85u as=89.3f ps=0.85u w=0.47u l=0.16u
X3287 cml_tlatch_79.xmux.xp.S1 MOT21_P MOT21_N VSS sg13_lv_nmos ad=56.9f pd=0.74u as=56.9f ps=0.74u w=0.17u l=0.17u
X3288 cml_tlatch_34.xmux.xn.S1 CKA0_N cml_tlatch_34.xtail.S1 VSS sg13_lv_nmos ad=89.3f pd=0.85u as=89.3f ps=0.85u w=0.47u l=0.16u
X3289 cml_tlatch_5.INN cml_tlatch_5.INP cml_tlatch_96.xmux.xp.S1 VSS sg13_lv_nmos ad=56.9f pd=0.74u as=56.9f ps=0.74u w=0.17u l=0.17u
X3290 cml_tlatch_50.xmux.xp.S1 B3_2_N B3_2_P VSS sg13_lv_nmos ad=56.9f pd=0.74u as=56.9f ps=0.74u w=0.17u l=0.17u
X3291 cml_tlatch_32.xmux.xn.S1 CKB0_P cml_tlatch_32.xtail.S1 VSS sg13_lv_nmos ad=89.3f pd=0.85u as=89.3f ps=0.85u w=0.47u l=0.16u
X3292 cml_tlatch_34.xmux.xn.S1 cml_tlatch_38.OUTP A0_2_N VSS sg13_lv_nmos ad=63.19999f pd=0.74u as=63.19999f ps=0.74u w=0.26u l=0.38u
X3293 cml_tlatch_43.xmux.xn.S1 cml_tlatch_43.INP MOT10_N VSS sg13_lv_nmos ad=63.19999f pd=0.74u as=63.19999f ps=0.74u w=0.26u l=0.38u
X3294 cml_tlatch_51.OUTN cml_tlatch_51.OUTP cml_tlatch_51.xmux.xp.S1 VSS sg13_lv_nmos ad=56.9f pd=0.74u as=56.9f ps=0.74u w=0.17u l=0.17u
X3295 MOT29_P cml_tlatch_74.INN cml_tlatch_74.xmux.xn.S1 VSS sg13_lv_nmos ad=63.19999f pd=0.74u as=63.19999f ps=0.74u w=0.26u l=0.38u
X3296 cml_tlatch_24.xmux.xp.S1 MOT12_P MOT12_N VSS sg13_lv_nmos ad=56.9f pd=0.74u as=56.9f ps=0.74u w=0.17u l=0.17u
X3297 cml_tlatch_42.xmux.xn.S1 CKHA1_P cml_tlatch_42.xtail.S1 VSS sg13_lv_nmos ad=89.3f pd=0.85u as=89.3f ps=0.85u w=0.47u l=0.16u
X3298 GA1_P ENA0_N cml_gate2_2.xamp.xn.S1 VSS sg13_lv_nmos ad=0.1007p pd=0.91u as=0.1007p ps=0.91u w=0.53u l=0.13u
X3299 cml_tlatch_84.xmux.xn.S1 stub_bi_55.BOTN stub_bi_49.BOTP VSS sg13_lv_nmos ad=63.19999f pd=0.74u as=63.19999f ps=0.74u w=0.26u l=0.38u
X3300 VSS POLN cml_tlatch_6.xtail.S1 VSS sg13_lv_nmos ad=2.7982p pd=17.14u as=1.5637p ps=8.61u w=8.23u l=0.13u
X3301 cml_tlatch_4.INP cml_tlatch_4.INN cml_tlatch_12.xmux.xp.S1 VSS sg13_lv_nmos ad=56.9f pd=0.74u as=0.1019p ps=1.34u w=0.17u l=0.17u
X3302 cml_tlatch_23.OUTN cml_tlatch_23.OUTP cml_tlatch_23.xmux.xp.S1 VSS sg13_lv_nmos ad=56.9f pd=0.74u as=56.9f ps=0.74u w=0.17u l=0.17u
X3303 J1_P J4_P cml_tlatch_95.xmux.xn.S1 VSS sg13_lv_nmos ad=0.1082p pd=1.34u as=63.19999f ps=0.74u w=0.26u l=0.38u
X3304 cml_tlatch_50.xtail.S1 CKB3_N cml_tlatch_50.xmux.xn.S1 VSS sg13_lv_nmos ad=89.3f pd=0.85u as=89.3f ps=0.85u w=0.47u l=0.16u
X3305 A3_8_N A3_8_P cml_tlatch_68.xmux.xp.S1 VSS sg13_lv_nmos ad=56.9f pd=0.74u as=56.9f ps=0.74u w=0.17u l=0.17u
X3306 MOT26_N cml_tlatch_63.INP cml_tlatch_63.xmux.xn.S1 VSS sg13_lv_nmos ad=63.19999f pd=0.74u as=63.19999f ps=0.74u w=0.26u l=0.38u
X3307 cml_tlatch_30.OUTN cml_tlatch_30.OUTP cml_tlatch_30.xmux.xp.S1 VSS sg13_lv_nmos ad=56.9f pd=0.74u as=56.9f ps=0.74u w=0.17u l=0.17u
X3308 cml_tlatch_91.xtail.S1 CKA2_N cml_tlatch_91.xmux.xn.S1 VSS sg13_lv_nmos ad=89.3f pd=0.85u as=89.3f ps=0.85u w=0.47u l=0.16u
X3309 stub_bi_38.BOTN VDD VSS rppd l=5.17u w=1u
X3310 cml_tlatch_71.xmux.xp.S1 cml_tlatch_71.OUTN cml_tlatch_71.OUTP VSS sg13_lv_nmos ad=56.9f pd=0.74u as=56.9f ps=0.74u w=0.17u l=0.17u
X3311 cml_tlatch_67.OUTP cml_tlatch_67.OUTN cml_tlatch_67.xmux.xp.S1 VSS sg13_lv_nmos ad=56.9f pd=0.74u as=56.9f ps=0.74u w=0.17u l=0.17u
X3312 cml_tlatch_2.xtail.S1 CKB0_N cml_tlatch_2.xmux.xp.S1 VSS sg13_lv_nmos ad=89.3f pd=0.85u as=89.3f ps=0.85u w=0.47u l=0.16u
X3313 cml_tlatch_68.xmux.xp.S1 A3_8_N A3_8_P VSS sg13_lv_nmos ad=56.9f pd=0.74u as=56.9f ps=0.74u w=0.17u l=0.17u
X3314 cml_tlatch_74.INN cml_tlatch_74.INP cml_tlatch_88.xmux.xp.S1 VSS sg13_lv_nmos ad=56.9f pd=0.74u as=56.9f ps=0.74u w=0.17u l=0.17u
X3315 MOT22_P MOT22_N cml_tlatch_55.xmux.xp.S1 VSS sg13_lv_nmos ad=56.9f pd=0.74u as=56.9f ps=0.74u w=0.17u l=0.17u
X3316 B1_8_N B1_8_P cml_tlatch_10.xmux.xp.S1 VSS sg13_lv_nmos ad=56.9f pd=0.74u as=56.9f ps=0.74u w=0.17u l=0.17u
X3317 cml_gate2_9.xamp.xn.S1 NM1_P cml_gate2_9.xrtail.R1 VSS sg13_lv_nmos ad=0.1007p pd=0.91u as=0.1007p ps=0.91u w=0.53u l=0.13u
X3318 cml_tlatch_54.xmux.xp.S1 CKHA2_N cml_tlatch_54.xtail.S1 VSS sg13_lv_nmos ad=0.1598p pd=1.62u as=89.3f ps=0.85u w=0.47u l=0.16u
X3319 cml_tlatch_38.OUTN cml_tlatch_38.OUTP cml_tlatch_38.xmux.xp.S1 VSS sg13_lv_nmos ad=56.9f pd=0.74u as=56.9f ps=0.74u w=0.17u l=0.17u
X3320 B0_8_P cml_tlatch_2.OUTN cml_tlatch_1.xmux.xn.S1 VSS sg13_lv_nmos ad=63.19999f pd=0.74u as=63.19999f ps=0.74u w=0.26u l=0.38u
X3321 GA3_P ENA1_N cml_gate2_4.xamp.xn.S1 VSS sg13_lv_nmos ad=0.1007p pd=0.91u as=0.1007p ps=0.91u w=0.53u l=0.13u
X3322 cml_tlatch_56.OUTP cml_tlatch_56.OUTN cml_tlatch_56.xmux.xp.S1 VSS sg13_lv_nmos ad=56.9f pd=0.74u as=56.9f ps=0.74u w=0.17u l=0.17u
X3323 cml_tlatch_44.xmux.xp.S1 MOT28_P MOT28_N VSS sg13_lv_nmos ad=56.9f pd=0.74u as=56.9f ps=0.74u w=0.17u l=0.17u
X3324 VDD GB2_N VSS rppd l=7.42u w=1u
X3325 cml_tlatch_27.xmux.xp.S1 MOT2_N MOT2_P VSS sg13_lv_nmos ad=56.9f pd=0.74u as=56.9f ps=0.74u w=0.17u l=0.17u
X3326 cml_tlatch_36.xtail.S1 CKB1_N cml_tlatch_36.xmux.xn.S1 VSS sg13_lv_nmos ad=89.3f pd=0.85u as=0.1598p ps=1.62u w=0.47u l=0.16u
X3327 cml_tlatch_37.xmux.xp.S1 stub_bi_31.BOTN stub_bi_31.BOTP VSS sg13_lv_nmos ad=56.9f pd=0.74u as=56.9f ps=0.74u w=0.17u l=0.17u
X3328 J4_P J4_N cml_tlatch_92.xmux.xp.S1 VSS sg13_lv_nmos ad=56.9f pd=0.74u as=56.9f ps=0.74u w=0.17u l=0.17u
X3329 cml_tlatch_89.xmux.xp.S1 cml_tlatch_44.INN cml_tlatch_44.INP VSS sg13_lv_nmos ad=56.9f pd=0.74u as=56.9f ps=0.74u w=0.17u l=0.17u
X3330 cml_tlatch_43.xtail.S1 CKHA1_P cml_tlatch_43.xmux.xn.S1 VSS sg13_lv_nmos ad=0.1598p pd=1.62u as=89.3f ps=0.85u w=0.47u l=0.16u
X3331 GA3_N ENA1_P cml_gate2_4.xamp.xn.S1 VSS sg13_lv_nmos ad=0.1007p pd=0.91u as=0.1007p ps=0.91u w=0.53u l=0.13u
X3332 cml_tlatch_21.xtail.S1 CKA1_P cml_tlatch_21.xmux.xp.S1 VSS sg13_lv_nmos ad=89.3f pd=0.85u as=89.3f ps=0.85u w=0.47u l=0.16u
X3333 VDD cml_tlatch_22.OUTN VSS rppd l=5.17u w=1u
X3334 stub_bi_29.BOTN stub_bi_29.BOTP cml_tlatch_35.xmux.xp.S1 VSS sg13_lv_nmos ad=56.9f pd=0.74u as=56.9f ps=0.74u w=0.17u l=0.17u
X3335 cml_tlatch_6.xmux.xn.S1 B1_2_P MOT15_N VSS sg13_lv_nmos ad=63.19999f pd=0.74u as=63.19999f ps=0.74u w=0.26u l=0.38u
X3336 cml_tlatch_93.xtail.S1 CKJ_P cml_tlatch_93.xmux.xn.S1 VSS sg13_lv_nmos ad=89.3f pd=0.85u as=89.3f ps=0.85u w=0.47u l=0.16u
X3337 cml_tlatch_99.OUTN cml_tlatch_33.OUTP cml_tlatch_99.xmux.xn.S1 VSS sg13_lv_nmos ad=63.19999f pd=0.74u as=63.19999f ps=0.74u w=0.26u l=0.38u
X3338 MOT8_N A1_8_P cml_tlatch_42.xmux.xn.S1 VSS sg13_lv_nmos ad=63.19999f pd=0.74u as=63.19999f ps=0.74u w=0.26u l=0.38u
X3339 A1_8_P A1_8_N cml_tlatch_19.xmux.xp.S1 VSS sg13_lv_nmos ad=56.9f pd=0.74u as=56.9f ps=0.74u w=0.17u l=0.17u
X3340 cml_tlatch_48.xmux.xp.S1 stub_bi_43.BOTP stub_bi_43.BOTN VSS sg13_lv_nmos ad=56.9f pd=0.74u as=56.9f ps=0.74u w=0.17u l=0.17u
X3341 stub_bi_38.BOTN B2_2_N cml_tlatch_46.xmux.xn.S1 VSS sg13_lv_nmos ad=63.19999f pd=0.74u as=63.19999f ps=0.74u w=0.26u l=0.38u
X3342 cml_tlatch_19.xtail.S1 CKA1_P cml_tlatch_19.xmux.xp.S1 VSS sg13_lv_nmos ad=89.3f pd=0.85u as=89.3f ps=0.85u w=0.47u l=0.16u
X3343 cml_tlatch_4.INP cml_tlatch_4.INN cml_tlatch_12.xmux.xp.S1 VSS sg13_lv_nmos ad=56.9f pd=0.74u as=56.9f ps=0.74u w=0.17u l=0.17u
X3344 cml_tlatch_11.xmux.xn.S1 cml_tlatch_4.INP stub_bi_15.BOTP VSS sg13_lv_nmos ad=0.1082p pd=1.34u as=63.19999f ps=0.74u w=0.26u l=0.38u
X3345 cml_tlatch_73.xmux.xn.S1 CKHB3_P cml_tlatch_73.xtail.S1 VSS sg13_lv_nmos ad=89.3f pd=0.85u as=89.3f ps=0.85u w=0.47u l=0.16u
X3346 cml_tlatch_90.xtail.S1 POLN VSS VSS sg13_lv_nmos ad=1.5637p pd=8.61u as=1.5637p ps=8.61u w=8.23u l=0.13u
X3347 cml_tlatch_88.xmux.xp.S1 cml_tlatch_74.INP cml_tlatch_74.INN VSS sg13_lv_nmos ad=56.9f pd=0.74u as=56.9f ps=0.74u w=0.17u l=0.17u
X3348 cml_drv_1.xrtail.R1 ENA_N ENA1_P VSS sg13_lv_nmos ad=56.2f pd=0.74u as=56.2f ps=0.74u w=0.16u l=0.19u
X3349 cml_tlatch_8.xmux.xp.S1 cml_tlatch_8.OUTP cml_tlatch_8.OUTN VSS sg13_lv_nmos ad=56.9f pd=0.74u as=56.9f ps=0.74u w=0.17u l=0.17u
X3350 cml_tlatch_55.xmux.xp.S1 MOT22_P MOT22_N VSS sg13_lv_nmos ad=56.9f pd=0.74u as=56.9f ps=0.74u w=0.17u l=0.17u
X3351 cml_tlatch_54.xmux.xp.S1 MOT20_N MOT20_P VSS sg13_lv_nmos ad=56.9f pd=0.74u as=56.9f ps=0.74u w=0.17u l=0.17u
X3352 cml_tlatch_69.OUTP cml_tlatch_69.OUTN cml_tlatch_69.xmux.xp.S1 VSS sg13_lv_nmos ad=56.9f pd=0.74u as=56.9f ps=0.74u w=0.17u l=0.17u
X3353 cml_tlatch_0.xmux.xn.S1 cml_tlatch_99.OUTP cml_tlatch_0.OUTN VSS sg13_lv_nmos ad=63.19999f pd=0.74u as=63.19999f ps=0.74u w=0.26u l=0.38u
X3354 cml_tlatch_61.OUTN cml_tlatch_61.OUTP cml_tlatch_61.xmux.xp.S1 VSS sg13_lv_nmos ad=56.9f pd=0.74u as=0.1019p ps=1.34u w=0.17u l=0.17u
X3355 CKA2_P CK_P hs_to_clk_7.D2 VSS sg13_lv_nmos ad=0.408p pd=3.08u as=0.228p ps=1.58u w=1.2u l=0.2u
X3356 VDD MOT6_P VSS rppd l=5.17u w=1u
X3357 cml_tlatch_46.xmux.xn.S1 B2_2_P stub_bi_38.BOTP VSS sg13_lv_nmos ad=63.19999f pd=0.74u as=0.1082p ps=1.34u w=0.26u l=0.38u
X3358 cml_tlatch_7.OUTN cml_tlatch_8.OUTP cml_tlatch_7.xmux.xn.S1 VSS sg13_lv_nmos ad=63.19999f pd=0.74u as=63.19999f ps=0.74u w=0.26u l=0.38u
X3359 cml_tlatch_10.xtail.S1 CKB1_P cml_tlatch_10.xmux.xp.S1 VSS sg13_lv_nmos ad=89.3f pd=0.85u as=89.3f ps=0.85u w=0.47u l=0.16u
X3360 cml_tlatch_35.xtail.S1 CKB1_P cml_tlatch_35.xmux.xn.S1 VSS sg13_lv_nmos ad=89.3f pd=0.85u as=89.3f ps=0.85u w=0.47u l=0.16u
X3361 MOT19_N MOT19_P cml_tlatch_78.xmux.xp.S1 VSS sg13_lv_nmos ad=56.9f pd=0.74u as=56.9f ps=0.74u w=0.17u l=0.17u
X3362 cml_tlatch_26.xtail.S1 CKHA0_N cml_tlatch_26.xmux.xp.S1 VSS sg13_lv_nmos ad=89.3f pd=0.85u as=89.3f ps=0.85u w=0.47u l=0.16u
X3363 cml_tlatch_73.xmux.xp.S1 MOT27_P MOT27_N VSS sg13_lv_nmos ad=56.9f pd=0.74u as=56.9f ps=0.74u w=0.17u l=0.17u
X3364 cml_tlatch_85.xtail.S1 CKA2_P cml_tlatch_85.xmux.xp.S1 VSS sg13_lv_nmos ad=89.3f pd=0.85u as=89.3f ps=0.85u w=0.47u l=0.16u
X3365 cml_tlatch_73.INP cml_tlatch_73.INN cml_tlatch_66.xmux.xp.S1 VSS sg13_lv_nmos ad=56.9f pd=0.74u as=56.9f ps=0.74u w=0.17u l=0.17u
X3366 VSS POLN cml_tlatch_3.xtail.S1 VSS sg13_lv_nmos ad=2.7982p pd=17.14u as=1.5637p ps=8.61u w=8.23u l=0.13u
X3367 cml_tlatch_52.xmux.xp.S1 MOT16_P MOT16_N VSS sg13_lv_nmos ad=56.9f pd=0.74u as=56.9f ps=0.74u w=0.17u l=0.17u
X3368 A1_2_P cml_tlatch_41.OUTN cml_tlatch_40.xmux.xn.S1 VSS sg13_lv_nmos ad=63.19999f pd=0.74u as=63.19999f ps=0.74u w=0.26u l=0.38u
X3369 stub_bi_17.BOTN stub_bi_17.BOTP cml_tlatch_13.xmux.xp.S1 VSS sg13_lv_nmos ad=56.9f pd=0.74u as=56.9f ps=0.74u w=0.17u l=0.17u
X3370 MOT30_P MOT30_N cml_tlatch_45.xmux.xp.S1 VSS sg13_lv_nmos ad=56.9f pd=0.74u as=56.9f ps=0.74u w=0.17u l=0.17u
X3371 cml_tlatch_74.xtail.S1 CKHB3_P cml_tlatch_74.xmux.xn.S1 VSS sg13_lv_nmos ad=0.1598p pd=1.62u as=89.3f ps=0.85u w=0.47u l=0.16u
X3372 MOT29_N MOT29_P cml_tlatch_74.xmux.xp.S1 VSS sg13_lv_nmos ad=56.9f pd=0.74u as=56.9f ps=0.74u w=0.17u l=0.17u
X3373 cml_tlatch_46.xmux.xp.S1 stub_bi_38.BOTN stub_bi_38.BOTP VSS sg13_lv_nmos ad=56.9f pd=0.74u as=56.9f ps=0.74u w=0.17u l=0.17u
X3374 cml_tlatch_97.INN cml_tlatch_97.INP cml_tlatch_39.xmux.xp.S1 VSS sg13_lv_nmos ad=56.9f pd=0.74u as=56.9f ps=0.74u w=0.17u l=0.17u
X3375 MOT4_P MOT4_N cml_tlatch_28.xmux.xp.S1 VSS sg13_lv_nmos ad=56.9f pd=0.74u as=56.9f ps=0.74u w=0.17u l=0.17u
X3376 cml_tlatch_87.OUTN cml_tlatch_87.INP cml_tlatch_87.xmux.xn.S1 VSS sg13_lv_nmos ad=63.19999f pd=0.74u as=63.19999f ps=0.74u w=0.26u l=0.38u
X3377 cml_tlatch_49.xmux.xp.S1 CKB3_N cml_tlatch_49.xtail.S1 VSS sg13_lv_nmos ad=89.3f pd=0.85u as=89.3f ps=0.85u w=0.47u l=0.16u
X3378 cml_tlatch_75.xmux.xp.S1 CKHB3_N cml_tlatch_75.xtail.S1 VSS sg13_lv_nmos ad=89.3f pd=0.85u as=89.3f ps=0.85u w=0.47u l=0.16u
X3379 cml_drvb_3.xrtail.R2 GA0_N CKHA0_P VSS sg13_lv_nmos ad=0.1463p pd=1.15u as=0.2618p ps=2.22u w=0.77u l=0.21u
X3380 cml_tlatch_25.xmux.xp.S1 MOT14_N MOT14_P VSS sg13_lv_nmos ad=56.9f pd=0.74u as=56.9f ps=0.74u w=0.17u l=0.17u
X3381 cml_tlatch_42.xmux.xp.S1 MOT8_P MOT8_N VSS sg13_lv_nmos ad=56.9f pd=0.74u as=56.9f ps=0.74u w=0.17u l=0.17u
X3382 cml_tlatch_68.xmux.xn.S1 cml_tlatch_69.OUTN A3_8_P VSS sg13_lv_nmos ad=63.19999f pd=0.74u as=63.19999f ps=0.74u w=0.26u l=0.38u
X3383 stub_bi_63.BOTN stub_bi_49.BOTP cml_tlatch_83.xmux.xn.S1 VSS sg13_lv_nmos ad=63.19999f pd=0.74u as=63.19999f ps=0.74u w=0.26u l=0.38u
X3384 cml_tlatch_7.xtail.S1 CKB0_P cml_tlatch_7.xmux.xp.S1 VSS sg13_lv_nmos ad=89.3f pd=0.85u as=0.1598p ps=1.62u w=0.47u l=0.16u
X3385 cml_tlatch_23.OUTN cml_tlatch_23.OUTP cml_tlatch_23.xmux.xp.S1 VSS sg13_lv_nmos ad=56.9f pd=0.74u as=56.9f ps=0.74u w=0.17u l=0.17u
X3386 J1_N J1_P cml_tlatch_95.xmux.xp.S1 VSS sg13_lv_nmos ad=56.9f pd=0.74u as=56.9f ps=0.74u w=0.17u l=0.17u
X3387 cml_tlatch_86.xtail.S1 CKA2_P cml_tlatch_86.xmux.xn.S1 VSS sg13_lv_nmos ad=89.3f pd=0.85u as=89.3f ps=0.85u w=0.47u l=0.16u
X3388 cml_tlatch_57.xtail.S1 POLN VSS VSS sg13_lv_nmos ad=1.5637p pd=8.61u as=2.7982p ps=17.14u w=8.23u l=0.13u
X3389 cml_tlatch_32.xtail.S1 POLN VSS VSS sg13_lv_nmos ad=1.5637p pd=8.61u as=2.7982p ps=17.14u w=8.23u l=0.13u
X3390 CLK_W_N CLK_W_P cml_tlatch_93.xmux.xp.S1 VSS sg13_lv_nmos ad=56.9f pd=0.74u as=56.9f ps=0.74u w=0.17u l=0.17u
X3391 cml_tlatch_25.xmux.xp.S1 CKHA1_N cml_tlatch_25.xtail.S1 VSS sg13_lv_nmos ad=89.3f pd=0.85u as=89.3f ps=0.85u w=0.47u l=0.16u
X3392 cml_tlatch_21.xtail.S1 CKA1_P cml_tlatch_21.xmux.xp.S1 VSS sg13_lv_nmos ad=89.3f pd=0.85u as=89.3f ps=0.85u w=0.47u l=0.16u
X3393 cml_tlatch_61.OUTN cml_tlatch_61.OUTP cml_tlatch_61.xmux.xp.S1 VSS sg13_lv_nmos ad=56.9f pd=0.74u as=56.9f ps=0.74u w=0.17u l=0.17u
X3394 cml_tlatch_2.OUTP cml_tlatch_2.OUTN cml_tlatch_2.xmux.xp.S1 VSS sg13_lv_nmos ad=56.9f pd=0.74u as=56.9f ps=0.74u w=0.17u l=0.17u
X3395 MOT22_N A2_2_P cml_tlatch_55.xmux.xn.S1 VSS sg13_lv_nmos ad=63.19999f pd=0.74u as=0.1082p ps=1.34u w=0.26u l=0.38u
X3396 stub_bi_63.BOTP VDD VSS rppd l=5.17u w=1u
X3397 cml_tlatch_94.xmux.xp.S1 J2_P J2_N VSS sg13_lv_nmos ad=56.9f pd=0.74u as=56.9f ps=0.74u w=0.17u l=0.17u
X3398 cml_tlatch_94.xmux.xp.S1 J2_N J2_P VSS sg13_lv_nmos ad=56.9f pd=0.74u as=56.9f ps=0.74u w=0.17u l=0.17u
X3399 cml_tlatch_5.xtail.S1 CKHB1_P cml_tlatch_5.xmux.xn.S1 VSS sg13_lv_nmos ad=89.3f pd=0.85u as=89.3f ps=0.85u w=0.47u l=0.16u
X3400 MOT19_P stub_bi_63.BOTP cml_tlatch_78.xmux.xn.S1 VSS sg13_lv_nmos ad=63.19999f pd=0.74u as=63.19999f ps=0.74u w=0.26u l=0.38u
X3401 cml_tlatch_47.xmux.xp.S1 B2_2_P B2_2_N VSS sg13_lv_nmos ad=56.9f pd=0.74u as=56.9f ps=0.74u w=0.17u l=0.17u
X3402 cml_tlatch_24.xmux.xn.S1 cml_tlatch_24.INN MOT12_P VSS sg13_lv_nmos ad=63.19999f pd=0.74u as=0.1082p ps=1.34u w=0.26u l=0.38u
X3403 B0_8_P B0_8_N cml_tlatch_1.xmux.xp.S1 VSS sg13_lv_nmos ad=56.9f pd=0.74u as=56.9f ps=0.74u w=0.17u l=0.17u
X3404 NS1_N J4_N cml_drvb_8.xrtail.R2 VSS sg13_lv_nmos ad=0.2618p pd=2.22u as=0.1463p ps=1.15u w=0.77u l=0.21u
X3405 cml_tlatch_56.xtail.S1 CKA3_P cml_tlatch_56.xmux.xn.S1 VSS sg13_lv_nmos ad=89.3f pd=0.85u as=89.3f ps=0.85u w=0.47u l=0.16u
X3406 cml_tlatch_44.INP cml_tlatch_56.OUTN cml_tlatch_89.xmux.xn.S1 VSS sg13_lv_nmos ad=63.19999f pd=0.74u as=0.1082p ps=1.34u w=0.26u l=0.38u
X3407 cml_tlatch_82.xtail.S1 CKB2_P cml_tlatch_82.xmux.xn.S1 VSS sg13_lv_nmos ad=0.1598p pd=1.62u as=89.3f ps=0.85u w=0.47u l=0.16u
X3408 cml_tlatch_58.OUTP cml_tlatch_58.OUTN cml_tlatch_58.xmux.xp.S1 VSS sg13_lv_nmos ad=56.9f pd=0.74u as=56.9f ps=0.74u w=0.17u l=0.17u
X3409 cml_tlatch_27.xmux.xp.S1 MOT2_N MOT2_P VSS sg13_lv_nmos ad=0.1019p pd=1.34u as=56.9f ps=0.74u w=0.17u l=0.17u
X3410 cml_tlatch_85.xmux.xn.S1 cml_tlatch_86.OUTP A2_8_N VSS sg13_lv_nmos ad=63.19999f pd=0.74u as=63.19999f ps=0.74u w=0.26u l=0.38u
X3411 cml_tlatch_53.xmux.xn.S1 CKHA2_P cml_tlatch_53.xtail.S1 VSS sg13_lv_nmos ad=89.3f pd=0.85u as=89.3f ps=0.85u w=0.47u l=0.16u
X3412 cml_tlatch_26.xmux.xp.S1 MOT0_N MOT0_P VSS sg13_lv_nmos ad=56.9f pd=0.74u as=56.9f ps=0.74u w=0.17u l=0.17u
X3413 B3_2_P cml_tlatch_51.OUTN cml_tlatch_50.xmux.xn.S1 VSS sg13_lv_nmos ad=63.19999f pd=0.74u as=63.19999f ps=0.74u w=0.26u l=0.38u
X3414 cml_drv_3.xrtail.R1 ENA_P ENA0_N VSS sg13_lv_nmos ad=56.2f pd=0.74u as=0.1012p ps=1.34u w=0.16u l=0.19u
X3415 VSS POLN cml_tlatch_52.xtail.S1 VSS sg13_lv_nmos ad=2.7982p pd=17.14u as=1.5637p ps=8.61u w=8.23u l=0.13u
X3416 cml_tlatch_85.xmux.xn.S1 cml_tlatch_86.OUTP A2_8_N VSS sg13_lv_nmos ad=63.19999f pd=0.74u as=63.19999f ps=0.74u w=0.26u l=0.38u
X3417 cml_tlatch_49.OUTN VDD VSS rppd l=5.17u w=1u
X3418 cml_tlatch_65.xmux.xp.S1 cml_tlatch_65.OUTN cml_tlatch_65.OUTP VSS sg13_lv_nmos ad=56.9f pd=0.74u as=56.9f ps=0.74u w=0.17u l=0.17u
X3419 MOT31_N VDD VSS rppd l=5.17u w=1u
X3420 stub_bi_49.BOTP stub_bi_49.BOTN cml_tlatch_84.xmux.xp.S1 VSS sg13_lv_nmos ad=56.9f pd=0.74u as=56.9f ps=0.74u w=0.17u l=0.17u
X3421 VDD MOT5_N VSS rppd l=5.17u w=1u
X3422 cml_tlatch_22.xmux.xp.S1 cml_tlatch_22.OUTP cml_tlatch_22.OUTN VSS sg13_lv_nmos ad=56.9f pd=0.74u as=56.9f ps=0.74u w=0.17u l=0.17u
X3423 cml_gate2_7.xamp.xn.S1 ENB0_N GB2_P VSS sg13_lv_nmos ad=0.1007p pd=0.91u as=0.1007p ps=0.91u w=0.53u l=0.13u
X3424 B0_8_N cml_tlatch_2.OUTP cml_tlatch_1.xmux.xn.S1 VSS sg13_lv_nmos ad=63.19999f pd=0.74u as=63.19999f ps=0.74u w=0.26u l=0.38u
X3425 VSS POLN cml_tlatch_59.xtail.S1 VSS sg13_lv_nmos ad=2.7982p pd=17.14u as=1.5637p ps=8.61u w=8.23u l=0.13u
X3426 A3_2_N A3_2_P cml_tlatch_57.xmux.xp.S1 VSS sg13_lv_nmos ad=56.9f pd=0.74u as=0.1019p ps=1.34u w=0.17u l=0.17u
X3427 cml_gate2_3.xrtail.R1 CKB0_N GA0_P VSS sg13_lv_nmos ad=0.1007p pd=0.91u as=0.1007p ps=0.91u w=0.53u l=0.13u
X3428 cml_tlatch_22.OUTP cml_tlatch_24.INN cml_tlatch_22.xmux.xn.S1 VSS sg13_lv_nmos ad=0.1082p pd=1.34u as=63.19999f ps=0.74u w=0.26u l=0.38u
X3429 cml_tlatch_37.xmux.xn.S1 CKB1_P cml_tlatch_37.xtail.S1 VSS sg13_lv_nmos ad=89.3f pd=0.85u as=89.3f ps=0.85u w=0.47u l=0.16u
X3430 cml_tlatch_54.xmux.xp.S1 MOT20_N MOT20_P VSS sg13_lv_nmos ad=56.9f pd=0.74u as=56.9f ps=0.74u w=0.17u l=0.17u
X3431 MOT9_N MOT9_P cml_tlatch_3.xmux.xp.S1 VSS sg13_lv_nmos ad=56.9f pd=0.74u as=56.9f ps=0.74u w=0.17u l=0.17u
X3432 VSS hs_to_clk_4.sg13_lv_nmos_2HGZLP_0.G VSS VSS sg13_lv_nmos ad=2.071p pd=11.28u as=0 ps=0 w=10.9u l=1.38u
X3433 ENB1_P VDD VSS rppd l=8.13u w=1u
X3434 cml_tlatch_65.xmux.xp.S1 cml_tlatch_65.OUTN cml_tlatch_65.OUTP VSS sg13_lv_nmos ad=0.1019p pd=1.34u as=56.9f ps=0.74u w=0.17u l=0.17u
X3435 MOT30_P MOT30_N cml_tlatch_45.xmux.xp.S1 VSS sg13_lv_nmos ad=56.9f pd=0.74u as=0.1019p ps=1.34u w=0.17u l=0.17u
X3436 cml_tlatch_91.xmux.xp.S1 cml_tlatch_91.OUTP cml_tlatch_91.OUTN VSS sg13_lv_nmos ad=0.1019p pd=1.34u as=56.9f ps=0.74u w=0.17u l=0.17u
X3437 cml_tlatch_93.xmux.xp.S1 CLK_W_P CLK_W_N VSS sg13_lv_nmos ad=56.9f pd=0.74u as=56.9f ps=0.74u w=0.17u l=0.17u
X3438 cml_tlatch_40.xmux.xp.S1 CKA1_P cml_tlatch_40.xtail.S1 VSS sg13_lv_nmos ad=89.3f pd=0.85u as=89.3f ps=0.85u w=0.47u l=0.16u
X3439 cml_tlatch_77.xmux.xn.S1 B2_8_N MOT17_P VSS sg13_lv_nmos ad=63.19999f pd=0.74u as=63.19999f ps=0.74u w=0.26u l=0.38u
X3440 B2_2_N stub_bi_43.BOTN cml_tlatch_47.xmux.xn.S1 VSS sg13_lv_nmos ad=63.19999f pd=0.74u as=63.19999f ps=0.74u w=0.26u l=0.38u
X3441 cml_tlatch_24.xmux.xp.S1 MOT12_N MOT12_P VSS sg13_lv_nmos ad=56.9f pd=0.74u as=56.9f ps=0.74u w=0.17u l=0.17u
X3442 cml_gate2_8.xamp.xn.S1 J2_P ENB_N VSS sg13_lv_nmos ad=0.1007p pd=0.91u as=0.1007p ps=0.91u w=0.53u l=0.13u
X3443 cml_tlatch_65.xmux.xn.S1 cml_tlatch_73.INN cml_tlatch_65.OUTP VSS sg13_lv_nmos ad=63.19999f pd=0.74u as=0.1082p ps=1.34u w=0.26u l=0.38u
X3444 cml_tlatch_72.xmux.xp.S1 CKHB3_N cml_tlatch_72.xtail.S1 VSS sg13_lv_nmos ad=89.3f pd=0.85u as=89.3f ps=0.85u w=0.47u l=0.16u
X3445 stub_bi_15.BOTN stub_bi_15.BOTP cml_tlatch_11.xmux.xp.S1 VSS sg13_lv_nmos ad=56.9f pd=0.74u as=56.9f ps=0.74u w=0.17u l=0.17u
X3446 MOT17_N B2_8_P cml_tlatch_77.xmux.xn.S1 VSS sg13_lv_nmos ad=63.19999f pd=0.74u as=63.19999f ps=0.74u w=0.26u l=0.38u
X3447 cml_tlatch_51.xtail.S1 CKB3_N cml_tlatch_51.xmux.xp.S1 VSS sg13_lv_nmos ad=89.3f pd=0.85u as=89.3f ps=0.85u w=0.47u l=0.16u
X3448 cml_tlatch_87.xmux.xp.S1 cml_tlatch_87.OUTP cml_tlatch_87.OUTN VSS sg13_lv_nmos ad=56.9f pd=0.74u as=56.9f ps=0.74u w=0.17u l=0.17u
X3449 cml_tlatch_73.INN cml_tlatch_73.INP cml_tlatch_66.xmux.xp.S1 VSS sg13_lv_nmos ad=56.9f pd=0.74u as=56.9f ps=0.74u w=0.17u l=0.17u
X3450 GB2_P CKA2_N cml_gate2_7.xrtail.R1 VSS sg13_lv_nmos ad=0.1007p pd=0.91u as=0.1007p ps=0.91u w=0.53u l=0.13u
X3451 A2_2_P cml_tlatch_61.OUTN cml_tlatch_60.xmux.xn.S1 VSS sg13_lv_nmos ad=0.1082p pd=1.34u as=63.19999f ps=0.74u w=0.26u l=0.38u
X3452 cml_tlatch_87.xmux.xp.S1 cml_tlatch_87.OUTN cml_tlatch_87.OUTP VSS sg13_lv_nmos ad=56.9f pd=0.74u as=56.9f ps=0.74u w=0.17u l=0.17u
X3453 cml_tlatch_43.xmux.xn.S1 CKHA1_P cml_tlatch_43.xtail.S1 VSS sg13_lv_nmos ad=89.3f pd=0.85u as=89.3f ps=0.85u w=0.47u l=0.16u
X3454 cml_tlatch_94.xmux.xp.S1 CKJ_P cml_tlatch_94.xtail.S1 VSS sg13_lv_nmos ad=89.3f pd=0.85u as=89.3f ps=0.85u w=0.47u l=0.16u
X3455 cml_tlatch_91.OUTP cml_tlatch_91.OUTN cml_tlatch_91.xmux.xp.S1 VSS sg13_lv_nmos ad=56.9f pd=0.74u as=56.9f ps=0.74u w=0.17u l=0.17u
X3456 cml_tlatch_90.xmux.xp.S1 stub_bi_55.BOTP stub_bi_55.BOTN VSS sg13_lv_nmos ad=56.9f pd=0.74u as=56.9f ps=0.74u w=0.17u l=0.17u
X3457 cml_tlatch_16.xmux.xn.S1 cml_tlatch_98.OUTP MOT5_N VSS sg13_lv_nmos ad=63.19999f pd=0.74u as=63.19999f ps=0.74u w=0.26u l=0.38u
X3458 MOT24_N MOT24_P cml_tlatch_62.xmux.xp.S1 VSS sg13_lv_nmos ad=56.9f pd=0.74u as=56.9f ps=0.74u w=0.17u l=0.17u
X3459 cml_tlatch_84.xmux.xn.S1 CKB2_P cml_tlatch_84.xtail.S1 VSS sg13_lv_nmos ad=89.3f pd=0.85u as=89.3f ps=0.85u w=0.47u l=0.16u
X3460 MOT25_N MOT25_P cml_tlatch_72.xmux.xp.S1 VSS sg13_lv_nmos ad=56.9f pd=0.74u as=56.9f ps=0.74u w=0.17u l=0.17u
X3461 cml_tlatch_30.xtail.S1 CKB0_P cml_tlatch_30.xmux.xn.S1 VSS sg13_lv_nmos ad=89.3f pd=0.85u as=89.3f ps=0.85u w=0.47u l=0.16u
X3462 cml_tlatch_16.xmux.xn.S1 cml_tlatch_98.OUTP MOT5_N VSS sg13_lv_nmos ad=63.19999f pd=0.74u as=63.19999f ps=0.74u w=0.26u l=0.38u
X3463 MOT0_P A0_8_N cml_tlatch_26.xmux.xn.S1 VSS sg13_lv_nmos ad=63.19999f pd=0.74u as=63.19999f ps=0.74u w=0.26u l=0.38u
X3464 cml_tlatch_29.xmux.xn.S1 CKHA0_P cml_tlatch_29.xtail.S1 VSS sg13_lv_nmos ad=89.3f pd=0.85u as=89.3f ps=0.85u w=0.47u l=0.16u
X3465 cml_tlatch_44.xtail.S1 CKHA3_P cml_tlatch_44.xmux.xn.S1 VSS sg13_lv_nmos ad=89.3f pd=0.85u as=89.3f ps=0.85u w=0.47u l=0.16u
X3466 CKHB2_N GB2_P cml_drvb_7.xrtail.R2 VSS sg13_lv_nmos ad=0.2618p pd=2.22u as=0.1463p ps=1.15u w=0.77u l=0.21u
X3467 CKB3_P hs_to_clk_5.sg13_lv_nmos_2HGZLP_0.G VSS rppd l=4.25u w=1u
X3468 cml_tlatch_99.xtail.S1 CKA0_N cml_tlatch_99.xmux.xn.S1 VSS sg13_lv_nmos ad=89.3f pd=0.85u as=89.3f ps=0.85u w=0.47u l=0.16u
X3469 cml_tlatch_42.xmux.xp.S1 MOT8_P MOT8_N VSS sg13_lv_nmos ad=56.9f pd=0.74u as=56.9f ps=0.74u w=0.17u l=0.17u
X3470 cml_tlatch_37.xmux.xn.S1 D1_P stub_bi_31.BOTP VSS sg13_lv_nmos ad=0.1082p pd=1.34u as=63.19999f ps=0.74u w=0.26u l=0.38u
X3471 cml_gate2_4.xrtail.R1 CKB3_P cml_gate2_4.xamp.xn.S1 VSS sg13_lv_nmos ad=0.1007p pd=0.91u as=0.1007p ps=0.91u w=0.53u l=0.13u
X3472 cml_tlatch_85.xmux.xp.S1 A2_8_P A2_8_N VSS sg13_lv_nmos ad=56.9f pd=0.74u as=56.9f ps=0.74u w=0.17u l=0.17u
X3473 VDD A3_8_P VSS rppd l=5.17u w=1u
X3474 CLK_W_N CLK_W_P cml_tlatch_93.xmux.xp.S1 VSS sg13_lv_nmos ad=56.9f pd=0.74u as=56.9f ps=0.74u w=0.17u l=0.17u
X3475 cml_tlatch_51.xmux.xp.S1 cml_tlatch_51.OUTN cml_tlatch_51.OUTP VSS sg13_lv_nmos ad=56.9f pd=0.74u as=56.9f ps=0.74u w=0.17u l=0.17u
X3476 cml_tlatch_32.xmux.xn.S1 D0_P cml_tlatch_32.OUTN VSS sg13_lv_nmos ad=63.19999f pd=0.74u as=63.19999f ps=0.74u w=0.26u l=0.38u
X3477 MOT23_N MOT23_P cml_tlatch_80.xmux.xp.S1 VSS sg13_lv_nmos ad=56.9f pd=0.74u as=56.9f ps=0.74u w=0.17u l=0.17u
X3478 MOT6_P A0_2_N cml_tlatch_29.xmux.xn.S1 VSS sg13_lv_nmos ad=63.19999f pd=0.74u as=63.19999f ps=0.74u w=0.26u l=0.38u
X3479 cml_tlatch_75.xmux.xp.S1 MOT31_P MOT31_N VSS sg13_lv_nmos ad=56.9f pd=0.74u as=56.9f ps=0.74u w=0.17u l=0.17u
X3480 cml_tlatch_35.xmux.xn.S1 CKB1_P cml_tlatch_35.xtail.S1 VSS sg13_lv_nmos ad=89.3f pd=0.85u as=89.3f ps=0.85u w=0.47u l=0.16u
X3481 cml_tlatch_2.xtail.S1 CKB0_N cml_tlatch_2.xmux.xp.S1 VSS sg13_lv_nmos ad=89.3f pd=0.85u as=89.3f ps=0.85u w=0.47u l=0.16u
X3482 cml_tlatch_5.xtail.S1 CKHB1_N cml_tlatch_5.xmux.xp.S1 VSS sg13_lv_nmos ad=89.3f pd=0.85u as=89.3f ps=0.85u w=0.47u l=0.16u
X3483 cml_tlatch_59.xmux.xp.S1 cml_tlatch_91.INN cml_tlatch_91.INP VSS sg13_lv_nmos ad=56.9f pd=0.74u as=56.9f ps=0.74u w=0.17u l=0.17u
X3484 cml_tlatch_31.xtail.S1 CKB0_N cml_tlatch_31.xmux.xn.S1 VSS sg13_lv_nmos ad=89.3f pd=0.85u as=89.3f ps=0.85u w=0.47u l=0.16u
X3485 cml_tlatch_22.xmux.xp.S1 cml_tlatch_22.OUTP cml_tlatch_22.OUTN VSS sg13_lv_nmos ad=56.9f pd=0.74u as=56.9f ps=0.74u w=0.17u l=0.17u
X3486 cml_tlatch_32.xmux.xn.S1 D0_P cml_tlatch_32.OUTN VSS sg13_lv_nmos ad=63.19999f pd=0.74u as=63.19999f ps=0.74u w=0.26u l=0.38u
X3487 MOT25_N VDD VSS rppd l=5.17u w=1u
X3488 cml_tlatch_70.xmux.xp.S1 CKA3_P cml_tlatch_70.xtail.S1 VSS sg13_lv_nmos ad=0.1598p pd=1.62u as=89.3f ps=0.85u w=0.47u l=0.16u
X3489 cml_tlatch_51.xmux.xp.S1 cml_tlatch_51.OUTN cml_tlatch_51.OUTP VSS sg13_lv_nmos ad=0.1019p pd=1.34u as=56.9f ps=0.74u w=0.17u l=0.17u
X3490 cml_tlatch_9.xtail.S1 CKA0_P cml_tlatch_9.xmux.xp.S1 VSS sg13_lv_nmos ad=89.3f pd=0.85u as=89.3f ps=0.85u w=0.47u l=0.16u
X3491 cml_tlatch_97.xtail.S1 CKA1_P cml_tlatch_97.xmux.xp.S1 VSS sg13_lv_nmos ad=89.3f pd=0.85u as=89.3f ps=0.85u w=0.47u l=0.16u
X3492 MOT23_P MOT23_N cml_tlatch_80.xmux.xp.S1 VSS sg13_lv_nmos ad=56.9f pd=0.74u as=56.9f ps=0.74u w=0.17u l=0.17u
X3493 cml_tlatch_0.OUTN cml_tlatch_0.OUTP cml_tlatch_0.xmux.xp.S1 VSS sg13_lv_nmos ad=56.9f pd=0.74u as=56.9f ps=0.74u w=0.17u l=0.17u
X3494 cml_tlatch_22.xmux.xp.S1 cml_tlatch_22.OUTP cml_tlatch_22.OUTN VSS sg13_lv_nmos ad=56.9f pd=0.74u as=56.9f ps=0.74u w=0.17u l=0.17u
X3495 CLK_W_P J2_P cml_tlatch_93.xmux.xn.S1 VSS sg13_lv_nmos ad=63.19999f pd=0.74u as=63.19999f ps=0.74u w=0.26u l=0.38u
X3496 VSS POLN cml_tlatch_42.xtail.S1 VSS sg13_lv_nmos ad=1.5637p pd=8.61u as=1.5637p ps=8.61u w=8.23u l=0.13u
X3497 stub_bi_31.BOTN stub_bi_31.BOTP cml_tlatch_37.xmux.xp.S1 VSS sg13_lv_nmos ad=56.9f pd=0.74u as=56.9f ps=0.74u w=0.17u l=0.17u
X3498 ENB_P J2_N cml_gate2_8.xamp.xn.S1 VSS sg13_lv_nmos ad=0.1007p pd=0.91u as=0.1007p ps=0.91u w=0.53u l=0.13u
X3499 cml_tlatch_0.xmux.xp.S1 CKA0_N cml_tlatch_0.xtail.S1 VSS sg13_lv_nmos ad=89.3f pd=0.85u as=89.3f ps=0.85u w=0.47u l=0.16u
X3500 cml_tlatch_41.xmux.xp.S1 cml_tlatch_41.OUTP cml_tlatch_41.OUTN VSS sg13_lv_nmos ad=56.9f pd=0.74u as=56.9f ps=0.74u w=0.17u l=0.17u
X3501 cml_tlatch_63.xmux.xp.S1 CKHA3_N cml_tlatch_63.xtail.S1 VSS sg13_lv_nmos ad=89.3f pd=0.85u as=89.3f ps=0.85u w=0.47u l=0.16u
X3502 GB3_N ENB0_P cml_gate2_6.xamp.xn.S1 VSS sg13_lv_nmos ad=0.1007p pd=0.91u as=0.1007p ps=0.91u w=0.53u l=0.13u
X3503 cml_tlatch_23.OUTP cml_tlatch_23.OUTN cml_tlatch_23.xmux.xp.S1 VSS sg13_lv_nmos ad=56.9f pd=0.74u as=56.9f ps=0.74u w=0.17u l=0.17u
X3504 MOT9_N MOT9_P cml_tlatch_3.xmux.xp.S1 VSS sg13_lv_nmos ad=56.9f pd=0.74u as=56.9f ps=0.74u w=0.17u l=0.17u
X3505 B1_2_N B1_2_P cml_tlatch_36.xmux.xp.S1 VSS sg13_lv_nmos ad=56.9f pd=0.74u as=56.9f ps=0.74u w=0.17u l=0.17u
X3506 VDD A3_2_P VSS rppd l=5.17u w=1u
X3507 cml_tlatch_49.xmux.xp.S1 cml_tlatch_49.OUTP cml_tlatch_49.OUTN VSS sg13_lv_nmos ad=56.9f pd=0.74u as=56.9f ps=0.74u w=0.17u l=0.17u
X3508 cml_tlatch_51.xtail.S1 CKB3_P cml_tlatch_51.xmux.xn.S1 VSS sg13_lv_nmos ad=89.3f pd=0.85u as=89.3f ps=0.85u w=0.47u l=0.16u
X3509 B2_8_P B2_8_N cml_tlatch_81.xmux.xp.S1 VSS sg13_lv_nmos ad=56.9f pd=0.74u as=56.9f ps=0.74u w=0.17u l=0.17u
X3510 cml_tlatch_72.xmux.xp.S1 MOT25_N MOT25_P VSS sg13_lv_nmos ad=56.9f pd=0.74u as=56.9f ps=0.74u w=0.17u l=0.17u
X3511 cml_tlatch_10.xtail.S1 CKB1_P cml_tlatch_10.xmux.xp.S1 VSS sg13_lv_nmos ad=89.3f pd=0.85u as=89.3f ps=0.85u w=0.47u l=0.16u
X3512 cml_tlatch_87.xmux.xp.S1 cml_tlatch_87.OUTP cml_tlatch_87.OUTN VSS sg13_lv_nmos ad=56.9f pd=0.74u as=56.9f ps=0.74u w=0.17u l=0.17u
X3513 cml_tlatch_26.xtail.S1 CKHA0_N cml_tlatch_26.xmux.xp.S1 VSS sg13_lv_nmos ad=89.3f pd=0.85u as=89.3f ps=0.85u w=0.47u l=0.16u
X3514 cml_tlatch_1.xmux.xn.S1 cml_tlatch_2.OUTN B0_8_P VSS sg13_lv_nmos ad=63.19999f pd=0.74u as=63.19999f ps=0.74u w=0.26u l=0.38u
X3515 MOT5_N MOT5_P cml_tlatch_16.xmux.xp.S1 VSS sg13_lv_nmos ad=56.9f pd=0.74u as=56.9f ps=0.74u w=0.17u l=0.17u
X3516 cml_tlatch_97.INP A1_2_N cml_tlatch_39.xmux.xn.S1 VSS sg13_lv_nmos ad=63.19999f pd=0.74u as=63.19999f ps=0.74u w=0.26u l=0.38u
X3517 stub_bi_63.BOTN stub_bi_63.BOTP cml_tlatch_83.xmux.xp.S1 VSS sg13_lv_nmos ad=56.9f pd=0.74u as=56.9f ps=0.74u w=0.17u l=0.17u
X3518 MOT8_P MOT8_N cml_tlatch_42.xmux.xp.S1 VSS sg13_lv_nmos ad=56.9f pd=0.74u as=56.9f ps=0.74u w=0.17u l=0.17u
X3519 MOT1_P B0_8_N cml_tlatch_14.xmux.xn.S1 VSS sg13_lv_nmos ad=0.1082p pd=1.34u as=63.19999f ps=0.74u w=0.26u l=0.38u
X3520 MOT11_P MOT11_N cml_tlatch_4.xmux.xp.S1 VSS sg13_lv_nmos ad=56.9f pd=0.74u as=56.9f ps=0.74u w=0.17u l=0.17u
X3521 cml_tlatch_84.xmux.xp.S1 CKB2_N cml_tlatch_84.xtail.S1 VSS sg13_lv_nmos ad=89.3f pd=0.85u as=89.3f ps=0.85u w=0.47u l=0.16u
X3522 cml_tlatch_81.xmux.xn.S1 stub_bi_62.BOTP B2_8_P VSS sg13_lv_nmos ad=0.1082p pd=1.34u as=63.19999f ps=0.74u w=0.26u l=0.38u
X3523 cml_tlatch_71.xmux.xp.S1 CKA3_N cml_tlatch_71.xtail.S1 VSS sg13_lv_nmos ad=89.3f pd=0.85u as=89.3f ps=0.85u w=0.47u l=0.16u
X3524 cml_tlatch_97.xmux.xp.S1 cml_tlatch_24.INN cml_tlatch_24.INP VSS sg13_lv_nmos ad=56.9f pd=0.74u as=56.9f ps=0.74u w=0.17u l=0.17u
X3525 cml_tlatch_69.OUTN cml_tlatch_69.OUTP cml_tlatch_69.xmux.xp.S1 VSS sg13_lv_nmos ad=56.9f pd=0.74u as=56.9f ps=0.74u w=0.17u l=0.17u
X3526 cml_tlatch_33.xmux.xp.S1 cml_tlatch_33.OUTN cml_tlatch_33.OUTP VSS sg13_lv_nmos ad=56.9f pd=0.74u as=56.9f ps=0.74u w=0.17u l=0.17u
X3527 cml_tlatch_37.xtail.S1 CKB1_P cml_tlatch_37.xmux.xn.S1 VSS sg13_lv_nmos ad=89.3f pd=0.85u as=0.1598p ps=1.62u w=0.47u l=0.16u
X3528 MOT31_P MOT31_N cml_tlatch_75.xmux.xp.S1 VSS sg13_lv_nmos ad=56.9f pd=0.74u as=56.9f ps=0.74u w=0.17u l=0.17u
X3529 VSS hs_to_clk_6.sg13_lv_nmos_2HGZLP_0.G VSS VSS sg13_lv_nmos ad=2.071p pd=11.28u as=0 ps=0 w=10.9u l=1.38u
X3530 cml_tlatch_39.xmux.xp.S1 CKA1_N cml_tlatch_39.xtail.S1 VSS sg13_lv_nmos ad=89.3f pd=0.85u as=89.3f ps=0.85u w=0.47u l=0.16u
X3531 cml_tlatch_22.OUTP cml_tlatch_22.OUTN cml_tlatch_22.xmux.xp.S1 VSS sg13_lv_nmos ad=56.9f pd=0.74u as=56.9f ps=0.74u w=0.17u l=0.17u
X3532 stub_bi_62.BOTN stub_bi_62.BOTP cml_tlatch_82.xmux.xp.S1 VSS sg13_lv_nmos ad=56.9f pd=0.74u as=56.9f ps=0.74u w=0.17u l=0.17u
X3533 cml_tlatch_24.INN cml_tlatch_24.INP cml_tlatch_97.xmux.xp.S1 VSS sg13_lv_nmos ad=56.9f pd=0.74u as=56.9f ps=0.74u w=0.17u l=0.17u
X3534 ENA_P NM1_N cml_gate2_9.xrtail.R1 VSS sg13_lv_nmos ad=0.1007p pd=0.91u as=0.1007p ps=0.91u w=0.53u l=0.13u
X3535 MOT24_P MOT24_N cml_tlatch_62.xmux.xp.S1 VSS sg13_lv_nmos ad=56.9f pd=0.74u as=56.9f ps=0.74u w=0.17u l=0.17u
X3536 MOT20_P cml_tlatch_91.OUTN cml_tlatch_54.xmux.xn.S1 VSS sg13_lv_nmos ad=0.1082p pd=1.34u as=63.19999f ps=0.74u w=0.26u l=0.38u
X3537 cml_tlatch_96.xmux.xp.S1 cml_tlatch_5.INP cml_tlatch_5.INN VSS sg13_lv_nmos ad=56.9f pd=0.74u as=56.9f ps=0.74u w=0.17u l=0.17u
X3538 MOT27_P MOT27_N cml_tlatch_73.xmux.xp.S1 VSS sg13_lv_nmos ad=56.9f pd=0.74u as=56.9f ps=0.74u w=0.17u l=0.17u
X3539 stub_bi_55.BOTN stub_bi_38.BOTP cml_tlatch_90.xmux.xn.S1 VSS sg13_lv_nmos ad=63.19999f pd=0.74u as=63.19999f ps=0.74u w=0.26u l=0.38u
X3540 cml_tlatch_6.xmux.xp.S1 MOT15_N MOT15_P VSS sg13_lv_nmos ad=56.9f pd=0.74u as=56.9f ps=0.74u w=0.17u l=0.17u
X3541 cml_gate2_5.xrtail.R1 CKB2_P cml_gate2_5.xamp.xn.S1 VSS sg13_lv_nmos ad=0.1007p pd=0.91u as=0.1007p ps=0.91u w=0.53u l=0.13u
X3542 cml_tlatch_29.xmux.xp.S1 MOT6_P MOT6_N VSS sg13_lv_nmos ad=56.9f pd=0.74u as=56.9f ps=0.74u w=0.17u l=0.17u
X3543 cml_tlatch_85.xmux.xn.S1 CKA2_N cml_tlatch_85.xtail.S1 VSS sg13_lv_nmos ad=89.3f pd=0.85u as=89.3f ps=0.85u w=0.47u l=0.16u
X3544 cml_tlatch_24.xtail.S1 CKHA1_N cml_tlatch_24.xmux.xp.S1 VSS sg13_lv_nmos ad=89.3f pd=0.85u as=89.3f ps=0.85u w=0.47u l=0.16u
X3545 cml_tlatch_62.xtail.S1 CKHA3_P cml_tlatch_62.xmux.xn.S1 VSS sg13_lv_nmos ad=89.3f pd=0.85u as=0.1598p ps=1.62u w=0.47u l=0.16u
X3546 VSS POLN cml_tlatch_30.xtail.S1 VSS sg13_lv_nmos ad=2.7982p pd=17.14u as=1.5637p ps=8.61u w=8.23u l=0.13u
X3547 VSS POLN cml_tlatch_94.xtail.S1 VSS sg13_lv_nmos ad=1.5637p pd=8.61u as=1.5637p ps=8.61u w=8.23u l=0.13u
X3548 cml_tlatch_6.xmux.xp.S1 CKHB1_N cml_tlatch_6.xtail.S1 VSS sg13_lv_nmos ad=89.3f pd=0.85u as=89.3f ps=0.85u w=0.47u l=0.16u
X3549 cml_tlatch_35.xmux.xp.S1 CKB1_N cml_tlatch_35.xtail.S1 VSS sg13_lv_nmos ad=89.3f pd=0.85u as=89.3f ps=0.85u w=0.47u l=0.16u
X3550 cml_tlatch_94.xtail.S1 CKJ_P cml_tlatch_94.xmux.xp.S1 VSS sg13_lv_nmos ad=89.3f pd=0.85u as=89.3f ps=0.85u w=0.47u l=0.16u
X3551 cml_tlatch_18.xmux.xn.S1 cml_tlatch_23.OUTP cml_tlatch_18.OUTN VSS sg13_lv_nmos ad=63.19999f pd=0.74u as=63.19999f ps=0.74u w=0.26u l=0.38u
X3552 MOT23_N B2_2_P cml_tlatch_80.xmux.xn.S1 VSS sg13_lv_nmos ad=63.19999f pd=0.74u as=0.1082p ps=1.34u w=0.26u l=0.38u
X3553 cml_tlatch_20.xmux.xp.S1 cml_tlatch_20.OUTP cml_tlatch_20.OUTN VSS sg13_lv_nmos ad=56.9f pd=0.74u as=56.9f ps=0.74u w=0.17u l=0.17u
X3554 cml_tlatch_71.OUTP cml_tlatch_71.OUTN cml_tlatch_71.xmux.xp.S1 VSS sg13_lv_nmos ad=56.9f pd=0.74u as=56.9f ps=0.74u w=0.17u l=0.17u
X3555 cml_tlatch_0.OUTN cml_tlatch_0.OUTP cml_tlatch_0.xmux.xp.S1 VSS sg13_lv_nmos ad=56.9f pd=0.74u as=56.9f ps=0.74u w=0.17u l=0.17u
X3556 cml_tlatch_26.xtail.S1 POLN VSS VSS sg13_lv_nmos ad=1.5637p pd=8.61u as=1.5637p ps=8.61u w=8.23u l=0.13u
X3557 cml_tlatch_60.xmux.xp.S1 A2_2_P A2_2_N VSS sg13_lv_nmos ad=56.9f pd=0.74u as=56.9f ps=0.74u w=0.17u l=0.17u
X3558 cml_tlatch_58.OUTN cml_tlatch_58.OUTP cml_tlatch_58.xmux.xp.S1 VSS sg13_lv_nmos ad=56.9f pd=0.74u as=56.9f ps=0.74u w=0.17u l=0.17u
X3559 A1_8_N A1_8_P cml_tlatch_19.xmux.xp.S1 VSS sg13_lv_nmos ad=56.9f pd=0.74u as=56.9f ps=0.74u w=0.17u l=0.17u
X3560 cml_tlatch_92.xmux.xn.S1 CKJ_N cml_tlatch_92.xtail.S1 VSS sg13_lv_nmos ad=89.3f pd=0.85u as=89.3f ps=0.85u w=0.47u l=0.16u
X3561 cml_tlatch_98.xmux.xp.S1 cml_tlatch_98.OUTN cml_tlatch_98.OUTP VSS sg13_lv_nmos ad=56.9f pd=0.74u as=56.9f ps=0.74u w=0.17u l=0.17u
X3562 cml_tlatch_36.xmux.xp.S1 B1_2_N B1_2_P VSS sg13_lv_nmos ad=56.9f pd=0.74u as=56.9f ps=0.74u w=0.17u l=0.17u
X3563 cml_tlatch_21.xtail.S1 CKA1_N cml_tlatch_21.xmux.xn.S1 VSS sg13_lv_nmos ad=89.3f pd=0.85u as=89.3f ps=0.85u w=0.47u l=0.16u
X3564 B3_8_N cml_tlatch_65.OUTP cml_tlatch_64.xmux.xn.S1 VSS sg13_lv_nmos ad=63.19999f pd=0.74u as=63.19999f ps=0.74u w=0.26u l=0.38u
X3565 cml_tlatch_41.OUTP D1_N cml_tlatch_41.xmux.xn.S1 VSS sg13_lv_nmos ad=63.19999f pd=0.74u as=63.19999f ps=0.74u w=0.26u l=0.38u
X3566 VDD cml_tlatch_38.OUTP VSS rppd l=5.17u w=1u
X3567 MOT2_P MOT2_N cml_tlatch_27.xmux.xp.S1 VSS sg13_lv_nmos ad=56.9f pd=0.74u as=56.9f ps=0.74u w=0.17u l=0.17u
X3568 stub_bi_31.BOTP stub_bi_31.BOTN cml_tlatch_37.xmux.xp.S1 VSS sg13_lv_nmos ad=56.9f pd=0.74u as=56.9f ps=0.74u w=0.17u l=0.17u
X3569 cml_tlatch_83.xmux.xn.S1 stub_bi_49.BOTP stub_bi_63.BOTN VSS sg13_lv_nmos ad=63.19999f pd=0.74u as=63.19999f ps=0.74u w=0.26u l=0.38u
X3570 cml_tlatch_22.xmux.xn.S1 CKA1_P cml_tlatch_22.xtail.S1 VSS sg13_lv_nmos ad=89.3f pd=0.85u as=89.3f ps=0.85u w=0.47u l=0.16u
X3571 ENB0_P ENB_N cml_drv_2.xrtail.R1 VSS sg13_lv_nmos ad=56.2f pd=0.74u as=56.2f ps=0.74u w=0.16u l=0.19u
X3572 cml_tlatch_44.INP cml_tlatch_44.INN cml_tlatch_89.xmux.xp.S1 VSS sg13_lv_nmos ad=56.9f pd=0.74u as=56.9f ps=0.74u w=0.17u l=0.17u
X3573 A0_8_P A0_8_N cml_tlatch_9.xmux.xp.S1 VSS sg13_lv_nmos ad=56.9f pd=0.74u as=56.9f ps=0.74u w=0.17u l=0.17u
X3574 cml_tlatch_97.INP cml_tlatch_97.INN cml_tlatch_39.xmux.xp.S1 VSS sg13_lv_nmos ad=56.9f pd=0.74u as=56.9f ps=0.74u w=0.17u l=0.17u
X3575 cml_tlatch_9.xmux.xp.S1 A0_8_P A0_8_N VSS sg13_lv_nmos ad=56.9f pd=0.74u as=56.9f ps=0.74u w=0.17u l=0.17u
X3576 cml_tlatch_98.xmux.xp.S1 CKB0_P cml_tlatch_98.xtail.S1 VSS sg13_lv_nmos ad=89.3f pd=0.85u as=89.3f ps=0.85u w=0.47u l=0.16u
X3577 cml_tlatch_22.xmux.xp.S1 cml_tlatch_22.OUTN cml_tlatch_22.OUTP VSS sg13_lv_nmos ad=0.1019p pd=1.34u as=56.9f ps=0.74u w=0.17u l=0.17u
X3578 cml_tlatch_54.xtail.S1 CKHA2_N cml_tlatch_54.xmux.xp.S1 VSS sg13_lv_nmos ad=89.3f pd=0.85u as=89.3f ps=0.85u w=0.47u l=0.16u
X3579 cml_tlatch_76.xmux.xn.S1 CKA2_P cml_tlatch_76.xtail.S1 VSS sg13_lv_nmos ad=0.1598p pd=1.62u as=89.3f ps=0.85u w=0.47u l=0.16u
X3580 cml_gate2_1.xrtail.R1 CKA0_N GB0_P VSS sg13_lv_nmos ad=0.1007p pd=0.91u as=0.1007p ps=0.91u w=0.53u l=0.13u
X3581 cml_tlatch_4.INN stub_bi_17.BOTN cml_tlatch_12.xmux.xn.S1 VSS sg13_lv_nmos ad=63.19999f pd=0.74u as=63.19999f ps=0.74u w=0.26u l=0.38u
X3582 cml_tlatch_68.xmux.xp.S1 CKA3_P cml_tlatch_68.xtail.S1 VSS sg13_lv_nmos ad=89.3f pd=0.85u as=89.3f ps=0.85u w=0.47u l=0.16u
X3583 cml_tlatch_19.xmux.xp.S1 A1_8_N A1_8_P VSS sg13_lv_nmos ad=56.9f pd=0.74u as=56.9f ps=0.74u w=0.17u l=0.17u
X3584 B2_8_P B2_8_N cml_tlatch_81.xmux.xp.S1 VSS sg13_lv_nmos ad=56.9f pd=0.74u as=56.9f ps=0.74u w=0.17u l=0.17u
X3585 cml_tlatch_30.OUTP B0_2_N cml_tlatch_30.xmux.xn.S1 VSS sg13_lv_nmos ad=63.19999f pd=0.74u as=63.19999f ps=0.74u w=0.26u l=0.38u
X3586 cml_tlatch_65.xtail.S1 CKB3_N cml_tlatch_65.xmux.xp.S1 VSS sg13_lv_nmos ad=89.3f pd=0.85u as=89.3f ps=0.85u w=0.47u l=0.16u
X3587 stub_bi_43.BOTN stub_bi_43.BOTP cml_tlatch_48.xmux.xp.S1 VSS sg13_lv_nmos ad=56.9f pd=0.74u as=56.9f ps=0.74u w=0.17u l=0.17u
X3588 MOT6_P MOT6_N cml_tlatch_29.xmux.xp.S1 VSS sg13_lv_nmos ad=56.9f pd=0.74u as=56.9f ps=0.74u w=0.17u l=0.17u
X3589 cml_tlatch_90.xmux.xn.S1 CKB2_N cml_tlatch_90.xtail.S1 VSS sg13_lv_nmos ad=89.3f pd=0.85u as=89.3f ps=0.85u w=0.47u l=0.16u
X3590 MOT31_P MOT31_N cml_tlatch_75.xmux.xp.S1 VSS sg13_lv_nmos ad=56.9f pd=0.74u as=0.1019p ps=1.34u w=0.17u l=0.17u
X3591 cml_tlatch_92.xmux.xn.S1 CLK_W_P J4_P VSS sg13_lv_nmos ad=63.19999f pd=0.74u as=63.19999f ps=0.74u w=0.26u l=0.38u
X3592 MOT22_N MOT22_P cml_tlatch_55.xmux.xp.S1 VSS sg13_lv_nmos ad=56.9f pd=0.74u as=56.9f ps=0.74u w=0.17u l=0.17u
X3593 cml_tlatch_18.xmux.xp.S1 cml_tlatch_18.OUTP cml_tlatch_18.OUTN VSS sg13_lv_nmos ad=56.9f pd=0.74u as=56.9f ps=0.74u w=0.17u l=0.17u
X3594 cml_tlatch_44.INN cml_tlatch_56.OUTP cml_tlatch_89.xmux.xn.S1 VSS sg13_lv_nmos ad=63.19999f pd=0.74u as=63.19999f ps=0.74u w=0.26u l=0.38u
X3595 cml_tlatch_69.xmux.xp.S1 cml_tlatch_69.OUTN cml_tlatch_69.OUTP VSS sg13_lv_nmos ad=56.9f pd=0.74u as=56.9f ps=0.74u w=0.17u l=0.17u
X3596 cml_tlatch_60.xmux.xn.S1 CKA2_N cml_tlatch_60.xtail.S1 VSS sg13_lv_nmos ad=89.3f pd=0.85u as=89.3f ps=0.85u w=0.47u l=0.16u
X3597 cml_tlatch_43.xmux.xn.S1 CKHA1_P cml_tlatch_43.xtail.S1 VSS sg13_lv_nmos ad=89.3f pd=0.85u as=89.3f ps=0.85u w=0.47u l=0.16u
X3598 cml_tlatch_41.xtail.S1 CKA1_N cml_tlatch_41.xmux.xp.S1 VSS sg13_lv_nmos ad=89.3f pd=0.85u as=89.3f ps=0.85u w=0.47u l=0.16u
X3599 cml_tlatch_50.xmux.xn.S1 cml_tlatch_51.OUTN B3_2_P VSS sg13_lv_nmos ad=63.19999f pd=0.74u as=63.19999f ps=0.74u w=0.26u l=0.38u
X3600 cml_tlatch_64.xmux.xp.S1 CKB3_P cml_tlatch_64.xtail.S1 VSS sg13_lv_nmos ad=89.3f pd=0.85u as=89.3f ps=0.85u w=0.47u l=0.16u
X3601 cml_tlatch_29.xmux.xn.S1 CKHA0_P cml_tlatch_29.xtail.S1 VSS sg13_lv_nmos ad=89.3f pd=0.85u as=89.3f ps=0.85u w=0.47u l=0.16u
X3602 cml_tlatch_78.xmux.xp.S1 MOT19_P MOT19_N VSS sg13_lv_nmos ad=56.9f pd=0.74u as=56.9f ps=0.74u w=0.17u l=0.17u
X3603 cml_tlatch_98.OUTN cml_tlatch_98.OUTP cml_tlatch_98.xmux.xp.S1 VSS sg13_lv_nmos ad=56.9f pd=0.74u as=56.9f ps=0.74u w=0.17u l=0.17u
X3604 cml_tlatch_20.OUTP cml_tlatch_20.OUTN cml_tlatch_20.xmux.xp.S1 VSS sg13_lv_nmos ad=56.9f pd=0.74u as=56.9f ps=0.74u w=0.17u l=0.17u
X3605 VSS hs_to_clk_1.sg13_lv_nmos_2HGZLP_0.G VSS VSS sg13_lv_nmos ad=2.071p pd=11.28u as=0 ps=0 w=10.9u l=1.38u
X3606 cml_tlatch_7.xtail.S1 POLN VSS VSS sg13_lv_nmos ad=1.5637p pd=8.61u as=2.7982p ps=17.14u w=8.23u l=0.13u
X3607 cml_tlatch_51.OUTP D3_N cml_tlatch_51.xmux.xn.S1 VSS sg13_lv_nmos ad=63.19999f pd=0.74u as=63.19999f ps=0.74u w=0.26u l=0.38u
X3608 cml_tlatch_66.xmux.xp.S1 cml_tlatch_73.INN cml_tlatch_73.INP VSS sg13_lv_nmos ad=56.9f pd=0.74u as=56.9f ps=0.74u w=0.17u l=0.17u
X3609 cml_tlatch_34.xmux.xp.S1 CKA0_P cml_tlatch_34.xtail.S1 VSS sg13_lv_nmos ad=89.3f pd=0.85u as=89.3f ps=0.85u w=0.47u l=0.16u
X3610 cml_tlatch_3.xmux.xp.S1 CKHB1_N cml_tlatch_3.xtail.S1 VSS sg13_lv_nmos ad=89.3f pd=0.85u as=89.3f ps=0.85u w=0.47u l=0.16u
X3611 cml_tlatch_38.xtail.S1 POLN VSS VSS sg13_lv_nmos ad=1.5637p pd=8.61u as=2.7982p ps=17.14u w=8.23u l=0.13u
X3612 cml_tlatch_17.xmux.xn.S1 CKHB0_P cml_tlatch_17.xtail.S1 VSS sg13_lv_nmos ad=89.3f pd=0.85u as=89.3f ps=0.85u w=0.47u l=0.16u
X3613 cml_tlatch_43.xmux.xp.S1 MOT10_P MOT10_N VSS sg13_lv_nmos ad=56.9f pd=0.74u as=56.9f ps=0.74u w=0.17u l=0.17u
X3614 cml_tlatch_37.xtail.S1 CKB1_N cml_tlatch_37.xmux.xp.S1 VSS sg13_lv_nmos ad=89.3f pd=0.85u as=89.3f ps=0.85u w=0.47u l=0.16u
X3615 A1_2_N cml_tlatch_41.OUTP cml_tlatch_40.xmux.xn.S1 VSS sg13_lv_nmos ad=63.19999f pd=0.74u as=63.19999f ps=0.74u w=0.26u l=0.38u
X3616 cml_tlatch_96.xmux.xp.S1 cml_tlatch_5.INP cml_tlatch_5.INN VSS sg13_lv_nmos ad=56.9f pd=0.74u as=56.9f ps=0.74u w=0.17u l=0.17u
X3617 stub_bi_38.BOTP stub_bi_38.BOTN cml_tlatch_46.xmux.xp.S1 VSS sg13_lv_nmos ad=56.9f pd=0.74u as=56.9f ps=0.74u w=0.17u l=0.17u
X3618 cml_tlatch_61.xtail.S1 CKA2_N cml_tlatch_61.xmux.xp.S1 VSS sg13_lv_nmos ad=89.3f pd=0.85u as=89.3f ps=0.85u w=0.47u l=0.16u
X3619 cml_gate2_6.xrtail.R1 CKA3_P cml_gate2_6.xamp.xn.S1 VSS sg13_lv_nmos ad=0.1007p pd=0.91u as=0.1007p ps=0.91u w=0.53u l=0.13u
X3620 cml_tlatch_28.xmux.xp.S1 MOT4_N MOT4_P VSS sg13_lv_nmos ad=56.9f pd=0.74u as=56.9f ps=0.74u w=0.17u l=0.17u
X3621 cml_tlatch_2.OUTP cml_tlatch_7.OUTN cml_tlatch_2.xmux.xn.S1 VSS sg13_lv_nmos ad=63.19999f pd=0.74u as=63.19999f ps=0.74u w=0.26u l=0.38u
X3622 cml_tlatch_29.xmux.xp.S1 MOT6_P MOT6_N VSS sg13_lv_nmos ad=56.9f pd=0.74u as=56.9f ps=0.74u w=0.17u l=0.17u
X3623 cml_tlatch_20.OUTP cml_tlatch_20.OUTN cml_tlatch_20.xmux.xp.S1 VSS sg13_lv_nmos ad=56.9f pd=0.74u as=56.9f ps=0.74u w=0.17u l=0.17u
X3624 cml_tlatch_60.xmux.xp.S1 CKA2_P cml_tlatch_60.xtail.S1 VSS sg13_lv_nmos ad=89.3f pd=0.85u as=0.1598p ps=1.62u w=0.47u l=0.16u
X3625 VSS hs_to_clk_0.sg13_lv_nmos_2HGZLP_0.G VSS VSS sg13_lv_nmos ad=2.071p pd=11.28u as=0 ps=0 w=10.9u l=1.38u
X3626 cml_tlatch_26.xmux.xp.S1 CKHA0_N cml_tlatch_26.xtail.S1 VSS sg13_lv_nmos ad=89.3f pd=0.85u as=0.1598p ps=1.62u w=0.47u l=0.16u
X3627 cml_tlatch_64.xmux.xp.S1 B3_8_P B3_8_N VSS sg13_lv_nmos ad=56.9f pd=0.74u as=56.9f ps=0.74u w=0.17u l=0.17u
X3628 cml_tlatch_84.xmux.xn.S1 stub_bi_55.BOTP stub_bi_49.BOTN VSS sg13_lv_nmos ad=63.19999f pd=0.74u as=63.19999f ps=0.74u w=0.26u l=0.38u
X3629 cml_tlatch_31.xtail.S1 CKB0_N cml_tlatch_31.xmux.xn.S1 VSS sg13_lv_nmos ad=89.3f pd=0.85u as=89.3f ps=0.85u w=0.47u l=0.16u
X3630 cml_tlatch_24.xtail.S1 CKHA1_P cml_tlatch_24.xmux.xn.S1 VSS sg13_lv_nmos ad=0.1598p pd=1.62u as=89.3f ps=0.85u w=0.47u l=0.16u
X3631 cml_tlatch_70.xmux.xp.S1 CKA3_P cml_tlatch_70.xtail.S1 VSS sg13_lv_nmos ad=89.3f pd=0.85u as=89.3f ps=0.85u w=0.47u l=0.16u
X3632 cml_tlatch_94.xtail.S1 CKJ_N cml_tlatch_94.xmux.xn.S1 VSS sg13_lv_nmos ad=89.3f pd=0.85u as=89.3f ps=0.85u w=0.47u l=0.16u
X3633 ENB_P VDD VSS rppd l=7.42u w=1u
X3634 cml_tlatch_23.xtail.S1 CKA0_N cml_tlatch_23.xmux.xn.S1 VSS sg13_lv_nmos ad=89.3f pd=0.85u as=89.3f ps=0.85u w=0.47u l=0.16u
X3635 B1_2_N VDD VSS rppd l=5.17u w=1u
X3636 cml_tlatch_77.xmux.xn.S1 B2_8_P MOT17_N VSS sg13_lv_nmos ad=63.19999f pd=0.74u as=63.19999f ps=0.74u w=0.26u l=0.38u
X3637 MOT7_P B0_2_N cml_tlatch_17.xmux.xn.S1 VSS sg13_lv_nmos ad=63.19999f pd=0.74u as=63.19999f ps=0.74u w=0.26u l=0.38u
X3638 cml_tlatch_2.xmux.xp.S1 cml_tlatch_2.OUTN cml_tlatch_2.OUTP VSS sg13_lv_nmos ad=56.9f pd=0.74u as=56.9f ps=0.74u w=0.17u l=0.17u
X3639 MOT10_N cml_tlatch_43.INP cml_tlatch_43.xmux.xn.S1 VSS sg13_lv_nmos ad=63.19999f pd=0.74u as=63.19999f ps=0.74u w=0.26u l=0.38u
X3640 cml_tlatch_74.xmux.xn.S1 CKHB3_P cml_tlatch_74.xtail.S1 VSS sg13_lv_nmos ad=89.3f pd=0.85u as=89.3f ps=0.85u w=0.47u l=0.16u
X3641 J2_N J2_P cml_tlatch_94.xmux.xp.S1 VSS sg13_lv_nmos ad=56.9f pd=0.74u as=56.9f ps=0.74u w=0.17u l=0.17u
X3642 J2_P J2_N cml_tlatch_94.xmux.xp.S1 VSS sg13_lv_nmos ad=56.9f pd=0.74u as=56.9f ps=0.74u w=0.17u l=0.17u
X3643 cml_tlatch_60.xmux.xp.S1 A2_2_P A2_2_N VSS sg13_lv_nmos ad=56.9f pd=0.74u as=56.9f ps=0.74u w=0.17u l=0.17u
X3644 cml_tlatch_73.INP cml_tlatch_73.INN cml_tlatch_66.xmux.xp.S1 VSS sg13_lv_nmos ad=56.9f pd=0.74u as=56.9f ps=0.74u w=0.17u l=0.17u
X3645 B2_2_N B2_2_P cml_tlatch_47.xmux.xp.S1 VSS sg13_lv_nmos ad=56.9f pd=0.74u as=56.9f ps=0.74u w=0.17u l=0.17u
X3646 cml_tlatch_26.xmux.xp.S1 MOT0_P MOT0_N VSS sg13_lv_nmos ad=56.9f pd=0.74u as=56.9f ps=0.74u w=0.17u l=0.17u
X3647 cml_tlatch_1.xmux.xp.S1 B0_8_N B0_8_P VSS sg13_lv_nmos ad=56.9f pd=0.74u as=56.9f ps=0.74u w=0.17u l=0.17u
X3648 cml_tlatch_49.xmux.xp.S1 cml_tlatch_49.OUTN cml_tlatch_49.OUTP VSS sg13_lv_nmos ad=56.9f pd=0.74u as=56.9f ps=0.74u w=0.17u l=0.17u
X3649 cml_tlatch_61.OUTP D2_N cml_tlatch_61.xmux.xn.S1 VSS sg13_lv_nmos ad=0.1082p pd=1.34u as=63.19999f ps=0.74u w=0.26u l=0.38u
X3650 cml_tlatch_58.xmux.xp.S1 cml_tlatch_58.OUTN cml_tlatch_58.OUTP VSS sg13_lv_nmos ad=56.9f pd=0.74u as=56.9f ps=0.74u w=0.17u l=0.17u
X3651 cml_tlatch_0.xmux.xp.S1 CKA0_N cml_tlatch_0.xtail.S1 VSS sg13_lv_nmos ad=89.3f pd=0.85u as=89.3f ps=0.85u w=0.47u l=0.16u
X3652 cml_tlatch_70.xmux.xp.S1 cml_tlatch_63.INP cml_tlatch_63.INN VSS sg13_lv_nmos ad=0.1019p pd=1.34u as=56.9f ps=0.74u w=0.17u l=0.17u
X3653 cml_tlatch_52.xmux.xp.S1 CKHA2_N cml_tlatch_52.xtail.S1 VSS sg13_lv_nmos ad=89.3f pd=0.85u as=89.3f ps=0.85u w=0.47u l=0.16u
X3654 MOT21_N MOT21_P cml_tlatch_79.xmux.xp.S1 VSS sg13_lv_nmos ad=56.9f pd=0.74u as=56.9f ps=0.74u w=0.17u l=0.17u
X3655 cml_tlatch_74.xmux.xp.S1 MOT29_P MOT29_N VSS sg13_lv_nmos ad=56.9f pd=0.74u as=56.9f ps=0.74u w=0.17u l=0.17u
X3656 cml_tlatch_0.xmux.xn.S1 CKA0_P cml_tlatch_0.xtail.S1 VSS sg13_lv_nmos ad=89.3f pd=0.85u as=89.3f ps=0.85u w=0.47u l=0.16u
X3657 cml_tlatch_87.INN cml_tlatch_87.INP cml_tlatch_76.xmux.xp.S1 VSS sg13_lv_nmos ad=56.9f pd=0.74u as=56.9f ps=0.74u w=0.17u l=0.17u
X3658 cml_tlatch_28.xtail.S1 POLN VSS VSS sg13_lv_nmos ad=1.5637p pd=8.61u as=1.5637p ps=8.61u w=8.23u l=0.13u
X3659 cml_tlatch_84.xmux.xp.S1 stub_bi_49.BOTN stub_bi_49.BOTP VSS sg13_lv_nmos ad=56.9f pd=0.74u as=56.9f ps=0.74u w=0.17u l=0.17u
X3660 cml_tlatch_41.OUTP cml_tlatch_41.OUTN cml_tlatch_41.xmux.xp.S1 VSS sg13_lv_nmos ad=56.9f pd=0.74u as=56.9f ps=0.74u w=0.17u l=0.17u
X3661 VSS POLN cml_tlatch_4.xtail.S1 VSS sg13_lv_nmos ad=2.7982p pd=17.14u as=1.5637p ps=8.61u w=8.23u l=0.13u
X3662 cml_tlatch_54.xtail.S1 POLN VSS VSS sg13_lv_nmos ad=1.5637p pd=8.61u as=1.5637p ps=8.61u w=8.23u l=0.13u
X3663 MOT7_N MOT7_P cml_tlatch_17.xmux.xp.S1 VSS sg13_lv_nmos ad=56.9f pd=0.74u as=56.9f ps=0.74u w=0.17u l=0.17u
X3664 cml_tlatch_12.xmux.xp.S1 cml_tlatch_4.INN cml_tlatch_4.INP VSS sg13_lv_nmos ad=56.9f pd=0.74u as=56.9f ps=0.74u w=0.17u l=0.17u
X3665 cml_tlatch_12.xmux.xp.S1 CKB1_P cml_tlatch_12.xtail.S1 VSS sg13_lv_nmos ad=89.3f pd=0.85u as=89.3f ps=0.85u w=0.47u l=0.16u
X3666 cml_tlatch_69.xmux.xp.S1 cml_tlatch_69.OUTN cml_tlatch_69.OUTP VSS sg13_lv_nmos ad=56.9f pd=0.74u as=56.9f ps=0.74u w=0.17u l=0.17u
X3667 cml_tlatch_18.xmux.xp.S1 cml_tlatch_18.OUTP cml_tlatch_18.OUTN VSS sg13_lv_nmos ad=0.1019p pd=1.34u as=56.9f ps=0.74u w=0.17u l=0.17u
X3668 cml_tlatch_65.OUTP cml_tlatch_65.OUTN cml_tlatch_65.xmux.xp.S1 VSS sg13_lv_nmos ad=56.9f pd=0.74u as=56.9f ps=0.74u w=0.17u l=0.17u
X3669 cml_tlatch_43.xmux.xp.S1 CKHA1_N cml_tlatch_43.xtail.S1 VSS sg13_lv_nmos ad=89.3f pd=0.85u as=89.3f ps=0.85u w=0.47u l=0.16u
X3670 cml_tlatch_41.OUTP cml_tlatch_41.OUTN cml_tlatch_41.xmux.xp.S1 VSS sg13_lv_nmos ad=56.9f pd=0.74u as=56.9f ps=0.74u w=0.17u l=0.17u
X3671 cml_tlatch_91.OUTN cml_tlatch_91.OUTP cml_tlatch_91.xmux.xp.S1 VSS sg13_lv_nmos ad=56.9f pd=0.74u as=56.9f ps=0.74u w=0.17u l=0.17u
X3672 cml_tlatch_14.xmux.xn.S1 CKHB0_P cml_tlatch_14.xtail.S1 VSS sg13_lv_nmos ad=89.3f pd=0.85u as=89.3f ps=0.85u w=0.47u l=0.16u
X3673 cml_tlatch_57.xtail.S1 CKA3_P cml_tlatch_57.xmux.xp.S1 VSS sg13_lv_nmos ad=89.3f pd=0.85u as=89.3f ps=0.85u w=0.47u l=0.16u
X3674 MOT29_N cml_tlatch_74.INP cml_tlatch_74.xmux.xn.S1 VSS sg13_lv_nmos ad=63.19999f pd=0.74u as=63.19999f ps=0.74u w=0.26u l=0.38u
X3675 cml_tlatch_46.xmux.xn.S1 B2_2_N stub_bi_38.BOTN VSS sg13_lv_nmos ad=63.19999f pd=0.74u as=0.1082p ps=1.34u w=0.26u l=0.38u
X3676 CKA0_N CK_N hs_to_clk_0.D2 VSS sg13_lv_nmos ad=0.408p pd=3.08u as=0.228p ps=1.58u w=1.2u l=0.2u
X3677 GB0_P ENB1_N cml_gate2_1.xamp.xn.S1 VSS sg13_lv_nmos ad=0.1802p pd=1.74u as=0.1007p ps=0.91u w=0.53u l=0.13u
X3678 cml_tlatch_84.xmux.xp.S1 CKB2_N cml_tlatch_84.xtail.S1 VSS sg13_lv_nmos ad=89.3f pd=0.85u as=89.3f ps=0.85u w=0.47u l=0.16u
X3679 cml_tlatch_22.OUTN cml_tlatch_24.INP cml_tlatch_22.xmux.xn.S1 VSS sg13_lv_nmos ad=63.19999f pd=0.74u as=0.1082p ps=1.34u w=0.26u l=0.38u
X3680 cml_tlatch_42.xmux.xn.S1 A1_8_P MOT8_N VSS sg13_lv_nmos ad=63.19999f pd=0.74u as=0.1082p ps=1.34u w=0.26u l=0.38u
X3681 stub_bi_15.BOTP cml_tlatch_4.INP cml_tlatch_11.xmux.xn.S1 VSS sg13_lv_nmos ad=63.19999f pd=0.74u as=63.19999f ps=0.74u w=0.26u l=0.38u
X3682 ENB1_P ENB_N cml_drv_0.xrtail.R1 VSS sg13_lv_nmos ad=56.2f pd=0.74u as=56.2f ps=0.74u w=0.16u l=0.19u
X3683 cml_tlatch_11.xmux.xp.S1 stub_bi_15.BOTP stub_bi_15.BOTN VSS sg13_lv_nmos ad=56.9f pd=0.74u as=56.9f ps=0.74u w=0.17u l=0.17u
X3684 cml_tlatch_94.xmux.xp.S1 J2_P J2_N VSS sg13_lv_nmos ad=56.9f pd=0.74u as=56.9f ps=0.74u w=0.17u l=0.17u
X3685 cml_tlatch_95.xmux.xp.S1 J1_N J1_P VSS sg13_lv_nmos ad=56.9f pd=0.74u as=56.9f ps=0.74u w=0.17u l=0.17u
X3686 cml_tlatch_66.xmux.xp.S1 cml_tlatch_73.INP cml_tlatch_73.INN VSS sg13_lv_nmos ad=56.9f pd=0.74u as=56.9f ps=0.74u w=0.17u l=0.17u
X3687 GA2_P CKB2_N cml_gate2_5.xrtail.R1 VSS sg13_lv_nmos ad=0.1007p pd=0.91u as=0.1007p ps=0.91u w=0.53u l=0.13u
X3688 cml_tlatch_87.OUTP cml_tlatch_87.OUTN cml_tlatch_87.xmux.xp.S1 VSS sg13_lv_nmos ad=56.9f pd=0.74u as=0.1019p ps=1.34u w=0.17u l=0.17u
X3689 MOT0_P MOT0_N cml_tlatch_26.xmux.xp.S1 VSS sg13_lv_nmos ad=56.9f pd=0.74u as=56.9f ps=0.74u w=0.17u l=0.17u
X3690 cml_tlatch_74.INP cml_tlatch_74.INN cml_tlatch_88.xmux.xp.S1 VSS sg13_lv_nmos ad=56.9f pd=0.74u as=56.9f ps=0.74u w=0.17u l=0.17u
X3691 cml_tlatch_7.xmux.xn.S1 cml_tlatch_8.OUTP cml_tlatch_7.OUTN VSS sg13_lv_nmos ad=63.19999f pd=0.74u as=63.19999f ps=0.74u w=0.26u l=0.38u
X3692 cml_tlatch_96.xtail.S1 CKB1_P cml_tlatch_96.xmux.xp.S1 VSS sg13_lv_nmos ad=0.1598p pd=1.62u as=89.3f ps=0.85u w=0.47u l=0.16u
X3693 MOT13_P cml_tlatch_5.INN cml_tlatch_5.xmux.xn.S1 VSS sg13_lv_nmos ad=63.19999f pd=0.74u as=63.19999f ps=0.74u w=0.26u l=0.38u
X3694 cml_tlatch_28.xmux.xp.S1 MOT4_N MOT4_P VSS sg13_lv_nmos ad=0.1019p pd=1.34u as=56.9f ps=0.74u w=0.17u l=0.17u
X3695 cml_tlatch_7.xmux.xn.S1 cml_tlatch_8.OUTP cml_tlatch_7.OUTN VSS sg13_lv_nmos ad=63.19999f pd=0.74u as=63.19999f ps=0.74u w=0.26u l=0.38u
X3696 cml_tlatch_54.xmux.xn.S1 CKHA2_P cml_tlatch_54.xtail.S1 VSS sg13_lv_nmos ad=89.3f pd=0.85u as=89.3f ps=0.85u w=0.47u l=0.16u
X3697 MOT14_P MOT14_N cml_tlatch_25.xmux.xp.S1 VSS sg13_lv_nmos ad=56.9f pd=0.74u as=56.9f ps=0.74u w=0.17u l=0.17u
X3698 cml_tlatch_10.xmux.xn.S1 stub_bi_15.BOTN B1_8_N VSS sg13_lv_nmos ad=63.19999f pd=0.74u as=63.19999f ps=0.74u w=0.26u l=0.38u
X3699 cml_tlatch_0.xtail.S1 POLN VSS VSS sg13_lv_nmos ad=1.5637p pd=8.61u as=1.5637p ps=8.61u w=8.23u l=0.13u
X3700 MOT8_N MOT8_P cml_tlatch_42.xmux.xp.S1 VSS sg13_lv_nmos ad=56.9f pd=0.74u as=56.9f ps=0.74u w=0.17u l=0.17u
X3701 cml_tlatch_85.xmux.xn.S1 CKA2_N cml_tlatch_85.xtail.S1 VSS sg13_lv_nmos ad=89.3f pd=0.85u as=89.3f ps=0.85u w=0.47u l=0.16u
X3702 A2_8_N A2_8_P cml_tlatch_85.xmux.xp.S1 VSS sg13_lv_nmos ad=56.9f pd=0.74u as=56.9f ps=0.74u w=0.17u l=0.17u
X3703 VSS POLN cml_tlatch_53.xtail.S1 VSS sg13_lv_nmos ad=2.7982p pd=17.14u as=1.5637p ps=8.61u w=8.23u l=0.13u
X3704 CKA0_P CK_P hs_to_clk_0.D2 VSS sg13_lv_nmos ad=0.408p pd=3.08u as=0.228p ps=1.58u w=1.2u l=0.2u
X3705 cml_tlatch_19.xmux.xn.S1 cml_tlatch_20.OUTN A1_8_P VSS sg13_lv_nmos ad=63.19999f pd=0.74u as=63.19999f ps=0.74u w=0.26u l=0.38u
X3706 cml_tlatch_35.xmux.xp.S1 CKB1_N cml_tlatch_35.xtail.S1 VSS sg13_lv_nmos ad=89.3f pd=0.85u as=89.3f ps=0.85u w=0.47u l=0.16u
X3707 VSS POLN cml_tlatch_64.xtail.S1 VSS sg13_lv_nmos ad=1.5637p pd=8.61u as=1.5637p ps=8.61u w=8.23u l=0.13u
X3708 MOT18_P MOT18_N cml_tlatch_53.xmux.xp.S1 VSS sg13_lv_nmos ad=56.9f pd=0.74u as=56.9f ps=0.74u w=0.17u l=0.17u
X3709 cml_gate2_7.xrtail.R1 CKA2_P cml_gate2_7.xamp.xn.S1 VSS sg13_lv_nmos ad=0.1007p pd=0.91u as=0.1007p ps=0.91u w=0.53u l=0.13u
X3710 cml_tlatch_61.xmux.xp.S1 cml_tlatch_61.OUTP cml_tlatch_61.OUTN VSS sg13_lv_nmos ad=56.9f pd=0.74u as=56.9f ps=0.74u w=0.17u l=0.17u
X3711 A0_2_N A0_2_P cml_tlatch_34.xmux.xp.S1 VSS sg13_lv_nmos ad=56.9f pd=0.74u as=56.9f ps=0.74u w=0.17u l=0.17u
X3712 cml_tlatch_49.xtail.S1 CKB3_P cml_tlatch_49.xmux.xn.S1 VSS sg13_lv_nmos ad=89.3f pd=0.85u as=0.1598p ps=1.62u w=0.47u l=0.16u
X3713 VDD cml_tlatch_58.OUTP VSS rppd l=5.17u w=1u
X3714 cml_tlatch_18.xmux.xn.S1 CKA0_P cml_tlatch_18.xtail.S1 VSS sg13_lv_nmos ad=89.3f pd=0.85u as=89.3f ps=0.85u w=0.47u l=0.16u
X3715 J2_N J2_P cml_tlatch_94.xmux.xp.S1 VSS sg13_lv_nmos ad=56.9f pd=0.74u as=56.9f ps=0.74u w=0.17u l=0.17u
X3716 cml_tlatch_91.INP cml_tlatch_91.INN cml_tlatch_59.xmux.xp.S1 VSS sg13_lv_nmos ad=56.9f pd=0.74u as=56.9f ps=0.74u w=0.17u l=0.17u
X3717 cml_gate2_2.xrtail.R1 CKB1_N GA1_P VSS sg13_lv_nmos ad=0.1007p pd=0.91u as=0.1007p ps=0.91u w=0.53u l=0.13u
X3718 MOT10_P MOT10_N cml_tlatch_43.xmux.xp.S1 VSS sg13_lv_nmos ad=56.9f pd=0.74u as=56.9f ps=0.74u w=0.17u l=0.17u
X3719 cml_tlatch_97.xmux.xn.S1 CKA1_N cml_tlatch_97.xtail.S1 VSS sg13_lv_nmos ad=89.3f pd=0.85u as=89.3f ps=0.85u w=0.47u l=0.16u
X3720 cml_tlatch_24.INP cml_tlatch_97.INN cml_tlatch_97.xmux.xn.S1 VSS sg13_lv_nmos ad=63.19999f pd=0.74u as=63.19999f ps=0.74u w=0.26u l=0.38u
X3721 cml_gate2_9.xamp.xn.S1 J1_P ENA_N VSS sg13_lv_nmos ad=0.1007p pd=0.91u as=0.1007p ps=0.91u w=0.53u l=0.13u
X3722 cml_tlatch_58.xmux.xp.S1 cml_tlatch_58.OUTN cml_tlatch_58.OUTP VSS sg13_lv_nmos ad=56.9f pd=0.74u as=56.9f ps=0.74u w=0.17u l=0.17u
X3723 cml_tlatch_87.OUTP cml_tlatch_87.OUTN cml_tlatch_87.xmux.xp.S1 VSS sg13_lv_nmos ad=56.9f pd=0.74u as=56.9f ps=0.74u w=0.17u l=0.17u
X3724 B3_8_P B3_8_N cml_tlatch_64.xmux.xp.S1 VSS sg13_lv_nmos ad=56.9f pd=0.74u as=56.9f ps=0.74u w=0.17u l=0.17u
X3725 cml_tlatch_51.OUTP cml_tlatch_51.OUTN cml_tlatch_51.xmux.xp.S1 VSS sg13_lv_nmos ad=56.9f pd=0.74u as=56.9f ps=0.74u w=0.17u l=0.17u
X3726 cml_tlatch_78.xmux.xn.S1 stub_bi_63.BOTP MOT19_P VSS sg13_lv_nmos ad=63.19999f pd=0.74u as=63.19999f ps=0.74u w=0.26u l=0.38u
X3727 cml_tlatch_91.xmux.xn.S1 CKA2_N cml_tlatch_91.xtail.S1 VSS sg13_lv_nmos ad=0.1598p pd=1.62u as=89.3f ps=0.85u w=0.47u l=0.16u
X3728 GA1_P CKB1_N cml_gate2_2.xrtail.R1 VSS sg13_lv_nmos ad=0.1007p pd=0.91u as=0.1007p ps=0.91u w=0.53u l=0.13u
X3729 MOT19_N stub_bi_63.BOTN cml_tlatch_78.xmux.xn.S1 VSS sg13_lv_nmos ad=63.19999f pd=0.74u as=63.19999f ps=0.74u w=0.26u l=0.38u
X3730 cml_tlatch_9.xtail.S1 CKA0_N cml_tlatch_9.xmux.xn.S1 VSS sg13_lv_nmos ad=89.3f pd=0.85u as=89.3f ps=0.85u w=0.47u l=0.16u
X3731 cml_gate2_8.xrtail.R1 NS1_N ENB_P VSS sg13_lv_nmos ad=0.1007p pd=0.91u as=0.1007p ps=0.91u w=0.53u l=0.13u
X3732 GA3_P ENA1_N cml_gate2_4.xamp.xn.S1 VSS sg13_lv_nmos ad=0.1802p pd=1.74u as=0.1007p ps=0.91u w=0.53u l=0.13u
X3733 cml_tlatch_84.xmux.xp.S1 stub_bi_49.BOTN stub_bi_49.BOTP VSS sg13_lv_nmos ad=56.9f pd=0.74u as=56.9f ps=0.74u w=0.17u l=0.17u
X3734 cml_tlatch_14.xmux.xp.S1 MOT1_N MOT1_P VSS sg13_lv_nmos ad=56.9f pd=0.74u as=56.9f ps=0.74u w=0.17u l=0.17u
X3735 cml_tlatch_24.xmux.xn.S1 CKHA1_P cml_tlatch_24.xtail.S1 VSS sg13_lv_nmos ad=89.3f pd=0.85u as=89.3f ps=0.85u w=0.47u l=0.16u
X3736 cml_tlatch_10.xmux.xp.S1 B1_8_N B1_8_P VSS sg13_lv_nmos ad=56.9f pd=0.74u as=56.9f ps=0.74u w=0.17u l=0.17u
X3737 cml_tlatch_37.xmux.xp.S1 stub_bi_31.BOTP stub_bi_31.BOTN VSS sg13_lv_nmos ad=56.9f pd=0.74u as=56.9f ps=0.74u w=0.17u l=0.17u
X3738 cml_tlatch_95.xmux.xp.S1 CKJ_N cml_tlatch_95.xtail.S1 VSS sg13_lv_nmos ad=89.3f pd=0.85u as=89.3f ps=0.85u w=0.47u l=0.16u
X3739 cml_tlatch_59.xtail.S1 CKA2_P cml_tlatch_59.xmux.xn.S1 VSS sg13_lv_nmos ad=89.3f pd=0.85u as=89.3f ps=0.85u w=0.47u l=0.16u
X3740 VSS POLN cml_tlatch_70.xtail.S1 VSS sg13_lv_nmos ad=1.5637p pd=8.61u as=1.5637p ps=8.61u w=8.23u l=0.13u
X3741 cml_tlatch_24.xtail.S1 POLN VSS VSS sg13_lv_nmos ad=1.5637p pd=8.61u as=2.7982p ps=17.14u w=8.23u l=0.13u
X3742 cml_tlatch_0.xmux.xp.S1 cml_tlatch_0.OUTN cml_tlatch_0.OUTP VSS sg13_lv_nmos ad=56.9f pd=0.74u as=56.9f ps=0.74u w=0.17u l=0.17u
X3743 cml_tlatch_55.xtail.S1 CKHA2_P cml_tlatch_55.xmux.xn.S1 VSS sg13_lv_nmos ad=89.3f pd=0.85u as=89.3f ps=0.85u w=0.47u l=0.16u
X3744 MOT2_P cml_tlatch_23.OUTN cml_tlatch_27.xmux.xn.S1 VSS sg13_lv_nmos ad=63.19999f pd=0.74u as=63.19999f ps=0.74u w=0.26u l=0.38u
X3745 ENB0_N ENB_P cml_drv_2.xrtail.R1 VSS sg13_lv_nmos ad=56.2f pd=0.74u as=56.2f ps=0.74u w=0.16u l=0.19u
X3746 A2_8_N cml_tlatch_86.OUTP cml_tlatch_85.xmux.xn.S1 VSS sg13_lv_nmos ad=63.19999f pd=0.74u as=63.19999f ps=0.74u w=0.26u l=0.38u
X3747 cml_tlatch_23.xmux.xp.S1 cml_tlatch_23.OUTN cml_tlatch_23.OUTP VSS sg13_lv_nmos ad=56.9f pd=0.74u as=56.9f ps=0.74u w=0.17u l=0.17u
X3748 cml_tlatch_87.INP cml_tlatch_87.INN cml_tlatch_76.xmux.xp.S1 VSS sg13_lv_nmos ad=56.9f pd=0.74u as=56.9f ps=0.74u w=0.17u l=0.17u
X3749 B0_2_P B0_2_N cml_tlatch_31.xmux.xp.S1 VSS sg13_lv_nmos ad=56.9f pd=0.74u as=56.9f ps=0.74u w=0.17u l=0.17u
X3750 cml_tlatch_20.xtail.S1 CKA1_N cml_tlatch_20.xmux.xp.S1 VSS sg13_lv_nmos ad=89.3f pd=0.85u as=89.3f ps=0.85u w=0.47u l=0.16u
X3751 B2_8_N B2_8_P cml_tlatch_81.xmux.xp.S1 VSS sg13_lv_nmos ad=56.9f pd=0.74u as=56.9f ps=0.74u w=0.17u l=0.17u
X3752 VSS hs_to_clk_4.sg13_lv_nmos_2HGZLP_0.G VSS VSS sg13_lv_nmos ad=2.071p pd=11.28u as=0 ps=0 w=10.9u l=1.38u
X3753 cml_tlatch_99.xmux.xp.S1 cml_tlatch_99.OUTN cml_tlatch_99.OUTP VSS sg13_lv_nmos ad=56.9f pd=0.74u as=56.9f ps=0.74u w=0.17u l=0.17u
X3754 cml_tlatch_60.xmux.xn.S1 CKA2_N cml_tlatch_60.xtail.S1 VSS sg13_lv_nmos ad=89.3f pd=0.85u as=89.3f ps=0.85u w=0.47u l=0.16u
X3755 cml_tlatch_56.xmux.xp.S1 cml_tlatch_56.OUTP cml_tlatch_56.OUTN VSS sg13_lv_nmos ad=56.9f pd=0.74u as=56.9f ps=0.74u w=0.17u l=0.17u
X3756 cml_tlatch_90.xmux.xp.S1 stub_bi_55.BOTN stub_bi_55.BOTP VSS sg13_lv_nmos ad=0.1019p pd=1.34u as=56.9f ps=0.74u w=0.17u l=0.17u
X3757 MOT7_P MOT7_N cml_tlatch_17.xmux.xp.S1 VSS sg13_lv_nmos ad=56.9f pd=0.74u as=56.9f ps=0.74u w=0.17u l=0.17u
X3758 cml_tlatch_49.OUTN cml_tlatch_49.OUTP cml_tlatch_49.xmux.xp.S1 VSS sg13_lv_nmos ad=56.9f pd=0.74u as=56.9f ps=0.74u w=0.17u l=0.17u
X3759 cml_tlatch_77.xmux.xp.S1 MOT17_N MOT17_P VSS sg13_lv_nmos ad=56.9f pd=0.74u as=56.9f ps=0.74u w=0.17u l=0.17u
X3760 cml_tlatch_21.xmux.xn.S1 cml_tlatch_22.OUTN cml_tlatch_43.INP VSS sg13_lv_nmos ad=63.19999f pd=0.74u as=63.19999f ps=0.74u w=0.26u l=0.38u
X3761 cml_tlatch_30.xmux.xp.S1 CKB0_N cml_tlatch_30.xtail.S1 VSS sg13_lv_nmos ad=89.3f pd=0.85u as=89.3f ps=0.85u w=0.47u l=0.16u
X3762 cml_tlatch_2.OUTP cml_tlatch_7.OUTN cml_tlatch_2.xmux.xn.S1 VSS sg13_lv_nmos ad=63.19999f pd=0.74u as=63.19999f ps=0.74u w=0.26u l=0.38u
X3763 cml_tlatch_52.xtail.S1 CKHA2_N cml_tlatch_52.xmux.xp.S1 VSS sg13_lv_nmos ad=89.3f pd=0.85u as=89.3f ps=0.85u w=0.47u l=0.16u
X3764 MOT27_N VDD VSS rppd l=5.17u w=1u
X3765 B0_2_P cml_tlatch_32.OUTN cml_tlatch_31.xmux.xn.S1 VSS sg13_lv_nmos ad=63.19999f pd=0.74u as=63.19999f ps=0.74u w=0.26u l=0.38u
X3766 cml_tlatch_42.xmux.xp.S1 MOT8_N MOT8_P VSS sg13_lv_nmos ad=56.9f pd=0.74u as=56.9f ps=0.74u w=0.17u l=0.17u
X3767 cml_tlatch_11.xtail.S1 CKB1_N cml_tlatch_11.xmux.xp.S1 VSS sg13_lv_nmos ad=89.3f pd=0.85u as=89.3f ps=0.85u w=0.47u l=0.16u
X3768 cml_tlatch_4.xmux.xp.S1 MOT11_N MOT11_P VSS sg13_lv_nmos ad=56.9f pd=0.74u as=56.9f ps=0.74u w=0.17u l=0.17u
X3769 VDD GB2_P VSS rppd l=7.42u w=1u
X3770 stub_bi_38.BOTN stub_bi_38.BOTP cml_tlatch_46.xmux.xp.S1 VSS sg13_lv_nmos ad=56.9f pd=0.74u as=56.9f ps=0.74u w=0.17u l=0.17u
X3771 cml_tlatch_17.xmux.xn.S1 CKHB0_P cml_tlatch_17.xtail.S1 VSS sg13_lv_nmos ad=89.3f pd=0.85u as=89.3f ps=0.85u w=0.47u l=0.16u
X3772 cml_tlatch_86.xtail.S1 CKA2_N cml_tlatch_86.xmux.xp.S1 VSS sg13_lv_nmos ad=89.3f pd=0.85u as=89.3f ps=0.85u w=0.47u l=0.16u
X3773 cml_tlatch_37.xtail.S1 CKB1_N cml_tlatch_37.xmux.xp.S1 VSS sg13_lv_nmos ad=89.3f pd=0.85u as=89.3f ps=0.85u w=0.47u l=0.16u
X3774 cml_tlatch_57.xmux.xp.S1 A3_2_P A3_2_N VSS sg13_lv_nmos ad=56.9f pd=0.74u as=56.9f ps=0.74u w=0.17u l=0.17u
X3775 B0_8_N B0_8_P cml_tlatch_1.xmux.xp.S1 VSS sg13_lv_nmos ad=56.9f pd=0.74u as=56.9f ps=0.74u w=0.17u l=0.17u
X3776 cml_tlatch_81.xtail.S1 POLN VSS VSS sg13_lv_nmos ad=1.5637p pd=8.61u as=1.5637p ps=8.61u w=8.23u l=0.13u
X3777 cml_tlatch_60.xmux.xn.S1 cml_tlatch_61.OUTN A2_2_P VSS sg13_lv_nmos ad=63.19999f pd=0.74u as=63.19999f ps=0.74u w=0.26u l=0.38u
X3778 cml_tlatch_7.xmux.xp.S1 cml_tlatch_7.OUTP cml_tlatch_7.OUTN VSS sg13_lv_nmos ad=56.9f pd=0.74u as=56.9f ps=0.74u w=0.17u l=0.17u
X3779 cml_tlatch_33.OUTP cml_tlatch_33.OUTN cml_tlatch_33.xmux.xp.S1 VSS sg13_lv_nmos ad=56.9f pd=0.74u as=56.9f ps=0.74u w=0.17u l=0.17u
X3780 cml_tlatch_12.xtail.S1 CKB1_N cml_tlatch_12.xmux.xn.S1 VSS sg13_lv_nmos ad=0.1598p pd=1.62u as=89.3f ps=0.85u w=0.47u l=0.16u
X3781 cml_tlatch_62.xtail.S1 CKHA3_N cml_tlatch_62.xmux.xp.S1 VSS sg13_lv_nmos ad=89.3f pd=0.85u as=89.3f ps=0.85u w=0.47u l=0.16u
X3782 VSS POLN cml_tlatch_43.xtail.S1 VSS sg13_lv_nmos ad=1.5637p pd=8.61u as=1.5637p ps=8.61u w=8.23u l=0.13u
X3783 cml_tlatch_15.xtail.S1 CKHB0_N cml_tlatch_15.xmux.xp.S1 VSS sg13_lv_nmos ad=89.3f pd=0.85u as=89.3f ps=0.85u w=0.47u l=0.16u
X3784 cml_tlatch_60.xmux.xn.S1 cml_tlatch_61.OUTN A2_2_P VSS sg13_lv_nmos ad=63.19999f pd=0.74u as=63.19999f ps=0.74u w=0.26u l=0.38u
X3785 cml_tlatch_99.OUTP cml_tlatch_33.OUTN cml_tlatch_99.xmux.xn.S1 VSS sg13_lv_nmos ad=63.19999f pd=0.74u as=0.1082p ps=1.34u w=0.26u l=0.38u
X3786 MOT5_N cml_tlatch_98.OUTP cml_tlatch_16.xmux.xn.S1 VSS sg13_lv_nmos ad=63.19999f pd=0.74u as=63.19999f ps=0.74u w=0.26u l=0.38u
X3787 CKB1_P hs_to_clk_2.sg13_lv_nmos_2HGZLP_0.G VSS rppd l=4.25u w=1u
X3788 cml_tlatch_69.xmux.xn.S1 cml_tlatch_63.INN cml_tlatch_69.OUTP VSS sg13_lv_nmos ad=63.19999f pd=0.74u as=63.19999f ps=0.74u w=0.26u l=0.38u
X3789 cml_tlatch_8.xtail.S1 POLN VSS VSS sg13_lv_nmos ad=1.5637p pd=8.61u as=2.7982p ps=17.14u w=8.23u l=0.13u
X3790 cml_tlatch_62.xmux.xp.S1 MOT24_N MOT24_P VSS sg13_lv_nmos ad=56.9f pd=0.74u as=56.9f ps=0.74u w=0.17u l=0.17u
X3791 cml_tlatch_73.xmux.xp.S1 MOT27_N MOT27_P VSS sg13_lv_nmos ad=56.9f pd=0.74u as=56.9f ps=0.74u w=0.17u l=0.17u
X3792 cml_tlatch_84.xtail.S1 CKB2_N cml_tlatch_84.xmux.xp.S1 VSS sg13_lv_nmos ad=89.3f pd=0.85u as=0.1598p ps=1.62u w=0.47u l=0.16u
X3793 cml_tlatch_44.xmux.xp.S1 CKHA3_N cml_tlatch_44.xtail.S1 VSS sg13_lv_nmos ad=89.3f pd=0.85u as=89.3f ps=0.85u w=0.47u l=0.16u
X3794 MOT6_N MOT6_P cml_tlatch_29.xmux.xp.S1 VSS sg13_lv_nmos ad=56.9f pd=0.74u as=0.1019p ps=1.34u w=0.17u l=0.17u
X3795 cml_tlatch_71.OUTN cml_tlatch_71.OUTP cml_tlatch_71.xmux.xp.S1 VSS sg13_lv_nmos ad=56.9f pd=0.74u as=56.9f ps=0.74u w=0.17u l=0.17u
X3796 cml_tlatch_32.xtail.S1 POLN VSS VSS sg13_lv_nmos ad=1.5637p pd=8.61u as=1.5637p ps=8.61u w=8.23u l=0.13u
X3797 stub_bi_31.BOTP D1_P cml_tlatch_37.xmux.xn.S1 VSS sg13_lv_nmos ad=63.19999f pd=0.74u as=63.19999f ps=0.74u w=0.26u l=0.38u
X3798 cml_tlatch_49.xtail.S1 CKB3_N cml_tlatch_49.xmux.xp.S1 VSS sg13_lv_nmos ad=89.3f pd=0.85u as=89.3f ps=0.85u w=0.47u l=0.16u
X3799 MOT10_P MOT10_N cml_tlatch_43.xmux.xp.S1 VSS sg13_lv_nmos ad=56.9f pd=0.74u as=56.9f ps=0.74u w=0.17u l=0.17u
X3800 cml_tlatch_92.xmux.xp.S1 CKJ_P cml_tlatch_92.xtail.S1 VSS sg13_lv_nmos ad=89.3f pd=0.85u as=89.3f ps=0.85u w=0.47u l=0.16u
X3801 VDD cml_tlatch_23.OUTP VSS rppd l=5.17u w=1u
X3802 cml_tlatch_61.xmux.xn.S1 CKA2_P cml_tlatch_61.xtail.S1 VSS sg13_lv_nmos ad=89.3f pd=0.85u as=89.3f ps=0.85u w=0.47u l=0.16u
X3803 cml_tlatch_7.xmux.xn.S1 cml_tlatch_8.OUTN cml_tlatch_7.OUTP VSS sg13_lv_nmos ad=0.1082p pd=1.34u as=63.19999f ps=0.74u w=0.26u l=0.38u
X3804 cml_tlatch_66.xmux.xp.S1 CKB3_P cml_tlatch_66.xtail.S1 VSS sg13_lv_nmos ad=89.3f pd=0.85u as=89.3f ps=0.85u w=0.47u l=0.16u
X3805 cml_tlatch_82.xmux.xp.S1 stub_bi_62.BOTN stub_bi_62.BOTP VSS sg13_lv_nmos ad=56.9f pd=0.74u as=56.9f ps=0.74u w=0.17u l=0.17u
X3806 cml_tlatch_15.xmux.xp.S1 MOT3_P MOT3_N VSS sg13_lv_nmos ad=56.9f pd=0.74u as=56.9f ps=0.74u w=0.17u l=0.17u
X3807 cml_tlatch_20.OUTN cml_tlatch_20.OUTP cml_tlatch_20.xmux.xp.S1 VSS sg13_lv_nmos ad=56.9f pd=0.74u as=56.9f ps=0.74u w=0.17u l=0.17u
X3808 cml_tlatch_51.xmux.xn.S1 D3_N cml_tlatch_51.OUTP VSS sg13_lv_nmos ad=63.19999f pd=0.74u as=63.19999f ps=0.74u w=0.26u l=0.38u
X3809 cml_tlatch_7.xmux.xn.S1 CKB0_N cml_tlatch_7.xtail.S1 VSS sg13_lv_nmos ad=89.3f pd=0.85u as=89.3f ps=0.85u w=0.47u l=0.16u
X3810 cml_tlatch_32.OUTN D0_P cml_tlatch_32.xmux.xn.S1 VSS sg13_lv_nmos ad=63.19999f pd=0.74u as=63.19999f ps=0.74u w=0.26u l=0.38u
X3811 cml_tlatch_29.xmux.xn.S1 A0_2_N MOT6_P VSS sg13_lv_nmos ad=63.19999f pd=0.74u as=63.19999f ps=0.74u w=0.26u l=0.38u
X3812 cml_tlatch_67.xtail.S1 CKB3_N cml_tlatch_67.xmux.xp.S1 VSS sg13_lv_nmos ad=89.3f pd=0.85u as=89.3f ps=0.85u w=0.47u l=0.16u
X3813 cml_tlatch_22.xmux.xp.S1 CKA1_N cml_tlatch_22.xtail.S1 VSS sg13_lv_nmos ad=0.1598p pd=1.62u as=89.3f ps=0.85u w=0.47u l=0.16u
X3814 stub_bi_29.BOTP stub_bi_29.BOTN cml_tlatch_35.xmux.xp.S1 VSS sg13_lv_nmos ad=56.9f pd=0.74u as=56.9f ps=0.74u w=0.17u l=0.17u
X3815 cml_tlatch_98.OUTP cml_tlatch_98.OUTN cml_tlatch_98.xmux.xp.S1 VSS sg13_lv_nmos ad=56.9f pd=0.74u as=56.9f ps=0.74u w=0.17u l=0.17u
X3816 MOT3_P cml_tlatch_7.OUTN cml_tlatch_15.xmux.xn.S1 VSS sg13_lv_nmos ad=0.1082p pd=1.34u as=63.19999f ps=0.74u w=0.26u l=0.38u
X3817 MOT13_P MOT13_N cml_tlatch_5.xmux.xp.S1 VSS sg13_lv_nmos ad=56.9f pd=0.74u as=56.9f ps=0.74u w=0.17u l=0.17u
X3818 cml_tlatch_25.xmux.xn.S1 CKHA1_P cml_tlatch_25.xtail.S1 VSS sg13_lv_nmos ad=89.3f pd=0.85u as=89.3f ps=0.85u w=0.47u l=0.16u
X3819 cml_tlatch_0.xmux.xp.S1 cml_tlatch_0.OUTN cml_tlatch_0.OUTP VSS sg13_lv_nmos ad=0.1019p pd=1.34u as=56.9f ps=0.74u w=0.17u l=0.17u
X3820 B1_2_P B1_2_N cml_tlatch_36.xmux.xp.S1 VSS sg13_lv_nmos ad=56.9f pd=0.74u as=0.1019p ps=1.34u w=0.17u l=0.17u
X3821 cml_tlatch_35.xtail.S1 CKB1_N cml_tlatch_35.xmux.xp.S1 VSS sg13_lv_nmos ad=89.3f pd=0.85u as=0.1598p ps=1.62u w=0.47u l=0.16u
X3822 cml_tlatch_86.OUTP cml_tlatch_86.OUTN cml_tlatch_86.xmux.xp.S1 VSS sg13_lv_nmos ad=56.9f pd=0.74u as=56.9f ps=0.74u w=0.17u l=0.17u
X3823 cml_tlatch_41.OUTN cml_tlatch_41.OUTP cml_tlatch_41.xmux.xp.S1 VSS sg13_lv_nmos ad=56.9f pd=0.74u as=56.9f ps=0.74u w=0.17u l=0.17u
X3824 cml_tlatch_93.xmux.xn.S1 J2_P CLK_W_P VSS sg13_lv_nmos ad=63.19999f pd=0.74u as=63.19999f ps=0.74u w=0.26u l=0.38u
X3825 cml_tlatch_7.OUTP cml_tlatch_7.OUTN cml_tlatch_7.xmux.xp.S1 VSS sg13_lv_nmos ad=56.9f pd=0.74u as=0.1019p ps=1.34u w=0.17u l=0.17u
X3826 cml_tlatch_89.xmux.xp.S1 cml_tlatch_44.INN cml_tlatch_44.INP VSS sg13_lv_nmos ad=56.9f pd=0.74u as=56.9f ps=0.74u w=0.17u l=0.17u
X3827 cml_tlatch_9.xmux.xp.S1 A0_8_N A0_8_P VSS sg13_lv_nmos ad=56.9f pd=0.74u as=56.9f ps=0.74u w=0.17u l=0.17u
X3828 cml_tlatch_20.xtail.S1 CKA1_P cml_tlatch_20.xmux.xn.S1 VSS sg13_lv_nmos ad=89.3f pd=0.85u as=89.3f ps=0.85u w=0.47u l=0.16u
X3829 MOT16_N A2_8_P cml_tlatch_52.xmux.xn.S1 VSS sg13_lv_nmos ad=0.1082p pd=1.34u as=63.19999f ps=0.74u w=0.26u l=0.38u
X3830 cml_tlatch_22.OUTP cml_tlatch_22.OUTN cml_tlatch_22.xmux.xp.S1 VSS sg13_lv_nmos ad=56.9f pd=0.74u as=56.9f ps=0.74u w=0.17u l=0.17u
X3831 cml_tlatch_14.xmux.xn.S1 CKHB0_P cml_tlatch_14.xtail.S1 VSS sg13_lv_nmos ad=89.3f pd=0.85u as=89.3f ps=0.85u w=0.47u l=0.16u
X3832 cml_tlatch_21.xmux.xp.S1 cml_tlatch_43.INN cml_tlatch_43.INP VSS sg13_lv_nmos ad=56.9f pd=0.74u as=56.9f ps=0.74u w=0.17u l=0.17u
X3833 MOT25_P MOT25_N cml_tlatch_72.xmux.xp.S1 VSS sg13_lv_nmos ad=56.9f pd=0.74u as=56.9f ps=0.74u w=0.17u l=0.17u
X3834 cml_tlatch_81.xmux.xp.S1 B2_8_N B2_8_P VSS sg13_lv_nmos ad=56.9f pd=0.74u as=56.9f ps=0.74u w=0.17u l=0.17u
X3835 MOT29_P MOT29_N cml_tlatch_74.xmux.xp.S1 VSS sg13_lv_nmos ad=56.9f pd=0.74u as=56.9f ps=0.74u w=0.17u l=0.17u
X3836 cml_tlatch_63.xtail.S1 CKHA3_P cml_tlatch_63.xmux.xn.S1 VSS sg13_lv_nmos ad=89.3f pd=0.85u as=0.1598p ps=1.62u w=0.47u l=0.16u
X3837 cml_tlatch_4.xmux.xp.S1 MOT11_N MOT11_P VSS sg13_lv_nmos ad=0.1019p pd=1.34u as=56.9f ps=0.74u w=0.17u l=0.17u
X3838 cml_tlatch_58.xmux.xp.S1 CKA3_N cml_tlatch_58.xtail.S1 VSS sg13_lv_nmos ad=89.3f pd=0.85u as=89.3f ps=0.85u w=0.47u l=0.16u
X3839 cml_tlatch_18.OUTN cml_tlatch_18.OUTP cml_tlatch_18.xmux.xp.S1 VSS sg13_lv_nmos ad=56.9f pd=0.74u as=56.9f ps=0.74u w=0.17u l=0.17u
X3840 VSS POLN cml_tlatch_95.xtail.S1 VSS sg13_lv_nmos ad=1.5637p pd=8.61u as=1.5637p ps=8.61u w=8.23u l=0.13u
X3841 cml_tlatch_95.xtail.S1 CKJ_N cml_tlatch_95.xmux.xp.S1 VSS sg13_lv_nmos ad=89.3f pd=0.85u as=89.3f ps=0.85u w=0.47u l=0.16u
X3842 cml_tlatch_96.xtail.S1 CKB1_P cml_tlatch_96.xmux.xp.S1 VSS sg13_lv_nmos ad=89.3f pd=0.85u as=89.3f ps=0.85u w=0.47u l=0.16u
X3843 cml_tlatch_79.xmux.xn.S1 stub_bi_55.BOTP MOT21_P VSS sg13_lv_nmos ad=63.19999f pd=0.74u as=63.19999f ps=0.74u w=0.26u l=0.38u
X3844 ENB1_N ENB_P cml_drv_0.xrtail.R1 VSS sg13_lv_nmos ad=56.2f pd=0.74u as=56.2f ps=0.74u w=0.16u l=0.19u
X3845 cml_tlatch_50.xtail.S1 CKB3_P cml_tlatch_50.xmux.xp.S1 VSS sg13_lv_nmos ad=89.3f pd=0.85u as=89.3f ps=0.85u w=0.47u l=0.16u
X3846 cml_tlatch_76.xtail.S1 CKA2_P cml_tlatch_76.xmux.xn.S1 VSS sg13_lv_nmos ad=89.3f pd=0.85u as=89.3f ps=0.85u w=0.47u l=0.16u
X3847 cml_tlatch_24.INP cml_tlatch_24.INN cml_tlatch_97.xmux.xp.S1 VSS sg13_lv_nmos ad=56.9f pd=0.74u as=56.9f ps=0.74u w=0.17u l=0.17u
X3848 GB2_P CKA2_N cml_gate2_7.xrtail.R1 VSS sg13_lv_nmos ad=0.1007p pd=0.91u as=0.1007p ps=0.91u w=0.53u l=0.13u
X3849 cml_tlatch_55.xmux.xn.S1 CKHA2_P cml_tlatch_55.xtail.S1 VSS sg13_lv_nmos ad=89.3f pd=0.85u as=89.3f ps=0.85u w=0.47u l=0.16u
X3850 B1_2_P B1_2_N cml_tlatch_36.xmux.xp.S1 VSS sg13_lv_nmos ad=56.9f pd=0.74u as=56.9f ps=0.74u w=0.17u l=0.17u
X3851 cml_tlatch_35.xmux.xn.S1 B1_2_P stub_bi_29.BOTP VSS sg13_lv_nmos ad=0.1082p pd=1.34u as=63.19999f ps=0.74u w=0.26u l=0.38u
X3852 cml_tlatch_67.xmux.xp.S1 cml_tlatch_67.OUTP cml_tlatch_67.OUTN VSS sg13_lv_nmos ad=56.9f pd=0.74u as=56.9f ps=0.74u w=0.17u l=0.17u
X3853 MOT19_N MOT19_P cml_tlatch_78.xmux.xp.S1 VSS sg13_lv_nmos ad=56.9f pd=0.74u as=56.9f ps=0.74u w=0.17u l=0.17u
X3854 cml_tlatch_14.xmux.xn.S1 B0_8_N MOT1_P VSS sg13_lv_nmos ad=63.19999f pd=0.74u as=63.19999f ps=0.74u w=0.26u l=0.38u
X3855 cml_tlatch_51.xmux.xp.S1 CKB3_N cml_tlatch_51.xtail.S1 VSS sg13_lv_nmos ad=89.3f pd=0.85u as=89.3f ps=0.85u w=0.47u l=0.16u
X3856 B0_2_N cml_tlatch_32.OUTP cml_tlatch_31.xmux.xn.S1 VSS sg13_lv_nmos ad=63.19999f pd=0.74u as=63.19999f ps=0.74u w=0.26u l=0.38u
X3857 J4_N J4_P cml_tlatch_92.xmux.xp.S1 VSS sg13_lv_nmos ad=56.9f pd=0.74u as=56.9f ps=0.74u w=0.17u l=0.17u
X3858 cml_tlatch_7.OUTP cml_tlatch_7.OUTN cml_tlatch_7.xmux.xp.S1 VSS sg13_lv_nmos ad=56.9f pd=0.74u as=56.9f ps=0.74u w=0.17u l=0.17u
X3859 cml_tlatch_14.xmux.xn.S1 B0_8_N MOT1_P VSS sg13_lv_nmos ad=63.19999f pd=0.74u as=63.19999f ps=0.74u w=0.26u l=0.38u
X3860 B2_8_P stub_bi_62.BOTP cml_tlatch_81.xmux.xn.S1 VSS sg13_lv_nmos ad=63.19999f pd=0.74u as=63.19999f ps=0.74u w=0.26u l=0.38u
X3861 MOT15_P MOT15_N cml_tlatch_6.xmux.xp.S1 VSS sg13_lv_nmos ad=56.9f pd=0.74u as=56.9f ps=0.74u w=0.17u l=0.17u
X3862 cml_tlatch_84.xtail.S1 CKB2_P cml_tlatch_84.xmux.xn.S1 VSS sg13_lv_nmos ad=89.3f pd=0.85u as=89.3f ps=0.85u w=0.47u l=0.16u
X3863 MOT4_P MOT4_N cml_tlatch_28.xmux.xp.S1 VSS sg13_lv_nmos ad=56.9f pd=0.74u as=56.9f ps=0.74u w=0.17u l=0.17u
X3864 cml_tlatch_18.xmux.xn.S1 CKA0_P cml_tlatch_18.xtail.S1 VSS sg13_lv_nmos ad=89.3f pd=0.85u as=89.3f ps=0.85u w=0.47u l=0.16u
X3865 MOT6_N MOT6_P cml_tlatch_29.xmux.xp.S1 VSS sg13_lv_nmos ad=56.9f pd=0.74u as=56.9f ps=0.74u w=0.17u l=0.17u
X3866 cml_tlatch_45.xmux.xn.S1 CKHA3_P cml_tlatch_45.xtail.S1 VSS sg13_lv_nmos ad=89.3f pd=0.85u as=89.3f ps=0.85u w=0.47u l=0.16u
X3867 cml_tlatch_20.xmux.xp.S1 cml_tlatch_20.OUTN cml_tlatch_20.OUTP VSS sg13_lv_nmos ad=56.9f pd=0.74u as=56.9f ps=0.74u w=0.17u l=0.17u
X3868 cml_tlatch_67.xmux.xp.S1 cml_tlatch_67.OUTP cml_tlatch_67.OUTN VSS sg13_lv_nmos ad=0.1019p pd=1.34u as=56.9f ps=0.74u w=0.17u l=0.17u
X3869 cml_tlatch_61.OUTP cml_tlatch_61.OUTN cml_tlatch_61.xmux.xp.S1 VSS sg13_lv_nmos ad=56.9f pd=0.74u as=56.9f ps=0.74u w=0.17u l=0.17u
X3870 B3_2_P B3_2_N cml_tlatch_50.xmux.xp.S1 VSS sg13_lv_nmos ad=56.9f pd=0.74u as=56.9f ps=0.74u w=0.17u l=0.17u
X3871 cml_tlatch_99.xmux.xn.S1 CKA0_N cml_tlatch_99.xtail.S1 VSS sg13_lv_nmos ad=89.3f pd=0.85u as=89.3f ps=0.85u w=0.47u l=0.16u
X3872 cml_drvb_7.xrtail.R2 GB2_N CKHB2_P VSS sg13_lv_nmos ad=0.1463p pd=1.15u as=0.2618p ps=2.22u w=0.77u l=0.21u
X3873 cml_tlatch_20.xtail.S1 CKA1_P cml_tlatch_20.xmux.xn.S1 VSS sg13_lv_nmos ad=89.3f pd=0.85u as=89.3f ps=0.85u w=0.47u l=0.16u
X3874 cml_tlatch_93.xtail.S1 CKJ_N cml_tlatch_93.xmux.xp.S1 VSS sg13_lv_nmos ad=89.3f pd=0.85u as=89.3f ps=0.85u w=0.47u l=0.16u
X3875 cml_tlatch_70.xmux.xn.S1 cml_tlatch_71.OUTP cml_tlatch_63.INN VSS sg13_lv_nmos ad=63.19999f pd=0.74u as=63.19999f ps=0.74u w=0.26u l=0.38u
X3876 cml_tlatch_15.xmux.xp.S1 MOT3_P MOT3_N VSS sg13_lv_nmos ad=56.9f pd=0.74u as=56.9f ps=0.74u w=0.17u l=0.17u
X3877 stub_bi_17.BOTP stub_bi_17.BOTN cml_tlatch_13.xmux.xp.S1 VSS sg13_lv_nmos ad=56.9f pd=0.74u as=56.9f ps=0.74u w=0.17u l=0.17u
X3878 cml_tlatch_51.xmux.xp.S1 cml_tlatch_51.OUTP cml_tlatch_51.OUTN VSS sg13_lv_nmos ad=56.9f pd=0.74u as=56.9f ps=0.74u w=0.17u l=0.17u
X3879 cml_tlatch_2.OUTP cml_tlatch_2.OUTN cml_tlatch_2.xmux.xp.S1 VSS sg13_lv_nmos ad=56.9f pd=0.74u as=56.9f ps=0.74u w=0.17u l=0.17u
X3880 cml_gate2_0.xrtail.R1 CKA1_N GB1_P VSS sg13_lv_nmos ad=0.1007p pd=0.91u as=0.1007p ps=0.91u w=0.53u l=0.13u
X3881 A2_2_N A2_2_P cml_tlatch_60.xmux.xp.S1 VSS sg13_lv_nmos ad=56.9f pd=0.74u as=56.9f ps=0.74u w=0.17u l=0.17u
X3882 cml_tlatch_89.xtail.S1 CKA3_P cml_tlatch_89.xmux.xp.S1 VSS sg13_lv_nmos ad=89.3f pd=0.85u as=89.3f ps=0.85u w=0.47u l=0.16u
X3883 cml_tlatch_47.xmux.xp.S1 B2_2_P B2_2_N VSS sg13_lv_nmos ad=56.9f pd=0.74u as=56.9f ps=0.74u w=0.17u l=0.17u
X3884 MOT0_N MOT0_P cml_tlatch_26.xmux.xp.S1 VSS sg13_lv_nmos ad=56.9f pd=0.74u as=56.9f ps=0.74u w=0.17u l=0.17u
X3885 cml_gate2_1.xamp.xn.S1 ENB1_N GB0_P VSS sg13_lv_nmos ad=0.1007p pd=0.91u as=0.1007p ps=0.91u w=0.53u l=0.13u
X3886 J2_N J1_P cml_tlatch_94.xmux.xn.S1 VSS sg13_lv_nmos ad=0.1082p pd=1.34u as=63.19999f ps=0.74u w=0.26u l=0.38u
X3887 cml_tlatch_98.xmux.xp.S1 cml_tlatch_98.OUTP cml_tlatch_98.OUTN VSS sg13_lv_nmos ad=56.9f pd=0.74u as=56.9f ps=0.74u w=0.17u l=0.17u
X3888 cml_tlatch_24.xmux.xn.S1 CKHA1_P cml_tlatch_24.xtail.S1 VSS sg13_lv_nmos ad=89.3f pd=0.85u as=89.3f ps=0.85u w=0.47u l=0.16u
X3889 cml_tlatch_15.xmux.xp.S1 CKHB0_N cml_tlatch_15.xtail.S1 VSS sg13_lv_nmos ad=89.3f pd=0.85u as=89.3f ps=0.85u w=0.47u l=0.16u
X3890 cml_tlatch_59.xtail.S1 CKA2_P cml_tlatch_59.xmux.xn.S1 VSS sg13_lv_nmos ad=89.3f pd=0.85u as=89.3f ps=0.85u w=0.47u l=0.16u
X3891 A3_8_P A3_8_N cml_tlatch_68.xmux.xp.S1 VSS sg13_lv_nmos ad=56.9f pd=0.74u as=56.9f ps=0.74u w=0.17u l=0.17u
X3892 cml_tlatch_33.OUTN A0_2_P cml_tlatch_33.xmux.xn.S1 VSS sg13_lv_nmos ad=63.19999f pd=0.74u as=0.1082p ps=1.34u w=0.26u l=0.38u
X3893 cml_tlatch_55.xmux.xp.S1 MOT22_N MOT22_P VSS sg13_lv_nmos ad=56.9f pd=0.74u as=56.9f ps=0.74u w=0.17u l=0.17u
X3894 GB1_P CKA1_N cml_gate2_0.xrtail.R1 VSS sg13_lv_nmos ad=0.1007p pd=0.91u as=0.1007p ps=0.91u w=0.53u l=0.13u
X3895 cml_tlatch_10.xmux.xp.S1 B1_8_P B1_8_N VSS sg13_lv_nmos ad=56.9f pd=0.74u as=56.9f ps=0.74u w=0.17u l=0.17u
X3896 cml_tlatch_38.xmux.xp.S1 cml_tlatch_38.OUTP cml_tlatch_38.OUTN VSS sg13_lv_nmos ad=56.9f pd=0.74u as=56.9f ps=0.74u w=0.17u l=0.17u
X3897 cml_tlatch_33.xtail.S1 CKA0_P cml_tlatch_33.xmux.xn.S1 VSS sg13_lv_nmos ad=89.3f pd=0.85u as=89.3f ps=0.85u w=0.47u l=0.16u
X3898 cml_tlatch_63.INP cml_tlatch_63.INN cml_tlatch_70.xmux.xp.S1 VSS sg13_lv_nmos ad=56.9f pd=0.74u as=56.9f ps=0.74u w=0.17u l=0.17u
X3899 cml_tlatch_79.xmux.xp.S1 MOT21_P MOT21_N VSS sg13_lv_nmos ad=56.9f pd=0.74u as=56.9f ps=0.74u w=0.17u l=0.17u
X3900 cml_tlatch_9.xmux.xp.S1 CKA0_P cml_tlatch_9.xtail.S1 VSS sg13_lv_nmos ad=0.1598p pd=1.62u as=89.3f ps=0.85u w=0.47u l=0.16u
X3901 cml_tlatch_64.xmux.xn.S1 cml_tlatch_65.OUTP B3_8_N VSS sg13_lv_nmos ad=63.19999f pd=0.74u as=0.1082p ps=1.34u w=0.26u l=0.38u
X3902 cml_tlatch_81.xtail.S1 CKB2_N cml_tlatch_81.xmux.xn.S1 VSS sg13_lv_nmos ad=89.3f pd=0.85u as=89.3f ps=0.85u w=0.47u l=0.16u
X3903 cml_tlatch_40.xmux.xn.S1 cml_tlatch_41.OUTP A1_2_N VSS sg13_lv_nmos ad=63.19999f pd=0.74u as=63.19999f ps=0.74u w=0.26u l=0.38u
X3904 cml_tlatch_92.xtail.S1 CKJ_P cml_tlatch_92.xmux.xp.S1 VSS sg13_lv_nmos ad=89.3f pd=0.85u as=89.3f ps=0.85u w=0.47u l=0.16u
X3905 ENB_P J2_N cml_gate2_8.xamp.xn.S1 VSS sg13_lv_nmos ad=0.1007p pd=0.91u as=0.1007p ps=0.91u w=0.53u l=0.13u
X3906 cml_drvb_4.xrtail.R2 GA3_N CKHA3_P VSS sg13_lv_nmos ad=0.1463p pd=1.15u as=0.2618p ps=2.22u w=0.77u l=0.21u
X3907 cml_tlatch_92.xmux.xp.S1 J4_N J4_P VSS sg13_lv_nmos ad=56.9f pd=0.74u as=56.9f ps=0.74u w=0.17u l=0.17u
X3908 cml_tlatch_80.xtail.S1 CKHB2_P cml_tlatch_80.xmux.xn.S1 VSS sg13_lv_nmos ad=89.3f pd=0.85u as=89.3f ps=0.85u w=0.47u l=0.16u
X3909 cml_tlatch_46.xtail.S1 CKB2_P cml_tlatch_46.xmux.xn.S1 VSS sg13_lv_nmos ad=0.1598p pd=1.62u as=89.3f ps=0.85u w=0.47u l=0.16u
X3910 cml_tlatch_8.OUTN cml_tlatch_98.OUTP cml_tlatch_8.xmux.xn.S1 VSS sg13_lv_nmos ad=63.19999f pd=0.74u as=63.19999f ps=0.74u w=0.26u l=0.38u
X3911 cml_tlatch_24.xmux.xp.S1 MOT12_P MOT12_N VSS sg13_lv_nmos ad=56.9f pd=0.74u as=56.9f ps=0.74u w=0.17u l=0.17u
X3912 cml_tlatch_66.xtail.S1 CKB3_P cml_tlatch_66.xmux.xp.S1 VSS sg13_lv_nmos ad=89.3f pd=0.85u as=89.3f ps=0.85u w=0.47u l=0.16u
X3913 cml_tlatch_4.INP cml_tlatch_4.INN cml_tlatch_12.xmux.xp.S1 VSS sg13_lv_nmos ad=56.9f pd=0.74u as=56.9f ps=0.74u w=0.17u l=0.17u
X3914 ENA1_N ENA_P cml_drv_1.xrtail.R1 VSS sg13_lv_nmos ad=0.1012p pd=1.34u as=56.2f ps=0.74u w=0.16u l=0.19u
X3915 cml_tlatch_35.xmux.xp.S1 stub_bi_29.BOTP stub_bi_29.BOTN VSS sg13_lv_nmos ad=56.9f pd=0.74u as=56.9f ps=0.74u w=0.17u l=0.17u
X3916 stub_bi_63.BOTN stub_bi_49.BOTP cml_tlatch_83.xmux.xn.S1 VSS sg13_lv_nmos ad=63.19999f pd=0.74u as=63.19999f ps=0.74u w=0.26u l=0.38u
X3917 cml_tlatch_18.OUTN cml_tlatch_18.OUTP cml_tlatch_18.xmux.xp.S1 VSS sg13_lv_nmos ad=56.9f pd=0.74u as=56.9f ps=0.74u w=0.17u l=0.17u
X3918 cml_tlatch_67.OUTP cml_tlatch_67.OUTN cml_tlatch_67.xmux.xp.S1 VSS sg13_lv_nmos ad=56.9f pd=0.74u as=56.9f ps=0.74u w=0.17u l=0.17u
X3919 cml_tlatch_69.OUTP cml_tlatch_69.OUTN cml_tlatch_69.xmux.xp.S1 VSS sg13_lv_nmos ad=56.9f pd=0.74u as=56.9f ps=0.74u w=0.17u l=0.17u
X3920 cml_tlatch_18.xtail.S1 CKA0_N cml_tlatch_18.xmux.xp.S1 VSS sg13_lv_nmos ad=89.3f pd=0.85u as=89.3f ps=0.85u w=0.47u l=0.16u
X3921 cml_tlatch_69.xtail.S1 POLN VSS VSS sg13_lv_nmos ad=1.5637p pd=8.61u as=1.5637p ps=8.61u w=8.23u l=0.13u
X3922 cml_tlatch_41.xmux.xp.S1 cml_tlatch_41.OUTN cml_tlatch_41.OUTP VSS sg13_lv_nmos ad=56.9f pd=0.74u as=56.9f ps=0.74u w=0.17u l=0.17u
X3923 cml_tlatch_11.xtail.S1 CKB1_N cml_tlatch_11.xmux.xp.S1 VSS sg13_lv_nmos ad=89.3f pd=0.85u as=89.3f ps=0.85u w=0.47u l=0.16u
X3924 cml_tlatch_74.INN cml_tlatch_74.INP cml_tlatch_88.xmux.xp.S1 VSS sg13_lv_nmos ad=56.9f pd=0.74u as=56.9f ps=0.74u w=0.17u l=0.17u
X3925 cml_tlatch_30.xmux.xn.S1 B0_2_N cml_tlatch_30.OUTP VSS sg13_lv_nmos ad=63.19999f pd=0.74u as=63.19999f ps=0.74u w=0.26u l=0.38u
X3926 cml_tlatch_91.xmux.xp.S1 cml_tlatch_91.OUTP cml_tlatch_91.OUTN VSS sg13_lv_nmos ad=56.9f pd=0.74u as=56.9f ps=0.74u w=0.17u l=0.17u
X3927 cml_tlatch_78.xmux.xn.S1 stub_bi_63.BOTN MOT19_N VSS sg13_lv_nmos ad=63.19999f pd=0.74u as=63.19999f ps=0.74u w=0.26u l=0.38u
X3928 cml_tlatch_32.OUTP cml_tlatch_32.OUTN cml_tlatch_32.xmux.xp.S1 VSS sg13_lv_nmos ad=56.9f pd=0.74u as=56.9f ps=0.74u w=0.17u l=0.17u
X3929 cml_tlatch_12.xmux.xn.S1 stub_bi_17.BOTN cml_tlatch_4.INN VSS sg13_lv_nmos ad=63.19999f pd=0.74u as=0.1082p ps=1.34u w=0.26u l=0.38u
X3930 cml_drvb_9.xrtail.R2 VSS VSS rppd l=2.72u w=1u
X3931 cml_tlatch_30.xmux.xn.S1 B0_2_N cml_tlatch_30.OUTP VSS sg13_lv_nmos ad=63.19999f pd=0.74u as=63.19999f ps=0.74u w=0.26u l=0.38u
X3932 cml_tlatch_20.xmux.xp.S1 cml_tlatch_20.OUTN cml_tlatch_20.OUTP VSS sg13_lv_nmos ad=56.9f pd=0.74u as=56.9f ps=0.74u w=0.17u l=0.17u
X3933 stub_bi_15.BOTN stub_bi_15.BOTP cml_tlatch_11.xmux.xp.S1 VSS sg13_lv_nmos ad=56.9f pd=0.74u as=56.9f ps=0.74u w=0.17u l=0.17u
X3934 J1_P J1_N cml_tlatch_95.xmux.xp.S1 VSS sg13_lv_nmos ad=56.9f pd=0.74u as=56.9f ps=0.74u w=0.17u l=0.17u
X3935 cml_tlatch_82.xmux.xn.S1 stub_bi_63.BOTP stub_bi_62.BOTN VSS sg13_lv_nmos ad=0.1082p pd=1.34u as=63.19999f ps=0.74u w=0.26u l=0.38u
X3936 cml_tlatch_89.xmux.xn.S1 cml_tlatch_56.OUTP cml_tlatch_44.INN VSS sg13_lv_nmos ad=63.19999f pd=0.74u as=63.19999f ps=0.74u w=0.26u l=0.38u
X3937 cml_tlatch_12.xtail.S1 CKB1_N cml_tlatch_12.xmux.xn.S1 VSS sg13_lv_nmos ad=89.3f pd=0.85u as=89.3f ps=0.85u w=0.47u l=0.16u
X3938 cml_tlatch_62.xtail.S1 CKHA3_N cml_tlatch_62.xmux.xp.S1 VSS sg13_lv_nmos ad=89.3f pd=0.85u as=89.3f ps=0.85u w=0.47u l=0.16u
X3939 cml_tlatch_65.xmux.xp.S1 cml_tlatch_65.OUTP cml_tlatch_65.OUTN VSS sg13_lv_nmos ad=56.9f pd=0.74u as=56.9f ps=0.74u w=0.17u l=0.17u
X3940 B3_2_P cml_tlatch_51.OUTN cml_tlatch_50.xmux.xn.S1 VSS sg13_lv_nmos ad=63.19999f pd=0.74u as=63.19999f ps=0.74u w=0.26u l=0.38u
X3941 cml_gate2_4.xamp.xn.S1 ENA1_N GA3_P VSS sg13_lv_nmos ad=0.1007p pd=0.91u as=0.1007p ps=0.91u w=0.53u l=0.13u
X3942 cml_tlatch_13.xmux.xp.S1 stub_bi_17.BOTP stub_bi_17.BOTN VSS sg13_lv_nmos ad=0.1019p pd=1.34u as=56.9f ps=0.74u w=0.17u l=0.17u
X3943 B3_8_N B3_8_P cml_tlatch_64.xmux.xp.S1 VSS sg13_lv_nmos ad=56.9f pd=0.74u as=56.9f ps=0.74u w=0.17u l=0.17u
X3944 cml_tlatch_60.xmux.xp.S1 A2_2_N A2_2_P VSS sg13_lv_nmos ad=56.9f pd=0.74u as=56.9f ps=0.74u w=0.17u l=0.17u
X3945 GA2_N ENA1_P cml_gate2_5.xamp.xn.S1 VSS sg13_lv_nmos ad=0.1802p pd=1.74u as=0.1007p ps=0.91u w=0.53u l=0.13u
X3946 cml_tlatch_8.xmux.xp.S1 cml_tlatch_8.OUTP cml_tlatch_8.OUTN VSS sg13_lv_nmos ad=56.9f pd=0.74u as=56.9f ps=0.74u w=0.17u l=0.17u
X3947 ENA_P NM1_N cml_gate2_9.xrtail.R1 VSS sg13_lv_nmos ad=0.1802p pd=1.74u as=0.1007p ps=0.91u w=0.53u l=0.13u
X3948 cml_tlatch_53.xmux.xp.S1 MOT18_N MOT18_P VSS sg13_lv_nmos ad=56.9f pd=0.74u as=56.9f ps=0.74u w=0.17u l=0.17u
X3949 cml_tlatch_61.xmux.xn.S1 CKA2_P cml_tlatch_61.xtail.S1 VSS sg13_lv_nmos ad=89.3f pd=0.85u as=89.3f ps=0.85u w=0.47u l=0.16u
X3950 cml_tlatch_61.OUTN cml_tlatch_61.OUTP cml_tlatch_61.xmux.xp.S1 VSS sg13_lv_nmos ad=56.9f pd=0.74u as=56.9f ps=0.74u w=0.17u l=0.17u
X3951 cml_tlatch_2.xmux.xn.S1 cml_tlatch_7.OUTN cml_tlatch_2.OUTP VSS sg13_lv_nmos ad=63.19999f pd=0.74u as=63.19999f ps=0.74u w=0.26u l=0.38u
X3952 cml_tlatch_2.OUTP cml_tlatch_2.OUTN cml_tlatch_2.xmux.xp.S1 VSS sg13_lv_nmos ad=56.9f pd=0.74u as=56.9f ps=0.74u w=0.17u l=0.17u
X3953 cml_tlatch_96.xmux.xp.S1 CKB1_P cml_tlatch_96.xtail.S1 VSS sg13_lv_nmos ad=89.3f pd=0.85u as=89.3f ps=0.85u w=0.47u l=0.16u
X3954 cml_tlatch_47.xtail.S1 CKB2_N cml_tlatch_47.xmux.xn.S1 VSS sg13_lv_nmos ad=89.3f pd=0.85u as=89.3f ps=0.85u w=0.47u l=0.16u
X3955 cml_tlatch_12.xmux.xp.S1 cml_tlatch_4.INP cml_tlatch_4.INN VSS sg13_lv_nmos ad=56.9f pd=0.74u as=56.9f ps=0.74u w=0.17u l=0.17u
X3956 cml_tlatch_50.xmux.xp.S1 CKB3_P cml_tlatch_50.xtail.S1 VSS sg13_lv_nmos ad=89.3f pd=0.85u as=89.3f ps=0.85u w=0.47u l=0.16u
X3957 cml_tlatch_23.xmux.xp.S1 cml_tlatch_23.OUTP cml_tlatch_23.OUTN VSS sg13_lv_nmos ad=56.9f pd=0.74u as=56.9f ps=0.74u w=0.17u l=0.17u
X3958 VSS POLN cml_tlatch_51.xtail.S1 VSS sg13_lv_nmos ad=1.5637p pd=8.61u as=1.5637p ps=8.61u w=8.23u l=0.13u
X3959 cml_tlatch_49.OUTP cml_tlatch_49.OUTN cml_tlatch_49.xmux.xp.S1 VSS sg13_lv_nmos ad=56.9f pd=0.74u as=56.9f ps=0.74u w=0.17u l=0.17u
X3960 cml_tlatch_69.xmux.xn.S1 CKA3_P cml_tlatch_69.xtail.S1 VSS sg13_lv_nmos ad=0.1598p pd=1.62u as=89.3f ps=0.85u w=0.47u l=0.16u
X3961 MOT25_P VDD VSS rppd l=5.17u w=1u
X3962 cml_tlatch_43.xmux.xp.S1 MOT10_N MOT10_P VSS sg13_lv_nmos ad=56.9f pd=0.74u as=56.9f ps=0.74u w=0.17u l=0.17u
X3963 cml_tlatch_24.xmux.xp.S1 CKHA1_N cml_tlatch_24.xtail.S1 VSS sg13_lv_nmos ad=89.3f pd=0.85u as=89.3f ps=0.85u w=0.47u l=0.16u
X3964 cml_tlatch_15.xmux.xn.S1 CKHB0_P cml_tlatch_15.xtail.S1 VSS sg13_lv_nmos ad=89.3f pd=0.85u as=89.3f ps=0.85u w=0.47u l=0.16u
X3965 cml_tlatch_22.xtail.S1 CKA1_N cml_tlatch_22.xmux.xp.S1 VSS sg13_lv_nmos ad=89.3f pd=0.85u as=89.3f ps=0.85u w=0.47u l=0.16u
X3966 A3_8_P A3_8_N cml_tlatch_68.xmux.xp.S1 VSS sg13_lv_nmos ad=56.9f pd=0.74u as=56.9f ps=0.74u w=0.17u l=0.17u
X3967 cml_tlatch_77.xtail.S1 CKHB2_P cml_tlatch_77.xmux.xn.S1 VSS sg13_lv_nmos ad=89.3f pd=0.85u as=89.3f ps=0.85u w=0.47u l=0.16u
X3968 cml_tlatch_64.xmux.xp.S1 B3_8_N B3_8_P VSS sg13_lv_nmos ad=56.9f pd=0.74u as=56.9f ps=0.74u w=0.17u l=0.17u
X3969 cml_tlatch_58.OUTP cml_tlatch_58.OUTN cml_tlatch_58.xmux.xp.S1 VSS sg13_lv_nmos ad=56.9f pd=0.74u as=56.9f ps=0.74u w=0.17u l=0.17u
X3970 cml_tlatch_40.xmux.xp.S1 A1_2_P A1_2_N VSS sg13_lv_nmos ad=56.9f pd=0.74u as=56.9f ps=0.74u w=0.17u l=0.17u
X3971 ENB0_N ENB_P cml_drv_2.xrtail.R1 VSS sg13_lv_nmos ad=56.2f pd=0.74u as=0.1012p ps=1.34u w=0.16u l=0.19u
X3972 cml_tlatch_70.xtail.S1 CKA3_N cml_tlatch_70.xmux.xn.S1 VSS sg13_lv_nmos ad=89.3f pd=0.85u as=89.3f ps=0.85u w=0.47u l=0.16u
X3973 cml_tlatch_55.xmux.xp.S1 MOT22_N MOT22_P VSS sg13_lv_nmos ad=0.1019p pd=1.34u as=56.9f ps=0.74u w=0.17u l=0.17u
X3974 cml_tlatch_52.xmux.xp.S1 MOT16_P MOT16_N VSS sg13_lv_nmos ad=56.9f pd=0.74u as=56.9f ps=0.74u w=0.17u l=0.17u
X3975 MOT30_P MOT30_N cml_tlatch_45.xmux.xp.S1 VSS sg13_lv_nmos ad=56.9f pd=0.74u as=56.9f ps=0.74u w=0.17u l=0.17u
X3976 MOT17_N B2_8_P cml_tlatch_77.xmux.xn.S1 VSS sg13_lv_nmos ad=63.19999f pd=0.74u as=63.19999f ps=0.74u w=0.26u l=0.38u
X3977 cml_tlatch_17.xmux.xn.S1 B0_2_N MOT7_P VSS sg13_lv_nmos ad=63.19999f pd=0.74u as=63.19999f ps=0.74u w=0.26u l=0.38u
X3978 cml_tlatch_38.xmux.xp.S1 cml_tlatch_38.OUTP cml_tlatch_38.OUTN VSS sg13_lv_nmos ad=0.1019p pd=1.34u as=56.9f ps=0.74u w=0.17u l=0.17u
X3979 cml_tlatch_43.xmux.xn.S1 cml_tlatch_43.INP MOT10_N VSS sg13_lv_nmos ad=63.19999f pd=0.74u as=0.1082p ps=1.34u w=0.26u l=0.38u
X3980 cml_tlatch_97.INN cml_tlatch_97.INP cml_tlatch_39.xmux.xp.S1 VSS sg13_lv_nmos ad=56.9f pd=0.74u as=56.9f ps=0.74u w=0.17u l=0.17u
X3981 stub_bi_49.BOTP stub_bi_49.BOTN cml_tlatch_84.xmux.xp.S1 VSS sg13_lv_nmos ad=56.9f pd=0.74u as=56.9f ps=0.74u w=0.17u l=0.17u
X3982 cml_tlatch_61.xmux.xn.S1 D2_N cml_tlatch_61.OUTP VSS sg13_lv_nmos ad=63.19999f pd=0.74u as=63.19999f ps=0.74u w=0.26u l=0.38u
X3983 MOT1_P MOT1_N cml_tlatch_14.xmux.xp.S1 VSS sg13_lv_nmos ad=56.9f pd=0.74u as=56.9f ps=0.74u w=0.17u l=0.17u
X3984 cml_tlatch_6.xmux.xn.S1 CKHB1_P cml_tlatch_6.xtail.S1 VSS sg13_lv_nmos ad=89.3f pd=0.85u as=89.3f ps=0.85u w=0.47u l=0.16u
X3985 cml_tlatch_41.xmux.xp.S1 cml_tlatch_41.OUTN cml_tlatch_41.OUTP VSS sg13_lv_nmos ad=56.9f pd=0.74u as=56.9f ps=0.74u w=0.17u l=0.17u
X3986 B1_8_P B1_8_N cml_tlatch_10.xmux.xp.S1 VSS sg13_lv_nmos ad=56.9f pd=0.74u as=56.9f ps=0.74u w=0.17u l=0.17u
X3987 stub_bi_31.BOTN stub_bi_31.BOTP cml_tlatch_37.xmux.xp.S1 VSS sg13_lv_nmos ad=56.9f pd=0.74u as=56.9f ps=0.74u w=0.17u l=0.17u
X3988 cml_tlatch_25.xmux.xp.S1 MOT14_N MOT14_P VSS sg13_lv_nmos ad=56.9f pd=0.74u as=56.9f ps=0.74u w=0.17u l=0.17u
X3989 cml_tlatch_92.xtail.S1 CKJ_N cml_tlatch_92.xmux.xn.S1 VSS sg13_lv_nmos ad=89.3f pd=0.85u as=89.3f ps=0.85u w=0.47u l=0.16u
X3990 cml_tlatch_0.OUTP cml_tlatch_0.OUTN cml_tlatch_0.xmux.xp.S1 VSS sg13_lv_nmos ad=56.9f pd=0.74u as=56.9f ps=0.74u w=0.17u l=0.17u
X3991 cml_tlatch_17.xmux.xp.S1 MOT7_P MOT7_N VSS sg13_lv_nmos ad=56.9f pd=0.74u as=56.9f ps=0.74u w=0.17u l=0.17u
X3992 cml_tlatch_61.xmux.xn.S1 D2_N cml_tlatch_61.OUTP VSS sg13_lv_nmos ad=63.19999f pd=0.74u as=63.19999f ps=0.74u w=0.26u l=0.38u
X3993 cml_gate2_0.xamp.xn.S1 ENB1_N GB1_P VSS sg13_lv_nmos ad=0.1007p pd=0.91u as=0.1007p ps=0.91u w=0.53u l=0.13u
X3994 cml_tlatch_93.xmux.xp.S1 CKJ_N cml_tlatch_93.xtail.S1 VSS sg13_lv_nmos ad=89.3f pd=0.85u as=89.3f ps=0.85u w=0.47u l=0.16u
X3995 cml_tlatch_23.OUTP cml_tlatch_23.OUTN cml_tlatch_23.xmux.xp.S1 VSS sg13_lv_nmos ad=56.9f pd=0.74u as=0.1019p ps=1.34u w=0.17u l=0.17u
X3996 cml_tlatch_69.xmux.xp.S1 CKA3_N cml_tlatch_69.xtail.S1 VSS sg13_lv_nmos ad=89.3f pd=0.85u as=89.3f ps=0.85u w=0.47u l=0.16u
X3997 VSS hs_to_clk_4.sg13_lv_nmos_2HGZLP_0.G VSS VSS sg13_lv_nmos ad=2.071p pd=11.28u as=0 ps=0 w=10.9u l=1.38u
X3998 VDD ENA0_P VSS rppd l=8.13u w=1u
X3999 cml_tlatch_91.xtail.S1 CKA2_N cml_tlatch_91.xmux.xn.S1 VSS sg13_lv_nmos ad=89.3f pd=0.85u as=89.3f ps=0.85u w=0.47u l=0.16u
X4000 A1_8_P cml_tlatch_20.OUTN cml_tlatch_19.xmux.xn.S1 VSS sg13_lv_nmos ad=0.1082p pd=1.34u as=63.19999f ps=0.74u w=0.26u l=0.38u
X4001 cml_tlatch_81.xmux.xp.S1 B2_8_P B2_8_N VSS sg13_lv_nmos ad=56.9f pd=0.74u as=56.9f ps=0.74u w=0.17u l=0.17u
X4002 hs_to_clk_0.sg13_lv_nmos_2HGZLP_0.G CKA0_N VSS rppd l=4.25u w=1u
X4003 cml_tlatch_91.xmux.xp.S1 cml_tlatch_91.OUTP cml_tlatch_91.OUTN VSS sg13_lv_nmos ad=56.9f pd=0.74u as=56.9f ps=0.74u w=0.17u l=0.17u
X4004 B0_2_N cml_tlatch_32.OUTP cml_tlatch_31.xmux.xn.S1 VSS sg13_lv_nmos ad=63.19999f pd=0.74u as=63.19999f ps=0.74u w=0.26u l=0.38u
X4005 cml_tlatch_99.OUTP cml_tlatch_99.OUTN cml_tlatch_99.xmux.xp.S1 VSS sg13_lv_nmos ad=56.9f pd=0.74u as=56.9f ps=0.74u w=0.17u l=0.17u
X4006 cml_tlatch_11.xtail.S1 POLN VSS VSS sg13_lv_nmos ad=1.5637p pd=8.61u as=2.7982p ps=17.14u w=8.23u l=0.13u
X4007 cml_tlatch_56.OUTN cml_tlatch_56.OUTP cml_tlatch_56.xmux.xp.S1 VSS sg13_lv_nmos ad=56.9f pd=0.74u as=56.9f ps=0.74u w=0.17u l=0.17u
X4008 cml_tlatch_22.OUTP cml_tlatch_24.INN cml_tlatch_22.xmux.xn.S1 VSS sg13_lv_nmos ad=63.19999f pd=0.74u as=0.1082p ps=1.34u w=0.26u l=0.38u
X4009 MOT20_P MOT20_N cml_tlatch_54.xmux.xp.S1 VSS sg13_lv_nmos ad=56.9f pd=0.74u as=56.9f ps=0.74u w=0.17u l=0.17u
X4010 cml_tlatch_87.xtail.S1 POLN VSS VSS sg13_lv_nmos ad=1.5637p pd=8.61u as=2.7982p ps=17.14u w=8.23u l=0.13u
X4011 cml_tlatch_45.xmux.xp.S1 MOT30_P MOT30_N VSS sg13_lv_nmos ad=0.1019p pd=1.34u as=56.9f ps=0.74u w=0.17u l=0.17u
X4012 stub_bi_43.BOTP stub_bi_43.BOTN cml_tlatch_48.xmux.xp.S1 VSS sg13_lv_nmos ad=56.9f pd=0.74u as=56.9f ps=0.74u w=0.17u l=0.17u
X4013 cml_tlatch_65.xmux.xp.S1 CKB3_N cml_tlatch_65.xtail.S1 VSS sg13_lv_nmos ad=89.3f pd=0.85u as=89.3f ps=0.85u w=0.47u l=0.16u
X4014 cml_tlatch_90.xtail.S1 CKB2_N cml_tlatch_90.xmux.xn.S1 VSS sg13_lv_nmos ad=89.3f pd=0.85u as=89.3f ps=0.85u w=0.47u l=0.16u
X4015 cml_tlatch_74.xmux.xn.S1 cml_tlatch_74.INP MOT29_N VSS sg13_lv_nmos ad=63.19999f pd=0.74u as=63.19999f ps=0.74u w=0.26u l=0.38u
X4016 MOT11_P MOT11_N cml_tlatch_4.xmux.xp.S1 VSS sg13_lv_nmos ad=56.9f pd=0.74u as=56.9f ps=0.74u w=0.17u l=0.17u
X4017 cml_tlatch_46.xmux.xp.S1 stub_bi_38.BOTP stub_bi_38.BOTN VSS sg13_lv_nmos ad=56.9f pd=0.74u as=56.9f ps=0.74u w=0.17u l=0.17u
X4018 MOT12_P MOT12_N cml_tlatch_24.xmux.xp.S1 VSS sg13_lv_nmos ad=56.9f pd=0.74u as=56.9f ps=0.74u w=0.17u l=0.17u
X4019 cml_tlatch_97.xmux.xn.S1 cml_tlatch_97.INN cml_tlatch_24.INP VSS sg13_lv_nmos ad=63.19999f pd=0.74u as=63.19999f ps=0.74u w=0.26u l=0.38u
X4020 cml_drvb_9.xrtail.R2 CLK_W_N NM1_P VSS sg13_lv_nmos ad=0.1463p pd=1.15u as=0.2618p ps=2.22u w=0.77u l=0.21u
X4021 cml_tlatch_81.xmux.xn.S1 CKB2_N cml_tlatch_81.xtail.S1 VSS sg13_lv_nmos ad=89.3f pd=0.85u as=89.3f ps=0.85u w=0.47u l=0.16u
X4022 cml_tlatch_74.xmux.xn.S1 cml_tlatch_74.INP MOT29_N VSS sg13_lv_nmos ad=63.19999f pd=0.74u as=63.19999f ps=0.74u w=0.26u l=0.38u
X4023 cml_tlatch_80.xmux.xn.S1 CKHB2_P cml_tlatch_80.xtail.S1 VSS sg13_lv_nmos ad=89.3f pd=0.85u as=89.3f ps=0.85u w=0.47u l=0.16u
X4024 cml_gate2_3.xrtail.R1 CKB0_P cml_gate2_3.xamp.xn.S1 VSS sg13_lv_nmos ad=0.1007p pd=0.91u as=0.1007p ps=0.91u w=0.53u l=0.13u
X4025 MOT17_N MOT17_P cml_tlatch_77.xmux.xp.S1 VSS sg13_lv_nmos ad=56.9f pd=0.74u as=56.9f ps=0.74u w=0.17u l=0.17u
X4026 cml_gate2_9.xrtail.R1 NM1_N ENA_P VSS sg13_lv_nmos ad=0.1007p pd=0.91u as=0.1007p ps=0.91u w=0.53u l=0.13u
X4027 cml_tlatch_68.xmux.xn.S1 CKA3_N cml_tlatch_68.xtail.S1 VSS sg13_lv_nmos ad=89.3f pd=0.85u as=0.1598p ps=1.62u w=0.47u l=0.16u
X4028 cml_tlatch_1.xmux.xp.S1 B0_8_P B0_8_N VSS sg13_lv_nmos ad=56.9f pd=0.74u as=56.9f ps=0.74u w=0.17u l=0.17u
X4029 cml_tlatch_7.xtail.S1 POLN VSS VSS sg13_lv_nmos ad=1.5637p pd=8.61u as=1.5637p ps=8.61u w=8.23u l=0.13u
X4030 A3_2_N A3_2_P cml_tlatch_57.xmux.xp.S1 VSS sg13_lv_nmos ad=56.9f pd=0.74u as=56.9f ps=0.74u w=0.17u l=0.17u
X4031 stub_bi_55.BOTN stub_bi_55.BOTP cml_tlatch_90.xmux.xp.S1 VSS sg13_lv_nmos ad=56.9f pd=0.74u as=56.9f ps=0.74u w=0.17u l=0.17u
X4032 cml_tlatch_7.OUTN cml_tlatch_7.OUTP cml_tlatch_7.xmux.xp.S1 VSS sg13_lv_nmos ad=56.9f pd=0.74u as=56.9f ps=0.74u w=0.17u l=0.17u
X4033 cml_tlatch_62.xmux.xp.S1 MOT24_P MOT24_N VSS sg13_lv_nmos ad=56.9f pd=0.74u as=56.9f ps=0.74u w=0.17u l=0.17u
X4034 cml_tlatch_38.xtail.S1 POLN VSS VSS sg13_lv_nmos ad=1.5637p pd=8.61u as=1.5637p ps=8.61u w=8.23u l=0.13u
X4035 B2_2_P B2_2_N cml_tlatch_47.xmux.xp.S1 VSS sg13_lv_nmos ad=56.9f pd=0.74u as=56.9f ps=0.74u w=0.17u l=0.17u
X4036 cml_tlatch_38.xmux.xp.S1 CKA0_N cml_tlatch_38.xtail.S1 VSS sg13_lv_nmos ad=89.3f pd=0.85u as=89.3f ps=0.85u w=0.47u l=0.16u
X4037 cml_tlatch_39.xmux.xp.S1 cml_tlatch_97.INP cml_tlatch_97.INN VSS sg13_lv_nmos ad=0.1019p pd=1.34u as=56.9f ps=0.74u w=0.17u l=0.17u
X4038 cml_tlatch_78.xtail.S1 CKHB2_N cml_tlatch_78.xmux.xp.S1 VSS sg13_lv_nmos ad=89.3f pd=0.85u as=89.3f ps=0.85u w=0.47u l=0.16u
X4039 cml_tlatch_48.xtail.S1 POLN VSS VSS sg13_lv_nmos ad=1.5637p pd=8.61u as=1.5637p ps=8.61u w=8.23u l=0.13u
X4040 cml_tlatch_34.xtail.S1 CKA0_P cml_tlatch_34.xmux.xp.S1 VSS sg13_lv_nmos ad=89.3f pd=0.85u as=89.3f ps=0.85u w=0.47u l=0.16u
X4041 cml_gate2_5.xamp.xn.S1 ENA1_N GA2_P VSS sg13_lv_nmos ad=0.1007p pd=0.91u as=0.1007p ps=0.91u w=0.53u l=0.13u
X4042 cml_tlatch_31.xmux.xp.S1 B0_2_N B0_2_P VSS sg13_lv_nmos ad=56.9f pd=0.74u as=56.9f ps=0.74u w=0.17u l=0.17u
X4043 cml_tlatch_7.OUTN cml_tlatch_8.OUTP cml_tlatch_7.xmux.xn.S1 VSS sg13_lv_nmos ad=63.19999f pd=0.74u as=63.19999f ps=0.74u w=0.26u l=0.38u
X4044 MOT26_P MOT26_N cml_tlatch_63.xmux.xp.S1 VSS sg13_lv_nmos ad=56.9f pd=0.74u as=56.9f ps=0.74u w=0.17u l=0.17u
X4045 cml_tlatch_75.xmux.xn.S1 CKHB3_P cml_tlatch_75.xtail.S1 VSS sg13_lv_nmos ad=89.3f pd=0.85u as=89.3f ps=0.85u w=0.47u l=0.16u
X4046 cml_tlatch_81.xmux.xp.S1 B2_8_P B2_8_N VSS sg13_lv_nmos ad=56.9f pd=0.74u as=56.9f ps=0.74u w=0.17u l=0.17u
X4047 MOT4_P cml_tlatch_99.OUTN cml_tlatch_28.xmux.xn.S1 VSS sg13_lv_nmos ad=63.19999f pd=0.74u as=63.19999f ps=0.74u w=0.26u l=0.38u
X4048 MOT27_P MOT27_N cml_tlatch_73.xmux.xp.S1 VSS sg13_lv_nmos ad=56.9f pd=0.74u as=56.9f ps=0.74u w=0.17u l=0.17u
X4049 cml_tlatch_93.xmux.xp.S1 CLK_W_P CLK_W_N VSS sg13_lv_nmos ad=56.9f pd=0.74u as=56.9f ps=0.74u w=0.17u l=0.17u
X4050 cml_tlatch_71.xmux.xp.S1 cml_tlatch_71.OUTP cml_tlatch_71.OUTN VSS sg13_lv_nmos ad=56.9f pd=0.74u as=56.9f ps=0.74u w=0.17u l=0.17u
X4051 cml_tlatch_3.xmux.xn.S1 CKHB1_P cml_tlatch_3.xtail.S1 VSS sg13_lv_nmos ad=89.3f pd=0.85u as=89.3f ps=0.85u w=0.47u l=0.16u
X4052 cml_tlatch_43.xmux.xp.S1 MOT10_N MOT10_P VSS sg13_lv_nmos ad=56.9f pd=0.74u as=56.9f ps=0.74u w=0.17u l=0.17u
X4053 cml_tlatch_12.xmux.xn.S1 CKB1_N cml_tlatch_12.xtail.S1 VSS sg13_lv_nmos ad=89.3f pd=0.85u as=89.3f ps=0.85u w=0.47u l=0.16u
X4054 cml_tlatch_87.xmux.xp.S1 cml_tlatch_87.OUTN cml_tlatch_87.OUTP VSS sg13_lv_nmos ad=56.9f pd=0.74u as=56.9f ps=0.74u w=0.17u l=0.17u
X4055 cml_tlatch_98.xtail.S1 CKB0_N cml_tlatch_98.xmux.xn.S1 VSS sg13_lv_nmos ad=89.3f pd=0.85u as=89.3f ps=0.85u w=0.47u l=0.16u
X4056 MOT3_N MOT3_P cml_tlatch_15.xmux.xp.S1 VSS sg13_lv_nmos ad=56.9f pd=0.74u as=0.1019p ps=1.34u w=0.17u l=0.17u
X4057 cml_tlatch_22.OUTN cml_tlatch_22.OUTP cml_tlatch_22.xmux.xp.S1 VSS sg13_lv_nmos ad=56.9f pd=0.74u as=56.9f ps=0.74u w=0.17u l=0.17u
X4058 stub_bi_62.BOTP stub_bi_62.BOTN cml_tlatch_82.xmux.xp.S1 VSS sg13_lv_nmos ad=56.9f pd=0.74u as=56.9f ps=0.74u w=0.17u l=0.17u
X4059 cml_tlatch_8.OUTN cml_tlatch_98.OUTP cml_tlatch_8.xmux.xn.S1 VSS sg13_lv_nmos ad=63.19999f pd=0.74u as=63.19999f ps=0.74u w=0.26u l=0.38u
X4060 cml_tlatch_46.xmux.xp.S1 stub_bi_38.BOTP stub_bi_38.BOTN VSS sg13_lv_nmos ad=56.9f pd=0.74u as=56.9f ps=0.74u w=0.17u l=0.17u
X4061 cml_tlatch_9.xmux.xn.S1 cml_tlatch_18.OUTP A0_8_N VSS sg13_lv_nmos ad=63.19999f pd=0.74u as=63.19999f ps=0.74u w=0.26u l=0.38u
X4062 cml_tlatch_98.xmux.xp.S1 cml_tlatch_98.OUTN cml_tlatch_98.OUTP VSS sg13_lv_nmos ad=56.9f pd=0.74u as=56.9f ps=0.74u w=0.17u l=0.17u
X4063 cml_tlatch_5.xmux.xp.S1 MOT13_N MOT13_P VSS sg13_lv_nmos ad=56.9f pd=0.74u as=56.9f ps=0.74u w=0.17u l=0.17u
X4064 cml_tlatch_0.OUTP cml_tlatch_0.OUTN cml_tlatch_0.xmux.xp.S1 VSS sg13_lv_nmos ad=56.9f pd=0.74u as=56.9f ps=0.74u w=0.17u l=0.17u
X4065 MOT20_N cml_tlatch_91.OUTP cml_tlatch_54.xmux.xn.S1 VSS sg13_lv_nmos ad=63.19999f pd=0.74u as=63.19999f ps=0.74u w=0.26u l=0.38u
X4066 cml_tlatch_80.xmux.xp.S1 MOT23_N MOT23_P VSS sg13_lv_nmos ad=56.9f pd=0.74u as=56.9f ps=0.74u w=0.17u l=0.17u
X4067 VSS POLN cml_tlatch_33.xtail.S1 VSS sg13_lv_nmos ad=1.5637p pd=8.61u as=1.5637p ps=8.61u w=8.23u l=0.13u
X4068 GA1_P ENA0_N cml_gate2_2.xamp.xn.S1 VSS sg13_lv_nmos ad=0.1802p pd=1.74u as=0.1007p ps=0.91u w=0.53u l=0.13u
X4069 cml_tlatch_22.OUTN cml_tlatch_22.OUTP cml_tlatch_22.xmux.xp.S1 VSS sg13_lv_nmos ad=56.9f pd=0.74u as=56.9f ps=0.74u w=0.17u l=0.17u
X4070 cml_tlatch_86.xmux.xp.S1 cml_tlatch_86.OUTN cml_tlatch_86.OUTP VSS sg13_lv_nmos ad=56.9f pd=0.74u as=56.9f ps=0.74u w=0.17u l=0.17u
X4071 cml_tlatch_47.xmux.xn.S1 CKB2_N cml_tlatch_47.xtail.S1 VSS sg13_lv_nmos ad=89.3f pd=0.85u as=89.3f ps=0.85u w=0.47u l=0.16u
X4072 VSS POLN cml_tlatch_21.xtail.S1 VSS sg13_lv_nmos ad=1.5637p pd=8.61u as=1.5637p ps=8.61u w=8.23u l=0.13u
X4073 cml_tlatch_21.xtail.S1 CKA1_P cml_tlatch_21.xmux.xp.S1 VSS sg13_lv_nmos ad=89.3f pd=0.85u as=89.3f ps=0.85u w=0.47u l=0.16u
X4074 cml_tlatch_57.xmux.xn.S1 CKA3_N cml_tlatch_57.xtail.S1 VSS sg13_lv_nmos ad=89.3f pd=0.85u as=0.1598p ps=1.62u w=0.47u l=0.16u
X4075 cml_tlatch_36.xmux.xn.S1 stub_bi_31.BOTP B1_2_P VSS sg13_lv_nmos ad=63.19999f pd=0.74u as=63.19999f ps=0.74u w=0.26u l=0.38u
X4076 A0_8_P A0_8_N cml_tlatch_9.xmux.xp.S1 VSS sg13_lv_nmos ad=56.9f pd=0.74u as=56.9f ps=0.74u w=0.17u l=0.17u
X4077 cml_tlatch_63.INN cml_tlatch_71.OUTP cml_tlatch_70.xmux.xn.S1 VSS sg13_lv_nmos ad=0.1082p pd=1.34u as=63.19999f ps=0.74u w=0.26u l=0.38u
X4078 cml_tlatch_34.xtail.S1 CKA0_N cml_tlatch_34.xmux.xn.S1 VSS sg13_lv_nmos ad=89.3f pd=0.85u as=89.3f ps=0.85u w=0.47u l=0.16u
X4079 cml_tlatch_16.xtail.S1 CKHB0_N cml_tlatch_16.xmux.xp.S1 VSS sg13_lv_nmos ad=89.3f pd=0.85u as=89.3f ps=0.85u w=0.47u l=0.16u
X4080 cml_tlatch_0.xtail.S1 CKA0_P cml_tlatch_0.xmux.xn.S1 VSS sg13_lv_nmos ad=89.3f pd=0.85u as=89.3f ps=0.85u w=0.47u l=0.16u
X4081 ENB1_N ENB_P cml_drv_0.xrtail.R1 VSS sg13_lv_nmos ad=56.2f pd=0.74u as=0.1012p ps=1.34u w=0.16u l=0.19u
X4082 cml_tlatch_3.xmux.xp.S1 MOT9_P MOT9_N VSS sg13_lv_nmos ad=56.9f pd=0.74u as=56.9f ps=0.74u w=0.17u l=0.17u
X4083 cml_tlatch_77.xmux.xn.S1 CKHB2_P cml_tlatch_77.xtail.S1 VSS sg13_lv_nmos ad=89.3f pd=0.85u as=89.3f ps=0.85u w=0.47u l=0.16u
X4084 cml_tlatch_74.xmux.xp.S1 MOT29_N MOT29_P VSS sg13_lv_nmos ad=56.9f pd=0.74u as=56.9f ps=0.74u w=0.17u l=0.17u
X4085 cml_tlatch_59.xmux.xp.S1 CKA2_N cml_tlatch_59.xtail.S1 VSS sg13_lv_nmos ad=89.3f pd=0.85u as=89.3f ps=0.85u w=0.47u l=0.16u
X4086 cml_tlatch_12.xtail.S1 CKB1_P cml_tlatch_12.xmux.xp.S1 VSS sg13_lv_nmos ad=89.3f pd=0.85u as=89.3f ps=0.85u w=0.47u l=0.16u
X4087 MOT25_P B3_8_N cml_tlatch_72.xmux.xn.S1 VSS sg13_lv_nmos ad=63.19999f pd=0.74u as=63.19999f ps=0.74u w=0.26u l=0.38u
X4088 MOT11_P MOT11_N cml_tlatch_4.xmux.xp.S1 VSS sg13_lv_nmos ad=56.9f pd=0.74u as=56.9f ps=0.74u w=0.17u l=0.17u
X4089 MOT12_P MOT12_N cml_tlatch_24.xmux.xp.S1 VSS sg13_lv_nmos ad=56.9f pd=0.74u as=56.9f ps=0.74u w=0.17u l=0.17u
X4090 cml_tlatch_43.INP cml_tlatch_22.OUTN cml_tlatch_21.xmux.xn.S1 VSS sg13_lv_nmos ad=63.19999f pd=0.74u as=63.19999f ps=0.74u w=0.26u l=0.38u
X4091 cml_tlatch_72.xmux.xn.S1 CKHB3_P cml_tlatch_72.xtail.S1 VSS sg13_lv_nmos ad=89.3f pd=0.85u as=89.3f ps=0.85u w=0.47u l=0.16u
X4092 cml_tlatch_16.xmux.xp.S1 MOT5_P MOT5_N VSS sg13_lv_nmos ad=56.9f pd=0.74u as=56.9f ps=0.74u w=0.17u l=0.17u
X4093 cml_tlatch_97.xmux.xp.S1 cml_tlatch_24.INN cml_tlatch_24.INP VSS sg13_lv_nmos ad=56.9f pd=0.74u as=56.9f ps=0.74u w=0.17u l=0.17u
X4094 stub_bi_55.BOTN stub_bi_55.BOTP cml_tlatch_90.xmux.xp.S1 VSS sg13_lv_nmos ad=56.9f pd=0.74u as=56.9f ps=0.74u w=0.17u l=0.17u
X4095 cml_tlatch_81.xmux.xp.S1 CKB2_P cml_tlatch_81.xtail.S1 VSS sg13_lv_nmos ad=89.3f pd=0.85u as=89.3f ps=0.85u w=0.47u l=0.16u
X4096 cml_tlatch_31.xmux.xn.S1 cml_tlatch_32.OUTN B0_2_P VSS sg13_lv_nmos ad=63.19999f pd=0.74u as=63.19999f ps=0.74u w=0.26u l=0.38u
X4097 cml_tlatch_29.xtail.S1 CKHA0_N cml_tlatch_29.xmux.xp.S1 VSS sg13_lv_nmos ad=89.3f pd=0.85u as=89.3f ps=0.85u w=0.47u l=0.16u
X4098 MOT15_N MOT15_P cml_tlatch_6.xmux.xp.S1 VSS sg13_lv_nmos ad=56.9f pd=0.74u as=56.9f ps=0.74u w=0.17u l=0.17u
X4099 cml_tlatch_68.xmux.xp.S1 CKA3_P cml_tlatch_68.xtail.S1 VSS sg13_lv_nmos ad=89.3f pd=0.85u as=89.3f ps=0.85u w=0.47u l=0.16u
X4100 cml_tlatch_31.xmux.xn.S1 cml_tlatch_32.OUTN B0_2_P VSS sg13_lv_nmos ad=63.19999f pd=0.74u as=63.19999f ps=0.74u w=0.26u l=0.38u
X4101 cml_tlatch_7.xmux.xp.S1 cml_tlatch_7.OUTN cml_tlatch_7.OUTP VSS sg13_lv_nmos ad=56.9f pd=0.74u as=56.9f ps=0.74u w=0.17u l=0.17u
X4102 cml_tlatch_2.OUTN cml_tlatch_7.OUTP cml_tlatch_2.xmux.xn.S1 VSS sg13_lv_nmos ad=63.19999f pd=0.74u as=63.19999f ps=0.74u w=0.26u l=0.38u
X4103 cml_tlatch_20.xmux.xn.S1 cml_tlatch_43.INN cml_tlatch_20.OUTP VSS sg13_lv_nmos ad=63.19999f pd=0.74u as=63.19999f ps=0.74u w=0.26u l=0.38u
X4104 cml_tlatch_29.xmux.xp.S1 MOT6_P MOT6_N VSS sg13_lv_nmos ad=56.9f pd=0.74u as=56.9f ps=0.74u w=0.17u l=0.17u
X4105 cml_tlatch_71.xmux.xp.S1 cml_tlatch_71.OUTP cml_tlatch_71.OUTN VSS sg13_lv_nmos ad=56.9f pd=0.74u as=56.9f ps=0.74u w=0.17u l=0.17u
X4106 cml_tlatch_67.OUTN cml_tlatch_67.OUTP cml_tlatch_67.xmux.xp.S1 VSS sg13_lv_nmos ad=56.9f pd=0.74u as=56.9f ps=0.74u w=0.17u l=0.17u
X4107 MOT17_P MOT17_N cml_tlatch_77.xmux.xp.S1 VSS sg13_lv_nmos ad=56.9f pd=0.74u as=56.9f ps=0.74u w=0.17u l=0.17u
X4108 cml_tlatch_82.xmux.xp.S1 stub_bi_62.BOTP stub_bi_62.BOTN VSS sg13_lv_nmos ad=56.9f pd=0.74u as=56.9f ps=0.74u w=0.17u l=0.17u
X4109 cml_tlatch_85.xmux.xp.S1 A2_8_N A2_8_P VSS sg13_lv_nmos ad=56.9f pd=0.74u as=56.9f ps=0.74u w=0.17u l=0.17u
X4110 cml_gate2_8.xamp.xn.S1 J2_N ENB_P VSS sg13_lv_nmos ad=0.1007p pd=0.91u as=0.1802p ps=1.74u w=0.53u l=0.13u
X4111 A2_2_P cml_tlatch_61.OUTN cml_tlatch_60.xmux.xn.S1 VSS sg13_lv_nmos ad=63.19999f pd=0.74u as=63.19999f ps=0.74u w=0.26u l=0.38u
X4112 cml_tlatch_61.xmux.xp.S1 cml_tlatch_61.OUTN cml_tlatch_61.OUTP VSS sg13_lv_nmos ad=56.9f pd=0.74u as=56.9f ps=0.74u w=0.17u l=0.17u
X4113 VSS POLN cml_tlatch_16.xtail.S1 VSS sg13_lv_nmos ad=2.7982p pd=17.14u as=1.5637p ps=8.61u w=8.23u l=0.13u
X4114 cml_tlatch_72.xmux.xp.S1 MOT25_N MOT25_P VSS sg13_lv_nmos ad=56.9f pd=0.74u as=56.9f ps=0.74u w=0.17u l=0.17u
X4115 GB2_N ENB0_P cml_gate2_7.xamp.xn.S1 VSS sg13_lv_nmos ad=0.1802p pd=1.74u as=0.1007p ps=0.91u w=0.53u l=0.13u
X4116 cml_tlatch_40.xmux.xp.S1 CKA1_P cml_tlatch_40.xtail.S1 VSS sg13_lv_nmos ad=89.3f pd=0.85u as=89.3f ps=0.85u w=0.47u l=0.16u
X4117 cml_tlatch_50.xmux.xp.S1 B3_2_N B3_2_P VSS sg13_lv_nmos ad=56.9f pd=0.74u as=56.9f ps=0.74u w=0.17u l=0.17u
X4118 cml_tlatch_69.xmux.xn.S1 CKA3_P cml_tlatch_69.xtail.S1 VSS sg13_lv_nmos ad=89.3f pd=0.85u as=89.3f ps=0.85u w=0.47u l=0.16u
X4119 MOT31_N MOT31_P cml_tlatch_75.xmux.xp.S1 VSS sg13_lv_nmos ad=56.9f pd=0.74u as=56.9f ps=0.74u w=0.17u l=0.17u
X4120 MOT18_N cml_tlatch_87.OUTP cml_tlatch_53.xmux.xn.S1 VSS sg13_lv_nmos ad=0.1082p pd=1.34u as=63.19999f ps=0.74u w=0.26u l=0.38u
X4121 cml_tlatch_15.xmux.xn.S1 CKHB0_P cml_tlatch_15.xtail.S1 VSS sg13_lv_nmos ad=89.3f pd=0.85u as=89.3f ps=0.85u w=0.47u l=0.16u
X4122 cml_tlatch_27.xmux.xp.S1 CKHA0_N cml_tlatch_27.xtail.S1 VSS sg13_lv_nmos ad=0.1598p pd=1.62u as=89.3f ps=0.85u w=0.47u l=0.16u
X4123 MOT3_N MOT3_P cml_tlatch_15.xmux.xp.S1 VSS sg13_lv_nmos ad=56.9f pd=0.74u as=56.9f ps=0.74u w=0.17u l=0.17u
X4124 cml_tlatch_87.xmux.xp.S1 CKA2_P cml_tlatch_87.xtail.S1 VSS sg13_lv_nmos ad=89.3f pd=0.85u as=89.3f ps=0.85u w=0.47u l=0.16u
X4125 cml_tlatch_62.xtail.S1 POLN VSS VSS sg13_lv_nmos ad=1.5637p pd=8.61u as=2.7982p ps=17.14u w=8.23u l=0.13u
X4126 cml_tlatch_13.xmux.xp.S1 stub_bi_17.BOTN stub_bi_17.BOTP VSS sg13_lv_nmos ad=56.9f pd=0.74u as=56.9f ps=0.74u w=0.17u l=0.17u
X4127 cml_tlatch_30.OUTP VDD VSS rppd l=5.17u w=1u
X4128 B3_2_N B3_2_P cml_tlatch_50.xmux.xp.S1 VSS sg13_lv_nmos ad=56.9f pd=0.74u as=56.9f ps=0.74u w=0.17u l=0.17u
X4129 A3_8_N A3_8_P cml_tlatch_68.xmux.xp.S1 VSS sg13_lv_nmos ad=56.9f pd=0.74u as=56.9f ps=0.74u w=0.17u l=0.17u
X4130 J4_N CLK_W_N cml_tlatch_92.xmux.xn.S1 VSS sg13_lv_nmos ad=63.19999f pd=0.74u as=63.19999f ps=0.74u w=0.26u l=0.38u
X4131 cml_tlatch_44.xtail.S1 CKHA3_P cml_tlatch_44.xmux.xn.S1 VSS sg13_lv_nmos ad=89.3f pd=0.85u as=0.1598p ps=1.62u w=0.47u l=0.16u
X4132 cml_tlatch_30.OUTN cml_tlatch_30.OUTP cml_tlatch_30.xmux.xp.S1 VSS sg13_lv_nmos ad=56.9f pd=0.74u as=56.9f ps=0.74u w=0.17u l=0.17u
X4133 cml_tlatch_89.xmux.xp.S1 cml_tlatch_44.INP cml_tlatch_44.INN VSS sg13_lv_nmos ad=0.1019p pd=1.34u as=56.9f ps=0.74u w=0.17u l=0.17u
X4134 cml_tlatch_5.xmux.xp.S1 MOT13_N MOT13_P VSS sg13_lv_nmos ad=0.1019p pd=1.34u as=56.9f ps=0.74u w=0.17u l=0.17u
X4135 cml_tlatch_36.xmux.xp.S1 CKB1_P cml_tlatch_36.xtail.S1 VSS sg13_lv_nmos ad=89.3f pd=0.85u as=89.3f ps=0.85u w=0.47u l=0.16u
X4136 cml_tlatch_80.xmux.xp.S1 MOT23_N MOT23_P VSS sg13_lv_nmos ad=0.1019p pd=1.34u as=56.9f ps=0.74u w=0.17u l=0.17u
X4137 cml_tlatch_0.xmux.xp.S1 cml_tlatch_0.OUTP cml_tlatch_0.OUTN VSS sg13_lv_nmos ad=56.9f pd=0.74u as=56.9f ps=0.74u w=0.17u l=0.17u
X4138 MOT31_P MOT31_N cml_tlatch_75.xmux.xp.S1 VSS sg13_lv_nmos ad=56.9f pd=0.74u as=56.9f ps=0.74u w=0.17u l=0.17u
X4139 GA1_P CKB1_N cml_gate2_2.xrtail.R1 VSS sg13_lv_nmos ad=0.1007p pd=0.91u as=0.1007p ps=0.91u w=0.53u l=0.13u
X4140 MOT22_P MOT22_N cml_tlatch_55.xmux.xp.S1 VSS sg13_lv_nmos ad=56.9f pd=0.74u as=56.9f ps=0.74u w=0.17u l=0.17u
X4141 cml_tlatch_19.xmux.xp.S1 A1_8_P A1_8_N VSS sg13_lv_nmos ad=56.9f pd=0.74u as=56.9f ps=0.74u w=0.17u l=0.17u
X4142 B1_8_N B1_8_P cml_tlatch_10.xmux.xp.S1 VSS sg13_lv_nmos ad=56.9f pd=0.74u as=56.9f ps=0.74u w=0.17u l=0.17u
X4143 cml_tlatch_38.OUTN cml_tlatch_38.OUTP cml_tlatch_38.xmux.xp.S1 VSS sg13_lv_nmos ad=56.9f pd=0.74u as=56.9f ps=0.74u w=0.17u l=0.17u
X4144 CKB3_N CK_P hs_to_clk_5.D2 VSS sg13_lv_nmos ad=0.228p pd=1.58u as=0.228p ps=1.58u w=1.2u l=0.2u
X4145 cml_tlatch_51.OUTP D3_N cml_tlatch_51.xmux.xn.S1 VSS sg13_lv_nmos ad=63.19999f pd=0.74u as=63.19999f ps=0.74u w=0.26u l=0.38u
X4146 MOT21_N MOT21_P cml_tlatch_79.xmux.xp.S1 VSS sg13_lv_nmos ad=56.9f pd=0.74u as=56.9f ps=0.74u w=0.17u l=0.17u
X4147 B3_2_P B3_2_N cml_tlatch_50.xmux.xp.S1 VSS sg13_lv_nmos ad=56.9f pd=0.74u as=56.9f ps=0.74u w=0.17u l=0.17u
X4148 cml_tlatch_15.xmux.xn.S1 cml_tlatch_7.OUTN MOT3_P VSS sg13_lv_nmos ad=63.19999f pd=0.74u as=63.19999f ps=0.74u w=0.26u l=0.38u
X4149 cml_tlatch_6.xmux.xp.S1 MOT15_N MOT15_P VSS sg13_lv_nmos ad=56.9f pd=0.74u as=56.9f ps=0.74u w=0.17u l=0.17u
X4150 cml_tlatch_56.OUTP cml_tlatch_56.OUTN cml_tlatch_56.xmux.xp.S1 VSS sg13_lv_nmos ad=56.9f pd=0.74u as=56.9f ps=0.74u w=0.17u l=0.17u
X4151 cml_tlatch_9.xmux.xn.S1 CKA0_N cml_tlatch_9.xtail.S1 VSS sg13_lv_nmos ad=89.3f pd=0.85u as=89.3f ps=0.85u w=0.47u l=0.16u
X4152 CLK_W_P CLK_W_N cml_tlatch_93.xmux.xp.S1 VSS sg13_lv_nmos ad=56.9f pd=0.74u as=56.9f ps=0.74u w=0.17u l=0.17u
X4153 cml_tlatch_15.xmux.xn.S1 cml_tlatch_7.OUTN MOT3_P VSS sg13_lv_nmos ad=63.19999f pd=0.74u as=63.19999f ps=0.74u w=0.26u l=0.38u
X4154 cml_tlatch_37.xmux.xp.S1 stub_bi_31.BOTN stub_bi_31.BOTP VSS sg13_lv_nmos ad=56.9f pd=0.74u as=56.9f ps=0.74u w=0.17u l=0.17u
X4155 cml_tlatch_43.INP cml_tlatch_43.INN cml_tlatch_21.xmux.xp.S1 VSS sg13_lv_nmos ad=56.9f pd=0.74u as=56.9f ps=0.74u w=0.17u l=0.17u
X4156 hs_to_clk_8.sg13_lv_nmos_2HGZLP_0.G CKJ_N VSS rppd l=4.25u w=1u
X4157 GA3_P CKB3_N cml_gate2_4.xrtail.R1 VSS sg13_lv_nmos ad=0.1007p pd=0.91u as=0.1007p ps=0.91u w=0.53u l=0.13u
X4158 cml_tlatch_39.xmux.xp.S1 cml_tlatch_97.INN cml_tlatch_97.INP VSS sg13_lv_nmos ad=56.9f pd=0.74u as=56.9f ps=0.74u w=0.17u l=0.17u
X4159 stub_bi_29.BOTN stub_bi_29.BOTP cml_tlatch_35.xmux.xp.S1 VSS sg13_lv_nmos ad=56.9f pd=0.74u as=56.9f ps=0.74u w=0.17u l=0.17u
X4160 cml_tlatch_11.xmux.xn.S1 CKB1_P cml_tlatch_11.xtail.S1 VSS sg13_lv_nmos ad=89.3f pd=0.85u as=89.3f ps=0.85u w=0.47u l=0.16u
X4161 cml_tlatch_48.xtail.S1 CKB2_P cml_tlatch_48.xmux.xn.S1 VSS sg13_lv_nmos ad=89.3f pd=0.85u as=89.3f ps=0.85u w=0.47u l=0.16u
X4162 cml_tlatch_9.xtail.S1 CKA0_P cml_tlatch_9.xmux.xp.S1 VSS sg13_lv_nmos ad=89.3f pd=0.85u as=89.3f ps=0.85u w=0.47u l=0.16u
X4163 cml_tlatch_18.xmux.xp.S1 cml_tlatch_18.OUTP cml_tlatch_18.OUTN VSS sg13_lv_nmos ad=56.9f pd=0.74u as=56.9f ps=0.74u w=0.17u l=0.17u
X4164 A1_8_P A1_8_N cml_tlatch_19.xmux.xp.S1 VSS sg13_lv_nmos ad=56.9f pd=0.74u as=56.9f ps=0.74u w=0.17u l=0.17u
X4165 cml_tlatch_48.xmux.xp.S1 stub_bi_43.BOTP stub_bi_43.BOTN VSS sg13_lv_nmos ad=56.9f pd=0.74u as=56.9f ps=0.74u w=0.17u l=0.17u
X4166 cml_tlatch_29.xmux.xp.S1 MOT6_N MOT6_P VSS sg13_lv_nmos ad=56.9f pd=0.74u as=56.9f ps=0.74u w=0.17u l=0.17u
X4167 cml_tlatch_88.xmux.xp.S1 cml_tlatch_74.INP cml_tlatch_74.INN VSS sg13_lv_nmos ad=56.9f pd=0.74u as=56.9f ps=0.74u w=0.17u l=0.17u
X4168 cml_tlatch_69.OUTN cml_tlatch_63.INP cml_tlatch_69.xmux.xn.S1 VSS sg13_lv_nmos ad=63.19999f pd=0.74u as=63.19999f ps=0.74u w=0.26u l=0.38u
X4169 VSS POLN cml_tlatch_1.xtail.S1 VSS sg13_lv_nmos ad=1.5637p pd=8.61u as=1.5637p ps=8.61u w=8.23u l=0.13u
X4170 cml_tlatch_16.xmux.xp.S1 MOT5_P MOT5_N VSS sg13_lv_nmos ad=56.9f pd=0.74u as=56.9f ps=0.74u w=0.17u l=0.17u
X4171 cml_tlatch_25.xmux.xn.S1 A1_2_N MOT14_P VSS sg13_lv_nmos ad=63.19999f pd=0.74u as=63.19999f ps=0.74u w=0.26u l=0.38u
X4172 cml_tlatch_36.xmux.xp.S1 B1_2_N B1_2_P VSS sg13_lv_nmos ad=56.9f pd=0.74u as=56.9f ps=0.74u w=0.17u l=0.17u
X4173 cml_tlatch_35.xmux.xn.S1 B1_2_N stub_bi_29.BOTN VSS sg13_lv_nmos ad=0.1082p pd=1.34u as=63.19999f ps=0.74u w=0.26u l=0.38u
X4174 cml_tlatch_26.xtail.S1 CKHA0_P cml_tlatch_26.xmux.xn.S1 VSS sg13_lv_nmos ad=89.3f pd=0.85u as=89.3f ps=0.85u w=0.47u l=0.16u
X4175 cml_tlatch_95.xmux.xp.S1 J1_P J1_N VSS sg13_lv_nmos ad=56.9f pd=0.74u as=56.9f ps=0.74u w=0.17u l=0.17u
X4176 J1_N J4_N cml_tlatch_95.xmux.xn.S1 VSS sg13_lv_nmos ad=0.1082p pd=1.34u as=63.19999f ps=0.74u w=0.26u l=0.38u
X4177 cml_tlatch_7.xmux.xp.S1 cml_tlatch_7.OUTN cml_tlatch_7.OUTP VSS sg13_lv_nmos ad=56.9f pd=0.74u as=56.9f ps=0.74u w=0.17u l=0.17u
X4178 cml_tlatch_38.xmux.xp.S1 CKA0_N cml_tlatch_38.xtail.S1 VSS sg13_lv_nmos ad=89.3f pd=0.85u as=89.3f ps=0.85u w=0.47u l=0.16u
X4179 MOT21_P stub_bi_55.BOTP cml_tlatch_79.xmux.xn.S1 VSS sg13_lv_nmos ad=63.19999f pd=0.74u as=63.19999f ps=0.74u w=0.26u l=0.38u
X4180 cml_gate2_1.xrtail.R1 CKA0_P cml_gate2_1.xamp.xn.S1 VSS sg13_lv_nmos ad=0.1007p pd=0.91u as=0.1007p ps=0.91u w=0.53u l=0.13u
X4181 cml_tlatch_16.xmux.xp.S1 CKHB0_N cml_tlatch_16.xtail.S1 VSS sg13_lv_nmos ad=89.3f pd=0.85u as=89.3f ps=0.85u w=0.47u l=0.16u
X4182 cml_tlatch_67.xtail.S1 CKB3_P cml_tlatch_67.xmux.xn.S1 VSS sg13_lv_nmos ad=89.3f pd=0.85u as=89.3f ps=0.85u w=0.47u l=0.16u
X4183 cml_tlatch_69.xmux.xp.S1 cml_tlatch_69.OUTP cml_tlatch_69.OUTN VSS sg13_lv_nmos ad=56.9f pd=0.74u as=56.9f ps=0.74u w=0.17u l=0.17u
X4184 VSS POLN cml_tlatch_86.xtail.S1 VSS sg13_lv_nmos ad=1.5637p pd=8.61u as=1.5637p ps=8.61u w=8.23u l=0.13u
X4185 cml_tlatch_65.OUTN cml_tlatch_65.OUTP cml_tlatch_65.xmux.xp.S1 VSS sg13_lv_nmos ad=56.9f pd=0.74u as=56.9f ps=0.74u w=0.17u l=0.17u
X4186 cml_tlatch_99.xmux.xp.S1 CKA0_P cml_tlatch_99.xtail.S1 VSS sg13_lv_nmos ad=89.3f pd=0.85u as=89.3f ps=0.85u w=0.47u l=0.16u
X4187 cml_tlatch_91.INN cml_tlatch_91.INP cml_tlatch_59.xmux.xp.S1 VSS sg13_lv_nmos ad=56.9f pd=0.74u as=56.9f ps=0.74u w=0.17u l=0.17u
X4188 cml_tlatch_20.OUTP cml_tlatch_20.OUTN cml_tlatch_20.xmux.xp.S1 VSS sg13_lv_nmos ad=56.9f pd=0.74u as=56.9f ps=0.74u w=0.17u l=0.17u
X4189 stub_bi_17.BOTN stub_bi_17.BOTP cml_tlatch_13.xmux.xp.S1 VSS sg13_lv_nmos ad=56.9f pd=0.74u as=56.9f ps=0.74u w=0.17u l=0.17u
X4190 cml_tlatch_31.xmux.xn.S1 cml_tlatch_32.OUTP B0_2_N VSS sg13_lv_nmos ad=63.19999f pd=0.74u as=63.19999f ps=0.74u w=0.26u l=0.38u
X4191 stub_bi_29.BOTP B1_2_P cml_tlatch_35.xmux.xn.S1 VSS sg13_lv_nmos ad=63.19999f pd=0.74u as=63.19999f ps=0.74u w=0.26u l=0.38u
X4192 MOT10_N MOT10_P cml_tlatch_43.xmux.xp.S1 VSS sg13_lv_nmos ad=56.9f pd=0.74u as=56.9f ps=0.74u w=0.17u l=0.17u
X4193 MOT1_P B0_8_N cml_tlatch_14.xmux.xn.S1 VSS sg13_lv_nmos ad=63.19999f pd=0.74u as=63.19999f ps=0.74u w=0.26u l=0.38u
X4194 cml_tlatch_19.xmux.xn.S1 CKA1_N cml_tlatch_19.xtail.S1 VSS sg13_lv_nmos ad=89.3f pd=0.85u as=89.3f ps=0.85u w=0.47u l=0.16u
X4195 A2_2_P A2_2_N cml_tlatch_60.xmux.xp.S1 VSS sg13_lv_nmos ad=56.9f pd=0.74u as=0.1019p ps=1.34u w=0.17u l=0.17u
X4196 cml_tlatch_8.xtail.S1 POLN VSS VSS sg13_lv_nmos ad=1.5637p pd=8.61u as=1.5637p ps=8.61u w=8.23u l=0.13u
X4197 cml_tlatch_8.OUTN cml_tlatch_8.OUTP cml_tlatch_8.xmux.xp.S1 VSS sg13_lv_nmos ad=56.9f pd=0.74u as=56.9f ps=0.74u w=0.17u l=0.17u
X4198 cml_tlatch_81.xmux.xn.S1 stub_bi_62.BOTP B2_8_P VSS sg13_lv_nmos ad=63.19999f pd=0.74u as=63.19999f ps=0.74u w=0.26u l=0.38u
X4199 cml_tlatch_88.xtail.S1 CKB3_P cml_tlatch_88.xmux.xp.S1 VSS sg13_lv_nmos ad=89.3f pd=0.85u as=0.1598p ps=1.62u w=0.47u l=0.16u
X4200 cml_tlatch_73.xtail.S1 CKHB3_N cml_tlatch_73.xmux.xp.S1 VSS sg13_lv_nmos ad=89.3f pd=0.85u as=89.3f ps=0.85u w=0.47u l=0.16u
X4201 cml_gate2_8.xamp.xn.S1 NS1_P cml_gate2_8.xrtail.R1 VSS sg13_lv_nmos ad=0.1802p pd=1.74u as=0.1007p ps=0.91u w=0.53u l=0.13u
X4202 cml_tlatch_51.OUTN cml_tlatch_51.OUTP cml_tlatch_51.xmux.xp.S1 VSS sg13_lv_nmos ad=56.9f pd=0.74u as=56.9f ps=0.74u w=0.17u l=0.17u
X4203 cml_tlatch_98.xtail.S1 CKB0_N cml_tlatch_98.xmux.xn.S1 VSS sg13_lv_nmos ad=89.3f pd=0.85u as=89.3f ps=0.85u w=0.47u l=0.16u
X4204 VSS POLN cml_tlatch_15.xtail.S1 VSS sg13_lv_nmos ad=2.7982p pd=17.14u as=1.5637p ps=8.61u w=8.23u l=0.13u
X4205 cml_tlatch_4.INN cml_tlatch_4.INP cml_tlatch_12.xmux.xp.S1 VSS sg13_lv_nmos ad=56.9f pd=0.74u as=0.1019p ps=1.34u w=0.17u l=0.17u
X4206 cml_gate2_9.xamp.xn.S1 J1_N ENA_P VSS sg13_lv_nmos ad=0.1007p pd=0.91u as=0.1007p ps=0.91u w=0.53u l=0.13u
X4207 cml_tlatch_31.xmux.xp.S1 CKB0_P cml_tlatch_31.xtail.S1 VSS sg13_lv_nmos ad=89.3f pd=0.85u as=89.3f ps=0.85u w=0.47u l=0.16u
X4208 cml_tlatch_23.OUTN cml_tlatch_23.OUTP cml_tlatch_23.xmux.xp.S1 VSS sg13_lv_nmos ad=56.9f pd=0.74u as=56.9f ps=0.74u w=0.17u l=0.17u
X4209 J1_N J1_P cml_tlatch_95.xmux.xp.S1 VSS sg13_lv_nmos ad=56.9f pd=0.74u as=0.1019p ps=1.34u w=0.17u l=0.17u
X4210 cml_tlatch_32.xmux.xp.S1 cml_tlatch_32.OUTN cml_tlatch_32.OUTP VSS sg13_lv_nmos ad=56.9f pd=0.74u as=56.9f ps=0.74u w=0.17u l=0.17u
X4211 CKHB1_P VDD VSS rppd l=13.09u w=1u
X4212 cml_tlatch_64.xmux.xp.S1 B3_8_P B3_8_N VSS sg13_lv_nmos ad=56.9f pd=0.74u as=56.9f ps=0.74u w=0.17u l=0.17u
X4213 cml_tlatch_98.OUTN cml_tlatch_98.OUTP cml_tlatch_98.xmux.xp.S1 VSS sg13_lv_nmos ad=56.9f pd=0.74u as=56.9f ps=0.74u w=0.17u l=0.17u
X4214 cml_tlatch_71.xmux.xp.S1 CKA3_N cml_tlatch_71.xtail.S1 VSS sg13_lv_nmos ad=89.3f pd=0.85u as=89.3f ps=0.85u w=0.47u l=0.16u
X4215 cml_tlatch_67.OUTP cml_tlatch_67.OUTN cml_tlatch_67.xmux.xp.S1 VSS sg13_lv_nmos ad=56.9f pd=0.74u as=56.9f ps=0.74u w=0.17u l=0.17u
X4216 cml_tlatch_68.xmux.xp.S1 A3_8_N A3_8_P VSS sg13_lv_nmos ad=56.9f pd=0.74u as=56.9f ps=0.74u w=0.17u l=0.17u
X4217 cml_tlatch_66.xmux.xp.S1 cml_tlatch_73.INN cml_tlatch_73.INP VSS sg13_lv_nmos ad=56.9f pd=0.74u as=56.9f ps=0.74u w=0.17u l=0.17u
X4218 MOT26_N MOT26_P cml_tlatch_63.xmux.xp.S1 VSS sg13_lv_nmos ad=56.9f pd=0.74u as=56.9f ps=0.74u w=0.17u l=0.17u
X4219 MOT22_P MOT22_N cml_tlatch_55.xmux.xp.S1 VSS sg13_lv_nmos ad=56.9f pd=0.74u as=56.9f ps=0.74u w=0.17u l=0.17u
X4220 cml_tlatch_45.xmux.xp.S1 MOT30_N MOT30_P VSS sg13_lv_nmos ad=56.9f pd=0.74u as=56.9f ps=0.74u w=0.17u l=0.17u
X4221 MOT16_N MOT16_P cml_tlatch_52.xmux.xp.S1 VSS sg13_lv_nmos ad=56.9f pd=0.74u as=56.9f ps=0.74u w=0.17u l=0.17u
X4222 B0_8_P B0_8_N cml_tlatch_1.xmux.xp.S1 VSS sg13_lv_nmos ad=56.9f pd=0.74u as=56.9f ps=0.74u w=0.17u l=0.17u
X4223 B1_8_N B1_8_P cml_tlatch_10.xmux.xp.S1 VSS sg13_lv_nmos ad=56.9f pd=0.74u as=56.9f ps=0.74u w=0.17u l=0.17u
X4224 cml_tlatch_38.OUTN cml_tlatch_38.OUTP cml_tlatch_38.xmux.xp.S1 VSS sg13_lv_nmos ad=56.9f pd=0.74u as=56.9f ps=0.74u w=0.17u l=0.17u
X4225 MOT12_P VDD VSS rppd l=5.17u w=1u
X4226 cml_tlatch_34.xtail.S1 POLN VSS VSS sg13_lv_nmos ad=1.5637p pd=8.61u as=2.7982p ps=17.14u w=8.23u l=0.13u
X4227 cml_tlatch_91.xtail.S1 CKA2_P cml_tlatch_91.xmux.xp.S1 VSS sg13_lv_nmos ad=89.3f pd=0.85u as=89.3f ps=0.85u w=0.47u l=0.16u
X4228 cml_tlatch_49.xmux.xp.S1 cml_tlatch_49.OUTN cml_tlatch_49.OUTP VSS sg13_lv_nmos ad=56.9f pd=0.74u as=56.9f ps=0.74u w=0.17u l=0.17u
X4229 cml_tlatch_27.xmux.xp.S1 MOT2_N MOT2_P VSS sg13_lv_nmos ad=56.9f pd=0.74u as=56.9f ps=0.74u w=0.17u l=0.17u
X4230 cml_tlatch_10.xmux.xp.S1 B1_8_N B1_8_P VSS sg13_lv_nmos ad=56.9f pd=0.74u as=56.9f ps=0.74u w=0.17u l=0.17u
X4231 cml_tlatch_67.xmux.xp.S1 CKB3_N cml_tlatch_67.xtail.S1 VSS sg13_lv_nmos ad=89.3f pd=0.85u as=89.3f ps=0.85u w=0.47u l=0.16u
X4232 J4_P J4_N cml_tlatch_92.xmux.xp.S1 VSS sg13_lv_nmos ad=56.9f pd=0.74u as=56.9f ps=0.74u w=0.17u l=0.17u
X4233 ENA0_P ENA_N cml_drv_3.xrtail.R1 VSS sg13_lv_nmos ad=56.2f pd=0.74u as=56.2f ps=0.74u w=0.16u l=0.19u
X4234 A2_2_P A2_2_N cml_tlatch_60.xmux.xp.S1 VSS sg13_lv_nmos ad=56.9f pd=0.74u as=56.9f ps=0.74u w=0.17u l=0.17u
X4235 cml_tlatch_25.xtail.S1 CKHA1_P cml_tlatch_25.xmux.xn.S1 VSS sg13_lv_nmos ad=89.3f pd=0.85u as=89.3f ps=0.85u w=0.47u l=0.16u
X4236 cml_tlatch_74.INP cml_tlatch_74.INN cml_tlatch_88.xmux.xp.S1 VSS sg13_lv_nmos ad=56.9f pd=0.74u as=56.9f ps=0.74u w=0.17u l=0.17u
X4237 hs_to_clk_1.D2 CK_P CKB0_N VSS sg13_lv_nmos ad=0.408p pd=3.08u as=0.228p ps=1.58u w=1.2u l=0.2u
X4238 stub_bi_29.BOTN stub_bi_29.BOTP cml_tlatch_35.xmux.xp.S1 VSS sg13_lv_nmos ad=56.9f pd=0.74u as=56.9f ps=0.74u w=0.17u l=0.17u
X4239 cml_tlatch_55.xmux.xp.S1 CKHA2_N cml_tlatch_55.xtail.S1 VSS sg13_lv_nmos ad=89.3f pd=0.85u as=89.3f ps=0.85u w=0.47u l=0.16u
X4240 stub_bi_15.BOTP stub_bi_15.BOTN cml_tlatch_11.xmux.xp.S1 VSS sg13_lv_nmos ad=56.9f pd=0.74u as=56.9f ps=0.74u w=0.17u l=0.17u
X4241 cml_tlatch_59.xmux.xp.S1 CKA2_N cml_tlatch_59.xtail.S1 VSS sg13_lv_nmos ad=89.3f pd=0.85u as=89.3f ps=0.85u w=0.47u l=0.16u
X4242 cml_tlatch_67.xmux.xp.S1 cml_tlatch_67.OUTN cml_tlatch_67.OUTP VSS sg13_lv_nmos ad=56.9f pd=0.74u as=56.9f ps=0.74u w=0.17u l=0.17u
X4243 A1_2_N cml_tlatch_41.OUTP cml_tlatch_40.xmux.xn.S1 VSS sg13_lv_nmos ad=63.19999f pd=0.74u as=63.19999f ps=0.74u w=0.26u l=0.38u
X4244 cml_tlatch_4.INN cml_tlatch_4.INP cml_tlatch_12.xmux.xp.S1 VSS sg13_lv_nmos ad=56.9f pd=0.74u as=56.9f ps=0.74u w=0.17u l=0.17u
X4245 cml_tlatch_41.OUTP cml_tlatch_41.OUTN cml_tlatch_41.xmux.xp.S1 VSS sg13_lv_nmos ad=56.9f pd=0.74u as=56.9f ps=0.74u w=0.17u l=0.17u
X4246 cml_tlatch_8.xmux.xn.S1 cml_tlatch_98.OUTP cml_tlatch_8.OUTN VSS sg13_lv_nmos ad=63.19999f pd=0.74u as=63.19999f ps=0.74u w=0.26u l=0.38u
X4247 cml_tlatch_40.xtail.S1 POLN VSS VSS sg13_lv_nmos ad=1.5637p pd=8.61u as=2.7982p ps=17.14u w=8.23u l=0.13u
X4248 cml_tlatch_96.xmux.xp.S1 cml_tlatch_5.INN cml_tlatch_5.INP VSS sg13_lv_nmos ad=56.9f pd=0.74u as=56.9f ps=0.74u w=0.17u l=0.17u
X4249 cml_tlatch_99.xmux.xp.S1 cml_tlatch_99.OUTN cml_tlatch_99.OUTP VSS sg13_lv_nmos ad=56.9f pd=0.74u as=56.9f ps=0.74u w=0.17u l=0.17u
X4250 cml_tlatch_40.xmux.xn.S1 CKA1_N cml_tlatch_40.xtail.S1 VSS sg13_lv_nmos ad=89.3f pd=0.85u as=89.3f ps=0.85u w=0.47u l=0.16u
X4251 cml_tlatch_55.xmux.xp.S1 MOT22_P MOT22_N VSS sg13_lv_nmos ad=56.9f pd=0.74u as=56.9f ps=0.74u w=0.17u l=0.17u
X4252 cml_tlatch_54.xmux.xp.S1 MOT20_N MOT20_P VSS sg13_lv_nmos ad=56.9f pd=0.74u as=56.9f ps=0.74u w=0.17u l=0.17u
X4253 MOT30_N MOT30_P cml_tlatch_45.xmux.xp.S1 VSS sg13_lv_nmos ad=56.9f pd=0.74u as=56.9f ps=0.74u w=0.17u l=0.17u
X4254 cml_tlatch_83.xmux.xn.S1 stub_bi_49.BOTP stub_bi_63.BOTN VSS sg13_lv_nmos ad=63.19999f pd=0.74u as=0.1082p ps=1.34u w=0.26u l=0.38u
X4255 cml_tlatch_23.xmux.xp.S1 CKA0_P cml_tlatch_23.xtail.S1 VSS sg13_lv_nmos ad=89.3f pd=0.85u as=89.3f ps=0.85u w=0.47u l=0.16u
X4256 cml_tlatch_20.xtail.S1 POLN VSS VSS sg13_lv_nmos ad=1.5637p pd=8.61u as=1.5637p ps=8.61u w=8.23u l=0.13u
X4257 cml_tlatch_65.xmux.xp.S1 cml_tlatch_65.OUTN cml_tlatch_65.OUTP VSS sg13_lv_nmos ad=56.9f pd=0.74u as=56.9f ps=0.74u w=0.17u l=0.17u
X4258 cml_tlatch_48.xmux.xp.S1 stub_bi_43.BOTN stub_bi_43.BOTP VSS sg13_lv_nmos ad=56.9f pd=0.74u as=56.9f ps=0.74u w=0.17u l=0.17u
X4259 ENB0_P VDD VSS rppd l=8.13u w=1u
X4260 cml_tlatch_68.xmux.xn.S1 cml_tlatch_69.OUTP A3_8_N VSS sg13_lv_nmos ad=63.19999f pd=0.74u as=63.19999f ps=0.74u w=0.26u l=0.38u
X4261 cml_tlatch_81.xmux.xp.S1 CKB2_P cml_tlatch_81.xtail.S1 VSS sg13_lv_nmos ad=89.3f pd=0.85u as=89.3f ps=0.85u w=0.47u l=0.16u
X4262 cml_tlatch_54.xmux.xn.S1 cml_tlatch_91.OUTP MOT20_N VSS sg13_lv_nmos ad=63.19999f pd=0.74u as=63.19999f ps=0.74u w=0.26u l=0.38u
X4263 VDD GA0_N VSS rppd l=7.42u w=1u
X4264 MOT27_P VDD VSS rppd l=5.17u w=1u
X4265 cml_tlatch_24.xmux.xp.S1 MOT12_N MOT12_P VSS sg13_lv_nmos ad=56.9f pd=0.74u as=56.9f ps=0.74u w=0.17u l=0.17u
X4266 cml_tlatch_87.INN cml_tlatch_87.INP cml_tlatch_76.xmux.xp.S1 VSS sg13_lv_nmos ad=56.9f pd=0.74u as=56.9f ps=0.74u w=0.17u l=0.17u
X4267 hs_to_clk_1.D2 CK_N CKB0_P VSS sg13_lv_nmos ad=0.408p pd=3.08u as=0.228p ps=1.58u w=1.2u l=0.2u
X4268 cml_tlatch_73.xmux.xp.S1 MOT27_P MOT27_N VSS sg13_lv_nmos ad=0.1019p pd=1.34u as=56.9f ps=0.74u w=0.17u l=0.17u
X4269 cml_tlatch_16.xmux.xn.S1 CKHB0_P cml_tlatch_16.xtail.S1 VSS sg13_lv_nmos ad=89.3f pd=0.85u as=89.3f ps=0.85u w=0.47u l=0.16u
X4270 cml_tlatch_78.xtail.S1 CKHB2_P cml_tlatch_78.xmux.xn.S1 VSS sg13_lv_nmos ad=89.3f pd=0.85u as=89.3f ps=0.85u w=0.47u l=0.16u
X4271 cml_tlatch_30.OUTP B0_2_N cml_tlatch_30.xmux.xn.S1 VSS sg13_lv_nmos ad=63.19999f pd=0.74u as=63.19999f ps=0.74u w=0.26u l=0.38u
X4272 cml_tlatch_73.INN cml_tlatch_73.INP cml_tlatch_66.xmux.xp.S1 VSS sg13_lv_nmos ad=56.9f pd=0.74u as=56.9f ps=0.74u w=0.17u l=0.17u
X4273 B0_8_N B0_8_P cml_tlatch_1.xmux.xp.S1 VSS sg13_lv_nmos ad=56.9f pd=0.74u as=56.9f ps=0.74u w=0.17u l=0.17u
X4274 cml_tlatch_17.xtail.S1 CKHB0_N cml_tlatch_17.xmux.xp.S1 VSS sg13_lv_nmos ad=89.3f pd=0.85u as=89.3f ps=0.85u w=0.47u l=0.16u
X4275 cml_tlatch_57.xmux.xp.S1 A3_2_P A3_2_N VSS sg13_lv_nmos ad=56.9f pd=0.74u as=56.9f ps=0.74u w=0.17u l=0.17u
X4276 MOT19_N stub_bi_63.BOTN cml_tlatch_78.xmux.xn.S1 VSS sg13_lv_nmos ad=63.19999f pd=0.74u as=63.19999f ps=0.74u w=0.26u l=0.38u
X4277 cml_tlatch_7.xmux.xp.S1 cml_tlatch_7.OUTP cml_tlatch_7.OUTN VSS sg13_lv_nmos ad=56.9f pd=0.74u as=56.9f ps=0.74u w=0.17u l=0.17u
X4278 MOT7_N MOT7_P cml_tlatch_17.xmux.xp.S1 VSS sg13_lv_nmos ad=56.9f pd=0.74u as=56.9f ps=0.74u w=0.17u l=0.17u
X4279 MOT24_N MOT24_P cml_tlatch_62.xmux.xp.S1 VSS sg13_lv_nmos ad=56.9f pd=0.74u as=56.9f ps=0.74u w=0.17u l=0.17u
X4280 cml_tlatch_48.xmux.xn.S1 CKB2_P cml_tlatch_48.xtail.S1 VSS sg13_lv_nmos ad=89.3f pd=0.85u as=89.3f ps=0.85u w=0.47u l=0.16u
X4281 cml_tlatch_44.INN cml_tlatch_56.OUTP cml_tlatch_89.xmux.xn.S1 VSS sg13_lv_nmos ad=63.19999f pd=0.74u as=0.1082p ps=1.34u w=0.26u l=0.38u
X4282 stub_bi_62.BOTN stub_bi_63.BOTP cml_tlatch_82.xmux.xn.S1 VSS sg13_lv_nmos ad=63.19999f pd=0.74u as=63.19999f ps=0.74u w=0.26u l=0.38u
X4283 cml_tlatch_97.INN cml_tlatch_97.INP cml_tlatch_39.xmux.xp.S1 VSS sg13_lv_nmos ad=56.9f pd=0.74u as=56.9f ps=0.74u w=0.17u l=0.17u
X4284 cml_tlatch_58.xmux.xn.S1 CKA3_P cml_tlatch_58.xtail.S1 VSS sg13_lv_nmos ad=89.3f pd=0.85u as=0.1598p ps=1.62u w=0.47u l=0.16u
X4285 cml_tlatch_50.xmux.xn.S1 cml_tlatch_51.OUTN B3_2_P VSS sg13_lv_nmos ad=63.19999f pd=0.74u as=0.1082p ps=1.34u w=0.26u l=0.38u
X4286 cml_tlatch_37.xmux.xn.S1 D1_N stub_bi_31.BOTN VSS sg13_lv_nmos ad=63.19999f pd=0.74u as=63.19999f ps=0.74u w=0.26u l=0.38u
X4287 VSS POLN cml_tlatch_49.xtail.S1 VSS sg13_lv_nmos ad=2.7982p pd=17.14u as=1.5637p ps=8.61u w=8.23u l=0.13u
X4288 cml_tlatch_67.OUTN cml_tlatch_74.INP cml_tlatch_67.xmux.xn.S1 VSS sg13_lv_nmos ad=63.19999f pd=0.74u as=63.19999f ps=0.74u w=0.26u l=0.38u
X4289 cml_tlatch_85.xmux.xp.S1 A2_8_P A2_8_N VSS sg13_lv_nmos ad=56.9f pd=0.74u as=56.9f ps=0.74u w=0.17u l=0.17u
X4290 cml_tlatch_27.xmux.xp.S1 CKHA0_N cml_tlatch_27.xtail.S1 VSS sg13_lv_nmos ad=89.3f pd=0.85u as=89.3f ps=0.85u w=0.47u l=0.16u
X4291 cml_tlatch_42.xmux.xp.S1 MOT8_P MOT8_N VSS sg13_lv_nmos ad=56.9f pd=0.74u as=56.9f ps=0.74u w=0.17u l=0.17u
X4292 B3_2_N cml_tlatch_51.OUTP cml_tlatch_50.xmux.xn.S1 VSS sg13_lv_nmos ad=63.19999f pd=0.74u as=63.19999f ps=0.74u w=0.26u l=0.38u
X4293 cml_tlatch_8.xtail.S1 CKB0_N cml_tlatch_8.xmux.xp.S1 VSS sg13_lv_nmos ad=89.3f pd=0.85u as=89.3f ps=0.85u w=0.47u l=0.16u
X4294 cml_gate2_5.xamp.xn.S1 CKB2_P cml_gate2_5.xrtail.R1 VSS sg13_lv_nmos ad=0.1007p pd=0.91u as=0.1007p ps=0.91u w=0.53u l=0.13u
X4295 cml_tlatch_58.OUTN D3_P cml_tlatch_58.xmux.xn.S1 VSS sg13_lv_nmos ad=63.19999f pd=0.74u as=63.19999f ps=0.74u w=0.26u l=0.38u
X4296 cml_tlatch_13.xtail.S1 CKB1_N cml_tlatch_13.xmux.xp.S1 VSS sg13_lv_nmos ad=89.3f pd=0.85u as=89.3f ps=0.85u w=0.47u l=0.16u
X4297 CLK_W_N CLK_W_P cml_tlatch_93.xmux.xp.S1 VSS sg13_lv_nmos ad=56.9f pd=0.74u as=56.9f ps=0.74u w=0.17u l=0.17u
X4298 cml_tlatch_68.xtail.S1 CKA3_N cml_tlatch_68.xmux.xn.S1 VSS sg13_lv_nmos ad=89.3f pd=0.85u as=89.3f ps=0.85u w=0.47u l=0.16u
X4299 cml_tlatch_8.xtail.S1 CKB0_P cml_tlatch_8.xmux.xn.S1 VSS sg13_lv_nmos ad=0.1598p pd=1.62u as=89.3f ps=0.85u w=0.47u l=0.16u
X4300 cml_tlatch_62.xmux.xn.S1 A3_8_N MOT24_P VSS sg13_lv_nmos ad=0.1082p pd=1.34u as=63.19999f ps=0.74u w=0.26u l=0.38u
X4301 cml_tlatch_66.xtail.S1 CKB3_N cml_tlatch_66.xmux.xn.S1 VSS sg13_lv_nmos ad=89.3f pd=0.85u as=0.1598p ps=1.62u w=0.47u l=0.16u
X4302 MOT10_P MOT10_N cml_tlatch_43.xmux.xp.S1 VSS sg13_lv_nmos ad=56.9f pd=0.74u as=56.9f ps=0.74u w=0.17u l=0.17u
X4303 cml_tlatch_48.xmux.xp.S1 stub_bi_43.BOTN stub_bi_43.BOTP VSS sg13_lv_nmos ad=56.9f pd=0.74u as=56.9f ps=0.74u w=0.17u l=0.17u
X4304 cml_tlatch_94.xmux.xp.S1 J2_P J2_N VSS sg13_lv_nmos ad=56.9f pd=0.74u as=56.9f ps=0.74u w=0.17u l=0.17u
X4305 cml_tlatch_87.OUTP cml_tlatch_87.OUTN cml_tlatch_87.xmux.xp.S1 VSS sg13_lv_nmos ad=56.9f pd=0.74u as=56.9f ps=0.74u w=0.17u l=0.17u
X4306 A1_2_N A1_2_P cml_tlatch_40.xmux.xp.S1 VSS sg13_lv_nmos ad=56.9f pd=0.74u as=56.9f ps=0.74u w=0.17u l=0.17u
X4307 cml_tlatch_65.xmux.xn.S1 CKB3_P cml_tlatch_65.xtail.S1 VSS sg13_lv_nmos ad=89.3f pd=0.85u as=89.3f ps=0.85u w=0.47u l=0.16u
X4308 cml_tlatch_59.xmux.xp.S1 cml_tlatch_91.INN cml_tlatch_91.INP VSS sg13_lv_nmos ad=56.9f pd=0.74u as=56.9f ps=0.74u w=0.17u l=0.17u
X4309 GA0_P ENA0_N cml_gate2_3.xamp.xn.S1 VSS sg13_lv_nmos ad=0.1007p pd=0.91u as=0.1007p ps=0.91u w=0.53u l=0.13u
X4310 cml_tlatch_51.xmux.xp.S1 cml_tlatch_51.OUTN cml_tlatch_51.OUTP VSS sg13_lv_nmos ad=56.9f pd=0.74u as=56.9f ps=0.74u w=0.17u l=0.17u
X4311 B0_2_P VDD VSS rppd l=5.17u w=1u
X4312 GA0_N ENA0_P cml_gate2_3.xamp.xn.S1 VSS sg13_lv_nmos ad=0.1007p pd=0.91u as=0.1007p ps=0.91u w=0.53u l=0.13u
X4313 MOT13_P MOT13_N cml_tlatch_5.xmux.xp.S1 VSS sg13_lv_nmos ad=56.9f pd=0.74u as=56.9f ps=0.74u w=0.17u l=0.17u
X4314 GB1_P CKA1_N cml_gate2_0.xrtail.R1 VSS sg13_lv_nmos ad=0.1007p pd=0.91u as=0.1007p ps=0.91u w=0.53u l=0.13u
X4315 cml_tlatch_0.xmux.xp.S1 cml_tlatch_0.OUTN cml_tlatch_0.OUTP VSS sg13_lv_nmos ad=56.9f pd=0.74u as=56.9f ps=0.74u w=0.17u l=0.17u
X4316 MOT23_P MOT23_N cml_tlatch_80.xmux.xp.S1 VSS sg13_lv_nmos ad=56.9f pd=0.74u as=56.9f ps=0.74u w=0.17u l=0.17u
X4317 cml_tlatch_77.xmux.xn.S1 B2_8_P MOT17_N VSS sg13_lv_nmos ad=63.19999f pd=0.74u as=63.19999f ps=0.74u w=0.26u l=0.38u
X4318 cml_tlatch_22.xmux.xp.S1 cml_tlatch_22.OUTP cml_tlatch_22.OUTN VSS sg13_lv_nmos ad=56.9f pd=0.74u as=56.9f ps=0.74u w=0.17u l=0.17u
X4319 cml_tlatch_86.OUTP cml_tlatch_86.OUTN cml_tlatch_86.xmux.xp.S1 VSS sg13_lv_nmos ad=56.9f pd=0.74u as=56.9f ps=0.74u w=0.17u l=0.17u
X4320 cml_tlatch_65.xmux.xp.S1 cml_tlatch_65.OUTN cml_tlatch_65.OUTP VSS sg13_lv_nmos ad=56.9f pd=0.74u as=56.9f ps=0.74u w=0.17u l=0.17u
X4321 cml_tlatch_52.xmux.xn.S1 CKHA2_P cml_tlatch_52.xtail.S1 VSS sg13_lv_nmos ad=0.1598p pd=1.62u as=89.3f ps=0.85u w=0.47u l=0.16u
X4322 cml_tlatch_17.xtail.S1 POLN VSS VSS sg13_lv_nmos ad=1.5637p pd=8.61u as=2.7982p ps=17.14u w=8.23u l=0.13u
X4323 cml_tlatch_87.xtail.S1 CKA2_N cml_tlatch_87.xmux.xn.S1 VSS sg13_lv_nmos ad=89.3f pd=0.85u as=89.3f ps=0.85u w=0.47u l=0.16u
X4324 A2_2_N cml_tlatch_61.OUTP cml_tlatch_60.xmux.xn.S1 VSS sg13_lv_nmos ad=0.1082p pd=1.34u as=63.19999f ps=0.74u w=0.26u l=0.38u
X4325 A0_2_N A0_2_P cml_tlatch_34.xmux.xp.S1 VSS sg13_lv_nmos ad=56.9f pd=0.74u as=56.9f ps=0.74u w=0.17u l=0.17u
X4326 cml_tlatch_33.xmux.xn.S1 CKA0_P cml_tlatch_33.xtail.S1 VSS sg13_lv_nmos ad=0.1598p pd=1.62u as=89.3f ps=0.85u w=0.47u l=0.16u
X4327 VSS hs_to_clk_4.sg13_lv_nmos_2HGZLP_0.G VSS VSS sg13_lv_nmos ad=2.071p pd=11.28u as=0 ps=0 w=10.9u l=1.38u
X4328 cml_tlatch_99.xmux.xp.S1 cml_tlatch_99.OUTN cml_tlatch_99.OUTP VSS sg13_lv_nmos ad=56.9f pd=0.74u as=56.9f ps=0.74u w=0.17u l=0.17u
X4329 cml_tlatch_61.OUTP D2_N cml_tlatch_61.xmux.xn.S1 VSS sg13_lv_nmos ad=63.19999f pd=0.74u as=63.19999f ps=0.74u w=0.26u l=0.38u
X4330 cml_tlatch_79.xtail.S1 CKHB2_N cml_tlatch_79.xmux.xp.S1 VSS sg13_lv_nmos ad=89.3f pd=0.85u as=89.3f ps=0.85u w=0.47u l=0.16u
X4331 MOT0_N A0_8_P cml_tlatch_26.xmux.xn.S1 VSS sg13_lv_nmos ad=63.19999f pd=0.74u as=63.19999f ps=0.74u w=0.26u l=0.38u
X4332 MOT9_N MOT9_P cml_tlatch_3.xmux.xp.S1 VSS sg13_lv_nmos ad=56.9f pd=0.74u as=56.9f ps=0.74u w=0.17u l=0.17u
X4333 GB3_P CKA3_N cml_gate2_6.xrtail.R1 VSS sg13_lv_nmos ad=0.1007p pd=0.91u as=0.1007p ps=0.91u w=0.53u l=0.13u
X4334 MOT28_P MOT28_N cml_tlatch_44.xmux.xp.S1 VSS sg13_lv_nmos ad=56.9f pd=0.74u as=56.9f ps=0.74u w=0.17u l=0.17u
X4335 cml_tlatch_76.xmux.xp.S1 cml_tlatch_87.INN cml_tlatch_87.INP VSS sg13_lv_nmos ad=0.1019p pd=1.34u as=56.9f ps=0.74u w=0.17u l=0.17u
X4336 cml_tlatch_1.xtail.S1 CKB0_N cml_tlatch_1.xmux.xn.S1 VSS sg13_lv_nmos ad=89.3f pd=0.85u as=89.3f ps=0.85u w=0.47u l=0.16u
X4337 cml_tlatch_14.xtail.S1 CKHB0_N cml_tlatch_14.xmux.xp.S1 VSS sg13_lv_nmos ad=89.3f pd=0.85u as=89.3f ps=0.85u w=0.47u l=0.16u
X4338 MOT24_N MOT24_P cml_tlatch_62.xmux.xp.S1 VSS sg13_lv_nmos ad=56.9f pd=0.74u as=0.1019p ps=1.34u w=0.17u l=0.17u
X4339 MOT29_P MOT29_N cml_tlatch_74.xmux.xp.S1 VSS sg13_lv_nmos ad=56.9f pd=0.74u as=56.9f ps=0.74u w=0.17u l=0.17u
X4340 cml_tlatch_88.xtail.S1 CKB3_N cml_tlatch_88.xmux.xn.S1 VSS sg13_lv_nmos ad=89.3f pd=0.85u as=89.3f ps=0.85u w=0.47u l=0.16u
X4341 cml_tlatch_17.xmux.xp.S1 MOT7_N MOT7_P VSS sg13_lv_nmos ad=56.9f pd=0.74u as=56.9f ps=0.74u w=0.17u l=0.17u
X4342 cml_tlatch_4.xmux.xn.S1 CKHB1_P cml_tlatch_4.xtail.S1 VSS sg13_lv_nmos ad=89.3f pd=0.85u as=89.3f ps=0.85u w=0.47u l=0.16u
X4343 cml_tlatch_66.xtail.S1 POLN VSS VSS sg13_lv_nmos ad=1.5637p pd=8.61u as=2.7982p ps=17.14u w=8.23u l=0.13u
X4344 cml_tlatch_24.xmux.xp.S1 MOT12_N MOT12_P VSS sg13_lv_nmos ad=56.9f pd=0.74u as=56.9f ps=0.74u w=0.17u l=0.17u
X4345 cml_tlatch_57.xtail.S1 CKA3_N cml_tlatch_57.xmux.xn.S1 VSS sg13_lv_nmos ad=89.3f pd=0.85u as=89.3f ps=0.85u w=0.47u l=0.16u
X4346 cml_tlatch_6.xmux.xn.S1 B1_2_N MOT15_P VSS sg13_lv_nmos ad=63.19999f pd=0.74u as=63.19999f ps=0.74u w=0.26u l=0.38u
X4347 cml_tlatch_39.xtail.S1 CKA1_P cml_tlatch_39.xmux.xn.S1 VSS sg13_lv_nmos ad=89.3f pd=0.85u as=89.3f ps=0.85u w=0.47u l=0.16u
X4348 cml_tlatch_18.xmux.xp.S1 CKA0_N cml_tlatch_18.xtail.S1 VSS sg13_lv_nmos ad=0.1598p pd=1.62u as=89.3f ps=0.85u w=0.47u l=0.16u
X4349 cml_tlatch_87.xmux.xp.S1 cml_tlatch_87.OUTP cml_tlatch_87.OUTN VSS sg13_lv_nmos ad=56.9f pd=0.74u as=56.9f ps=0.74u w=0.17u l=0.17u
X4350 MOT6_N A0_2_P cml_tlatch_29.xmux.xn.S1 VSS sg13_lv_nmos ad=63.19999f pd=0.74u as=63.19999f ps=0.74u w=0.26u l=0.38u
X4351 MOT14_N VDD VSS rppd l=5.17u w=1u
X4352 stub_bi_63.BOTN stub_bi_63.BOTP cml_tlatch_83.xmux.xp.S1 VSS sg13_lv_nmos ad=56.9f pd=0.74u as=56.9f ps=0.74u w=0.17u l=0.17u
X4353 B0_8_N B0_8_P cml_tlatch_1.xmux.xp.S1 VSS sg13_lv_nmos ad=56.9f pd=0.74u as=56.9f ps=0.74u w=0.17u l=0.17u
X4354 MOT5_N MOT5_P cml_tlatch_16.xmux.xp.S1 VSS sg13_lv_nmos ad=56.9f pd=0.74u as=0.1019p ps=1.34u w=0.17u l=0.17u
X4355 cml_tlatch_5.xmux.xn.S1 cml_tlatch_5.INP MOT13_N VSS sg13_lv_nmos ad=63.19999f pd=0.74u as=63.19999f ps=0.74u w=0.26u l=0.38u
X4356 cml_tlatch_40.xmux.xp.S1 A1_2_N A1_2_P VSS sg13_lv_nmos ad=56.9f pd=0.74u as=56.9f ps=0.74u w=0.17u l=0.17u
X4357 cml_tlatch_90.xmux.xp.S1 stub_bi_55.BOTP stub_bi_55.BOTN VSS sg13_lv_nmos ad=56.9f pd=0.74u as=56.9f ps=0.74u w=0.17u l=0.17u
X4358 cml_tlatch_32.xmux.xn.S1 CKB0_P cml_tlatch_32.xtail.S1 VSS sg13_lv_nmos ad=89.3f pd=0.85u as=89.3f ps=0.85u w=0.47u l=0.16u
X4359 cml_tlatch_22.xtail.S1 CKA1_P cml_tlatch_22.xmux.xn.S1 VSS sg13_lv_nmos ad=89.3f pd=0.85u as=89.3f ps=0.85u w=0.47u l=0.16u
X4360 cml_tlatch_6.xmux.xp.S1 MOT15_P MOT15_N VSS sg13_lv_nmos ad=56.9f pd=0.74u as=56.9f ps=0.74u w=0.17u l=0.17u
X4361 cml_tlatch_24.INP cml_tlatch_97.INN cml_tlatch_97.xmux.xn.S1 VSS sg13_lv_nmos ad=63.19999f pd=0.74u as=63.19999f ps=0.74u w=0.26u l=0.38u
X4362 MOT29_N cml_tlatch_74.INP cml_tlatch_74.xmux.xn.S1 VSS sg13_lv_nmos ad=63.19999f pd=0.74u as=63.19999f ps=0.74u w=0.26u l=0.38u
X4363 cml_tlatch_48.xmux.xp.S1 CKB2_N cml_tlatch_48.xtail.S1 VSS sg13_lv_nmos ad=89.3f pd=0.85u as=89.3f ps=0.85u w=0.47u l=0.16u
X4364 B0_2_P B0_2_N cml_tlatch_31.xmux.xp.S1 VSS sg13_lv_nmos ad=56.9f pd=0.74u as=56.9f ps=0.74u w=0.17u l=0.17u
X4365 cml_tlatch_33.xmux.xp.S1 cml_tlatch_33.OUTN cml_tlatch_33.OUTP VSS sg13_lv_nmos ad=56.9f pd=0.74u as=56.9f ps=0.74u w=0.17u l=0.17u
X4366 B2_8_N B2_8_P cml_tlatch_81.xmux.xp.S1 VSS sg13_lv_nmos ad=56.9f pd=0.74u as=56.9f ps=0.74u w=0.17u l=0.17u
X4367 cml_tlatch_58.xmux.xp.S1 CKA3_N cml_tlatch_58.xtail.S1 VSS sg13_lv_nmos ad=89.3f pd=0.85u as=89.3f ps=0.85u w=0.47u l=0.16u
X4368 cml_drv_3.xrtail.R1 ENA_N ENA0_P VSS sg13_lv_nmos ad=56.2f pd=0.74u as=56.2f ps=0.74u w=0.16u l=0.19u
X4369 cml_tlatch_49.OUTN cml_tlatch_49.OUTP cml_tlatch_49.xmux.xp.S1 VSS sg13_lv_nmos ad=56.9f pd=0.74u as=56.9f ps=0.74u w=0.17u l=0.17u
X4370 cml_tlatch_71.OUTN cml_tlatch_71.OUTP cml_tlatch_71.xmux.xp.S1 VSS sg13_lv_nmos ad=56.9f pd=0.74u as=56.9f ps=0.74u w=0.17u l=0.17u
X4371 stub_bi_62.BOTN stub_bi_62.BOTP cml_tlatch_82.xmux.xp.S1 VSS sg13_lv_nmos ad=56.9f pd=0.74u as=0.1019p ps=1.34u w=0.17u l=0.17u
X4372 cml_tlatch_13.xtail.S1 CKB1_P cml_tlatch_13.xmux.xn.S1 VSS sg13_lv_nmos ad=89.3f pd=0.85u as=89.3f ps=0.85u w=0.47u l=0.16u
X4373 A2_8_P A2_8_N cml_tlatch_85.xmux.xp.S1 VSS sg13_lv_nmos ad=56.9f pd=0.74u as=56.9f ps=0.74u w=0.17u l=0.17u
X4374 cml_tlatch_57.xtail.S1 CKA3_P cml_tlatch_57.xmux.xp.S1 VSS sg13_lv_nmos ad=89.3f pd=0.85u as=89.3f ps=0.85u w=0.47u l=0.16u
X4375 cml_tlatch_77.xmux.xp.S1 MOT17_N MOT17_P VSS sg13_lv_nmos ad=56.9f pd=0.74u as=56.9f ps=0.74u w=0.17u l=0.17u
X4376 cml_tlatch_81.xtail.S1 CKB2_P cml_tlatch_81.xmux.xp.S1 VSS sg13_lv_nmos ad=89.3f pd=0.85u as=0.1598p ps=1.62u w=0.47u l=0.16u
X4377 cml_tlatch_61.OUTP cml_tlatch_61.OUTN cml_tlatch_61.xmux.xp.S1 VSS sg13_lv_nmos ad=56.9f pd=0.74u as=56.9f ps=0.74u w=0.17u l=0.17u
X4378 cml_tlatch_51.xmux.xp.S1 cml_tlatch_51.OUTN cml_tlatch_51.OUTP VSS sg13_lv_nmos ad=56.9f pd=0.74u as=56.9f ps=0.74u w=0.17u l=0.17u
X4379 cml_tlatch_89.xtail.S1 POLN VSS VSS sg13_lv_nmos ad=1.5637p pd=8.61u as=2.7982p ps=17.14u w=8.23u l=0.13u
X4380 cml_tlatch_76.xtail.S1 CKA2_P cml_tlatch_76.xmux.xn.S1 VSS sg13_lv_nmos ad=89.3f pd=0.85u as=89.3f ps=0.85u w=0.47u l=0.16u
X4381 cml_tlatch_33.xmux.xp.S1 CKA0_N cml_tlatch_33.xtail.S1 VSS sg13_lv_nmos ad=89.3f pd=0.85u as=89.3f ps=0.85u w=0.47u l=0.16u
X4382 cml_drv_3.xrtail.R1 ENA_P ENA0_N VSS sg13_lv_nmos ad=0.1012p pd=1.34u as=56.2f ps=0.74u w=0.16u l=0.19u
X4383 cml_tlatch_75.xmux.xp.S1 MOT31_P MOT31_N VSS sg13_lv_nmos ad=56.9f pd=0.74u as=56.9f ps=0.74u w=0.17u l=0.17u
X4384 cml_tlatch_15.xmux.xp.S1 MOT3_P MOT3_N VSS sg13_lv_nmos ad=56.9f pd=0.74u as=56.9f ps=0.74u w=0.17u l=0.17u
X4385 cml_tlatch_42.xmux.xp.S1 MOT8_N MOT8_P VSS sg13_lv_nmos ad=56.9f pd=0.74u as=56.9f ps=0.74u w=0.17u l=0.17u
X4386 cml_tlatch_22.xmux.xp.S1 cml_tlatch_22.OUTP cml_tlatch_22.OUTN VSS sg13_lv_nmos ad=56.9f pd=0.74u as=56.9f ps=0.74u w=0.17u l=0.17u
X4387 cml_tlatch_78.xmux.xn.S1 CKHB2_P cml_tlatch_78.xtail.S1 VSS sg13_lv_nmos ad=89.3f pd=0.85u as=89.3f ps=0.85u w=0.47u l=0.16u
X4388 stub_bi_17.BOTP stub_bi_17.BOTN cml_tlatch_13.xmux.xp.S1 VSS sg13_lv_nmos ad=56.9f pd=0.74u as=56.9f ps=0.74u w=0.17u l=0.17u
X4389 stub_bi_38.BOTN stub_bi_38.BOTP cml_tlatch_46.xmux.xp.S1 VSS sg13_lv_nmos ad=56.9f pd=0.74u as=56.9f ps=0.74u w=0.17u l=0.17u
X4390 cml_drv_2.xrtail.R1 ENB_P ENB0_N VSS sg13_lv_nmos ad=56.2f pd=0.74u as=56.2f ps=0.74u w=0.16u l=0.19u
X4391 cml_tlatch_72.xmux.xp.S1 MOT25_P MOT25_N VSS sg13_lv_nmos ad=56.9f pd=0.74u as=56.9f ps=0.74u w=0.17u l=0.17u
X4392 VSS hs_to_clk_0.sg13_lv_nmos_2HGZLP_0.G VSS VSS sg13_lv_nmos ad=2.071p pd=11.28u as=0 ps=0 w=10.9u l=1.38u
X4393 cml_tlatch_4.xtail.S1 CKHB1_N cml_tlatch_4.xmux.xp.S1 VSS sg13_lv_nmos ad=0.1598p pd=1.62u as=89.3f ps=0.85u w=0.47u l=0.16u
X4394 cml_tlatch_68.xmux.xp.S1 A3_8_P A3_8_N VSS sg13_lv_nmos ad=56.9f pd=0.74u as=56.9f ps=0.74u w=0.17u l=0.17u
X4395 cml_tlatch_38.OUTP D0_N cml_tlatch_38.xmux.xn.S1 VSS sg13_lv_nmos ad=63.19999f pd=0.74u as=63.19999f ps=0.74u w=0.26u l=0.38u
X4396 MOT13_P MOT13_N cml_tlatch_5.xmux.xp.S1 VSS sg13_lv_nmos ad=56.9f pd=0.74u as=56.9f ps=0.74u w=0.17u l=0.17u
X4397 cml_tlatch_91.xtail.S1 CKA2_P cml_tlatch_91.xmux.xp.S1 VSS sg13_lv_nmos ad=89.3f pd=0.85u as=89.3f ps=0.85u w=0.47u l=0.16u
X4398 MOT27_P cml_tlatch_73.INN cml_tlatch_73.xmux.xn.S1 VSS sg13_lv_nmos ad=63.19999f pd=0.74u as=63.19999f ps=0.74u w=0.26u l=0.38u
X4399 cml_tlatch_64.xtail.S1 CKB3_P cml_tlatch_64.xmux.xp.S1 VSS sg13_lv_nmos ad=89.3f pd=0.85u as=89.3f ps=0.85u w=0.47u l=0.16u
X4400 VDD MOT23_P VSS rppd l=5.17u w=1u
X4401 MOT23_P MOT23_N cml_tlatch_80.xmux.xp.S1 VSS sg13_lv_nmos ad=56.9f pd=0.74u as=56.9f ps=0.74u w=0.17u l=0.17u
X4402 cml_tlatch_0.OUTN cml_tlatch_0.OUTP cml_tlatch_0.xmux.xp.S1 VSS sg13_lv_nmos ad=56.9f pd=0.74u as=56.9f ps=0.74u w=0.17u l=0.17u
X4403 cml_tlatch_19.xmux.xp.S1 CKA1_P cml_tlatch_19.xtail.S1 VSS sg13_lv_nmos ad=0.1598p pd=1.62u as=89.3f ps=0.85u w=0.47u l=0.16u
X4404 cml_tlatch_75.xmux.xp.S1 MOT31_N MOT31_P VSS sg13_lv_nmos ad=56.9f pd=0.74u as=56.9f ps=0.74u w=0.17u l=0.17u
X4405 cml_tlatch_74.INP cml_tlatch_49.OUTN cml_tlatch_88.xmux.xn.S1 VSS sg13_lv_nmos ad=63.19999f pd=0.74u as=63.19999f ps=0.74u w=0.26u l=0.38u
X4406 cml_tlatch_39.xtail.S1 CKA1_P cml_tlatch_39.xmux.xn.S1 VSS sg13_lv_nmos ad=89.3f pd=0.85u as=89.3f ps=0.85u w=0.47u l=0.16u
X4407 cml_tlatch_35.xmux.xp.S1 stub_bi_29.BOTN stub_bi_29.BOTP VSS sg13_lv_nmos ad=0.1019p pd=1.34u as=56.9f ps=0.74u w=0.17u l=0.17u
X4408 cml_tlatch_58.OUTN cml_tlatch_58.OUTP cml_tlatch_58.xmux.xp.S1 VSS sg13_lv_nmos ad=56.9f pd=0.74u as=56.9f ps=0.74u w=0.17u l=0.17u
X4409 cml_tlatch_73.xmux.xn.S1 CKHB3_P cml_tlatch_73.xtail.S1 VSS sg13_lv_nmos ad=89.3f pd=0.85u as=89.3f ps=0.85u w=0.47u l=0.16u
X4410 cml_tlatch_27.xtail.S1 CKHA0_N cml_tlatch_27.xmux.xp.S1 VSS sg13_lv_nmos ad=89.3f pd=0.85u as=89.3f ps=0.85u w=0.47u l=0.16u
X4411 cml_tlatch_56.xmux.xp.S1 cml_tlatch_56.OUTN cml_tlatch_56.OUTP VSS sg13_lv_nmos ad=56.9f pd=0.74u as=56.9f ps=0.74u w=0.17u l=0.17u
X4412 MOT1_N B0_8_P cml_tlatch_14.xmux.xn.S1 VSS sg13_lv_nmos ad=0.1082p pd=1.34u as=63.19999f ps=0.74u w=0.26u l=0.38u
X4413 cml_tlatch_90.xtail.S1 CKB2_P cml_tlatch_90.xmux.xp.S1 VSS sg13_lv_nmos ad=0.1598p pd=1.62u as=89.3f ps=0.85u w=0.47u l=0.16u
X4414 cml_tlatch_99.OUTN cml_tlatch_99.OUTP cml_tlatch_99.xmux.xp.S1 VSS sg13_lv_nmos ad=56.9f pd=0.74u as=56.9f ps=0.74u w=0.17u l=0.17u
X4415 cml_tlatch_41.xmux.xp.S1 cml_tlatch_41.OUTP cml_tlatch_41.OUTN VSS sg13_lv_nmos ad=56.9f pd=0.74u as=56.9f ps=0.74u w=0.17u l=0.17u
X4416 cml_tlatch_81.xmux.xn.S1 stub_bi_62.BOTN B2_8_N VSS sg13_lv_nmos ad=0.1082p pd=1.34u as=63.19999f ps=0.74u w=0.26u l=0.38u
X4417 stub_bi_31.BOTP stub_bi_31.BOTN cml_tlatch_37.xmux.xp.S1 VSS sg13_lv_nmos ad=56.9f pd=0.74u as=56.9f ps=0.74u w=0.17u l=0.17u
X4418 cml_tlatch_6.xtail.S1 CKHB1_P cml_tlatch_6.xmux.xn.S1 VSS sg13_lv_nmos ad=89.3f pd=0.85u as=89.3f ps=0.85u w=0.47u l=0.16u
X4419 cml_tlatch_20.OUTP cml_tlatch_43.INN cml_tlatch_20.xmux.xn.S1 VSS sg13_lv_nmos ad=0.1082p pd=1.34u as=63.19999f ps=0.74u w=0.26u l=0.38u
X4420 cml_tlatch_44.INP cml_tlatch_44.INN cml_tlatch_89.xmux.xp.S1 VSS sg13_lv_nmos ad=56.9f pd=0.74u as=56.9f ps=0.74u w=0.17u l=0.17u
X4421 cml_tlatch_71.xtail.S1 POLN VSS VSS sg13_lv_nmos ad=1.5637p pd=8.61u as=1.5637p ps=8.61u w=8.23u l=0.13u
X4422 cml_tlatch_65.xtail.S1 CKB3_P cml_tlatch_65.xmux.xn.S1 VSS sg13_lv_nmos ad=89.3f pd=0.85u as=89.3f ps=0.85u w=0.47u l=0.16u
X4423 cml_tlatch_80.xmux.xp.S1 CKHB2_N cml_tlatch_80.xtail.S1 VSS sg13_lv_nmos ad=89.3f pd=0.85u as=89.3f ps=0.85u w=0.47u l=0.16u
X4424 cml_tlatch_83.xtail.S1 CKB2_P cml_tlatch_83.xmux.xp.S1 VSS sg13_lv_nmos ad=89.3f pd=0.85u as=89.3f ps=0.85u w=0.47u l=0.16u
X4425 cml_tlatch_23.xmux.xp.S1 CKA0_P cml_tlatch_23.xtail.S1 VSS sg13_lv_nmos ad=89.3f pd=0.85u as=89.3f ps=0.85u w=0.47u l=0.16u
X4426 A3_2_P A3_2_N cml_tlatch_57.xmux.xp.S1 VSS sg13_lv_nmos ad=56.9f pd=0.74u as=56.9f ps=0.74u w=0.17u l=0.17u
X4427 cml_tlatch_42.xtail.S1 CKHA1_N cml_tlatch_42.xmux.xp.S1 VSS sg13_lv_nmos ad=89.3f pd=0.85u as=0.1598p ps=1.62u w=0.47u l=0.16u
X4428 cml_tlatch_20.OUTN cml_tlatch_20.OUTP cml_tlatch_20.xmux.xp.S1 VSS sg13_lv_nmos ad=56.9f pd=0.74u as=56.9f ps=0.74u w=0.17u l=0.17u
X4429 cml_tlatch_23.xmux.xn.S1 CKA0_N cml_tlatch_23.xtail.S1 VSS sg13_lv_nmos ad=89.3f pd=0.85u as=89.3f ps=0.85u w=0.47u l=0.16u
X4430 cml_gate2_8.xrtail.R1 NS1_P cml_gate2_8.xamp.xn.S1 VSS sg13_lv_nmos ad=0.1007p pd=0.91u as=0.1007p ps=0.91u w=0.53u l=0.13u
X4431 stub_bi_43.BOTN stub_bi_43.BOTP cml_tlatch_48.xmux.xp.S1 VSS sg13_lv_nmos ad=56.9f pd=0.74u as=0.1019p ps=1.34u w=0.17u l=0.17u
X4432 cml_tlatch_70.xmux.xn.S1 cml_tlatch_71.OUTP cml_tlatch_63.INN VSS sg13_lv_nmos ad=63.19999f pd=0.74u as=63.19999f ps=0.74u w=0.26u l=0.38u
X4433 MOT6_P MOT6_N cml_tlatch_29.xmux.xp.S1 VSS sg13_lv_nmos ad=56.9f pd=0.74u as=56.9f ps=0.74u w=0.17u l=0.17u
X4434 cml_tlatch_68.xmux.xp.S1 A3_8_P A3_8_N VSS sg13_lv_nmos ad=56.9f pd=0.74u as=56.9f ps=0.74u w=0.17u l=0.17u
X4435 cml_tlatch_98.xmux.xn.S1 cml_tlatch_30.OUTN cml_tlatch_98.OUTP VSS sg13_lv_nmos ad=0.1082p pd=1.34u as=63.19999f ps=0.74u w=0.26u l=0.38u
X4436 stub_bi_55.BOTP stub_bi_38.BOTN cml_tlatch_90.xmux.xn.S1 VSS sg13_lv_nmos ad=63.19999f pd=0.74u as=63.19999f ps=0.74u w=0.26u l=0.38u
X4437 stub_bi_63.BOTP stub_bi_63.BOTN cml_tlatch_83.xmux.xp.S1 VSS sg13_lv_nmos ad=56.9f pd=0.74u as=56.9f ps=0.74u w=0.17u l=0.17u
X4438 cml_tlatch_30.xmux.xp.S1 cml_tlatch_30.OUTP cml_tlatch_30.OUTN VSS sg13_lv_nmos ad=56.9f pd=0.74u as=56.9f ps=0.74u w=0.17u l=0.17u
X4439 cml_tlatch_16.xmux.xn.S1 CKHB0_P cml_tlatch_16.xtail.S1 VSS sg13_lv_nmos ad=89.3f pd=0.85u as=89.3f ps=0.85u w=0.47u l=0.16u
X4440 MOT5_N MOT5_P cml_tlatch_16.xmux.xp.S1 VSS sg13_lv_nmos ad=56.9f pd=0.74u as=56.9f ps=0.74u w=0.17u l=0.17u
X4441 cml_tlatch_28.xmux.xp.S1 CKHA0_N cml_tlatch_28.xtail.S1 VSS sg13_lv_nmos ad=0.1598p pd=1.62u as=89.3f ps=0.85u w=0.47u l=0.16u
X4442 cml_tlatch_63.xtail.S1 POLN VSS VSS sg13_lv_nmos ad=1.5637p pd=8.61u as=2.7982p ps=17.14u w=8.23u l=0.13u
X4443 cml_tlatch_53.xtail.S1 CKHA2_N cml_tlatch_53.xmux.xp.S1 VSS sg13_lv_nmos ad=89.3f pd=0.85u as=89.3f ps=0.85u w=0.47u l=0.16u
X4444 B1_2_P B1_2_N cml_tlatch_36.xmux.xp.S1 VSS sg13_lv_nmos ad=56.9f pd=0.74u as=56.9f ps=0.74u w=0.17u l=0.17u
X4445 cml_tlatch_91.OUTP cml_tlatch_91.INN cml_tlatch_91.xmux.xn.S1 VSS sg13_lv_nmos ad=0.1082p pd=1.34u as=63.19999f ps=0.74u w=0.26u l=0.38u
X4446 VDD GB0_N VSS rppd l=7.42u w=1u
X4447 cml_tlatch_72.xmux.xn.S1 B3_8_N MOT25_P VSS sg13_lv_nmos ad=63.19999f pd=0.74u as=63.19999f ps=0.74u w=0.26u l=0.38u
X4448 cml_gate2_9.xamp.xn.S1 J1_P ENA_N VSS sg13_lv_nmos ad=0.1007p pd=0.91u as=0.1007p ps=0.91u w=0.53u l=0.13u
X4449 cml_gate2_3.xrtail.R1 CKB0_P cml_gate2_3.xamp.xn.S1 VSS sg13_lv_nmos ad=0.1007p pd=0.91u as=0.1007p ps=0.91u w=0.53u l=0.13u
X4450 cml_tlatch_72.xmux.xn.S1 B3_8_N MOT25_P VSS sg13_lv_nmos ad=63.19999f pd=0.74u as=63.19999f ps=0.74u w=0.26u l=0.38u
X4451 cml_tlatch_69.OUTN cml_tlatch_69.OUTP cml_tlatch_69.xmux.xp.S1 VSS sg13_lv_nmos ad=56.9f pd=0.74u as=56.9f ps=0.74u w=0.17u l=0.17u
X4452 cml_tlatch_33.xmux.xp.S1 cml_tlatch_33.OUTN cml_tlatch_33.OUTP VSS sg13_lv_nmos ad=0.1019p pd=1.34u as=56.9f ps=0.74u w=0.17u l=0.17u
X4453 cml_tlatch_56.xmux.xp.S1 cml_tlatch_56.OUTN cml_tlatch_56.OUTP VSS sg13_lv_nmos ad=56.9f pd=0.74u as=56.9f ps=0.74u w=0.17u l=0.17u
X4454 cml_tlatch_38.xmux.xn.S1 CKA0_P cml_tlatch_38.xtail.S1 VSS sg13_lv_nmos ad=89.3f pd=0.85u as=0.1598p ps=1.62u w=0.47u l=0.16u
X4455 cml_tlatch_8.xtail.S1 CKB0_N cml_tlatch_8.xmux.xp.S1 VSS sg13_lv_nmos ad=89.3f pd=0.85u as=89.3f ps=0.85u w=0.47u l=0.16u
X4456 cml_tlatch_22.OUTP cml_tlatch_22.OUTN cml_tlatch_22.xmux.xp.S1 VSS sg13_lv_nmos ad=56.9f pd=0.74u as=56.9f ps=0.74u w=0.17u l=0.17u
X4457 cml_tlatch_13.xmux.xp.S1 stub_bi_17.BOTP stub_bi_17.BOTN VSS sg13_lv_nmos ad=56.9f pd=0.74u as=56.9f ps=0.74u w=0.17u l=0.17u
X4458 cml_tlatch_68.xtail.S1 CKA3_N cml_tlatch_68.xmux.xn.S1 VSS sg13_lv_nmos ad=89.3f pd=0.85u as=89.3f ps=0.85u w=0.47u l=0.16u
X4459 B0_2_P cml_tlatch_32.OUTN cml_tlatch_31.xmux.xn.S1 VSS sg13_lv_nmos ad=63.19999f pd=0.74u as=63.19999f ps=0.74u w=0.26u l=0.38u
X4460 cml_tlatch_43.xmux.xp.S1 MOT10_P MOT10_N VSS sg13_lv_nmos ad=56.9f pd=0.74u as=56.9f ps=0.74u w=0.17u l=0.17u
X4461 cml_tlatch_96.xmux.xp.S1 cml_tlatch_5.INP cml_tlatch_5.INN VSS sg13_lv_nmos ad=56.9f pd=0.74u as=56.9f ps=0.74u w=0.17u l=0.17u
X4462 cml_gate2_5.xamp.xn.S1 ENA1_N GA2_P VSS sg13_lv_nmos ad=0.1007p pd=0.91u as=0.1007p ps=0.91u w=0.53u l=0.13u
X4463 cml_tlatch_45.xtail.S1 CKHA3_N cml_tlatch_45.xmux.xp.S1 VSS sg13_lv_nmos ad=89.3f pd=0.85u as=89.3f ps=0.85u w=0.47u l=0.16u
X4464 cml_tlatch_8.xmux.xp.S1 cml_tlatch_8.OUTP cml_tlatch_8.OUTN VSS sg13_lv_nmos ad=56.9f pd=0.74u as=56.9f ps=0.74u w=0.17u l=0.17u
X4465 cml_tlatch_46.xtail.S1 CKB2_N cml_tlatch_46.xmux.xp.S1 VSS sg13_lv_nmos ad=89.3f pd=0.85u as=89.3f ps=0.85u w=0.47u l=0.16u
X4466 cml_tlatch_2.xmux.xn.S1 cml_tlatch_7.OUTP cml_tlatch_2.OUTN VSS sg13_lv_nmos ad=63.19999f pd=0.74u as=63.19999f ps=0.74u w=0.26u l=0.38u
X4467 cml_tlatch_38.xmux.xn.S1 D0_P cml_tlatch_38.OUTN VSS sg13_lv_nmos ad=63.19999f pd=0.74u as=63.19999f ps=0.74u w=0.26u l=0.38u
X4468 cml_gate2_7.xamp.xn.S1 CKA2_P cml_gate2_7.xrtail.R1 VSS sg13_lv_nmos ad=0.1007p pd=0.91u as=0.1007p ps=0.91u w=0.53u l=0.13u
X4469 cml_tlatch_78.xmux.xp.S1 CKHB2_N cml_tlatch_78.xtail.S1 VSS sg13_lv_nmos ad=89.3f pd=0.85u as=89.3f ps=0.85u w=0.47u l=0.16u
X4470 cml_tlatch_41.xmux.xn.S1 CKA1_P cml_tlatch_41.xtail.S1 VSS sg13_lv_nmos ad=89.3f pd=0.85u as=89.3f ps=0.85u w=0.47u l=0.16u
X4471 cml_tlatch_2.xmux.xn.S1 cml_tlatch_7.OUTP cml_tlatch_2.OUTN VSS sg13_lv_nmos ad=63.19999f pd=0.74u as=63.19999f ps=0.74u w=0.26u l=0.38u
X4472 cml_tlatch_23.xmux.xp.S1 cml_tlatch_23.OUTP cml_tlatch_23.OUTN VSS sg13_lv_nmos ad=56.9f pd=0.74u as=56.9f ps=0.74u w=0.17u l=0.17u
X4473 cml_tlatch_43.xtail.S1 CKHA1_N cml_tlatch_43.xmux.xp.S1 VSS sg13_lv_nmos ad=89.3f pd=0.85u as=89.3f ps=0.85u w=0.47u l=0.16u
X4474 cml_tlatch_64.xtail.S1 CKB3_N cml_tlatch_64.xmux.xn.S1 VSS sg13_lv_nmos ad=0.1598p pd=1.62u as=89.3f ps=0.85u w=0.47u l=0.16u
X4475 cml_tlatch_98.xmux.xp.S1 cml_tlatch_98.OUTP cml_tlatch_98.OUTN VSS sg13_lv_nmos ad=56.9f pd=0.74u as=56.9f ps=0.74u w=0.17u l=0.17u
X4476 cml_tlatch_20.xmux.xp.S1 cml_tlatch_20.OUTP cml_tlatch_20.OUTN VSS sg13_lv_nmos ad=0.1019p pd=1.34u as=56.9f ps=0.74u w=0.17u l=0.17u
X4477 cml_tlatch_87.INN cml_tlatch_91.OUTP cml_tlatch_76.xmux.xn.S1 VSS sg13_lv_nmos ad=63.19999f pd=0.74u as=63.19999f ps=0.74u w=0.26u l=0.38u
X4478 cml_tlatch_3.xtail.S1 CKHB1_P cml_tlatch_3.xmux.xn.S1 VSS sg13_lv_nmos ad=89.3f pd=0.85u as=89.3f ps=0.85u w=0.47u l=0.16u
X4479 CKJ_P CK_P hs_to_clk_8.D2 VSS sg13_lv_nmos ad=0.408p pd=3.08u as=0.228p ps=1.58u w=1.2u l=0.2u
X4480 cml_tlatch_63.xmux.xp.S1 MOT26_P MOT26_N VSS sg13_lv_nmos ad=56.9f pd=0.74u as=56.9f ps=0.74u w=0.17u l=0.17u
X4481 VDD cml_tlatch_99.OUTN VSS rppd l=5.17u w=1u
X4482 cml_tlatch_55.xmux.xp.S1 MOT22_N MOT22_P VSS sg13_lv_nmos ad=56.9f pd=0.74u as=56.9f ps=0.74u w=0.17u l=0.17u
X4483 B2_2_N B2_2_P cml_tlatch_47.xmux.xp.S1 VSS sg13_lv_nmos ad=56.9f pd=0.74u as=56.9f ps=0.74u w=0.17u l=0.17u
X4484 cml_tlatch_10.xmux.xp.S1 B1_8_P B1_8_N VSS sg13_lv_nmos ad=56.9f pd=0.74u as=56.9f ps=0.74u w=0.17u l=0.17u
X4485 J4_N J4_P cml_tlatch_92.xmux.xp.S1 VSS sg13_lv_nmos ad=56.9f pd=0.74u as=56.9f ps=0.74u w=0.17u l=0.17u
X4486 cml_tlatch_51.xmux.xp.S1 cml_tlatch_51.OUTP cml_tlatch_51.OUTN VSS sg13_lv_nmos ad=56.9f pd=0.74u as=56.9f ps=0.74u w=0.17u l=0.17u
X4487 cml_tlatch_77.xmux.xp.S1 CKHB2_N cml_tlatch_77.xtail.S1 VSS sg13_lv_nmos ad=89.3f pd=0.85u as=89.3f ps=0.85u w=0.47u l=0.16u
X4488 cml_tlatch_1.xmux.xp.S1 B0_8_N B0_8_P VSS sg13_lv_nmos ad=56.9f pd=0.74u as=56.9f ps=0.74u w=0.17u l=0.17u
X4489 cml_tlatch_38.xmux.xp.S1 cml_tlatch_38.OUTP cml_tlatch_38.OUTN VSS sg13_lv_nmos ad=56.9f pd=0.74u as=56.9f ps=0.74u w=0.17u l=0.17u
X4490 cml_tlatch_27.xtail.S1 CKHA0_P cml_tlatch_27.xmux.xn.S1 VSS sg13_lv_nmos ad=89.3f pd=0.85u as=89.3f ps=0.85u w=0.47u l=0.16u
X4491 cml_tlatch_98.xmux.xp.S1 cml_tlatch_98.OUTN cml_tlatch_98.OUTP VSS sg13_lv_nmos ad=0.1019p pd=1.34u as=56.9f ps=0.74u w=0.17u l=0.17u
X4492 cml_tlatch_92.xmux.xn.S1 CLK_W_N J4_N VSS sg13_lv_nmos ad=63.19999f pd=0.74u as=63.19999f ps=0.74u w=0.26u l=0.38u
X4493 cml_tlatch_87.xtail.S1 CKA2_N cml_tlatch_87.xmux.xn.S1 VSS sg13_lv_nmos ad=89.3f pd=0.85u as=89.3f ps=0.85u w=0.47u l=0.16u
X4494 GB0_N ENB1_P cml_gate2_1.xamp.xn.S1 VSS sg13_lv_nmos ad=0.1007p pd=0.91u as=0.1007p ps=0.91u w=0.53u l=0.13u
X4495 MOT2_P MOT2_N cml_tlatch_27.xmux.xp.S1 VSS sg13_lv_nmos ad=56.9f pd=0.74u as=56.9f ps=0.74u w=0.17u l=0.17u
X4496 cml_tlatch_50.xmux.xn.S1 cml_tlatch_51.OUTP B3_2_N VSS sg13_lv_nmos ad=63.19999f pd=0.74u as=63.19999f ps=0.74u w=0.26u l=0.38u
X4497 VSS POLN cml_tlatch_33.xtail.S1 VSS sg13_lv_nmos ad=2.7982p pd=17.14u as=1.5637p ps=8.61u w=8.23u l=0.13u
X4498 stub_bi_31.BOTP stub_bi_31.BOTN cml_tlatch_37.xmux.xp.S1 VSS sg13_lv_nmos ad=56.9f pd=0.74u as=56.9f ps=0.74u w=0.17u l=0.17u
X4499 cml_tlatch_56.xmux.xn.S1 CKA3_P cml_tlatch_56.xtail.S1 VSS sg13_lv_nmos ad=0.1598p pd=1.62u as=89.3f ps=0.85u w=0.47u l=0.16u
X4500 cml_drv_0.xrtail.R1 ENB_P ENB1_N VSS sg13_lv_nmos ad=56.2f pd=0.74u as=56.2f ps=0.74u w=0.16u l=0.19u
X4501 cml_tlatch_44.INP cml_tlatch_44.INN cml_tlatch_89.xmux.xp.S1 VSS sg13_lv_nmos ad=56.9f pd=0.74u as=56.9f ps=0.74u w=0.17u l=0.17u
X4502 VSS POLN cml_tlatch_21.xtail.S1 VSS sg13_lv_nmos ad=2.7982p pd=17.14u as=1.5637p ps=8.61u w=8.23u l=0.13u
X4503 cml_tlatch_51.xmux.xn.S1 D3_N cml_tlatch_51.OUTP VSS sg13_lv_nmos ad=63.19999f pd=0.74u as=0.1082p ps=1.34u w=0.26u l=0.38u
X4504 cml_tlatch_88.xmux.xp.S1 cml_tlatch_74.INN cml_tlatch_74.INP VSS sg13_lv_nmos ad=56.9f pd=0.74u as=56.9f ps=0.74u w=0.17u l=0.17u
X4505 cml_tlatch_1.xtail.S1 CKB0_N cml_tlatch_1.xmux.xn.S1 VSS sg13_lv_nmos ad=89.3f pd=0.85u as=89.3f ps=0.85u w=0.47u l=0.16u
X4506 cml_tlatch_13.xtail.S1 POLN VSS VSS sg13_lv_nmos ad=1.5637p pd=8.61u as=2.7982p ps=17.14u w=8.23u l=0.13u
X4507 cml_tlatch_35.xmux.xp.S1 stub_bi_29.BOTP stub_bi_29.BOTN VSS sg13_lv_nmos ad=56.9f pd=0.74u as=56.9f ps=0.74u w=0.17u l=0.17u
X4508 cml_gate2_4.xamp.xn.S1 ENA1_P GA3_N VSS sg13_lv_nmos ad=0.1007p pd=0.91u as=0.1802p ps=1.74u w=0.53u l=0.13u
X4509 cml_tlatch_83.xtail.S1 CKB2_N cml_tlatch_83.xmux.xn.S1 VSS sg13_lv_nmos ad=0.1598p pd=1.62u as=89.3f ps=0.85u w=0.47u l=0.16u
X4510 cml_gate2_5.xrtail.R1 VSS VSS rppd l=4.86u w=1u
X4511 cml_tlatch_4.xmux.xp.S1 CKHB1_N cml_tlatch_4.xtail.S1 VSS sg13_lv_nmos ad=89.3f pd=0.85u as=89.3f ps=0.85u w=0.47u l=0.16u
X4512 MOT12_N MOT12_P cml_tlatch_24.xmux.xp.S1 VSS sg13_lv_nmos ad=56.9f pd=0.74u as=56.9f ps=0.74u w=0.17u l=0.17u
X4513 MOT3_P cml_tlatch_7.OUTN cml_tlatch_15.xmux.xn.S1 VSS sg13_lv_nmos ad=63.19999f pd=0.74u as=63.19999f ps=0.74u w=0.26u l=0.38u
X4514 cml_tlatch_19.xmux.xp.S1 A1_8_N A1_8_P VSS sg13_lv_nmos ad=56.9f pd=0.74u as=56.9f ps=0.74u w=0.17u l=0.17u
X4515 cml_tlatch_12.xmux.xp.S1 cml_tlatch_4.INN cml_tlatch_4.INP VSS sg13_lv_nmos ad=56.9f pd=0.74u as=56.9f ps=0.74u w=0.17u l=0.17u
X4516 cml_tlatch_94.xmux.xp.S1 J2_N J2_P VSS sg13_lv_nmos ad=56.9f pd=0.74u as=56.9f ps=0.74u w=0.17u l=0.17u
X4517 VDD cml_tlatch_44.INP VSS rppd l=5.17u w=1u
X4518 MOT6_P MOT6_N cml_tlatch_29.xmux.xp.S1 VSS sg13_lv_nmos ad=56.9f pd=0.74u as=56.9f ps=0.74u w=0.17u l=0.17u
X4519 cml_tlatch_97.xtail.S1 CKA1_N cml_tlatch_97.xmux.xn.S1 VSS sg13_lv_nmos ad=89.3f pd=0.85u as=89.3f ps=0.85u w=0.47u l=0.16u
X4520 cml_tlatch_5.INP cml_tlatch_5.INN cml_tlatch_96.xmux.xp.S1 VSS sg13_lv_nmos ad=56.9f pd=0.74u as=56.9f ps=0.74u w=0.17u l=0.17u
X4521 MOT0_N MOT0_P cml_tlatch_26.xmux.xp.S1 VSS sg13_lv_nmos ad=56.9f pd=0.74u as=56.9f ps=0.74u w=0.17u l=0.17u
X4522 cml_tlatch_57.xtail.S1 CKA3_N cml_tlatch_57.xmux.xn.S1 VSS sg13_lv_nmos ad=89.3f pd=0.85u as=89.3f ps=0.85u w=0.47u l=0.16u
X4523 cml_tlatch_74.xtail.S1 CKHB3_N cml_tlatch_74.xmux.xp.S1 VSS sg13_lv_nmos ad=89.3f pd=0.85u as=89.3f ps=0.85u w=0.47u l=0.16u
X4524 cml_tlatch_34.xmux.xn.S1 CKA0_N cml_tlatch_34.xtail.S1 VSS sg13_lv_nmos ad=0.1598p pd=1.62u as=89.3f ps=0.85u w=0.47u l=0.16u
X4525 MOT22_N MOT22_P cml_tlatch_55.xmux.xp.S1 VSS sg13_lv_nmos ad=56.9f pd=0.74u as=56.9f ps=0.74u w=0.17u l=0.17u
X4526 cml_tlatch_69.xmux.xp.S1 cml_tlatch_69.OUTN cml_tlatch_69.OUTP VSS sg13_lv_nmos ad=56.9f pd=0.74u as=56.9f ps=0.74u w=0.17u l=0.17u
X4527 cml_tlatch_45.xmux.xp.S1 MOT30_P MOT30_N VSS sg13_lv_nmos ad=56.9f pd=0.74u as=56.9f ps=0.74u w=0.17u l=0.17u
X4528 cml_tlatch_2.xtail.S1 CKB0_P cml_tlatch_2.xmux.xn.S1 VSS sg13_lv_nmos ad=89.3f pd=0.85u as=89.3f ps=0.85u w=0.47u l=0.16u
X4529 cml_tlatch_32.xmux.xn.S1 CKB0_P cml_tlatch_32.xtail.S1 VSS sg13_lv_nmos ad=89.3f pd=0.85u as=89.3f ps=0.85u w=0.47u l=0.16u
X4530 cml_tlatch_82.xmux.xp.S1 CKB2_N cml_tlatch_82.xtail.S1 VSS sg13_lv_nmos ad=89.3f pd=0.85u as=89.3f ps=0.85u w=0.47u l=0.16u
X4531 cml_tlatch_96.xtail.S1 CKB1_N cml_tlatch_96.xmux.xn.S1 VSS sg13_lv_nmos ad=89.3f pd=0.85u as=89.3f ps=0.85u w=0.47u l=0.16u
X4532 cml_tlatch_69.xmux.xn.S1 cml_tlatch_63.INP cml_tlatch_69.OUTN VSS sg13_lv_nmos ad=63.19999f pd=0.74u as=63.19999f ps=0.74u w=0.26u l=0.38u
X4533 GB3_P ENB0_N cml_gate2_6.xamp.xn.S1 VSS sg13_lv_nmos ad=0.1007p pd=0.91u as=0.1007p ps=0.91u w=0.53u l=0.13u
X4534 cml_tlatch_78.xmux.xp.S1 MOT19_P MOT19_N VSS sg13_lv_nmos ad=56.9f pd=0.74u as=56.9f ps=0.74u w=0.17u l=0.17u
X4535 cml_tlatch_76.xmux.xp.S1 cml_tlatch_87.INP cml_tlatch_87.INN VSS sg13_lv_nmos ad=56.9f pd=0.74u as=56.9f ps=0.74u w=0.17u l=0.17u
X4536 MOT7_N B0_2_P cml_tlatch_17.xmux.xn.S1 VSS sg13_lv_nmos ad=63.19999f pd=0.74u as=63.19999f ps=0.74u w=0.26u l=0.38u
X4537 MOT15_N VDD VSS rppd l=5.17u w=1u
X4538 cml_tlatch_11.xmux.xp.S1 stub_bi_15.BOTP stub_bi_15.BOTN VSS sg13_lv_nmos ad=56.9f pd=0.74u as=56.9f ps=0.74u w=0.17u l=0.17u
X4539 cml_tlatch_50.xtail.S1 CKB3_N cml_tlatch_50.xmux.xn.S1 VSS sg13_lv_nmos ad=0.1598p pd=1.62u as=89.3f ps=0.85u w=0.47u l=0.16u
X4540 cml_tlatch_69.xmux.xp.S1 CKA3_N cml_tlatch_69.xtail.S1 VSS sg13_lv_nmos ad=89.3f pd=0.85u as=89.3f ps=0.85u w=0.47u l=0.16u
X4541 MOT28_N MOT28_P cml_tlatch_44.xmux.xp.S1 VSS sg13_lv_nmos ad=56.9f pd=0.74u as=56.9f ps=0.74u w=0.17u l=0.17u
X4542 MOT27_N MOT27_P cml_tlatch_73.xmux.xp.S1 VSS sg13_lv_nmos ad=56.9f pd=0.74u as=56.9f ps=0.74u w=0.17u l=0.17u
X4543 cml_tlatch_48.xmux.xp.S1 CKB2_N cml_tlatch_48.xtail.S1 VSS sg13_lv_nmos ad=89.3f pd=0.85u as=89.3f ps=0.85u w=0.47u l=0.16u
X4544 cml_tlatch_91.xtail.S1 CKA2_N cml_tlatch_91.xmux.xn.S1 VSS sg13_lv_nmos ad=89.3f pd=0.85u as=89.3f ps=0.85u w=0.47u l=0.16u
X4545 cml_tlatch_66.xmux.xp.S1 cml_tlatch_73.INP cml_tlatch_73.INN VSS sg13_lv_nmos ad=56.9f pd=0.74u as=56.9f ps=0.74u w=0.17u l=0.17u
X4546 cml_tlatch_13.xmux.xp.S1 stub_bi_17.BOTP stub_bi_17.BOTN VSS sg13_lv_nmos ad=56.9f pd=0.74u as=56.9f ps=0.74u w=0.17u l=0.17u
X4547 stub_bi_29.BOTN B1_2_N cml_tlatch_35.xmux.xn.S1 VSS sg13_lv_nmos ad=63.19999f pd=0.74u as=63.19999f ps=0.74u w=0.26u l=0.38u
X4548 cml_tlatch_43.xmux.xp.S1 MOT10_P MOT10_N VSS sg13_lv_nmos ad=0.1019p pd=1.34u as=56.9f ps=0.74u w=0.17u l=0.17u
X4549 cml_tlatch_13.xtail.S1 CKB1_P cml_tlatch_13.xmux.xn.S1 VSS sg13_lv_nmos ad=89.3f pd=0.85u as=89.3f ps=0.85u w=0.47u l=0.16u
X4550 cml_tlatch_79.xmux.xn.S1 stub_bi_55.BOTP MOT21_P VSS sg13_lv_nmos ad=63.19999f pd=0.74u as=63.19999f ps=0.74u w=0.26u l=0.38u
X4551 cml_tlatch_29.xmux.xp.S1 CKHA0_N cml_tlatch_29.xtail.S1 VSS sg13_lv_nmos ad=89.3f pd=0.85u as=89.3f ps=0.85u w=0.47u l=0.16u
X4552 cml_tlatch_28.xmux.xp.S1 MOT4_N MOT4_P VSS sg13_lv_nmos ad=56.9f pd=0.74u as=56.9f ps=0.74u w=0.17u l=0.17u
X4553 MOT14_P MOT14_N cml_tlatch_25.xmux.xp.S1 VSS sg13_lv_nmos ad=56.9f pd=0.74u as=0.1019p ps=1.34u w=0.17u l=0.17u
X4554 A2_8_N A2_8_P cml_tlatch_85.xmux.xp.S1 VSS sg13_lv_nmos ad=56.9f pd=0.74u as=56.9f ps=0.74u w=0.17u l=0.17u
X4555 cml_tlatch_53.xmux.xp.S1 CKHA2_N cml_tlatch_53.xtail.S1 VSS sg13_lv_nmos ad=89.3f pd=0.85u as=89.3f ps=0.85u w=0.47u l=0.16u
X4556 cml_tlatch_30.xmux.xn.S1 B0_2_P cml_tlatch_30.OUTN VSS sg13_lv_nmos ad=0.1082p pd=1.34u as=63.19999f ps=0.74u w=0.26u l=0.38u
X4557 cml_tlatch_23.xmux.xp.S1 cml_tlatch_23.OUTP cml_tlatch_23.OUTN VSS sg13_lv_nmos ad=56.9f pd=0.74u as=56.9f ps=0.74u w=0.17u l=0.17u
X4558 cml_tlatch_32.OUTP cml_tlatch_32.OUTN cml_tlatch_32.xmux.xp.S1 VSS sg13_lv_nmos ad=56.9f pd=0.74u as=56.9f ps=0.74u w=0.17u l=0.17u
X4559 cml_tlatch_61.xmux.xp.S1 cml_tlatch_61.OUTP cml_tlatch_61.OUTN VSS sg13_lv_nmos ad=56.9f pd=0.74u as=56.9f ps=0.74u w=0.17u l=0.17u
X4560 J2_N J2_P cml_tlatch_94.xmux.xp.S1 VSS sg13_lv_nmos ad=56.9f pd=0.74u as=56.9f ps=0.74u w=0.17u l=0.17u
X4561 cml_tlatch_73.INN cml_tlatch_73.INP cml_tlatch_66.xmux.xp.S1 VSS sg13_lv_nmos ad=56.9f pd=0.74u as=56.9f ps=0.74u w=0.17u l=0.17u
X4562 cml_tlatch_62.xtail.S1 POLN VSS VSS sg13_lv_nmos ad=1.5637p pd=8.61u as=1.5637p ps=8.61u w=8.23u l=0.13u
X4563 cml_tlatch_73.INP cml_tlatch_73.INN cml_tlatch_66.xmux.xp.S1 VSS sg13_lv_nmos ad=56.9f pd=0.74u as=56.9f ps=0.74u w=0.17u l=0.17u
X4564 cml_tlatch_42.xtail.S1 CKHA1_P cml_tlatch_42.xmux.xn.S1 VSS sg13_lv_nmos ad=89.3f pd=0.85u as=89.3f ps=0.85u w=0.47u l=0.16u
X4565 cml_tlatch_40.xmux.xp.S1 A1_2_P A1_2_N VSS sg13_lv_nmos ad=56.9f pd=0.74u as=56.9f ps=0.74u w=0.17u l=0.17u
X4566 cml_tlatch_58.xtail.S1 CKA3_P cml_tlatch_58.xmux.xn.S1 VSS sg13_lv_nmos ad=89.3f pd=0.85u as=89.3f ps=0.85u w=0.47u l=0.16u
X4567 B2_2_N B2_2_P cml_tlatch_47.xmux.xp.S1 VSS sg13_lv_nmos ad=56.9f pd=0.74u as=56.9f ps=0.74u w=0.17u l=0.17u
X4568 A0_2_P A0_2_N cml_tlatch_34.xmux.xp.S1 VSS sg13_lv_nmos ad=56.9f pd=0.74u as=56.9f ps=0.74u w=0.17u l=0.17u
X4569 cml_tlatch_1.xmux.xp.S1 B0_8_N B0_8_P VSS sg13_lv_nmos ad=56.9f pd=0.74u as=56.9f ps=0.74u w=0.17u l=0.17u
X4570 cml_tlatch_91.INP cml_tlatch_91.INN cml_tlatch_59.xmux.xp.S1 VSS sg13_lv_nmos ad=56.9f pd=0.74u as=56.9f ps=0.74u w=0.17u l=0.17u
X4571 cml_tlatch_19.xtail.S1 CKA1_P cml_tlatch_19.xmux.xp.S1 VSS sg13_lv_nmos ad=89.3f pd=0.85u as=89.3f ps=0.85u w=0.47u l=0.16u
X4572 cml_tlatch_63.xmux.xp.S1 CKHA3_N cml_tlatch_63.xtail.S1 VSS sg13_lv_nmos ad=89.3f pd=0.85u as=89.3f ps=0.85u w=0.47u l=0.16u
X4573 cml_tlatch_58.xmux.xp.S1 cml_tlatch_58.OUTN cml_tlatch_58.OUTP VSS sg13_lv_nmos ad=56.9f pd=0.74u as=56.9f ps=0.74u w=0.17u l=0.17u
X4574 cml_tlatch_8.xmux.xn.S1 CKB0_P cml_tlatch_8.xtail.S1 VSS sg13_lv_nmos ad=89.3f pd=0.85u as=89.3f ps=0.85u w=0.47u l=0.16u
X4575 MOT29_P VDD VSS rppd l=5.17u w=1u
X4576 cml_tlatch_74.xmux.xp.S1 MOT29_P MOT29_N VSS sg13_lv_nmos ad=0.1019p pd=1.34u as=56.9f ps=0.74u w=0.17u l=0.17u
X4577 cml_tlatch_79.xtail.S1 CKHB2_P cml_tlatch_79.xmux.xn.S1 VSS sg13_lv_nmos ad=89.3f pd=0.85u as=89.3f ps=0.85u w=0.47u l=0.16u
X4578 cml_tlatch_46.xmux.xp.S1 CKB2_N cml_tlatch_46.xtail.S1 VSS sg13_lv_nmos ad=89.3f pd=0.85u as=89.3f ps=0.85u w=0.47u l=0.16u
X4579 cml_tlatch_60.xmux.xp.S1 A2_2_N A2_2_P VSS sg13_lv_nmos ad=56.9f pd=0.74u as=56.9f ps=0.74u w=0.17u l=0.17u
X4580 cml_tlatch_0.xmux.xn.S1 cml_tlatch_99.OUTN cml_tlatch_0.OUTP VSS sg13_lv_nmos ad=63.19999f pd=0.74u as=63.19999f ps=0.74u w=0.26u l=0.38u
X4581 cml_tlatch_84.xmux.xp.S1 stub_bi_49.BOTN stub_bi_49.BOTP VSS sg13_lv_nmos ad=56.9f pd=0.74u as=56.9f ps=0.74u w=0.17u l=0.17u
X4582 cml_tlatch_14.xmux.xp.S1 MOT1_N MOT1_P VSS sg13_lv_nmos ad=56.9f pd=0.74u as=56.9f ps=0.74u w=0.17u l=0.17u
X4583 cml_tlatch_56.xmux.xp.S1 CKA3_N cml_tlatch_56.xtail.S1 VSS sg13_lv_nmos ad=89.3f pd=0.85u as=0.1598p ps=1.62u w=0.47u l=0.16u
X4584 cml_tlatch_37.xmux.xp.S1 stub_bi_31.BOTP stub_bi_31.BOTN VSS sg13_lv_nmos ad=56.9f pd=0.74u as=56.9f ps=0.74u w=0.17u l=0.17u
X4585 cml_tlatch_53.xmux.xp.S1 MOT18_N MOT18_P VSS sg13_lv_nmos ad=56.9f pd=0.74u as=56.9f ps=0.74u w=0.17u l=0.17u
X4586 VSS hs_to_clk_4.sg13_lv_nmos_2HGZLP_0.G VSS VSS sg13_lv_nmos ad=2.071p pd=11.28u as=0 ps=0 w=10.9u l=1.38u
X4587 cml_tlatch_34.xmux.xp.S1 A0_2_P A0_2_N VSS sg13_lv_nmos ad=56.9f pd=0.74u as=56.9f ps=0.74u w=0.17u l=0.17u
X4588 cml_tlatch_20.xtail.S1 CKA1_P cml_tlatch_20.xmux.xn.S1 VSS sg13_lv_nmos ad=89.3f pd=0.85u as=89.3f ps=0.85u w=0.47u l=0.16u
X4589 cml_tlatch_12.xmux.xp.S1 cml_tlatch_4.INP cml_tlatch_4.INN VSS sg13_lv_nmos ad=56.9f pd=0.74u as=56.9f ps=0.74u w=0.17u l=0.17u
X4590 MOT9_N VDD VSS rppd l=5.17u w=1u
X4591 GA3_P CKB3_N cml_gate2_4.xrtail.R1 VSS sg13_lv_nmos ad=0.1802p pd=1.74u as=0.1007p ps=0.91u w=0.53u l=0.13u
X4592 cml_tlatch_23.xmux.xp.S1 cml_tlatch_23.OUTN cml_tlatch_23.OUTP VSS sg13_lv_nmos ad=56.9f pd=0.74u as=56.9f ps=0.74u w=0.17u l=0.17u
X4593 cml_gate2_5.xamp.xn.S1 ENA1_P GA2_N VSS sg13_lv_nmos ad=0.1007p pd=0.91u as=0.1007p ps=0.91u w=0.53u l=0.13u
X4594 cml_tlatch_28.xmux.xp.S1 CKHA0_N cml_tlatch_28.xtail.S1 VSS sg13_lv_nmos ad=89.3f pd=0.85u as=89.3f ps=0.85u w=0.47u l=0.16u
X4595 cml_tlatch_87.INP cml_tlatch_87.INN cml_tlatch_76.xmux.xp.S1 VSS sg13_lv_nmos ad=56.9f pd=0.74u as=56.9f ps=0.74u w=0.17u l=0.17u
X4596 cml_tlatch_65.OUTP cml_tlatch_65.OUTN cml_tlatch_65.xmux.xp.S1 VSS sg13_lv_nmos ad=56.9f pd=0.74u as=56.9f ps=0.74u w=0.17u l=0.17u
X4597 cml_tlatch_98.xmux.xn.S1 cml_tlatch_30.OUTP cml_tlatch_98.OUTN VSS sg13_lv_nmos ad=63.19999f pd=0.74u as=0.1082p ps=1.34u w=0.26u l=0.38u
X4598 A1_8_P cml_tlatch_20.OUTN cml_tlatch_19.xmux.xn.S1 VSS sg13_lv_nmos ad=63.19999f pd=0.74u as=0.1082p ps=1.34u w=0.26u l=0.38u
X4599 cml_tlatch_52.xtail.S1 CKHA2_P cml_tlatch_52.xmux.xn.S1 VSS sg13_lv_nmos ad=89.3f pd=0.85u as=89.3f ps=0.85u w=0.47u l=0.16u
X4600 cml_tlatch_63.xmux.xn.S1 cml_tlatch_63.INN MOT26_P VSS sg13_lv_nmos ad=0.1082p pd=1.34u as=63.19999f ps=0.74u w=0.26u l=0.38u
X4601 cml_tlatch_19.xmux.xn.S1 cml_tlatch_20.OUTP A1_8_N VSS sg13_lv_nmos ad=63.19999f pd=0.74u as=63.19999f ps=0.74u w=0.26u l=0.38u
X4602 MOT7_P MOT7_N cml_tlatch_17.xmux.xp.S1 VSS sg13_lv_nmos ad=56.9f pd=0.74u as=56.9f ps=0.74u w=0.17u l=0.17u
X4603 cml_tlatch_11.xtail.S1 CKB1_P cml_tlatch_11.xmux.xn.S1 VSS sg13_lv_nmos ad=89.3f pd=0.85u as=89.3f ps=0.85u w=0.47u l=0.16u
X4604 MOT12_P MOT12_N cml_tlatch_24.xmux.xp.S1 VSS sg13_lv_nmos ad=56.9f pd=0.74u as=56.9f ps=0.74u w=0.17u l=0.17u
X4605 cml_tlatch_88.xmux.xn.S1 cml_tlatch_49.OUTN cml_tlatch_74.INP VSS sg13_lv_nmos ad=63.19999f pd=0.74u as=63.19999f ps=0.74u w=0.26u l=0.38u
X4606 cml_tlatch_33.xtail.S1 CKA0_P cml_tlatch_33.xmux.xn.S1 VSS sg13_lv_nmos ad=89.3f pd=0.85u as=89.3f ps=0.85u w=0.47u l=0.16u
X4607 VSS POLN cml_tlatch_1.xtail.S1 VSS sg13_lv_nmos ad=2.7982p pd=17.14u as=1.5637p ps=8.61u w=8.23u l=0.13u
X4608 cml_tlatch_11.xmux.xp.S1 stub_bi_15.BOTP stub_bi_15.BOTN VSS sg13_lv_nmos ad=56.9f pd=0.74u as=56.9f ps=0.74u w=0.17u l=0.17u
X4609 cml_tlatch_87.OUTN cml_tlatch_87.OUTP cml_tlatch_87.xmux.xp.S1 VSS sg13_lv_nmos ad=56.9f pd=0.74u as=0.1019p ps=1.34u w=0.17u l=0.17u
X4610 cml_tlatch_83.xmux.xp.S1 stub_bi_63.BOTP stub_bi_63.BOTN VSS sg13_lv_nmos ad=56.9f pd=0.74u as=56.9f ps=0.74u w=0.17u l=0.17u
X4611 cml_tlatch_71.xmux.xn.S1 CKA3_P cml_tlatch_71.xtail.S1 VSS sg13_lv_nmos ad=89.3f pd=0.85u as=89.3f ps=0.85u w=0.47u l=0.16u
X4612 cml_gate2_1.xrtail.R1 CKA0_P cml_gate2_1.xamp.xn.S1 VSS sg13_lv_nmos ad=0.1007p pd=0.91u as=0.1007p ps=0.91u w=0.53u l=0.13u
X4613 MOT20_N cml_tlatch_91.OUTP cml_tlatch_54.xmux.xn.S1 VSS sg13_lv_nmos ad=63.19999f pd=0.74u as=63.19999f ps=0.74u w=0.26u l=0.38u
X4614 cml_tlatch_77.xmux.xp.S1 MOT17_P MOT17_N VSS sg13_lv_nmos ad=56.9f pd=0.74u as=56.9f ps=0.74u w=0.17u l=0.17u
X4615 cml_tlatch_24.INN cml_tlatch_97.INP cml_tlatch_97.xmux.xn.S1 VSS sg13_lv_nmos ad=63.19999f pd=0.74u as=63.19999f ps=0.74u w=0.26u l=0.38u
X4616 cml_tlatch_67.OUTP cml_tlatch_74.INN cml_tlatch_67.xmux.xn.S1 VSS sg13_lv_nmos ad=63.19999f pd=0.74u as=63.19999f ps=0.74u w=0.26u l=0.38u
X4617 cml_tlatch_78.xmux.xn.S1 stub_bi_63.BOTN MOT19_N VSS sg13_lv_nmos ad=63.19999f pd=0.74u as=63.19999f ps=0.74u w=0.26u l=0.38u
X4618 A2_8_N A2_8_P cml_tlatch_85.xmux.xp.S1 VSS sg13_lv_nmos ad=56.9f pd=0.74u as=56.9f ps=0.74u w=0.17u l=0.17u
X4619 cml_tlatch_31.xmux.xp.S1 B0_2_N B0_2_P VSS sg13_lv_nmos ad=56.9f pd=0.74u as=56.9f ps=0.74u w=0.17u l=0.17u
X4620 cml_tlatch_33.OUTP cml_tlatch_33.OUTN cml_tlatch_33.xmux.xp.S1 VSS sg13_lv_nmos ad=56.9f pd=0.74u as=56.9f ps=0.74u w=0.17u l=0.17u
X4621 MOT8_N MOT8_P cml_tlatch_42.xmux.xp.S1 VSS sg13_lv_nmos ad=56.9f pd=0.74u as=56.9f ps=0.74u w=0.17u l=0.17u
X4622 cml_tlatch_81.xmux.xp.S1 B2_8_P B2_8_N VSS sg13_lv_nmos ad=56.9f pd=0.74u as=56.9f ps=0.74u w=0.17u l=0.17u
X4623 cml_tlatch_18.xtail.S1 CKA0_N cml_tlatch_18.xmux.xp.S1 VSS sg13_lv_nmos ad=89.3f pd=0.85u as=89.3f ps=0.85u w=0.47u l=0.16u
X4624 GA1_N ENA0_P cml_gate2_2.xamp.xn.S1 VSS sg13_lv_nmos ad=0.1007p pd=0.91u as=0.1007p ps=0.91u w=0.53u l=0.13u
X4625 cml_tlatch_67.xmux.xn.S1 CKB3_P cml_tlatch_67.xtail.S1 VSS sg13_lv_nmos ad=89.3f pd=0.85u as=89.3f ps=0.85u w=0.47u l=0.16u
X4626 cml_tlatch_53.xmux.xn.S1 CKHA2_P cml_tlatch_53.xtail.S1 VSS sg13_lv_nmos ad=0.1598p pd=1.62u as=89.3f ps=0.85u w=0.47u l=0.16u
X4627 cml_tlatch_82.xmux.xn.S1 stub_bi_63.BOTP stub_bi_62.BOTN VSS sg13_lv_nmos ad=63.19999f pd=0.74u as=63.19999f ps=0.74u w=0.26u l=0.38u
X4628 MOT19_P MOT19_N cml_tlatch_78.xmux.xp.S1 VSS sg13_lv_nmos ad=56.9f pd=0.74u as=56.9f ps=0.74u w=0.17u l=0.17u
X4629 MOT17_P MOT17_N cml_tlatch_77.xmux.xp.S1 VSS sg13_lv_nmos ad=56.9f pd=0.74u as=56.9f ps=0.74u w=0.17u l=0.17u
X4630 cml_tlatch_32.xtail.S1 CKB0_P cml_tlatch_32.xmux.xn.S1 VSS sg13_lv_nmos ad=89.3f pd=0.85u as=0.1598p ps=1.62u w=0.47u l=0.16u
X4631 cml_tlatch_85.xmux.xp.S1 A2_8_N A2_8_P VSS sg13_lv_nmos ad=56.9f pd=0.74u as=56.9f ps=0.74u w=0.17u l=0.17u
X4632 cml_tlatch_75.xtail.S1 CKHB3_N cml_tlatch_75.xmux.xp.S1 VSS sg13_lv_nmos ad=89.3f pd=0.85u as=89.3f ps=0.85u w=0.47u l=0.16u
X4633 cml_tlatch_99.xtail.S1 CKA0_P cml_tlatch_99.xmux.xp.S1 VSS sg13_lv_nmos ad=89.3f pd=0.85u as=89.3f ps=0.85u w=0.47u l=0.16u
X4634 cml_tlatch_63.xmux.xp.S1 MOT26_N MOT26_P VSS sg13_lv_nmos ad=56.9f pd=0.74u as=56.9f ps=0.74u w=0.17u l=0.17u
X4635 stub_bi_43.BOTP stub_bi_43.BOTN cml_tlatch_48.xmux.xp.S1 VSS sg13_lv_nmos ad=56.9f pd=0.74u as=56.9f ps=0.74u w=0.17u l=0.17u
X4636 cml_tlatch_5.INN VDD VSS rppd l=5.17u w=1u
X4637 MOT2_N cml_tlatch_23.OUTP cml_tlatch_27.xmux.xn.S1 VSS sg13_lv_nmos ad=63.19999f pd=0.74u as=63.19999f ps=0.74u w=0.26u l=0.38u
X4638 cml_gate2_2.xamp.xn.S1 ENA0_P GA1_N VSS sg13_lv_nmos ad=0.1007p pd=0.91u as=0.1007p ps=0.91u w=0.53u l=0.13u
X4639 cml_tlatch_91.INP cml_tlatch_91.INN cml_tlatch_59.xmux.xp.S1 VSS sg13_lv_nmos ad=56.9f pd=0.74u as=56.9f ps=0.74u w=0.17u l=0.17u
X4640 cml_tlatch_86.xmux.xn.S1 CKA2_P cml_tlatch_86.xtail.S1 VSS sg13_lv_nmos ad=89.3f pd=0.85u as=89.3f ps=0.85u w=0.47u l=0.16u
X4641 cml_tlatch_58.xmux.xn.S1 D3_P cml_tlatch_58.OUTN VSS sg13_lv_nmos ad=63.19999f pd=0.74u as=63.19999f ps=0.74u w=0.26u l=0.38u
X4642 cml_tlatch_48.xtail.S1 CKB2_N cml_tlatch_48.xmux.xp.S1 VSS sg13_lv_nmos ad=89.3f pd=0.85u as=0.1598p ps=1.62u w=0.47u l=0.16u
X4643 cml_tlatch_46.xmux.xp.S1 stub_bi_38.BOTP stub_bi_38.BOTN VSS sg13_lv_nmos ad=56.9f pd=0.74u as=56.9f ps=0.74u w=0.17u l=0.17u
X4644 cml_tlatch_86.OUTN cml_tlatch_86.OUTP cml_tlatch_86.xmux.xp.S1 VSS sg13_lv_nmos ad=56.9f pd=0.74u as=56.9f ps=0.74u w=0.17u l=0.17u
X4645 cml_tlatch_87.OUTN cml_tlatch_87.OUTP cml_tlatch_87.xmux.xp.S1 VSS sg13_lv_nmos ad=56.9f pd=0.74u as=56.9f ps=0.74u w=0.17u l=0.17u
X4646 cml_tlatch_83.xmux.xp.S1 stub_bi_63.BOTP stub_bi_63.BOTN VSS sg13_lv_nmos ad=56.9f pd=0.74u as=56.9f ps=0.74u w=0.17u l=0.17u
X4647 cml_tlatch_91.xmux.xp.S1 cml_tlatch_91.OUTN cml_tlatch_91.OUTP VSS sg13_lv_nmos ad=56.9f pd=0.74u as=56.9f ps=0.74u w=0.17u l=0.17u
X4648 cml_tlatch_51.OUTP cml_tlatch_51.OUTN cml_tlatch_51.xmux.xp.S1 VSS sg13_lv_nmos ad=56.9f pd=0.74u as=56.9f ps=0.74u w=0.17u l=0.17u
X4649 cml_tlatch_57.xmux.xn.S1 cml_tlatch_58.OUTN A3_2_P VSS sg13_lv_nmos ad=63.19999f pd=0.74u as=63.19999f ps=0.74u w=0.26u l=0.38u
X4650 MOT24_P A3_8_N cml_tlatch_62.xmux.xn.S1 VSS sg13_lv_nmos ad=63.19999f pd=0.74u as=63.19999f ps=0.74u w=0.26u l=0.38u
X4651 cml_tlatch_5.xmux.xn.S1 CKHB1_P cml_tlatch_5.xtail.S1 VSS sg13_lv_nmos ad=89.3f pd=0.85u as=89.3f ps=0.85u w=0.47u l=0.16u
X4652 cml_tlatch_0.xmux.xp.S1 cml_tlatch_0.OUTP cml_tlatch_0.OUTN VSS sg13_lv_nmos ad=56.9f pd=0.74u as=56.9f ps=0.74u w=0.17u l=0.17u
X4653 cml_tlatch_80.xmux.xp.S1 MOT23_N MOT23_P VSS sg13_lv_nmos ad=56.9f pd=0.74u as=56.9f ps=0.74u w=0.17u l=0.17u
X4654 cml_tlatch_56.xmux.xn.S1 CKA3_P cml_tlatch_56.xtail.S1 VSS sg13_lv_nmos ad=89.3f pd=0.85u as=89.3f ps=0.85u w=0.47u l=0.16u
X4655 cml_tlatch_22.OUTN cml_tlatch_22.OUTP cml_tlatch_22.xmux.xp.S1 VSS sg13_lv_nmos ad=56.9f pd=0.74u as=56.9f ps=0.74u w=0.17u l=0.17u
X4656 stub_bi_29.BOTP stub_bi_29.BOTN cml_tlatch_35.xmux.xp.S1 VSS sg13_lv_nmos ad=56.9f pd=0.74u as=56.9f ps=0.74u w=0.17u l=0.17u
X4657 cml_tlatch_58.xmux.xp.S1 cml_tlatch_58.OUTP cml_tlatch_58.OUTN VSS sg13_lv_nmos ad=56.9f pd=0.74u as=56.9f ps=0.74u w=0.17u l=0.17u
X4658 cml_tlatch_34.xtail.S1 POLN VSS VSS sg13_lv_nmos ad=1.5637p pd=8.61u as=1.5637p ps=8.61u w=8.23u l=0.13u
X4659 cml_tlatch_14.xmux.xp.S1 MOT1_N MOT1_P VSS sg13_lv_nmos ad=56.9f pd=0.74u as=56.9f ps=0.74u w=0.17u l=0.17u
X4660 cml_tlatch_37.xmux.xp.S1 stub_bi_31.BOTP stub_bi_31.BOTN VSS sg13_lv_nmos ad=56.9f pd=0.74u as=56.9f ps=0.74u w=0.17u l=0.17u
X4661 cml_tlatch_98.OUTP cml_tlatch_98.OUTN cml_tlatch_98.xmux.xp.S1 VSS sg13_lv_nmos ad=56.9f pd=0.74u as=56.9f ps=0.74u w=0.17u l=0.17u
X4662 cml_tlatch_51.xtail.S1 CKB3_N cml_tlatch_51.xmux.xp.S1 VSS sg13_lv_nmos ad=89.3f pd=0.85u as=89.3f ps=0.85u w=0.47u l=0.16u
X4663 B0_2_N B0_2_P cml_tlatch_31.xmux.xp.S1 VSS sg13_lv_nmos ad=56.9f pd=0.74u as=0.1019p ps=1.34u w=0.17u l=0.17u
X4664 VDD cml_tlatch_33.OUTN VSS rppd l=5.17u w=1u
X4665 cml_tlatch_41.xmux.xp.S1 CKA1_N cml_tlatch_41.xtail.S1 VSS sg13_lv_nmos ad=0.1598p pd=1.62u as=89.3f ps=0.85u w=0.47u l=0.16u
X4666 cml_tlatch_4.xmux.xp.S1 CKHB1_N cml_tlatch_4.xtail.S1 VSS sg13_lv_nmos ad=89.3f pd=0.85u as=89.3f ps=0.85u w=0.47u l=0.16u
X4667 cml_tlatch_94.xmux.xp.S1 CKJ_P cml_tlatch_94.xtail.S1 VSS sg13_lv_nmos ad=89.3f pd=0.85u as=89.3f ps=0.85u w=0.47u l=0.16u
X4668 cml_tlatch_99.xmux.xp.S1 cml_tlatch_99.OUTP cml_tlatch_99.OUTN VSS sg13_lv_nmos ad=56.9f pd=0.74u as=56.9f ps=0.74u w=0.17u l=0.17u
X4669 cml_gate2_6.xamp.xn.S1 ENB0_P GB3_N VSS sg13_lv_nmos ad=0.1007p pd=0.91u as=0.1802p ps=1.74u w=0.53u l=0.13u
X4670 cml_tlatch_84.xmux.xp.S1 stub_bi_49.BOTP stub_bi_49.BOTN VSS sg13_lv_nmos ad=0.1019p pd=1.34u as=56.9f ps=0.74u w=0.17u l=0.17u
X4671 cml_tlatch_60.xmux.xn.S1 cml_tlatch_61.OUTP A2_2_N VSS sg13_lv_nmos ad=63.19999f pd=0.74u as=63.19999f ps=0.74u w=0.26u l=0.38u
X4672 cml_tlatch_2.xtail.S1 CKB0_P cml_tlatch_2.xmux.xn.S1 VSS sg13_lv_nmos ad=89.3f pd=0.85u as=89.3f ps=0.85u w=0.47u l=0.16u
X4673 cml_tlatch_99.xtail.S1 CKA0_N cml_tlatch_99.xmux.xn.S1 VSS sg13_lv_nmos ad=89.3f pd=0.85u as=89.3f ps=0.85u w=0.47u l=0.16u
X4674 cml_tlatch_49.OUTN cml_tlatch_49.OUTP cml_tlatch_49.xmux.xp.S1 VSS sg13_lv_nmos ad=56.9f pd=0.74u as=56.9f ps=0.74u w=0.17u l=0.17u
X4675 MOT7_P MOT7_N cml_tlatch_17.xmux.xp.S1 VSS sg13_lv_nmos ad=56.9f pd=0.74u as=56.9f ps=0.74u w=0.17u l=0.17u
X4676 cml_tlatch_60.xmux.xn.S1 cml_tlatch_61.OUTP A2_2_N VSS sg13_lv_nmos ad=63.19999f pd=0.74u as=63.19999f ps=0.74u w=0.26u l=0.38u
X4677 cml_tlatch_55.xtail.S1 CKHA2_N cml_tlatch_55.xmux.xp.S1 VSS sg13_lv_nmos ad=89.3f pd=0.85u as=89.3f ps=0.85u w=0.47u l=0.16u
X4678 cml_tlatch_82.xmux.xp.S1 CKB2_N cml_tlatch_82.xtail.S1 VSS sg13_lv_nmos ad=89.3f pd=0.85u as=89.3f ps=0.85u w=0.47u l=0.16u
X4679 cml_tlatch_29.xmux.xp.S1 MOT6_N MOT6_P VSS sg13_lv_nmos ad=56.9f pd=0.74u as=56.9f ps=0.74u w=0.17u l=0.17u
X4680 cml_tlatch_96.xtail.S1 CKB1_N cml_tlatch_96.xmux.xn.S1 VSS sg13_lv_nmos ad=89.3f pd=0.85u as=89.3f ps=0.85u w=0.47u l=0.16u
X4681 cml_tlatch_16.xmux.xp.S1 MOT5_P MOT5_N VSS sg13_lv_nmos ad=56.9f pd=0.74u as=56.9f ps=0.74u w=0.17u l=0.17u
X4682 A1_2_P A1_2_N cml_tlatch_40.xmux.xp.S1 VSS sg13_lv_nmos ad=56.9f pd=0.74u as=56.9f ps=0.74u w=0.17u l=0.17u
X4683 cml_tlatch_79.xmux.xn.S1 CKHB2_P cml_tlatch_79.xtail.S1 VSS sg13_lv_nmos ad=89.3f pd=0.85u as=89.3f ps=0.85u w=0.47u l=0.16u
X4684 VSS hs_to_clk_4.sg13_lv_nmos_2HGZLP_0.G VSS VSS sg13_lv_nmos ad=3.706p pd=22.48u as=0 ps=0 w=10.9u l=1.38u
X4685 cml_tlatch_4.xmux.xp.S1 MOT11_N MOT11_P VSS sg13_lv_nmos ad=56.9f pd=0.74u as=56.9f ps=0.74u w=0.17u l=0.17u
X4686 VSS POLN cml_tlatch_76.xtail.S1 VSS sg13_lv_nmos ad=1.5637p pd=8.61u as=1.5637p ps=8.61u w=8.23u l=0.13u
X4687 cml_tlatch_35.xmux.xn.S1 CKB1_P cml_tlatch_35.xtail.S1 VSS sg13_lv_nmos ad=89.3f pd=0.85u as=89.3f ps=0.85u w=0.47u l=0.16u
X4688 stub_bi_17.BOTP cml_tlatch_5.INP cml_tlatch_13.xmux.xn.S1 VSS sg13_lv_nmos ad=63.19999f pd=0.74u as=63.19999f ps=0.74u w=0.26u l=0.38u
X4689 cml_tlatch_5.xtail.S1 CKHB1_N cml_tlatch_5.xmux.xp.S1 VSS sg13_lv_nmos ad=0.1598p pd=1.62u as=89.3f ps=0.85u w=0.47u l=0.16u
X4690 cml_tlatch_58.xmux.xp.S1 cml_tlatch_58.OUTP cml_tlatch_58.OUTN VSS sg13_lv_nmos ad=56.9f pd=0.74u as=56.9f ps=0.74u w=0.17u l=0.17u
X4691 cml_tlatch_72.xtail.S1 CKHB3_N cml_tlatch_72.xmux.xp.S1 VSS sg13_lv_nmos ad=89.3f pd=0.85u as=89.3f ps=0.85u w=0.47u l=0.16u
X4692 cml_tlatch_23.xmux.xn.S1 cml_tlatch_0.OUTP cml_tlatch_23.OUTN VSS sg13_lv_nmos ad=63.19999f pd=0.74u as=63.19999f ps=0.74u w=0.26u l=0.38u
X4693 cml_tlatch_24.INP cml_tlatch_24.INN cml_tlatch_97.xmux.xp.S1 VSS sg13_lv_nmos ad=56.9f pd=0.74u as=56.9f ps=0.74u w=0.17u l=0.17u
X4694 ENA_N J1_P cml_gate2_9.xamp.xn.S1 VSS sg13_lv_nmos ad=0.1007p pd=0.91u as=0.1007p ps=0.91u w=0.53u l=0.13u
X4695 cml_tlatch_7.xmux.xp.S1 cml_tlatch_7.OUTP cml_tlatch_7.OUTN VSS sg13_lv_nmos ad=0.1019p pd=1.34u as=56.9f ps=0.74u w=0.17u l=0.17u
X4696 B3_2_N B3_2_P cml_tlatch_50.xmux.xp.S1 VSS sg13_lv_nmos ad=56.9f pd=0.74u as=56.9f ps=0.74u w=0.17u l=0.17u
X4697 B0_2_N B0_2_P cml_tlatch_31.xmux.xp.S1 VSS sg13_lv_nmos ad=56.9f pd=0.74u as=56.9f ps=0.74u w=0.17u l=0.17u
X4698 cml_tlatch_33.OUTP cml_tlatch_33.OUTN cml_tlatch_33.xmux.xp.S1 VSS sg13_lv_nmos ad=56.9f pd=0.74u as=56.9f ps=0.74u w=0.17u l=0.17u
X4699 MOT13_N cml_tlatch_5.INP cml_tlatch_5.xmux.xn.S1 VSS sg13_lv_nmos ad=63.19999f pd=0.74u as=63.19999f ps=0.74u w=0.26u l=0.38u
X4700 VDD cml_tlatch_87.OUTP VSS rppd l=5.17u w=1u
X4701 cml_tlatch_56.OUTN A3_2_P cml_tlatch_56.xmux.xn.S1 VSS sg13_lv_nmos ad=63.19999f pd=0.74u as=63.19999f ps=0.74u w=0.26u l=0.38u
X4702 cml_tlatch_74.xmux.xn.S1 CKHB3_P cml_tlatch_74.xtail.S1 VSS sg13_lv_nmos ad=89.3f pd=0.85u as=89.3f ps=0.85u w=0.47u l=0.16u
X4703 cml_tlatch_28.xtail.S1 CKHA0_N cml_tlatch_28.xmux.xp.S1 VSS sg13_lv_nmos ad=89.3f pd=0.85u as=89.3f ps=0.85u w=0.47u l=0.16u
X4704 cml_tlatch_29.xmux.xn.S1 A0_2_P MOT6_N VSS sg13_lv_nmos ad=63.19999f pd=0.74u as=63.19999f ps=0.74u w=0.26u l=0.38u
X4705 cml_tlatch_49.xmux.xp.S1 cml_tlatch_49.OUTP cml_tlatch_49.OUTN VSS sg13_lv_nmos ad=56.9f pd=0.74u as=56.9f ps=0.74u w=0.17u l=0.17u
X4706 cml_tlatch_17.xmux.xp.S1 CKHB0_N cml_tlatch_17.xtail.S1 VSS sg13_lv_nmos ad=89.3f pd=0.85u as=89.3f ps=0.85u w=0.47u l=0.16u
X4707 MOT10_N MOT10_P cml_tlatch_43.xmux.xp.S1 VSS sg13_lv_nmos ad=56.9f pd=0.74u as=56.9f ps=0.74u w=0.17u l=0.17u
X4708 cml_tlatch_36.xmux.xp.S1 B1_2_P B1_2_N VSS sg13_lv_nmos ad=56.9f pd=0.74u as=56.9f ps=0.74u w=0.17u l=0.17u
X4709 MOT3_N cml_tlatch_7.OUTP cml_tlatch_15.xmux.xn.S1 VSS sg13_lv_nmos ad=0.1082p pd=1.34u as=63.19999f ps=0.74u w=0.26u l=0.38u
X4710 cml_tlatch_5.INN cml_tlatch_5.INP cml_tlatch_96.xmux.xp.S1 VSS sg13_lv_nmos ad=56.9f pd=0.74u as=0.1019p ps=1.34u w=0.17u l=0.17u
X4711 MOT15_P MOT15_N cml_tlatch_6.xmux.xp.S1 VSS sg13_lv_nmos ad=56.9f pd=0.74u as=0.1019p ps=1.34u w=0.17u l=0.17u
X4712 MOT6_N MOT6_P cml_tlatch_29.xmux.xp.S1 VSS sg13_lv_nmos ad=56.9f pd=0.74u as=56.9f ps=0.74u w=0.17u l=0.17u
X4713 cml_gate2_5.xamp.xn.S1 CKB2_P cml_gate2_5.xrtail.R1 VSS sg13_lv_nmos ad=0.1007p pd=0.91u as=0.1007p ps=0.91u w=0.53u l=0.13u
X4714 cml_tlatch_67.xmux.xp.S1 cml_tlatch_67.OUTP cml_tlatch_67.OUTN VSS sg13_lv_nmos ad=56.9f pd=0.74u as=56.9f ps=0.74u w=0.17u l=0.17u
X4715 cml_tlatch_58.xtail.S1 CKA3_P cml_tlatch_58.xmux.xn.S1 VSS sg13_lv_nmos ad=89.3f pd=0.85u as=89.3f ps=0.85u w=0.47u l=0.16u
X4716 cml_tlatch_95.xmux.xn.S1 CKJ_P cml_tlatch_95.xtail.S1 VSS sg13_lv_nmos ad=89.3f pd=0.85u as=89.3f ps=0.85u w=0.47u l=0.16u
X4717 cml_tlatch_63.xmux.xp.S1 CKHA3_N cml_tlatch_63.xtail.S1 VSS sg13_lv_nmos ad=89.3f pd=0.85u as=89.3f ps=0.85u w=0.47u l=0.16u
X4718 VSS POLN cml_tlatch_2.xtail.S1 VSS sg13_lv_nmos ad=1.5637p pd=8.61u as=1.5637p ps=8.61u w=8.23u l=0.13u
X4719 cml_tlatch_20.OUTN cml_tlatch_20.OUTP cml_tlatch_20.xmux.xp.S1 VSS sg13_lv_nmos ad=56.9f pd=0.74u as=56.9f ps=0.74u w=0.17u l=0.17u
X4720 cml_tlatch_13.xmux.xp.S1 CKB1_N cml_tlatch_13.xtail.S1 VSS sg13_lv_nmos ad=89.3f pd=0.85u as=89.3f ps=0.85u w=0.47u l=0.16u
X4721 cml_tlatch_83.xmux.xn.S1 stub_bi_49.BOTN stub_bi_63.BOTP VSS sg13_lv_nmos ad=63.19999f pd=0.74u as=63.19999f ps=0.74u w=0.26u l=0.38u
X4722 cml_tlatch_0.xmux.xp.S1 cml_tlatch_0.OUTP cml_tlatch_0.OUTN VSS sg13_lv_nmos ad=56.9f pd=0.74u as=56.9f ps=0.74u w=0.17u l=0.17u
X4723 GA0_P ENA0_N cml_gate2_3.xamp.xn.S1 VSS sg13_lv_nmos ad=0.1802p pd=1.74u as=0.1007p ps=0.91u w=0.53u l=0.13u
X4724 MOT26_N MOT26_P cml_tlatch_63.xmux.xp.S1 VSS sg13_lv_nmos ad=56.9f pd=0.74u as=56.9f ps=0.74u w=0.17u l=0.17u
X4725 cml_tlatch_76.xmux.xp.S1 CKA2_N cml_tlatch_76.xtail.S1 VSS sg13_lv_nmos ad=89.3f pd=0.85u as=89.3f ps=0.85u w=0.47u l=0.16u
X4726 cml_tlatch_54.xtail.S1 CKHA2_N cml_tlatch_54.xmux.xp.S1 VSS sg13_lv_nmos ad=89.3f pd=0.85u as=89.3f ps=0.85u w=0.47u l=0.16u
X4727 cml_tlatch_92.xmux.xp.S1 J4_P J4_N VSS sg13_lv_nmos ad=56.9f pd=0.74u as=56.9f ps=0.74u w=0.17u l=0.17u
X4728 cml_tlatch_51.xtail.S1 CKB3_P cml_tlatch_51.xmux.xn.S1 VSS sg13_lv_nmos ad=0.1598p pd=1.62u as=89.3f ps=0.85u w=0.47u l=0.16u
X4729 cml_tlatch_98.OUTP cml_tlatch_98.OUTN cml_tlatch_98.xmux.xp.S1 VSS sg13_lv_nmos ad=56.9f pd=0.74u as=56.9f ps=0.74u w=0.17u l=0.17u
X4730 cml_tlatch_38.OUTP cml_tlatch_38.OUTN cml_tlatch_38.xmux.xp.S1 VSS sg13_lv_nmos ad=56.9f pd=0.74u as=56.9f ps=0.74u w=0.17u l=0.17u
X4731 cml_tlatch_73.xmux.xn.S1 cml_tlatch_73.INN MOT27_P VSS sg13_lv_nmos ad=63.19999f pd=0.74u as=63.19999f ps=0.74u w=0.26u l=0.38u
X4732 cml_tlatch_64.xmux.xn.S1 CKB3_N cml_tlatch_64.xtail.S1 VSS sg13_lv_nmos ad=89.3f pd=0.85u as=89.3f ps=0.85u w=0.47u l=0.16u
X4733 cml_tlatch_82.xmux.xp.S1 stub_bi_62.BOTP stub_bi_62.BOTN VSS sg13_lv_nmos ad=56.9f pd=0.74u as=56.9f ps=0.74u w=0.17u l=0.17u
X4734 cml_tlatch_37.xmux.xp.S1 stub_bi_31.BOTN stub_bi_31.BOTP VSS sg13_lv_nmos ad=56.9f pd=0.74u as=56.9f ps=0.74u w=0.17u l=0.17u
X4735 cml_tlatch_73.xmux.xn.S1 cml_tlatch_73.INN MOT27_P VSS sg13_lv_nmos ad=63.19999f pd=0.74u as=63.19999f ps=0.74u w=0.26u l=0.38u
X4736 cml_tlatch_63.INP cml_tlatch_63.INN cml_tlatch_70.xmux.xp.S1 VSS sg13_lv_nmos ad=56.9f pd=0.74u as=56.9f ps=0.74u w=0.17u l=0.17u
X4737 cml_tlatch_89.xmux.xp.S1 cml_tlatch_44.INN cml_tlatch_44.INP VSS sg13_lv_nmos ad=56.9f pd=0.74u as=56.9f ps=0.74u w=0.17u l=0.17u
X4738 cml_tlatch_5.INN cml_tlatch_5.INP cml_tlatch_96.xmux.xp.S1 VSS sg13_lv_nmos ad=56.9f pd=0.74u as=56.9f ps=0.74u w=0.17u l=0.17u
X4739 cml_tlatch_50.xmux.xp.S1 B3_2_N B3_2_P VSS sg13_lv_nmos ad=56.9f pd=0.74u as=56.9f ps=0.74u w=0.17u l=0.17u
X4740 cml_gate2_2.xrtail.R1 CKB1_P cml_gate2_2.xamp.xn.S1 VSS sg13_lv_nmos ad=0.1007p pd=0.91u as=0.1007p ps=0.91u w=0.53u l=0.13u
X4741 cml_tlatch_93.xmux.xn.S1 CKJ_P cml_tlatch_93.xtail.S1 VSS sg13_lv_nmos ad=89.3f pd=0.85u as=89.3f ps=0.85u w=0.47u l=0.16u
X4742 cml_tlatch_14.xmux.xn.S1 B0_8_P MOT1_N VSS sg13_lv_nmos ad=63.19999f pd=0.74u as=63.19999f ps=0.74u w=0.26u l=0.38u
X4743 cml_tlatch_89.xmux.xn.S1 CKA3_N cml_tlatch_89.xtail.S1 VSS sg13_lv_nmos ad=89.3f pd=0.85u as=89.3f ps=0.85u w=0.47u l=0.16u
X4744 cml_tlatch_24.xmux.xp.S1 MOT12_P MOT12_N VSS sg13_lv_nmos ad=56.9f pd=0.74u as=56.9f ps=0.74u w=0.17u l=0.17u
X4745 cml_tlatch_21.xmux.xp.S1 cml_tlatch_43.INP cml_tlatch_43.INN VSS sg13_lv_nmos ad=56.9f pd=0.74u as=56.9f ps=0.74u w=0.17u l=0.17u
X4746 cml_tlatch_21.xmux.xp.S1 cml_tlatch_43.INN cml_tlatch_43.INP VSS sg13_lv_nmos ad=56.9f pd=0.74u as=56.9f ps=0.74u w=0.17u l=0.17u
X4747 cml_tlatch_22.xtail.S1 POLN VSS VSS sg13_lv_nmos ad=1.5637p pd=8.61u as=1.5637p ps=8.61u w=8.23u l=0.13u
X4748 cml_tlatch_4.INP cml_tlatch_4.INN cml_tlatch_12.xmux.xp.S1 VSS sg13_lv_nmos ad=56.9f pd=0.74u as=56.9f ps=0.74u w=0.17u l=0.17u
X4749 GB3_P CKA3_N cml_gate2_6.xrtail.R1 VSS sg13_lv_nmos ad=0.1802p pd=1.74u as=0.1007p ps=0.91u w=0.53u l=0.13u
X4750 cml_tlatch_14.xmux.xn.S1 B0_8_P MOT1_N VSS sg13_lv_nmos ad=63.19999f pd=0.74u as=63.19999f ps=0.74u w=0.26u l=0.38u
X4751 cml_tlatch_29.xmux.xp.S1 MOT6_N MOT6_P VSS sg13_lv_nmos ad=56.9f pd=0.74u as=56.9f ps=0.74u w=0.17u l=0.17u
X4752 cml_tlatch_39.xmux.xp.S1 CKA1_N cml_tlatch_39.xtail.S1 VSS sg13_lv_nmos ad=89.3f pd=0.85u as=89.3f ps=0.85u w=0.47u l=0.16u
X4753 cml_tlatch_96.xmux.xp.S1 cml_tlatch_5.INN cml_tlatch_5.INP VSS sg13_lv_nmos ad=56.9f pd=0.74u as=56.9f ps=0.74u w=0.17u l=0.17u
X4754 A3_8_N A3_8_P cml_tlatch_68.xmux.xp.S1 VSS sg13_lv_nmos ad=56.9f pd=0.74u as=56.9f ps=0.74u w=0.17u l=0.17u
X4755 cml_gate2_2.xamp.xn.S1 CKB1_P cml_gate2_2.xrtail.R1 VSS sg13_lv_nmos ad=0.1007p pd=0.91u as=0.1007p ps=0.91u w=0.53u l=0.13u
X4756 cml_gate2_7.xamp.xn.S1 ENB0_P GB2_N VSS sg13_lv_nmos ad=0.1007p pd=0.91u as=0.1007p ps=0.91u w=0.53u l=0.13u
X4757 B2_8_N stub_bi_62.BOTN cml_tlatch_81.xmux.xn.S1 VSS sg13_lv_nmos ad=63.19999f pd=0.74u as=63.19999f ps=0.74u w=0.26u l=0.38u
X4758 cml_tlatch_30.OUTN cml_tlatch_30.OUTP cml_tlatch_30.xmux.xp.S1 VSS sg13_lv_nmos ad=56.9f pd=0.74u as=56.9f ps=0.74u w=0.17u l=0.17u
X4759 cml_tlatch_69.OUTP cml_tlatch_69.OUTN cml_tlatch_69.xmux.xp.S1 VSS sg13_lv_nmos ad=56.9f pd=0.74u as=0.1019p ps=1.34u w=0.17u l=0.17u
X4760 cml_tlatch_79.xmux.xp.S1 CKHB2_N cml_tlatch_79.xtail.S1 VSS sg13_lv_nmos ad=89.3f pd=0.85u as=89.3f ps=0.85u w=0.47u l=0.16u
X4761 cml_tlatch_18.OUTN cml_tlatch_18.OUTP cml_tlatch_18.xmux.xp.S1 VSS sg13_lv_nmos ad=56.9f pd=0.74u as=56.9f ps=0.74u w=0.17u l=0.17u
X4762 cml_tlatch_74.INN cml_tlatch_74.INP cml_tlatch_88.xmux.xp.S1 VSS sg13_lv_nmos ad=56.9f pd=0.74u as=56.9f ps=0.74u w=0.17u l=0.17u
X4763 cml_tlatch_14.xmux.xp.S1 CKHB0_N cml_tlatch_14.xtail.S1 VSS sg13_lv_nmos ad=89.3f pd=0.85u as=89.3f ps=0.85u w=0.47u l=0.16u
X4764 cml_tlatch_24.xtail.S1 CKHA1_N cml_tlatch_24.xmux.xp.S1 VSS sg13_lv_nmos ad=89.3f pd=0.85u as=89.3f ps=0.85u w=0.47u l=0.16u
X4765 cml_tlatch_12.xmux.xn.S1 stub_bi_17.BOTP cml_tlatch_4.INP VSS sg13_lv_nmos ad=0.1082p pd=1.34u as=63.19999f ps=0.74u w=0.26u l=0.38u
X4766 cml_tlatch_88.xmux.xn.S1 CKB3_N cml_tlatch_88.xtail.S1 VSS sg13_lv_nmos ad=89.3f pd=0.85u as=89.3f ps=0.85u w=0.47u l=0.16u
X4767 cml_tlatch_63.INN cml_tlatch_71.OUTP cml_tlatch_70.xmux.xn.S1 VSS sg13_lv_nmos ad=63.19999f pd=0.74u as=63.19999f ps=0.74u w=0.26u l=0.38u
X4768 cml_tlatch_94.xtail.S1 CKJ_P cml_tlatch_94.xmux.xp.S1 VSS sg13_lv_nmos ad=89.3f pd=0.85u as=89.3f ps=0.85u w=0.47u l=0.16u
X4769 cml_tlatch_67.xmux.xp.S1 cml_tlatch_67.OUTP cml_tlatch_67.OUTN VSS sg13_lv_nmos ad=56.9f pd=0.74u as=56.9f ps=0.74u w=0.17u l=0.17u
X4770 MOT19_N MOT19_P cml_tlatch_78.xmux.xp.S1 VSS sg13_lv_nmos ad=56.9f pd=0.74u as=56.9f ps=0.74u w=0.17u l=0.17u
X4771 VSS POLN cml_tlatch_92.xtail.S1 VSS sg13_lv_nmos ad=2.7982p pd=17.14u as=1.5637p ps=8.61u w=8.23u l=0.13u
X4772 J1_N J1_P cml_tlatch_95.xmux.xp.S1 VSS sg13_lv_nmos ad=56.9f pd=0.74u as=56.9f ps=0.74u w=0.17u l=0.17u
X4773 cml_tlatch_87.INN cml_tlatch_87.INP cml_tlatch_76.xmux.xp.S1 VSS sg13_lv_nmos ad=56.9f pd=0.74u as=56.9f ps=0.74u w=0.17u l=0.17u
X4774 cml_tlatch_56.OUTP cml_tlatch_56.OUTN cml_tlatch_56.xmux.xp.S1 VSS sg13_lv_nmos ad=56.9f pd=0.74u as=56.9f ps=0.74u w=0.17u l=0.17u
X4775 cml_tlatch_73.xmux.xp.S1 MOT27_P MOT27_N VSS sg13_lv_nmos ad=56.9f pd=0.74u as=56.9f ps=0.74u w=0.17u l=0.17u
X4776 cml_tlatch_3.xmux.xn.S1 B1_8_N MOT9_P VSS sg13_lv_nmos ad=63.19999f pd=0.74u as=63.19999f ps=0.74u w=0.26u l=0.38u
X4777 cml_tlatch_4.xtail.S1 CKHB1_P cml_tlatch_4.xmux.xn.S1 VSS sg13_lv_nmos ad=89.3f pd=0.85u as=89.3f ps=0.85u w=0.47u l=0.16u
X4778 cml_tlatch_44.xmux.xp.S1 MOT28_P MOT28_N VSS sg13_lv_nmos ad=56.9f pd=0.74u as=56.9f ps=0.74u w=0.17u l=0.17u
X4779 cml_tlatch_91.xmux.xn.S1 cml_tlatch_91.INN cml_tlatch_91.OUTP VSS sg13_lv_nmos ad=63.19999f pd=0.74u as=63.19999f ps=0.74u w=0.26u l=0.38u
X4780 CLK_W_P CLK_W_N cml_tlatch_93.xmux.xp.S1 VSS sg13_lv_nmos ad=56.9f pd=0.74u as=56.9f ps=0.74u w=0.17u l=0.17u
X4781 VSS cml_gate2_2.xrtail.R1 VSS rppd l=4.86u w=1u
X4782 cml_tlatch_34.xtail.S1 CKA0_N cml_tlatch_34.xmux.xn.S1 VSS sg13_lv_nmos ad=89.3f pd=0.85u as=89.3f ps=0.85u w=0.47u l=0.16u
X4783 cml_tlatch_28.xtail.S1 CKHA0_P cml_tlatch_28.xmux.xn.S1 VSS sg13_lv_nmos ad=89.3f pd=0.85u as=89.3f ps=0.85u w=0.47u l=0.16u
X4784 cml_tlatch_7.OUTP cml_tlatch_7.OUTN cml_tlatch_7.xmux.xp.S1 VSS sg13_lv_nmos ad=56.9f pd=0.74u as=56.9f ps=0.74u w=0.17u l=0.17u
X4785 MOT10_N MOT10_P cml_tlatch_43.xmux.xp.S1 VSS sg13_lv_nmos ad=56.9f pd=0.74u as=56.9f ps=0.74u w=0.17u l=0.17u
X4786 cml_tlatch_91.xmux.xn.S1 cml_tlatch_91.INN cml_tlatch_91.OUTP VSS sg13_lv_nmos ad=63.19999f pd=0.74u as=63.19999f ps=0.74u w=0.26u l=0.38u
X4787 MOT25_P B3_8_N cml_tlatch_72.xmux.xn.S1 VSS sg13_lv_nmos ad=63.19999f pd=0.74u as=63.19999f ps=0.74u w=0.26u l=0.38u
X4788 MOT4_P MOT4_N cml_tlatch_28.xmux.xp.S1 VSS sg13_lv_nmos ad=56.9f pd=0.74u as=56.9f ps=0.74u w=0.17u l=0.17u
X4789 cml_tlatch_59.xmux.xp.S1 cml_tlatch_91.INP cml_tlatch_91.INN VSS sg13_lv_nmos ad=0.1019p pd=1.34u as=56.9f ps=0.74u w=0.17u l=0.17u
X4790 cml_tlatch_82.xtail.S1 CKB2_N cml_tlatch_82.xmux.xp.S1 VSS sg13_lv_nmos ad=89.3f pd=0.85u as=0.1598p ps=1.62u w=0.47u l=0.16u
X4791 B3_8_N B3_8_P cml_tlatch_64.xmux.xp.S1 VSS sg13_lv_nmos ad=56.9f pd=0.74u as=0.1019p ps=1.34u w=0.17u l=0.17u
X4792 cml_tlatch_47.xmux.xn.S1 stub_bi_43.BOTP B2_2_P VSS sg13_lv_nmos ad=0.1082p pd=1.34u as=63.19999f ps=0.74u w=0.26u l=0.38u
X4793 GB1_N ENB1_P cml_gate2_0.xamp.xn.S1 VSS sg13_lv_nmos ad=0.1007p pd=0.91u as=0.1007p ps=0.91u w=0.53u l=0.13u
X4794 cml_tlatch_50.xmux.xn.S1 CKB3_N cml_tlatch_50.xtail.S1 VSS sg13_lv_nmos ad=89.3f pd=0.85u as=89.3f ps=0.85u w=0.47u l=0.16u
X4795 cml_tlatch_48.xmux.xp.S1 stub_bi_43.BOTP stub_bi_43.BOTN VSS sg13_lv_nmos ad=56.9f pd=0.74u as=56.9f ps=0.74u w=0.17u l=0.17u
X4796 cml_tlatch_32.xmux.xp.S1 cml_tlatch_32.OUTN cml_tlatch_32.OUTP VSS sg13_lv_nmos ad=56.9f pd=0.74u as=56.9f ps=0.74u w=0.17u l=0.17u
X4797 cml_gate2_4.xrtail.R1 CKB3_N GA3_P VSS sg13_lv_nmos ad=0.1007p pd=0.91u as=0.1007p ps=0.91u w=0.53u l=0.13u
X4798 cml_tlatch_5.xmux.xp.S1 CKHB1_N cml_tlatch_5.xtail.S1 VSS sg13_lv_nmos ad=89.3f pd=0.85u as=89.3f ps=0.85u w=0.47u l=0.16u
X4799 GA1_N VDD VSS rppd l=7.42u w=1u
X4800 cml_tlatch_87.INP cml_tlatch_91.OUTN cml_tlatch_76.xmux.xn.S1 VSS sg13_lv_nmos ad=63.19999f pd=0.74u as=63.19999f ps=0.74u w=0.26u l=0.38u
X4801 cml_tlatch_95.xmux.xp.S1 J1_N J1_P VSS sg13_lv_nmos ad=56.9f pd=0.74u as=56.9f ps=0.74u w=0.17u l=0.17u
X4802 cml_tlatch_61.OUTN cml_tlatch_61.OUTP cml_tlatch_61.xmux.xp.S1 VSS sg13_lv_nmos ad=56.9f pd=0.74u as=56.9f ps=0.74u w=0.17u l=0.17u
X4803 cml_tlatch_2.OUTP cml_tlatch_2.OUTN cml_tlatch_2.xmux.xp.S1 VSS sg13_lv_nmos ad=56.9f pd=0.74u as=56.9f ps=0.74u w=0.17u l=0.17u
X4804 cml_gate2_0.xamp.xn.S1 ENB1_P GB1_N VSS sg13_lv_nmos ad=0.1007p pd=0.91u as=0.1007p ps=0.91u w=0.53u l=0.13u
X4805 cml_tlatch_62.xmux.xn.S1 CKHA3_P cml_tlatch_62.xtail.S1 VSS sg13_lv_nmos ad=89.3f pd=0.85u as=89.3f ps=0.85u w=0.47u l=0.16u
X4806 VDD cml_tlatch_71.OUTN VSS rppd l=5.17u w=1u
X4807 cml_tlatch_47.xmux.xp.S1 B2_2_P B2_2_N VSS sg13_lv_nmos ad=56.9f pd=0.74u as=56.9f ps=0.74u w=0.17u l=0.17u
X4808 cml_tlatch_98.xmux.xp.S1 CKB0_P cml_tlatch_98.xtail.S1 VSS sg13_lv_nmos ad=89.3f pd=0.85u as=89.3f ps=0.85u w=0.47u l=0.16u
X4809 cml_tlatch_34.xmux.xp.S1 A0_2_N A0_2_P VSS sg13_lv_nmos ad=56.9f pd=0.74u as=56.9f ps=0.74u w=0.17u l=0.17u
X4810 cml_tlatch_68.xmux.xp.S1 CKA3_P cml_tlatch_68.xtail.S1 VSS sg13_lv_nmos ad=89.3f pd=0.85u as=89.3f ps=0.85u w=0.47u l=0.16u
X4811 cml_tlatch_2.OUTN cml_tlatch_7.OUTP cml_tlatch_2.xmux.xn.S1 VSS sg13_lv_nmos ad=63.19999f pd=0.74u as=63.19999f ps=0.74u w=0.26u l=0.38u
X4812 cml_tlatch_33.xtail.S1 CKA0_N cml_tlatch_33.xmux.xp.S1 VSS sg13_lv_nmos ad=89.3f pd=0.85u as=89.3f ps=0.85u w=0.47u l=0.16u
X4813 cml_tlatch_49.OUTP cml_tlatch_49.OUTN cml_tlatch_49.xmux.xp.S1 VSS sg13_lv_nmos ad=56.9f pd=0.74u as=0.1019p ps=1.34u w=0.17u l=0.17u
X4814 B0_8_P B0_8_N cml_tlatch_1.xmux.xp.S1 VSS sg13_lv_nmos ad=56.9f pd=0.74u as=56.9f ps=0.74u w=0.17u l=0.17u
X4815 cml_tlatch_65.xtail.S1 CKB3_N cml_tlatch_65.xmux.xp.S1 VSS sg13_lv_nmos ad=89.3f pd=0.85u as=89.3f ps=0.85u w=0.47u l=0.16u
X4816 cml_tlatch_20.xmux.xp.S1 CKA1_N cml_tlatch_20.xtail.S1 VSS sg13_lv_nmos ad=0.1598p pd=1.62u as=89.3f ps=0.85u w=0.47u l=0.16u
X4817 cml_tlatch_65.OUTN cml_tlatch_65.OUTP cml_tlatch_65.xmux.xp.S1 VSS sg13_lv_nmos ad=56.9f pd=0.74u as=56.9f ps=0.74u w=0.17u l=0.17u
X4818 cml_tlatch_1.xmux.xp.S1 CKB0_P cml_tlatch_1.xtail.S1 VSS sg13_lv_nmos ad=89.3f pd=0.85u as=89.3f ps=0.85u w=0.47u l=0.16u
X4819 cml_tlatch_58.OUTP cml_tlatch_58.OUTN cml_tlatch_58.xmux.xp.S1 VSS sg13_lv_nmos ad=56.9f pd=0.74u as=0.1019p ps=1.34u w=0.17u l=0.17u
X4820 cml_tlatch_68.xtail.S1 POLN VSS VSS sg13_lv_nmos ad=1.5637p pd=8.61u as=2.7982p ps=17.14u w=8.23u l=0.13u
X4821 MOT30_P MOT30_N cml_tlatch_45.xmux.xp.S1 VSS sg13_lv_nmos ad=56.9f pd=0.74u as=56.9f ps=0.74u w=0.17u l=0.17u
X4822 cml_tlatch_52.xmux.xp.S1 MOT16_P MOT16_N VSS sg13_lv_nmos ad=56.9f pd=0.74u as=56.9f ps=0.74u w=0.17u l=0.17u
X4823 cml_tlatch_63.INN cml_tlatch_63.INP cml_tlatch_70.xmux.xp.S1 VSS sg13_lv_nmos ad=56.9f pd=0.74u as=56.9f ps=0.74u w=0.17u l=0.17u
X4824 cml_tlatch_41.xtail.S1 CKA1_N cml_tlatch_41.xmux.xp.S1 VSS sg13_lv_nmos ad=89.3f pd=0.85u as=89.3f ps=0.85u w=0.47u l=0.16u
X4825 cml_tlatch_79.xmux.xp.S1 MOT21_P MOT21_N VSS sg13_lv_nmos ad=56.9f pd=0.74u as=56.9f ps=0.74u w=0.17u l=0.17u
X4826 cml_tlatch_66.xmux.xp.S1 cml_tlatch_73.INN cml_tlatch_73.INP VSS sg13_lv_nmos ad=56.9f pd=0.74u as=56.9f ps=0.74u w=0.17u l=0.17u
X4827 MOT29_N MOT29_P cml_tlatch_74.xmux.xp.S1 VSS sg13_lv_nmos ad=56.9f pd=0.74u as=56.9f ps=0.74u w=0.17u l=0.17u
X4828 A2_2_P A2_2_N cml_tlatch_60.xmux.xp.S1 VSS sg13_lv_nmos ad=56.9f pd=0.74u as=56.9f ps=0.74u w=0.17u l=0.17u
X4829 cml_tlatch_49.xmux.xn.S1 CKB3_P cml_tlatch_49.xtail.S1 VSS sg13_lv_nmos ad=89.3f pd=0.85u as=89.3f ps=0.85u w=0.47u l=0.16u
X4830 cml_tlatch_64.xmux.xp.S1 CKB3_P cml_tlatch_64.xtail.S1 VSS sg13_lv_nmos ad=89.3f pd=0.85u as=89.3f ps=0.85u w=0.47u l=0.16u
X4831 stub_bi_49.BOTP stub_bi_49.BOTN cml_tlatch_84.xmux.xp.S1 VSS sg13_lv_nmos ad=56.9f pd=0.74u as=0.1019p ps=1.34u w=0.17u l=0.17u
X4832 MOT1_P MOT1_N cml_tlatch_14.xmux.xp.S1 VSS sg13_lv_nmos ad=56.9f pd=0.74u as=0.1019p ps=1.34u w=0.17u l=0.17u
X4833 hs_to_clk_8.sg13_lv_nmos_2HGZLP_0.G CKJ_P VSS rppd l=4.25u w=1u
X4834 MOT18_P MOT18_N cml_tlatch_53.xmux.xp.S1 VSS sg13_lv_nmos ad=56.9f pd=0.74u as=56.9f ps=0.74u w=0.17u l=0.17u
X4835 A0_2_N A0_2_P cml_tlatch_34.xmux.xp.S1 VSS sg13_lv_nmos ad=56.9f pd=0.74u as=0.1019p ps=1.34u w=0.17u l=0.17u
X4836 cml_tlatch_24.xmux.xp.S1 MOT12_P MOT12_N VSS sg13_lv_nmos ad=0.1019p pd=1.34u as=56.9f ps=0.74u w=0.17u l=0.17u
X4837 cml_tlatch_87.xmux.xp.S1 CKA2_P cml_tlatch_87.xtail.S1 VSS sg13_lv_nmos ad=89.3f pd=0.85u as=89.3f ps=0.85u w=0.47u l=0.16u
X4838 cml_tlatch_4.INN cml_tlatch_4.INP cml_tlatch_12.xmux.xp.S1 VSS sg13_lv_nmos ad=56.9f pd=0.74u as=56.9f ps=0.74u w=0.17u l=0.17u
X4839 cml_tlatch_4.INP cml_tlatch_4.INN cml_tlatch_12.xmux.xp.S1 VSS sg13_lv_nmos ad=56.9f pd=0.74u as=56.9f ps=0.74u w=0.17u l=0.17u
X4840 VDD cml_tlatch_91.INN VSS rppd l=5.17u w=1u
X4841 cml_tlatch_32.xtail.S1 CKB0_N cml_tlatch_32.xmux.xp.S1 VSS sg13_lv_nmos ad=89.3f pd=0.85u as=89.3f ps=0.85u w=0.47u l=0.16u
X4842 cml_tlatch_34.xmux.xp.S1 CKA0_P cml_tlatch_34.xtail.S1 VSS sg13_lv_nmos ad=89.3f pd=0.85u as=89.3f ps=0.85u w=0.47u l=0.16u
X4843 VDD cml_tlatch_20.OUTP VSS rppd l=5.17u w=1u
X4844 VSS hs_to_clk_1.sg13_lv_nmos_2HGZLP_0.G VSS VSS sg13_lv_nmos ad=2.071p pd=11.28u as=0 ps=0 w=10.9u l=1.38u
X4845 J1_N J1_P cml_tlatch_95.xmux.xp.S1 VSS sg13_lv_nmos ad=56.9f pd=0.74u as=56.9f ps=0.74u w=0.17u l=0.17u
X4846 B3_2_N cml_tlatch_51.OUTP cml_tlatch_50.xmux.xn.S1 VSS sg13_lv_nmos ad=63.19999f pd=0.74u as=63.19999f ps=0.74u w=0.26u l=0.38u
X4847 cml_tlatch_11.xmux.xp.S1 stub_bi_15.BOTN stub_bi_15.BOTP VSS sg13_lv_nmos ad=0.1019p pd=1.34u as=56.9f ps=0.74u w=0.17u l=0.17u
X4848 cml_tlatch_67.OUTP cml_tlatch_67.OUTN cml_tlatch_67.xmux.xp.S1 VSS sg13_lv_nmos ad=56.9f pd=0.74u as=56.9f ps=0.74u w=0.17u l=0.17u
X4849 cml_tlatch_76.xmux.xp.S1 cml_tlatch_87.INN cml_tlatch_87.INP VSS sg13_lv_nmos ad=56.9f pd=0.74u as=56.9f ps=0.74u w=0.17u l=0.17u
X4850 cml_tlatch_54.xmux.xp.S1 CKHA2_N cml_tlatch_54.xtail.S1 VSS sg13_lv_nmos ad=89.3f pd=0.85u as=89.3f ps=0.85u w=0.47u l=0.16u
X4851 cml_gate2_8.xrtail.R1 NS1_P cml_gate2_8.xamp.xn.S1 VSS sg13_lv_nmos ad=0.1007p pd=0.91u as=0.1007p ps=0.91u w=0.53u l=0.13u
X4852 cml_tlatch_91.xmux.xp.S1 cml_tlatch_91.OUTP cml_tlatch_91.OUTN VSS sg13_lv_nmos ad=56.9f pd=0.74u as=56.9f ps=0.74u w=0.17u l=0.17u
X4853 cml_tlatch_56.xtail.S1 CKA3_N cml_tlatch_56.xmux.xp.S1 VSS sg13_lv_nmos ad=89.3f pd=0.85u as=89.3f ps=0.85u w=0.47u l=0.16u
X4854 cml_tlatch_80.xtail.S1 CKHB2_N cml_tlatch_80.xmux.xp.S1 VSS sg13_lv_nmos ad=89.3f pd=0.85u as=89.3f ps=0.85u w=0.47u l=0.16u
X4855 cml_tlatch_83.xmux.xp.S1 CKB2_P cml_tlatch_83.xtail.S1 VSS sg13_lv_nmos ad=89.3f pd=0.85u as=89.3f ps=0.85u w=0.47u l=0.16u
X4856 cml_tlatch_17.xmux.xp.S1 MOT7_N MOT7_P VSS sg13_lv_nmos ad=56.9f pd=0.74u as=56.9f ps=0.74u w=0.17u l=0.17u
X4857 cml_tlatch_97.xtail.S1 CKA1_P cml_tlatch_97.xmux.xp.S1 VSS sg13_lv_nmos ad=89.3f pd=0.85u as=89.3f ps=0.85u w=0.47u l=0.16u
X4858 cml_tlatch_70.xmux.xp.S1 CKA3_P cml_tlatch_70.xtail.S1 VSS sg13_lv_nmos ad=89.3f pd=0.85u as=89.3f ps=0.85u w=0.47u l=0.16u
X4859 cml_tlatch_63.xtail.S1 POLN VSS VSS sg13_lv_nmos ad=1.5637p pd=8.61u as=1.5637p ps=8.61u w=8.23u l=0.13u
X4860 stub_bi_15.BOTN stub_bi_15.BOTP cml_tlatch_11.xmux.xp.S1 VSS sg13_lv_nmos ad=56.9f pd=0.74u as=56.9f ps=0.74u w=0.17u l=0.17u
X4861 cml_tlatch_58.xmux.xn.S1 D3_N cml_tlatch_58.OUTP VSS sg13_lv_nmos ad=63.19999f pd=0.74u as=63.19999f ps=0.74u w=0.26u l=0.38u
X4862 cml_tlatch_23.xtail.S1 CKA0_N cml_tlatch_23.xmux.xn.S1 VSS sg13_lv_nmos ad=89.3f pd=0.85u as=89.3f ps=0.85u w=0.47u l=0.16u
X4863 cml_tlatch_43.xtail.S1 CKHA1_P cml_tlatch_43.xmux.xn.S1 VSS sg13_lv_nmos ad=89.3f pd=0.85u as=89.3f ps=0.85u w=0.47u l=0.16u
X4864 A0_8_P cml_tlatch_18.OUTN cml_tlatch_9.xmux.xn.S1 VSS sg13_lv_nmos ad=63.19999f pd=0.74u as=63.19999f ps=0.74u w=0.26u l=0.38u
X4865 cml_tlatch_44.xmux.xp.S1 CKHA3_N cml_tlatch_44.xtail.S1 VSS sg13_lv_nmos ad=89.3f pd=0.85u as=89.3f ps=0.85u w=0.47u l=0.16u
X4866 cml_tlatch_93.xtail.S1 CKJ_P cml_tlatch_93.xmux.xn.S1 VSS sg13_lv_nmos ad=89.3f pd=0.85u as=89.3f ps=0.85u w=0.47u l=0.16u
X4867 cml_tlatch_29.xtail.S1 CKHA0_P cml_tlatch_29.xmux.xn.S1 VSS sg13_lv_nmos ad=89.3f pd=0.85u as=89.3f ps=0.85u w=0.47u l=0.16u
X4868 MOT17_N MOT17_P cml_tlatch_77.xmux.xp.S1 VSS sg13_lv_nmos ad=56.9f pd=0.74u as=56.9f ps=0.74u w=0.17u l=0.17u
X4869 A3_2_N A3_2_P cml_tlatch_57.xmux.xp.S1 VSS sg13_lv_nmos ad=56.9f pd=0.74u as=56.9f ps=0.74u w=0.17u l=0.17u
X4870 cml_tlatch_69.OUTN cml_tlatch_63.INP cml_tlatch_69.xmux.xn.S1 VSS sg13_lv_nmos ad=63.19999f pd=0.74u as=0.1082p ps=1.34u w=0.26u l=0.38u
X4871 cml_tlatch_7.OUTN cml_tlatch_7.OUTP cml_tlatch_7.xmux.xp.S1 VSS sg13_lv_nmos ad=56.9f pd=0.74u as=56.9f ps=0.74u w=0.17u l=0.17u
X4872 cml_tlatch_17.xmux.xn.S1 B0_2_P MOT7_N VSS sg13_lv_nmos ad=63.19999f pd=0.74u as=63.19999f ps=0.74u w=0.26u l=0.38u
X4873 cml_tlatch_85.xmux.xp.S1 A2_8_P A2_8_N VSS sg13_lv_nmos ad=56.9f pd=0.74u as=56.9f ps=0.74u w=0.17u l=0.17u
X4874 B2_2_P B2_2_N cml_tlatch_47.xmux.xp.S1 VSS sg13_lv_nmos ad=56.9f pd=0.74u as=56.9f ps=0.74u w=0.17u l=0.17u
X4875 cml_tlatch_8.xmux.xp.S1 cml_tlatch_8.OUTP cml_tlatch_8.OUTN VSS sg13_lv_nmos ad=0.1019p pd=1.34u as=56.9f ps=0.74u w=0.17u l=0.17u
X4876 cml_tlatch_54.xmux.xp.S1 MOT20_N MOT20_P VSS sg13_lv_nmos ad=56.9f pd=0.74u as=56.9f ps=0.74u w=0.17u l=0.17u
X4877 cml_tlatch_61.OUTN cml_tlatch_61.OUTP cml_tlatch_61.xmux.xp.S1 VSS sg13_lv_nmos ad=56.9f pd=0.74u as=56.9f ps=0.74u w=0.17u l=0.17u
X4878 MOT26_P MOT26_N cml_tlatch_63.xmux.xp.S1 VSS sg13_lv_nmos ad=56.9f pd=0.74u as=56.9f ps=0.74u w=0.17u l=0.17u
X4879 cml_tlatch_48.xmux.xp.S1 stub_bi_43.BOTN stub_bi_43.BOTP VSS sg13_lv_nmos ad=56.9f pd=0.74u as=56.9f ps=0.74u w=0.17u l=0.17u
X4880 cml_tlatch_10.xtail.S1 CKB1_P cml_tlatch_10.xmux.xp.S1 VSS sg13_lv_nmos ad=89.3f pd=0.85u as=89.3f ps=0.85u w=0.47u l=0.16u
X4881 cml_tlatch_60.xtail.S1 CKA2_P cml_tlatch_60.xmux.xp.S1 VSS sg13_lv_nmos ad=89.3f pd=0.85u as=89.3f ps=0.85u w=0.47u l=0.16u
X4882 cml_gate2_7.xamp.xn.S1 CKA2_P cml_gate2_7.xrtail.R1 VSS sg13_lv_nmos ad=0.1007p pd=0.91u as=0.1007p ps=0.91u w=0.53u l=0.13u
X4883 MOT11_N VDD VSS rppd l=5.17u w=1u
X4884 cml_tlatch_59.xmux.xp.S1 cml_tlatch_91.INN cml_tlatch_91.INP VSS sg13_lv_nmos ad=56.9f pd=0.74u as=56.9f ps=0.74u w=0.17u l=0.17u
X4885 VDD GB0_P VSS rppd l=7.42u w=1u
X4886 cml_tlatch_43.xmux.xp.S1 MOT10_N MOT10_P VSS sg13_lv_nmos ad=56.9f pd=0.74u as=56.9f ps=0.74u w=0.17u l=0.17u
X4887 cml_gate2_5.xrtail.R1 CKB2_N GA2_P VSS sg13_lv_nmos ad=0.1007p pd=0.91u as=0.1007p ps=0.91u w=0.53u l=0.13u
X4888 cml_tlatch_53.xtail.S1 CKHA2_P cml_tlatch_53.xmux.xn.S1 VSS sg13_lv_nmos ad=89.3f pd=0.85u as=89.3f ps=0.85u w=0.47u l=0.16u
X4889 cml_tlatch_87.xmux.xp.S1 cml_tlatch_87.OUTN cml_tlatch_87.OUTP VSS sg13_lv_nmos ad=56.9f pd=0.74u as=56.9f ps=0.74u w=0.17u l=0.17u
X4890 A1_8_N cml_tlatch_20.OUTP cml_tlatch_19.xmux.xn.S1 VSS sg13_lv_nmos ad=0.1082p pd=1.34u as=63.19999f ps=0.74u w=0.26u l=0.38u
X4891 cml_tlatch_64.xmux.xp.S1 B3_8_N B3_8_P VSS sg13_lv_nmos ad=56.9f pd=0.74u as=56.9f ps=0.74u w=0.17u l=0.17u
X4892 cml_tlatch_91.OUTP cml_tlatch_91.OUTN cml_tlatch_91.xmux.xp.S1 VSS sg13_lv_nmos ad=56.9f pd=0.74u as=56.9f ps=0.74u w=0.17u l=0.17u
X4893 cml_tlatch_44.xmux.xn.S1 cml_tlatch_44.INN MOT28_P VSS sg13_lv_nmos ad=0.1082p pd=1.34u as=63.19999f ps=0.74u w=0.26u l=0.38u
X4894 cml_tlatch_52.xmux.xp.S1 MOT16_P MOT16_N VSS sg13_lv_nmos ad=0.1019p pd=1.34u as=56.9f ps=0.74u w=0.17u l=0.17u
X4895 MOT24_N MOT24_P cml_tlatch_62.xmux.xp.S1 VSS sg13_lv_nmos ad=56.9f pd=0.74u as=56.9f ps=0.74u w=0.17u l=0.17u
X4896 cml_tlatch_47.xtail.S1 CKB2_P cml_tlatch_47.xmux.xp.S1 VSS sg13_lv_nmos ad=89.3f pd=0.85u as=89.3f ps=0.85u w=0.47u l=0.16u
X4897 cml_tlatch_43.xmux.xp.S1 CKHA1_N cml_tlatch_43.xtail.S1 VSS sg13_lv_nmos ad=89.3f pd=0.85u as=89.3f ps=0.85u w=0.47u l=0.16u
X4898 cml_tlatch_97.xtail.S1 CKA1_P cml_tlatch_97.xmux.xp.S1 VSS sg13_lv_nmos ad=89.3f pd=0.85u as=89.3f ps=0.85u w=0.47u l=0.16u
X4899 cml_tlatch_97.INN cml_tlatch_97.INP cml_tlatch_39.xmux.xp.S1 VSS sg13_lv_nmos ad=56.9f pd=0.74u as=56.9f ps=0.74u w=0.17u l=0.17u
X4900 cml_tlatch_57.xtail.S1 CKA3_P cml_tlatch_57.xmux.xp.S1 VSS sg13_lv_nmos ad=89.3f pd=0.85u as=89.3f ps=0.85u w=0.47u l=0.16u
X4901 cml_tlatch_84.xmux.xp.S1 CKB2_N cml_tlatch_84.xtail.S1 VSS sg13_lv_nmos ad=89.3f pd=0.85u as=89.3f ps=0.85u w=0.47u l=0.16u
X4902 MOT1_P MOT1_N cml_tlatch_14.xmux.xp.S1 VSS sg13_lv_nmos ad=56.9f pd=0.74u as=56.9f ps=0.74u w=0.17u l=0.17u
X4903 cml_tlatch_19.xmux.xn.S1 CKA1_N cml_tlatch_19.xtail.S1 VSS sg13_lv_nmos ad=89.3f pd=0.85u as=0.1598p ps=1.62u w=0.47u l=0.16u
X4904 cml_tlatch_35.xmux.xp.S1 stub_bi_29.BOTN stub_bi_29.BOTP VSS sg13_lv_nmos ad=56.9f pd=0.74u as=56.9f ps=0.74u w=0.17u l=0.17u
X4905 stub_bi_31.BOTN stub_bi_31.BOTP cml_tlatch_37.xmux.xp.S1 VSS sg13_lv_nmos ad=56.9f pd=0.74u as=56.9f ps=0.74u w=0.17u l=0.17u
X4906 cml_tlatch_25.xmux.xp.S1 MOT14_N MOT14_P VSS sg13_lv_nmos ad=56.9f pd=0.74u as=56.9f ps=0.74u w=0.17u l=0.17u
X4907 cml_tlatch_25.xmux.xp.S1 CKHA1_N cml_tlatch_25.xtail.S1 VSS sg13_lv_nmos ad=89.3f pd=0.85u as=89.3f ps=0.85u w=0.47u l=0.16u
X4908 cml_tlatch_42.xmux.xp.S1 MOT8_P MOT8_N VSS sg13_lv_nmos ad=56.9f pd=0.74u as=56.9f ps=0.74u w=0.17u l=0.17u
X4909 cml_tlatch_73.xtail.S1 CKHB3_N cml_tlatch_73.xmux.xp.S1 VSS sg13_lv_nmos ad=89.3f pd=0.85u as=0.1598p ps=1.62u w=0.47u l=0.16u
X4910 cml_tlatch_0.OUTP cml_tlatch_0.OUTN cml_tlatch_0.xmux.xp.S1 VSS sg13_lv_nmos ad=56.9f pd=0.74u as=56.9f ps=0.74u w=0.17u l=0.17u
X4911 cml_tlatch_77.xtail.S1 CKHB2_N cml_tlatch_77.xmux.xp.S1 VSS sg13_lv_nmos ad=89.3f pd=0.85u as=89.3f ps=0.85u w=0.47u l=0.16u
X4912 cml_tlatch_0.xtail.S1 CKA0_N cml_tlatch_0.xmux.xp.S1 VSS sg13_lv_nmos ad=89.3f pd=0.85u as=89.3f ps=0.85u w=0.47u l=0.16u
X4913 cml_tlatch_97.xmux.xn.S1 cml_tlatch_97.INP cml_tlatch_24.INN VSS sg13_lv_nmos ad=63.19999f pd=0.74u as=63.19999f ps=0.74u w=0.26u l=0.38u
X4914 cml_tlatch_99.OUTN cml_tlatch_99.OUTP cml_tlatch_99.xmux.xp.S1 VSS sg13_lv_nmos ad=56.9f pd=0.74u as=56.9f ps=0.74u w=0.17u l=0.17u
X4915 cml_tlatch_86.xmux.xp.S1 cml_tlatch_86.OUTN cml_tlatch_86.OUTP VSS sg13_lv_nmos ad=56.9f pd=0.74u as=56.9f ps=0.74u w=0.17u l=0.17u
X4916 cml_tlatch_0.OUTP cml_tlatch_99.OUTN cml_tlatch_0.xmux.xn.S1 VSS sg13_lv_nmos ad=63.19999f pd=0.74u as=63.19999f ps=0.74u w=0.26u l=0.38u
X4917 cml_gate2_0.xrtail.R1 CKA1_P cml_gate2_0.xamp.xn.S1 VSS sg13_lv_nmos ad=0.1007p pd=0.91u as=0.1007p ps=0.91u w=0.53u l=0.13u
X4918 cml_tlatch_76.xmux.xp.S1 cml_tlatch_87.INN cml_tlatch_87.INP VSS sg13_lv_nmos ad=56.9f pd=0.74u as=56.9f ps=0.74u w=0.17u l=0.17u
X4919 hs_to_clk_7.sg13_lv_nmos_2HGZLP_0.G CKA2_P VSS rppd l=4.25u w=1u
X4920 cml_tlatch_54.xmux.xn.S1 CKHA2_P cml_tlatch_54.xtail.S1 VSS sg13_lv_nmos ad=0.1598p pd=1.62u as=89.3f ps=0.85u w=0.47u l=0.16u
X4921 MOT21_P MOT21_N cml_tlatch_79.xmux.xp.S1 VSS sg13_lv_nmos ad=56.9f pd=0.74u as=56.9f ps=0.74u w=0.17u l=0.17u
X4922 stub_bi_55.BOTP stub_bi_55.BOTN cml_tlatch_90.xmux.xp.S1 VSS sg13_lv_nmos ad=56.9f pd=0.74u as=56.9f ps=0.74u w=0.17u l=0.17u
X4923 cml_tlatch_82.xtail.S1 CKB2_P cml_tlatch_82.xmux.xn.S1 VSS sg13_lv_nmos ad=89.3f pd=0.85u as=89.3f ps=0.85u w=0.47u l=0.16u
X4924 GA1_P CKB1_N cml_gate2_2.xrtail.R1 VSS sg13_lv_nmos ad=0.1802p pd=1.74u as=0.1007p ps=0.91u w=0.53u l=0.13u
X4925 cml_tlatch_17.xmux.xp.S1 MOT7_N MOT7_P VSS sg13_lv_nmos ad=56.9f pd=0.74u as=56.9f ps=0.74u w=0.17u l=0.17u
X4926 cml_gate2_0.xamp.xn.S1 CKA1_P cml_gate2_0.xrtail.R1 VSS sg13_lv_nmos ad=0.1007p pd=0.91u as=0.1007p ps=0.91u w=0.53u l=0.13u
X4927 cml_tlatch_44.xmux.xp.S1 MOT28_N MOT28_P VSS sg13_lv_nmos ad=56.9f pd=0.74u as=56.9f ps=0.74u w=0.17u l=0.17u
X4928 cml_tlatch_33.xmux.xn.S1 A0_2_N cml_tlatch_33.OUTP VSS sg13_lv_nmos ad=63.19999f pd=0.74u as=63.19999f ps=0.74u w=0.26u l=0.38u
X4929 cml_drvb_5.xrtail.R2 GA2_N CKHA2_P VSS sg13_lv_nmos ad=0.1463p pd=1.15u as=0.2618p ps=2.22u w=0.77u l=0.21u
X4930 VSS hs_to_clk_4.sg13_lv_nmos_2HGZLP_0.G VSS VSS sg13_lv_nmos ad=2.071p pd=11.28u as=0 ps=0 w=10.9u l=1.38u
X4931 cml_tlatch_49.xtail.S1 CKB3_P cml_tlatch_49.xmux.xn.S1 VSS sg13_lv_nmos ad=89.3f pd=0.85u as=89.3f ps=0.85u w=0.47u l=0.16u
X4932 MOT11_P MOT11_N cml_tlatch_4.xmux.xp.S1 VSS sg13_lv_nmos ad=56.9f pd=0.74u as=56.9f ps=0.74u w=0.17u l=0.17u
X4933 cml_tlatch_21.xtail.S1 CKA1_N cml_tlatch_21.xmux.xn.S1 VSS sg13_lv_nmos ad=89.3f pd=0.85u as=89.3f ps=0.85u w=0.47u l=0.16u
X4934 MOT26_P MOT26_N cml_tlatch_63.xmux.xp.S1 VSS sg13_lv_nmos ad=56.9f pd=0.74u as=0.1019p ps=1.34u w=0.17u l=0.17u
X4935 cml_gate2_3.xamp.xn.S1 ENA0_N GA0_P VSS sg13_lv_nmos ad=0.1007p pd=0.91u as=0.1007p ps=0.91u w=0.53u l=0.13u
X4936 MOT26_P cml_tlatch_63.INN cml_tlatch_63.xmux.xn.S1 VSS sg13_lv_nmos ad=63.19999f pd=0.74u as=63.19999f ps=0.74u w=0.26u l=0.38u
X4937 cml_tlatch_72.xmux.xp.S1 MOT25_P MOT25_N VSS sg13_lv_nmos ad=56.9f pd=0.74u as=56.9f ps=0.74u w=0.17u l=0.17u
X4938 VSS POLN cml_tlatch_24.xtail.S1 VSS sg13_lv_nmos ad=2.7982p pd=17.14u as=1.5637p ps=8.61u w=8.23u l=0.13u
X4939 A3_2_N A3_2_P cml_tlatch_57.xmux.xp.S1 VSS sg13_lv_nmos ad=56.9f pd=0.74u as=56.9f ps=0.74u w=0.17u l=0.17u
X4940 cml_tlatch_7.OUTN cml_tlatch_7.OUTP cml_tlatch_7.xmux.xp.S1 VSS sg13_lv_nmos ad=56.9f pd=0.74u as=56.9f ps=0.74u w=0.17u l=0.17u
X4941 cml_tlatch_50.xmux.xp.S1 B3_2_P B3_2_N VSS sg13_lv_nmos ad=56.9f pd=0.74u as=56.9f ps=0.74u w=0.17u l=0.17u
X4942 cml_tlatch_74.INP cml_tlatch_49.OUTN cml_tlatch_88.xmux.xn.S1 VSS sg13_lv_nmos ad=63.19999f pd=0.74u as=63.19999f ps=0.74u w=0.26u l=0.38u
X4943 cml_tlatch_31.xmux.xp.S1 B0_2_P B0_2_N VSS sg13_lv_nmos ad=56.9f pd=0.74u as=56.9f ps=0.74u w=0.17u l=0.17u
X4944 cml_tlatch_33.xmux.xp.S1 cml_tlatch_33.OUTN cml_tlatch_33.OUTP VSS sg13_lv_nmos ad=56.9f pd=0.74u as=56.9f ps=0.74u w=0.17u l=0.17u
X4945 cml_tlatch_33.OUTN cml_tlatch_33.OUTP cml_tlatch_33.xmux.xp.S1 VSS sg13_lv_nmos ad=56.9f pd=0.74u as=56.9f ps=0.74u w=0.17u l=0.17u
X4946 NM1_N CLK_W_P cml_drvb_9.xrtail.R2 VSS sg13_lv_nmos ad=0.2618p pd=2.22u as=0.1463p ps=1.15u w=0.77u l=0.21u
X4947 A0_8_N cml_tlatch_18.OUTP cml_tlatch_9.xmux.xn.S1 VSS sg13_lv_nmos ad=63.19999f pd=0.74u as=0.1082p ps=1.34u w=0.26u l=0.38u
X4948 VSS hs_to_clk_3.sg13_lv_nmos_2HGZLP_0.G VSS VSS sg13_lv_nmos ad=2.071p pd=11.28u as=0 ps=0 w=10.9u l=1.38u
X4949 MOT9_N MOT9_P cml_tlatch_3.xmux.xp.S1 VSS sg13_lv_nmos ad=56.9f pd=0.74u as=56.9f ps=0.74u w=0.17u l=0.17u
X4950 cml_tlatch_54.xmux.xn.S1 cml_tlatch_91.OUTP MOT20_N VSS sg13_lv_nmos ad=63.19999f pd=0.74u as=63.19999f ps=0.74u w=0.26u l=0.38u
X4951 cml_tlatch_9.xtail.S1 CKA0_N cml_tlatch_9.xmux.xn.S1 VSS sg13_lv_nmos ad=89.3f pd=0.85u as=89.3f ps=0.85u w=0.47u l=0.16u
X4952 VSS POLN cml_tlatch_83.xtail.S1 VSS sg13_lv_nmos ad=1.5637p pd=8.61u as=1.5637p ps=8.61u w=8.23u l=0.13u
X4953 cml_tlatch_40.xmux.xn.S1 CKA1_N cml_tlatch_40.xtail.S1 VSS sg13_lv_nmos ad=89.3f pd=0.85u as=0.1598p ps=1.62u w=0.47u l=0.16u
X4954 B1_2_N B1_2_P cml_tlatch_36.xmux.xp.S1 VSS sg13_lv_nmos ad=56.9f pd=0.74u as=56.9f ps=0.74u w=0.17u l=0.17u
X4955 cml_tlatch_5.xmux.xp.S1 CKHB1_N cml_tlatch_5.xtail.S1 VSS sg13_lv_nmos ad=89.3f pd=0.85u as=89.3f ps=0.85u w=0.47u l=0.16u
X4956 A1_8_N A1_8_P cml_tlatch_19.xmux.xp.S1 VSS sg13_lv_nmos ad=56.9f pd=0.74u as=56.9f ps=0.74u w=0.17u l=0.17u
X4957 cml_tlatch_85.xtail.S1 CKA2_N cml_tlatch_85.xmux.xn.S1 VSS sg13_lv_nmos ad=89.3f pd=0.85u as=89.3f ps=0.85u w=0.47u l=0.16u
X4958 cml_tlatch_95.xmux.xp.S1 CKJ_N cml_tlatch_95.xtail.S1 VSS sg13_lv_nmos ad=89.3f pd=0.85u as=89.3f ps=0.85u w=0.47u l=0.16u
X4959 cml_tlatch_27.xtail.S1 POLN VSS VSS sg13_lv_nmos ad=1.5637p pd=8.61u as=1.5637p ps=8.61u w=8.23u l=0.13u
X4960 cml_tlatch_71.xmux.xp.S1 cml_tlatch_71.OUTP cml_tlatch_71.OUTN VSS sg13_lv_nmos ad=56.9f pd=0.74u as=56.9f ps=0.74u w=0.17u l=0.17u
X4961 cml_tlatch_61.xmux.xp.S1 cml_tlatch_61.OUTN cml_tlatch_61.OUTP VSS sg13_lv_nmos ad=56.9f pd=0.74u as=56.9f ps=0.74u w=0.17u l=0.17u
X4962 VSS hs_to_clk_1.sg13_lv_nmos_2HGZLP_0.G VSS VSS sg13_lv_nmos ad=2.071p pd=11.28u as=0 ps=0 w=10.9u l=1.38u
X4963 cml_tlatch_87.xmux.xp.S1 cml_tlatch_87.OUTP cml_tlatch_87.OUTN VSS sg13_lv_nmos ad=56.9f pd=0.74u as=56.9f ps=0.74u w=0.17u l=0.17u
X4964 cml_tlatch_16.xmux.xn.S1 cml_tlatch_98.OUTN MOT5_P VSS sg13_lv_nmos ad=63.19999f pd=0.74u as=63.19999f ps=0.74u w=0.26u l=0.38u
X4965 GB1_N VDD VSS rppd l=7.42u w=1u
X4966 cml_gate2_6.xrtail.R1 CKA3_N GB3_P VSS sg13_lv_nmos ad=0.1007p pd=0.91u as=0.1007p ps=0.91u w=0.53u l=0.13u
X4967 cml_tlatch_36.xmux.xn.S1 stub_bi_31.BOTN B1_2_N VSS sg13_lv_nmos ad=63.19999f pd=0.74u as=63.19999f ps=0.74u w=0.26u l=0.38u
X4968 stub_bi_63.BOTN stub_bi_63.BOTP cml_tlatch_83.xmux.xp.S1 VSS sg13_lv_nmos ad=56.9f pd=0.74u as=56.9f ps=0.74u w=0.17u l=0.17u
X4969 cml_tlatch_29.xmux.xn.S1 CKHA0_P cml_tlatch_29.xtail.S1 VSS sg13_lv_nmos ad=89.3f pd=0.85u as=89.3f ps=0.85u w=0.47u l=0.16u
X4970 MOT3_N MOT3_P cml_tlatch_15.xmux.xp.S1 VSS sg13_lv_nmos ad=56.9f pd=0.74u as=56.9f ps=0.74u w=0.17u l=0.17u
X4971 MOT8_P MOT8_N cml_tlatch_42.xmux.xp.S1 VSS sg13_lv_nmos ad=56.9f pd=0.74u as=56.9f ps=0.74u w=0.17u l=0.17u
X4972 cml_tlatch_20.xtail.S1 CKA1_N cml_tlatch_20.xmux.xp.S1 VSS sg13_lv_nmos ad=89.3f pd=0.85u as=89.3f ps=0.85u w=0.47u l=0.16u
X4973 cml_tlatch_97.INP cml_tlatch_97.INN cml_tlatch_39.xmux.xp.S1 VSS sg13_lv_nmos ad=56.9f pd=0.74u as=56.9f ps=0.74u w=0.17u l=0.17u
X4974 cml_tlatch_13.xmux.xp.S1 stub_bi_17.BOTN stub_bi_17.BOTP VSS sg13_lv_nmos ad=56.9f pd=0.74u as=56.9f ps=0.74u w=0.17u l=0.17u
X4975 cml_tlatch_6.xmux.xp.S1 MOT15_P MOT15_N VSS sg13_lv_nmos ad=56.9f pd=0.74u as=56.9f ps=0.74u w=0.17u l=0.17u
X4976 cml_tlatch_40.xmux.xn.S1 cml_tlatch_41.OUTN A1_2_P VSS sg13_lv_nmos ad=63.19999f pd=0.74u as=63.19999f ps=0.74u w=0.26u l=0.38u
X4977 MOT25_N MOT25_P cml_tlatch_72.xmux.xp.S1 VSS sg13_lv_nmos ad=56.9f pd=0.74u as=56.9f ps=0.74u w=0.17u l=0.17u
X4978 cml_tlatch_35.xmux.xp.S1 stub_bi_29.BOTN stub_bi_29.BOTP VSS sg13_lv_nmos ad=56.9f pd=0.74u as=56.9f ps=0.74u w=0.17u l=0.17u
X4979 cml_tlatch_58.OUTN D3_P cml_tlatch_58.xmux.xn.S1 VSS sg13_lv_nmos ad=63.19999f pd=0.74u as=0.1082p ps=1.34u w=0.26u l=0.38u
X4980 cml_tlatch_98.xmux.xp.S1 cml_tlatch_98.OUTN cml_tlatch_98.OUTP VSS sg13_lv_nmos ad=56.9f pd=0.74u as=56.9f ps=0.74u w=0.17u l=0.17u
X4981 cml_tlatch_5.xmux.xp.S1 MOT13_N MOT13_P VSS sg13_lv_nmos ad=56.9f pd=0.74u as=56.9f ps=0.74u w=0.17u l=0.17u
X4982 cml_tlatch_42.xmux.xn.S1 CKHA1_P cml_tlatch_42.xtail.S1 VSS sg13_lv_nmos ad=89.3f pd=0.85u as=89.3f ps=0.85u w=0.47u l=0.16u
X4983 cml_tlatch_30.xmux.xp.S1 CKB0_N cml_tlatch_30.xtail.S1 VSS sg13_lv_nmos ad=89.3f pd=0.85u as=89.3f ps=0.85u w=0.47u l=0.16u
X4984 cml_tlatch_38.xmux.xp.S1 cml_tlatch_38.OUTN cml_tlatch_38.OUTP VSS sg13_lv_nmos ad=56.9f pd=0.74u as=56.9f ps=0.74u w=0.17u l=0.17u
X4985 cml_tlatch_71.xmux.xn.S1 cml_tlatch_44.INP cml_tlatch_71.OUTN VSS sg13_lv_nmos ad=63.19999f pd=0.74u as=63.19999f ps=0.74u w=0.26u l=0.38u
X4986 MOT25_N B3_8_P cml_tlatch_72.xmux.xn.S1 VSS sg13_lv_nmos ad=63.19999f pd=0.74u as=63.19999f ps=0.74u w=0.26u l=0.38u
X4987 cml_tlatch_73.xmux.xp.S1 MOT27_N MOT27_P VSS sg13_lv_nmos ad=56.9f pd=0.74u as=56.9f ps=0.74u w=0.17u l=0.17u
X4988 VSS POLN cml_tlatch_99.xtail.S1 VSS sg13_lv_nmos ad=1.5637p pd=8.61u as=1.5637p ps=8.61u w=8.23u l=0.13u
X4989 cml_tlatch_21.xtail.S1 CKA1_N cml_tlatch_21.xmux.xn.S1 VSS sg13_lv_nmos ad=89.3f pd=0.85u as=89.3f ps=0.85u w=0.47u l=0.16u
X4990 stub_bi_17.BOTN VDD VSS rppd l=5.17u w=1u
X4991 cml_gate2_9.xrtail.R1 VSS VSS rppd l=4.86u w=1u
X4992 cml_tlatch_89.xmux.xp.S1 CKA3_P cml_tlatch_89.xtail.S1 VSS sg13_lv_nmos ad=0.1598p pd=1.62u as=89.3f ps=0.85u w=0.47u l=0.16u
X4993 MOT31_P MOT31_N cml_tlatch_75.xmux.xp.S1 VSS sg13_lv_nmos ad=56.9f pd=0.74u as=56.9f ps=0.74u w=0.17u l=0.17u
X4994 cml_tlatch_86.xmux.xp.S1 cml_tlatch_86.OUTN cml_tlatch_86.OUTP VSS sg13_lv_nmos ad=56.9f pd=0.74u as=56.9f ps=0.74u w=0.17u l=0.17u
X4995 stub_bi_62.BOTN stub_bi_62.BOTP cml_tlatch_82.xmux.xp.S1 VSS sg13_lv_nmos ad=56.9f pd=0.74u as=56.9f ps=0.74u w=0.17u l=0.17u
X4996 cml_tlatch_32.xtail.S1 CKB0_N cml_tlatch_32.xmux.xp.S1 VSS sg13_lv_nmos ad=89.3f pd=0.85u as=89.3f ps=0.85u w=0.47u l=0.16u
X4997 cml_tlatch_8.xtail.S1 CKB0_P cml_tlatch_8.xmux.xn.S1 VSS sg13_lv_nmos ad=89.3f pd=0.85u as=89.3f ps=0.85u w=0.47u l=0.16u
X4998 ENA_P NM1_N cml_gate2_9.xrtail.R1 VSS sg13_lv_nmos ad=0.1007p pd=0.91u as=0.1007p ps=0.91u w=0.53u l=0.13u
X4999 cml_tlatch_70.xmux.xp.S1 cml_tlatch_63.INN cml_tlatch_63.INP VSS sg13_lv_nmos ad=56.9f pd=0.74u as=56.9f ps=0.74u w=0.17u l=0.17u
X5000 MOT24_P MOT24_N cml_tlatch_62.xmux.xp.S1 VSS sg13_lv_nmos ad=56.9f pd=0.74u as=56.9f ps=0.74u w=0.17u l=0.17u
X5001 cml_tlatch_48.xmux.xn.S1 D2_N stub_bi_43.BOTN VSS sg13_lv_nmos ad=0.1082p pd=1.34u as=63.19999f ps=0.74u w=0.26u l=0.38u
X5002 cml_tlatch_51.xmux.xn.S1 CKB3_P cml_tlatch_51.xtail.S1 VSS sg13_lv_nmos ad=89.3f pd=0.85u as=89.3f ps=0.85u w=0.47u l=0.16u
X5003 cml_tlatch_56.xtail.S1 CKA3_N cml_tlatch_56.xmux.xp.S1 VSS sg13_lv_nmos ad=89.3f pd=0.85u as=89.3f ps=0.85u w=0.47u l=0.16u
X5004 MOT12_N MOT12_P cml_tlatch_24.xmux.xp.S1 VSS sg13_lv_nmos ad=56.9f pd=0.74u as=56.9f ps=0.74u w=0.17u l=0.17u
X5005 cml_tlatch_20.OUTP cml_tlatch_43.INN cml_tlatch_20.xmux.xn.S1 VSS sg13_lv_nmos ad=63.19999f pd=0.74u as=0.1082p ps=1.34u w=0.26u l=0.38u
X5006 cml_tlatch_68.xmux.xp.S1 A3_8_P A3_8_N VSS sg13_lv_nmos ad=56.9f pd=0.74u as=56.9f ps=0.74u w=0.17u l=0.17u
X5007 cml_tlatch_30.xmux.xp.S1 cml_tlatch_30.OUTP cml_tlatch_30.OUTN VSS sg13_lv_nmos ad=56.9f pd=0.74u as=56.9f ps=0.74u w=0.17u l=0.17u
X5008 cml_tlatch_60.xtail.S1 CKA2_N cml_tlatch_60.xmux.xn.S1 VSS sg13_lv_nmos ad=89.3f pd=0.85u as=89.3f ps=0.85u w=0.47u l=0.16u
X5009 cml_tlatch_84.xtail.S1 CKB2_N cml_tlatch_84.xmux.xp.S1 VSS sg13_lv_nmos ad=89.3f pd=0.85u as=89.3f ps=0.85u w=0.47u l=0.16u
X5010 stub_bi_17.BOTN cml_tlatch_5.INN cml_tlatch_13.xmux.xn.S1 VSS sg13_lv_nmos ad=63.19999f pd=0.74u as=63.19999f ps=0.74u w=0.26u l=0.38u
X5011 A2_2_N cml_tlatch_61.OUTP cml_tlatch_60.xmux.xn.S1 VSS sg13_lv_nmos ad=63.19999f pd=0.74u as=63.19999f ps=0.74u w=0.26u l=0.38u
X5012 cml_tlatch_44.xmux.xp.S1 CKHA3_N cml_tlatch_44.xtail.S1 VSS sg13_lv_nmos ad=89.3f pd=0.85u as=89.3f ps=0.85u w=0.47u l=0.16u
X5013 stub_bi_62.BOTP stub_bi_63.BOTN cml_tlatch_82.xmux.xn.S1 VSS sg13_lv_nmos ad=63.19999f pd=0.74u as=63.19999f ps=0.74u w=0.26u l=0.38u
X5014 cml_tlatch_88.xmux.xp.S1 cml_tlatch_74.INP cml_tlatch_74.INN VSS sg13_lv_nmos ad=56.9f pd=0.74u as=56.9f ps=0.74u w=0.17u l=0.17u
X5015 cml_tlatch_58.OUTN cml_tlatch_58.OUTP cml_tlatch_58.xmux.xp.S1 VSS sg13_lv_nmos ad=56.9f pd=0.74u as=56.9f ps=0.74u w=0.17u l=0.17u
X5016 MOT22_P A2_2_N cml_tlatch_55.xmux.xn.S1 VSS sg13_lv_nmos ad=63.19999f pd=0.74u as=63.19999f ps=0.74u w=0.26u l=0.38u
X5017 cml_tlatch_49.xtail.S1 CKB3_N cml_tlatch_49.xmux.xp.S1 VSS sg13_lv_nmos ad=0.1598p pd=1.62u as=89.3f ps=0.85u w=0.47u l=0.16u
X5018 cml_tlatch_97.xmux.xp.S1 cml_tlatch_24.INN cml_tlatch_24.INP VSS sg13_lv_nmos ad=56.9f pd=0.74u as=56.9f ps=0.74u w=0.17u l=0.17u
X5019 cml_tlatch_92.xmux.xp.S1 CKJ_P cml_tlatch_92.xtail.S1 VSS sg13_lv_nmos ad=89.3f pd=0.85u as=89.3f ps=0.85u w=0.47u l=0.16u
X5020 cml_tlatch_36.xmux.xp.S1 B1_2_N B1_2_P VSS sg13_lv_nmos ad=56.9f pd=0.74u as=56.9f ps=0.74u w=0.17u l=0.17u
X5021 cml_tlatch_12.xtail.S1 POLN VSS VSS sg13_lv_nmos ad=1.5637p pd=8.61u as=1.5637p ps=8.61u w=8.23u l=0.13u
X5022 cml_tlatch_31.xmux.xp.S1 B0_2_P B0_2_N VSS sg13_lv_nmos ad=56.9f pd=0.74u as=56.9f ps=0.74u w=0.17u l=0.17u
X5023 cml_tlatch_56.xmux.xp.S1 cml_tlatch_56.OUTN cml_tlatch_56.OUTP VSS sg13_lv_nmos ad=56.9f pd=0.74u as=56.9f ps=0.74u w=0.17u l=0.17u
X5024 cml_tlatch_56.OUTP A3_2_N cml_tlatch_56.xmux.xn.S1 VSS sg13_lv_nmos ad=63.19999f pd=0.74u as=63.19999f ps=0.74u w=0.26u l=0.38u
X5025 MOT28_N MOT28_P cml_tlatch_44.xmux.xp.S1 VSS sg13_lv_nmos ad=56.9f pd=0.74u as=56.9f ps=0.74u w=0.17u l=0.17u
X5026 cml_tlatch_17.xtail.S1 CKHB0_P cml_tlatch_17.xmux.xn.S1 VSS sg13_lv_nmos ad=89.3f pd=0.85u as=89.3f ps=0.85u w=0.47u l=0.16u
X5027 cml_tlatch_93.xmux.xp.S1 CLK_W_N CLK_W_P VSS sg13_lv_nmos ad=56.9f pd=0.74u as=56.9f ps=0.74u w=0.17u l=0.17u
X5028 ENB0_P ENB_N cml_drv_2.xrtail.R1 VSS sg13_lv_nmos ad=56.2f pd=0.74u as=56.2f ps=0.74u w=0.16u l=0.19u
X5029 cml_tlatch_70.xmux.xp.S1 cml_tlatch_63.INN cml_tlatch_63.INP VSS sg13_lv_nmos ad=56.9f pd=0.74u as=56.9f ps=0.74u w=0.17u l=0.17u
X5030 cml_tlatch_7.xmux.xp.S1 cml_tlatch_7.OUTN cml_tlatch_7.OUTP VSS sg13_lv_nmos ad=56.9f pd=0.74u as=56.9f ps=0.74u w=0.17u l=0.17u
X5031 cml_tlatch_13.xmux.xn.S1 cml_tlatch_5.INP stub_bi_17.BOTP VSS sg13_lv_nmos ad=63.19999f pd=0.74u as=0.1082p ps=1.34u w=0.26u l=0.38u
X5032 CKB3_N hs_to_clk_5.sg13_lv_nmos_2HGZLP_0.G VSS rppd l=4.25u w=1u
X5033 cml_tlatch_29.xmux.xp.S1 MOT6_P MOT6_N VSS sg13_lv_nmos ad=56.9f pd=0.74u as=56.9f ps=0.74u w=0.17u l=0.17u
X5034 cml_tlatch_91.INN cml_tlatch_91.INP cml_tlatch_59.xmux.xp.S1 VSS sg13_lv_nmos ad=56.9f pd=0.74u as=56.9f ps=0.74u w=0.17u l=0.17u
X5035 cml_tlatch_67.OUTN cml_tlatch_67.OUTP cml_tlatch_67.xmux.xp.S1 VSS sg13_lv_nmos ad=56.9f pd=0.74u as=56.9f ps=0.74u w=0.17u l=0.17u
X5036 cml_tlatch_56.xmux.xn.S1 A3_2_P cml_tlatch_56.OUTN VSS sg13_lv_nmos ad=63.19999f pd=0.74u as=63.19999f ps=0.74u w=0.26u l=0.38u
X5037 cml_gate2_2.xamp.xn.S1 ENA0_N GA1_P VSS sg13_lv_nmos ad=0.1007p pd=0.91u as=0.1007p ps=0.91u w=0.53u l=0.13u
X5038 B2_8_P B2_8_N cml_tlatch_81.xmux.xp.S1 VSS sg13_lv_nmos ad=56.9f pd=0.74u as=56.9f ps=0.74u w=0.17u l=0.17u
X5039 cml_tlatch_61.xmux.xp.S1 cml_tlatch_61.OUTN cml_tlatch_61.OUTP VSS sg13_lv_nmos ad=56.9f pd=0.74u as=56.9f ps=0.74u w=0.17u l=0.17u
X5040 MOT4_N cml_tlatch_99.OUTP cml_tlatch_28.xmux.xn.S1 VSS sg13_lv_nmos ad=0.1082p pd=1.34u as=63.19999f ps=0.74u w=0.26u l=0.38u
X5041 cml_tlatch_5.xmux.xn.S1 cml_tlatch_5.INP MOT13_N VSS sg13_lv_nmos ad=63.19999f pd=0.74u as=0.1082p ps=1.34u w=0.26u l=0.38u
X5042 MOT8_P A1_8_N cml_tlatch_42.xmux.xn.S1 VSS sg13_lv_nmos ad=63.19999f pd=0.74u as=63.19999f ps=0.74u w=0.26u l=0.38u
X5043 cml_tlatch_72.xmux.xp.S1 MOT25_N MOT25_P VSS sg13_lv_nmos ad=0.1019p pd=1.34u as=56.9f ps=0.74u w=0.17u l=0.17u
X5044 stub_bi_43.BOTN stub_bi_43.BOTP cml_tlatch_48.xmux.xp.S1 VSS sg13_lv_nmos ad=56.9f pd=0.74u as=56.9f ps=0.74u w=0.17u l=0.17u
X5045 cml_tlatch_94.xmux.xn.S1 CKJ_N cml_tlatch_94.xtail.S1 VSS sg13_lv_nmos ad=89.3f pd=0.85u as=89.3f ps=0.85u w=0.47u l=0.16u
X5046 cml_tlatch_74.INN cml_tlatch_74.INP cml_tlatch_88.xmux.xp.S1 VSS sg13_lv_nmos ad=56.9f pd=0.74u as=56.9f ps=0.74u w=0.17u l=0.17u
X5047 cml_tlatch_8.OUTN cml_tlatch_8.OUTP cml_tlatch_8.xmux.xp.S1 VSS sg13_lv_nmos ad=56.9f pd=0.74u as=56.9f ps=0.74u w=0.17u l=0.17u
X5048 cml_tlatch_15.xmux.xn.S1 cml_tlatch_7.OUTP MOT3_N VSS sg13_lv_nmos ad=63.19999f pd=0.74u as=63.19999f ps=0.74u w=0.26u l=0.38u
X5049 cml_tlatch_92.xmux.xp.S1 J4_N J4_P VSS sg13_lv_nmos ad=56.9f pd=0.74u as=56.9f ps=0.74u w=0.17u l=0.17u
X5050 cml_gate2_2.xamp.xn.S1 ENA0_P GA1_N VSS sg13_lv_nmos ad=0.1007p pd=0.91u as=0.1007p ps=0.91u w=0.53u l=0.13u
X5051 cml_tlatch_13.xmux.xp.S1 stub_bi_17.BOTN stub_bi_17.BOTP VSS sg13_lv_nmos ad=56.9f pd=0.74u as=56.9f ps=0.74u w=0.17u l=0.17u
X5052 cml_tlatch_51.OUTN cml_tlatch_51.OUTP cml_tlatch_51.xmux.xp.S1 VSS sg13_lv_nmos ad=56.9f pd=0.74u as=0.1019p ps=1.34u w=0.17u l=0.17u
X5053 MOT28_N VDD VSS rppd l=5.17u w=1u
X5054 cml_tlatch_15.xmux.xn.S1 cml_tlatch_7.OUTP MOT3_N VSS sg13_lv_nmos ad=63.19999f pd=0.74u as=63.19999f ps=0.74u w=0.26u l=0.38u
X5055 A0_2_P A0_2_N cml_tlatch_34.xmux.xp.S1 VSS sg13_lv_nmos ad=56.9f pd=0.74u as=56.9f ps=0.74u w=0.17u l=0.17u
X5056 cml_tlatch_71.xmux.xp.S1 cml_tlatch_71.OUTN cml_tlatch_71.OUTP VSS sg13_lv_nmos ad=0.1019p pd=1.34u as=56.9f ps=0.74u w=0.17u l=0.17u
X5057 cml_gate2_7.xrtail.R1 CKA2_N GB2_P VSS sg13_lv_nmos ad=0.1007p pd=0.91u as=0.1007p ps=0.91u w=0.53u l=0.13u
X5058 cml_tlatch_7.xtail.S1 CKB0_P cml_tlatch_7.xmux.xp.S1 VSS sg13_lv_nmos ad=89.3f pd=0.85u as=89.3f ps=0.85u w=0.47u l=0.16u
X5059 cml_tlatch_98.OUTN cml_tlatch_98.OUTP cml_tlatch_98.xmux.xp.S1 VSS sg13_lv_nmos ad=56.9f pd=0.74u as=56.9f ps=0.74u w=0.17u l=0.17u
X5060 cml_tlatch_7.xtail.S1 CKB0_N cml_tlatch_7.xmux.xn.S1 VSS sg13_lv_nmos ad=0.1598p pd=1.62u as=89.3f ps=0.85u w=0.47u l=0.16u
X5061 MOT22_P MOT22_N cml_tlatch_55.xmux.xp.S1 VSS sg13_lv_nmos ad=56.9f pd=0.74u as=56.9f ps=0.74u w=0.17u l=0.17u
X5062 cml_tlatch_58.xmux.xp.S1 CKA3_N cml_tlatch_58.xtail.S1 VSS sg13_lv_nmos ad=89.3f pd=0.85u as=89.3f ps=0.85u w=0.47u l=0.16u
X5063 MOT16_N MOT16_P cml_tlatch_52.xmux.xp.S1 VSS sg13_lv_nmos ad=56.9f pd=0.74u as=56.9f ps=0.74u w=0.17u l=0.17u
X5064 cml_tlatch_45.xmux.xp.S1 MOT30_N MOT30_P VSS sg13_lv_nmos ad=56.9f pd=0.74u as=56.9f ps=0.74u w=0.17u l=0.17u
X5065 cml_tlatch_38.OUTN cml_tlatch_38.OUTP cml_tlatch_38.xmux.xp.S1 VSS sg13_lv_nmos ad=56.9f pd=0.74u as=56.9f ps=0.74u w=0.17u l=0.17u
X5066 B1_8_N B1_8_P cml_tlatch_10.xmux.xp.S1 VSS sg13_lv_nmos ad=56.9f pd=0.74u as=56.9f ps=0.74u w=0.17u l=0.17u
X5067 B1_8_N VDD VSS rppd l=5.17u w=1u
X5068 cml_tlatch_95.xtail.S1 CKJ_N cml_tlatch_95.xmux.xp.S1 VSS sg13_lv_nmos ad=89.3f pd=0.85u as=89.3f ps=0.85u w=0.47u l=0.16u
X5069 MOT21_N MOT21_P cml_tlatch_79.xmux.xp.S1 VSS sg13_lv_nmos ad=56.9f pd=0.74u as=56.9f ps=0.74u w=0.17u l=0.17u
X5070 cml_tlatch_25.xmux.xn.S1 A1_2_P MOT14_N VSS sg13_lv_nmos ad=63.19999f pd=0.74u as=63.19999f ps=0.74u w=0.26u l=0.38u
X5071 cml_tlatch_5.xtail.S1 CKHB1_P cml_tlatch_5.xmux.xn.S1 VSS sg13_lv_nmos ad=89.3f pd=0.85u as=89.3f ps=0.85u w=0.47u l=0.16u
X5072 cml_tlatch_96.xmux.xp.S1 cml_tlatch_5.INP cml_tlatch_5.INN VSS sg13_lv_nmos ad=56.9f pd=0.74u as=56.9f ps=0.74u w=0.17u l=0.17u
X5073 VSS POLN cml_tlatch_65.xtail.S1 VSS sg13_lv_nmos ad=1.5637p pd=8.61u as=1.5637p ps=8.61u w=8.23u l=0.13u
X5074 B3_2_P B3_2_N cml_tlatch_50.xmux.xp.S1 VSS sg13_lv_nmos ad=56.9f pd=0.74u as=56.9f ps=0.74u w=0.17u l=0.17u
X5075 cml_tlatch_74.xmux.xp.S1 MOT29_P MOT29_N VSS sg13_lv_nmos ad=56.9f pd=0.74u as=56.9f ps=0.74u w=0.17u l=0.17u
X5076 cml_tlatch_4.xmux.xn.S1 cml_tlatch_4.INN MOT11_P VSS sg13_lv_nmos ad=63.19999f pd=0.74u as=63.19999f ps=0.74u w=0.26u l=0.38u
X5077 cml_tlatch_6.xmux.xp.S1 MOT15_N MOT15_P VSS sg13_lv_nmos ad=56.9f pd=0.74u as=56.9f ps=0.74u w=0.17u l=0.17u
X5078 cml_tlatch_70.xmux.xn.S1 CKA3_N cml_tlatch_70.xtail.S1 VSS sg13_lv_nmos ad=0.1598p pd=1.62u as=89.3f ps=0.85u w=0.47u l=0.16u
X5079 cml_tlatch_58.xtail.S1 POLN VSS VSS sg13_lv_nmos ad=1.5637p pd=8.61u as=2.7982p ps=17.14u w=8.23u l=0.13u
X5080 cml_tlatch_6.xmux.xp.S1 CKHB1_N cml_tlatch_6.xtail.S1 VSS sg13_lv_nmos ad=89.3f pd=0.85u as=89.3f ps=0.85u w=0.47u l=0.16u
X5081 cml_tlatch_96.xmux.xn.S1 stub_bi_29.BOTP cml_tlatch_5.INP VSS sg13_lv_nmos ad=63.19999f pd=0.74u as=63.19999f ps=0.74u w=0.26u l=0.38u
X5082 MOT12_N MOT12_P cml_tlatch_24.xmux.xp.S1 VSS sg13_lv_nmos ad=56.9f pd=0.74u as=56.9f ps=0.74u w=0.17u l=0.17u
X5083 cml_tlatch_43.INN cml_tlatch_43.INP cml_tlatch_21.xmux.xp.S1 VSS sg13_lv_nmos ad=56.9f pd=0.74u as=56.9f ps=0.74u w=0.17u l=0.17u
X5084 J4_P J4_N cml_tlatch_92.xmux.xp.S1 VSS sg13_lv_nmos ad=56.9f pd=0.74u as=0.1019p ps=1.34u w=0.17u l=0.17u
X5085 cml_tlatch_12.xmux.xp.S1 cml_tlatch_4.INN cml_tlatch_4.INP VSS sg13_lv_nmos ad=56.9f pd=0.74u as=56.9f ps=0.74u w=0.17u l=0.17u
X5086 VSS hs_to_clk_6.sg13_lv_nmos_2HGZLP_0.G VSS VSS sg13_lv_nmos ad=2.071p pd=11.28u as=0 ps=0 w=10.9u l=1.38u
X5087 MOT27_P cml_tlatch_73.INN cml_tlatch_73.xmux.xn.S1 VSS sg13_lv_nmos ad=63.19999f pd=0.74u as=63.19999f ps=0.74u w=0.26u l=0.38u
X5088 cml_tlatch_95.xmux.xp.S1 J1_P J1_N VSS sg13_lv_nmos ad=56.9f pd=0.74u as=56.9f ps=0.74u w=0.17u l=0.17u
X5089 cml_tlatch_51.xmux.xp.S1 CKB3_N cml_tlatch_51.xtail.S1 VSS sg13_lv_nmos ad=89.3f pd=0.85u as=89.3f ps=0.85u w=0.47u l=0.16u
X5090 stub_bi_29.BOTN stub_bi_29.BOTP cml_tlatch_35.xmux.xp.S1 VSS sg13_lv_nmos ad=56.9f pd=0.74u as=56.9f ps=0.74u w=0.17u l=0.17u
X5091 MOT9_P VDD VSS rppd l=5.17u w=1u
X5092 cml_tlatch_2.xmux.xp.S1 cml_tlatch_2.OUTN cml_tlatch_2.OUTP VSS sg13_lv_nmos ad=56.9f pd=0.74u as=56.9f ps=0.74u w=0.17u l=0.17u
X5093 stub_bi_15.BOTP stub_bi_15.BOTN cml_tlatch_11.xmux.xp.S1 VSS sg13_lv_nmos ad=56.9f pd=0.74u as=56.9f ps=0.74u w=0.17u l=0.17u
X5094 cml_tlatch_67.xmux.xp.S1 cml_tlatch_67.OUTN cml_tlatch_67.OUTP VSS sg13_lv_nmos ad=56.9f pd=0.74u as=56.9f ps=0.74u w=0.17u l=0.17u
X5095 cml_tlatch_14.xtail.S1 CKHB0_P cml_tlatch_14.xmux.xn.S1 VSS sg13_lv_nmos ad=89.3f pd=0.85u as=89.3f ps=0.85u w=0.47u l=0.16u
X5096 GB1_P CKA1_N cml_gate2_0.xrtail.R1 VSS sg13_lv_nmos ad=0.1802p pd=1.74u as=0.1007p ps=0.91u w=0.53u l=0.13u
X5097 J2_P J2_N cml_tlatch_94.xmux.xp.S1 VSS sg13_lv_nmos ad=56.9f pd=0.74u as=56.9f ps=0.74u w=0.17u l=0.17u
X5098 cml_tlatch_60.xmux.xp.S1 A2_2_P A2_2_N VSS sg13_lv_nmos ad=56.9f pd=0.74u as=56.9f ps=0.74u w=0.17u l=0.17u
X5099 cml_tlatch_26.xmux.xp.S1 MOT0_P MOT0_N VSS sg13_lv_nmos ad=56.9f pd=0.74u as=56.9f ps=0.74u w=0.17u l=0.17u
X5100 cml_tlatch_91.OUTN cml_tlatch_91.OUTP cml_tlatch_91.xmux.xp.S1 VSS sg13_lv_nmos ad=56.9f pd=0.74u as=0.1019p ps=1.34u w=0.17u l=0.17u
X5101 MOT1_N B0_8_P cml_tlatch_14.xmux.xn.S1 VSS sg13_lv_nmos ad=63.19999f pd=0.74u as=63.19999f ps=0.74u w=0.26u l=0.38u
X5102 hs_to_clk_5.sg13_lv_nmos_2HGZLP_0.G VDD VSS rppd l=0.68u w=1u
X5103 cml_tlatch_39.xtail.S1 CKA1_P cml_tlatch_39.xmux.xn.S1 VSS sg13_lv_nmos ad=89.3f pd=0.85u as=89.3f ps=0.85u w=0.47u l=0.16u
X5104 cml_drv_1.xrtail.R1 ENA_N ENA1_P VSS sg13_lv_nmos ad=56.2f pd=0.74u as=56.2f ps=0.74u w=0.16u l=0.19u
X5105 cml_tlatch_81.xmux.xn.S1 stub_bi_62.BOTN B2_8_N VSS sg13_lv_nmos ad=63.19999f pd=0.74u as=63.19999f ps=0.74u w=0.26u l=0.38u
X5106 cml_tlatch_99.xmux.xn.S1 CKA0_N cml_tlatch_99.xtail.S1 VSS sg13_lv_nmos ad=0.1598p pd=1.62u as=89.3f ps=0.85u w=0.47u l=0.16u
X5107 cml_tlatch_63.xmux.xn.S1 CKHA3_P cml_tlatch_63.xtail.S1 VSS sg13_lv_nmos ad=89.3f pd=0.85u as=89.3f ps=0.85u w=0.47u l=0.16u
X5108 cml_tlatch_95.xmux.xp.S1 J1_P J1_N VSS sg13_lv_nmos ad=0.1019p pd=1.34u as=56.9f ps=0.74u w=0.17u l=0.17u
X5109 stub_bi_63.BOTN VDD VSS rppd l=5.17u w=1u
X5110 MOT2_P MOT2_N cml_tlatch_27.xmux.xp.S1 VSS sg13_lv_nmos ad=56.9f pd=0.74u as=56.9f ps=0.74u w=0.17u l=0.17u
X5111 cml_tlatch_34.xmux.xn.S1 cml_tlatch_38.OUTN A0_2_P VSS sg13_lv_nmos ad=63.19999f pd=0.74u as=63.19999f ps=0.74u w=0.26u l=0.38u
X5112 cml_tlatch_55.xtail.S1 CKHA2_P cml_tlatch_55.xmux.xn.S1 VSS sg13_lv_nmos ad=89.3f pd=0.85u as=89.3f ps=0.85u w=0.47u l=0.16u
X5113 cml_tlatch_65.OUTN cml_tlatch_65.OUTP cml_tlatch_65.xmux.xp.S1 VSS sg13_lv_nmos ad=56.9f pd=0.74u as=56.9f ps=0.74u w=0.17u l=0.17u
X5114 cml_tlatch_4.INP stub_bi_17.BOTP cml_tlatch_12.xmux.xn.S1 VSS sg13_lv_nmos ad=63.19999f pd=0.74u as=63.19999f ps=0.74u w=0.26u l=0.38u
X5115 cml_tlatch_77.xmux.xp.S1 MOT17_P MOT17_N VSS sg13_lv_nmos ad=56.9f pd=0.74u as=56.9f ps=0.74u w=0.17u l=0.17u
X5116 MOT9_P B1_8_N cml_tlatch_3.xmux.xn.S1 VSS sg13_lv_nmos ad=63.19999f pd=0.74u as=63.19999f ps=0.74u w=0.26u l=0.38u
X5117 cml_tlatch_35.xtail.S1 CKB1_P cml_tlatch_35.xmux.xn.S1 VSS sg13_lv_nmos ad=89.3f pd=0.85u as=89.3f ps=0.85u w=0.47u l=0.16u
X5118 cml_tlatch_46.xmux.xp.S1 stub_bi_38.BOTN stub_bi_38.BOTP VSS sg13_lv_nmos ad=0.1019p pd=1.34u as=56.9f ps=0.74u w=0.17u l=0.17u
X5119 cml_drvb_2.xrtail.R2 VSS VSS rppd l=2.72u w=1u
X5120 VSS POLN cml_tlatch_57.xtail.S1 VSS sg13_lv_nmos ad=2.7982p pd=17.14u as=1.5637p ps=8.61u w=8.23u l=0.13u
X5121 cml_tlatch_47.xmux.xp.S1 B2_2_N B2_2_P VSS sg13_lv_nmos ad=56.9f pd=0.74u as=56.9f ps=0.74u w=0.17u l=0.17u
X5122 cml_tlatch_91.OUTP cml_tlatch_91.INN cml_tlatch_91.xmux.xn.S1 VSS sg13_lv_nmos ad=63.19999f pd=0.74u as=63.19999f ps=0.74u w=0.26u l=0.38u
X5123 cml_tlatch_8.OUTN cml_tlatch_8.OUTP cml_tlatch_8.xmux.xp.S1 VSS sg13_lv_nmos ad=56.9f pd=0.74u as=56.9f ps=0.74u w=0.17u l=0.17u
X5124 MOT20_P MOT20_N cml_tlatch_54.xmux.xp.S1 VSS sg13_lv_nmos ad=56.9f pd=0.74u as=56.9f ps=0.74u w=0.17u l=0.17u
X5125 cml_tlatch_84.xmux.xn.S1 CKB2_P cml_tlatch_84.xtail.S1 VSS sg13_lv_nmos ad=89.3f pd=0.85u as=89.3f ps=0.85u w=0.47u l=0.16u
X5126 cml_tlatch_69.xmux.xp.S1 cml_tlatch_69.OUTN cml_tlatch_69.OUTP VSS sg13_lv_nmos ad=56.9f pd=0.74u as=56.9f ps=0.74u w=0.17u l=0.17u
X5127 cml_tlatch_61.xmux.xp.S1 cml_tlatch_61.OUTP cml_tlatch_61.OUTN VSS sg13_lv_nmos ad=56.9f pd=0.74u as=56.9f ps=0.74u w=0.17u l=0.17u
X5128 cml_tlatch_18.xtail.S1 CKA0_P cml_tlatch_18.xmux.xn.S1 VSS sg13_lv_nmos ad=89.3f pd=0.85u as=89.3f ps=0.85u w=0.47u l=0.16u
X5129 stub_bi_43.BOTP D2_P cml_tlatch_48.xmux.xn.S1 VSS sg13_lv_nmos ad=63.19999f pd=0.74u as=63.19999f ps=0.74u w=0.26u l=0.38u
X5130 cml_tlatch_71.xmux.xn.S1 CKA3_P cml_tlatch_71.xtail.S1 VSS sg13_lv_nmos ad=89.3f pd=0.85u as=89.3f ps=0.85u w=0.47u l=0.16u
X5131 cml_tlatch_47.xtail.S1 POLN VSS VSS sg13_lv_nmos ad=1.5637p pd=8.61u as=2.7982p ps=17.14u w=8.23u l=0.13u
X5132 cml_tlatch_91.OUTN cml_tlatch_91.OUTP cml_tlatch_91.xmux.xp.S1 VSS sg13_lv_nmos ad=56.9f pd=0.74u as=56.9f ps=0.74u w=0.17u l=0.17u
X5133 cml_tlatch_92.xtail.S1 CKJ_P cml_tlatch_92.xmux.xp.S1 VSS sg13_lv_nmos ad=89.3f pd=0.85u as=89.3f ps=0.85u w=0.47u l=0.16u
X5134 ENB1_P ENB_N cml_drv_0.xrtail.R1 VSS sg13_lv_nmos ad=56.2f pd=0.74u as=56.2f ps=0.74u w=0.16u l=0.19u
X5135 VSS POLN cml_tlatch_2.xtail.S1 VSS sg13_lv_nmos ad=2.7982p pd=17.14u as=1.5637p ps=8.61u w=8.23u l=0.13u
X5136 cml_gate2_9.xrtail.R1 NM1_P cml_gate2_9.xamp.xn.S1 VSS sg13_lv_nmos ad=0.1007p pd=0.91u as=0.1007p ps=0.91u w=0.53u l=0.13u
X5137 B2_2_P stub_bi_43.BOTP cml_tlatch_47.xmux.xn.S1 VSS sg13_lv_nmos ad=63.19999f pd=0.74u as=63.19999f ps=0.74u w=0.26u l=0.38u
X5138 cml_tlatch_3.xmux.xp.S1 CKHB1_N cml_tlatch_3.xtail.S1 VSS sg13_lv_nmos ad=89.3f pd=0.85u as=89.3f ps=0.85u w=0.47u l=0.16u
X5139 cml_tlatch_65.xmux.xp.S1 cml_tlatch_65.OUTP cml_tlatch_65.OUTN VSS sg13_lv_nmos ad=56.9f pd=0.74u as=56.9f ps=0.74u w=0.17u l=0.17u
X5140 cml_tlatch_82.xtail.S1 POLN VSS VSS sg13_lv_nmos ad=1.5637p pd=8.61u as=1.5637p ps=8.61u w=8.23u l=0.13u
X5141 cml_tlatch_17.xmux.xn.S1 CKHB0_P cml_tlatch_17.xtail.S1 VSS sg13_lv_nmos ad=89.3f pd=0.85u as=89.3f ps=0.85u w=0.47u l=0.16u
X5142 cml_tlatch_37.xtail.S1 CKB1_N cml_tlatch_37.xmux.xp.S1 VSS sg13_lv_nmos ad=89.3f pd=0.85u as=89.3f ps=0.85u w=0.47u l=0.16u
X5143 MOT1_N MOT1_P cml_tlatch_14.xmux.xp.S1 VSS sg13_lv_nmos ad=56.9f pd=0.74u as=56.9f ps=0.74u w=0.17u l=0.17u
X5144 cml_tlatch_66.xmux.xp.S1 cml_tlatch_73.INP cml_tlatch_73.INN VSS sg13_lv_nmos ad=56.9f pd=0.74u as=56.9f ps=0.74u w=0.17u l=0.17u
X5145 A1_2_N A1_2_P cml_tlatch_40.xmux.xp.S1 VSS sg13_lv_nmos ad=56.9f pd=0.74u as=56.9f ps=0.74u w=0.17u l=0.17u
X5146 cml_tlatch_87.OUTP cml_tlatch_87.OUTN cml_tlatch_87.xmux.xp.S1 VSS sg13_lv_nmos ad=56.9f pd=0.74u as=56.9f ps=0.74u w=0.17u l=0.17u
X5147 cml_tlatch_95.xtail.S1 CKJ_P cml_tlatch_95.xmux.xn.S1 VSS sg13_lv_nmos ad=89.3f pd=0.85u as=89.3f ps=0.85u w=0.47u l=0.16u
X5148 cml_tlatch_91.xmux.xp.S1 cml_tlatch_91.OUTN cml_tlatch_91.OUTP VSS sg13_lv_nmos ad=56.9f pd=0.74u as=56.9f ps=0.74u w=0.17u l=0.17u
X5149 cml_tlatch_89.xmux.xp.S1 CKA3_P cml_tlatch_89.xtail.S1 VSS sg13_lv_nmos ad=89.3f pd=0.85u as=89.3f ps=0.85u w=0.47u l=0.16u
X5150 cml_tlatch_45.xmux.xp.S1 MOT30_N MOT30_P VSS sg13_lv_nmos ad=56.9f pd=0.74u as=56.9f ps=0.74u w=0.17u l=0.17u
X5151 MOT16_N MOT16_P cml_tlatch_52.xmux.xp.S1 VSS sg13_lv_nmos ad=56.9f pd=0.74u as=56.9f ps=0.74u w=0.17u l=0.17u
X5152 cml_tlatch_62.xmux.xp.S1 MOT24_P MOT24_N VSS sg13_lv_nmos ad=56.9f pd=0.74u as=56.9f ps=0.74u w=0.17u l=0.17u
X5153 cml_tlatch_24.xtail.S1 CKHA1_P cml_tlatch_24.xmux.xn.S1 VSS sg13_lv_nmos ad=89.3f pd=0.85u as=89.3f ps=0.85u w=0.47u l=0.16u
X5154 GB2_P ENB0_N cml_gate2_7.xamp.xn.S1 VSS sg13_lv_nmos ad=0.1802p pd=1.74u as=0.1007p ps=0.91u w=0.53u l=0.13u
X5155 cml_tlatch_14.xmux.xp.S1 MOT1_N MOT1_P VSS sg13_lv_nmos ad=56.9f pd=0.74u as=56.9f ps=0.74u w=0.17u l=0.17u
X5156 cml_tlatch_59.xmux.xn.S1 CKA2_P cml_tlatch_59.xtail.S1 VSS sg13_lv_nmos ad=89.3f pd=0.85u as=89.3f ps=0.85u w=0.47u l=0.16u
X5157 cml_tlatch_45.xtail.S1 CKHA3_N cml_tlatch_45.xmux.xp.S1 VSS sg13_lv_nmos ad=89.3f pd=0.85u as=89.3f ps=0.85u w=0.47u l=0.16u
X5158 MOT14_P MOT14_N cml_tlatch_25.xmux.xp.S1 VSS sg13_lv_nmos ad=56.9f pd=0.74u as=56.9f ps=0.74u w=0.17u l=0.17u
X5159 MOT14_N MOT14_P cml_tlatch_25.xmux.xp.S1 VSS sg13_lv_nmos ad=56.9f pd=0.74u as=56.9f ps=0.74u w=0.17u l=0.17u
X5160 cml_tlatch_94.xtail.S1 CKJ_N cml_tlatch_94.xmux.xn.S1 VSS sg13_lv_nmos ad=89.3f pd=0.85u as=89.3f ps=0.85u w=0.47u l=0.16u
X5161 GA0_P CKB0_N cml_gate2_3.xrtail.R1 VSS sg13_lv_nmos ad=0.1007p pd=0.91u as=0.1007p ps=0.91u w=0.53u l=0.13u
X5162 cml_tlatch_47.xmux.xp.S1 B2_2_N B2_2_P VSS sg13_lv_nmos ad=56.9f pd=0.74u as=56.9f ps=0.74u w=0.17u l=0.17u
X5163 cml_tlatch_93.xmux.xp.S1 CLK_W_P CLK_W_N VSS sg13_lv_nmos ad=56.9f pd=0.74u as=56.9f ps=0.74u w=0.17u l=0.17u
X5164 cml_tlatch_41.xmux.xn.S1 CKA1_P cml_tlatch_41.xtail.S1 VSS sg13_lv_nmos ad=89.3f pd=0.85u as=0.1598p ps=1.62u w=0.47u l=0.16u
X5165 cml_tlatch_66.xmux.xp.S1 CKB3_P cml_tlatch_66.xtail.S1 VSS sg13_lv_nmos ad=89.3f pd=0.85u as=89.3f ps=0.85u w=0.47u l=0.16u
X5166 cml_tlatch_99.xmux.xp.S1 cml_tlatch_99.OUTN cml_tlatch_99.OUTP VSS sg13_lv_nmos ad=56.9f pd=0.74u as=56.9f ps=0.74u w=0.17u l=0.17u
X5167 ENB_N J2_P cml_gate2_8.xamp.xn.S1 VSS sg13_lv_nmos ad=0.1007p pd=0.91u as=0.1007p ps=0.91u w=0.53u l=0.13u
X5168 cml_gate2_2.xamp.xn.S1 CKB1_P cml_gate2_2.xrtail.R1 VSS sg13_lv_nmos ad=0.1007p pd=0.91u as=0.1007p ps=0.91u w=0.53u l=0.13u
X5169 cml_tlatch_50.xmux.xn.S1 cml_tlatch_51.OUTP B3_2_N VSS sg13_lv_nmos ad=63.19999f pd=0.74u as=0.1082p ps=1.34u w=0.26u l=0.38u
X5170 MOT28_P MOT28_N cml_tlatch_44.xmux.xp.S1 VSS sg13_lv_nmos ad=56.9f pd=0.74u as=56.9f ps=0.74u w=0.17u l=0.17u
X5171 MOT30_N MOT30_P cml_tlatch_45.xmux.xp.S1 VSS sg13_lv_nmos ad=56.9f pd=0.74u as=56.9f ps=0.74u w=0.17u l=0.17u
X5172 cml_tlatch_52.xmux.xp.S1 CKHA2_N cml_tlatch_52.xtail.S1 VSS sg13_lv_nmos ad=89.3f pd=0.85u as=0.1598p ps=1.62u w=0.47u l=0.16u
X5173 cml_tlatch_58.xmux.xp.S1 cml_tlatch_58.OUTN cml_tlatch_58.OUTP VSS sg13_lv_nmos ad=56.9f pd=0.74u as=56.9f ps=0.74u w=0.17u l=0.17u
X5174 cml_tlatch_41.xmux.xn.S1 D1_N cml_tlatch_41.OUTP VSS sg13_lv_nmos ad=63.19999f pd=0.74u as=63.19999f ps=0.74u w=0.26u l=0.38u
X5175 ENA0_N ENA_P cml_drv_3.xrtail.R1 VSS sg13_lv_nmos ad=56.2f pd=0.74u as=56.2f ps=0.74u w=0.16u l=0.19u
X5176 cml_tlatch_96.xmux.xp.S1 CKB1_P cml_tlatch_96.xtail.S1 VSS sg13_lv_nmos ad=89.3f pd=0.85u as=89.3f ps=0.85u w=0.47u l=0.16u
X5177 cml_tlatch_71.OUTN cml_tlatch_44.INP cml_tlatch_71.xmux.xn.S1 VSS sg13_lv_nmos ad=0.1082p pd=1.34u as=63.19999f ps=0.74u w=0.26u l=0.38u
X5178 cml_tlatch_24.xmux.xp.S1 MOT12_N MOT12_P VSS sg13_lv_nmos ad=56.9f pd=0.74u as=56.9f ps=0.74u w=0.17u l=0.17u
X5179 cml_tlatch_40.xtail.S1 CKA1_P cml_tlatch_40.xmux.xp.S1 VSS sg13_lv_nmos ad=89.3f pd=0.85u as=89.3f ps=0.85u w=0.47u l=0.16u
X5180 cml_tlatch_62.xmux.xn.S1 A3_8_P MOT24_N VSS sg13_lv_nmos ad=0.1082p pd=1.34u as=63.19999f ps=0.74u w=0.26u l=0.38u
X5181 B0_8_P VDD VSS rppd l=5.17u w=1u
X5182 CKHA1_N GA1_P cml_drvb_2.xrtail.R2 VSS sg13_lv_nmos ad=0.2618p pd=2.22u as=0.1463p ps=1.15u w=0.77u l=0.21u
X5183 cml_tlatch_54.xtail.S1 CKHA2_P cml_tlatch_54.xmux.xn.S1 VSS sg13_lv_nmos ad=89.3f pd=0.85u as=89.3f ps=0.85u w=0.47u l=0.16u
X5184 MOT23_P B2_2_N cml_tlatch_80.xmux.xn.S1 VSS sg13_lv_nmos ad=63.19999f pd=0.74u as=63.19999f ps=0.74u w=0.26u l=0.38u
X5185 cml_tlatch_84.xmux.xp.S1 stub_bi_49.BOTN stub_bi_49.BOTP VSS sg13_lv_nmos ad=56.9f pd=0.74u as=56.9f ps=0.74u w=0.17u l=0.17u
X5186 cml_tlatch_77.xmux.xp.S1 MOT17_P MOT17_N VSS sg13_lv_nmos ad=56.9f pd=0.74u as=56.9f ps=0.74u w=0.17u l=0.17u
X5187 MOT21_N stub_bi_55.BOTN cml_tlatch_79.xmux.xn.S1 VSS sg13_lv_nmos ad=0.1082p pd=1.34u as=63.19999f ps=0.74u w=0.26u l=0.38u
X5188 B0_8_N B0_8_P cml_tlatch_1.xmux.xp.S1 VSS sg13_lv_nmos ad=56.9f pd=0.74u as=56.9f ps=0.74u w=0.17u l=0.17u
X5189 cml_tlatch_57.xmux.xp.S1 A3_2_P A3_2_N VSS sg13_lv_nmos ad=56.9f pd=0.74u as=56.9f ps=0.74u w=0.17u l=0.17u
X5190 cml_gate2_4.xamp.xn.S1 CKB3_P cml_gate2_4.xrtail.R1 VSS sg13_lv_nmos ad=0.1007p pd=0.91u as=0.1007p ps=0.91u w=0.53u l=0.13u
X5191 cml_tlatch_7.xmux.xp.S1 cml_tlatch_7.OUTP cml_tlatch_7.OUTN VSS sg13_lv_nmos ad=56.9f pd=0.74u as=56.9f ps=0.74u w=0.17u l=0.17u
X5192 cml_tlatch_24.xmux.xp.S1 CKHA1_N cml_tlatch_24.xtail.S1 VSS sg13_lv_nmos ad=89.3f pd=0.85u as=89.3f ps=0.85u w=0.47u l=0.16u
X5193 cml_tlatch_62.xmux.xp.S1 CKHA3_N cml_tlatch_62.xtail.S1 VSS sg13_lv_nmos ad=89.3f pd=0.85u as=89.3f ps=0.85u w=0.47u l=0.16u
X5194 ENB0_N ENB_P cml_drv_2.xrtail.R1 VSS sg13_lv_nmos ad=56.2f pd=0.74u as=56.2f ps=0.74u w=0.16u l=0.19u
X5195 cml_tlatch_33.xmux.xp.S1 cml_tlatch_33.OUTP cml_tlatch_33.OUTN VSS sg13_lv_nmos ad=56.9f pd=0.74u as=56.9f ps=0.74u w=0.17u l=0.17u
X5196 cml_tlatch_52.xmux.xn.S1 A2_8_N MOT16_P VSS sg13_lv_nmos ad=63.19999f pd=0.74u as=63.19999f ps=0.74u w=0.26u l=0.38u
X5197 cml_tlatch_20.OUTN cml_tlatch_43.INP cml_tlatch_20.xmux.xn.S1 VSS sg13_lv_nmos ad=63.19999f pd=0.74u as=63.19999f ps=0.74u w=0.26u l=0.38u
X5198 VSS POLN cml_tlatch_36.xtail.S1 VSS sg13_lv_nmos ad=1.5637p pd=8.61u as=1.5637p ps=8.61u w=8.23u l=0.13u
X5199 B3_8_P cml_tlatch_65.OUTN cml_tlatch_64.xmux.xn.S1 VSS sg13_lv_nmos ad=63.19999f pd=0.74u as=63.19999f ps=0.74u w=0.26u l=0.38u
X5200 cml_tlatch_14.xmux.xn.S1 CKHB0_P cml_tlatch_14.xtail.S1 VSS sg13_lv_nmos ad=89.3f pd=0.85u as=89.3f ps=0.85u w=0.47u l=0.16u
X5201 cml_tlatch_3.xmux.xp.S1 MOT9_P MOT9_N VSS sg13_lv_nmos ad=56.9f pd=0.74u as=56.9f ps=0.74u w=0.17u l=0.17u
X5202 cml_tlatch_36.xmux.xp.S1 B1_2_P B1_2_N VSS sg13_lv_nmos ad=56.9f pd=0.74u as=56.9f ps=0.74u w=0.17u l=0.17u
X5203 MOT29_P cml_tlatch_74.INN cml_tlatch_74.xmux.xn.S1 VSS sg13_lv_nmos ad=63.19999f pd=0.74u as=63.19999f ps=0.74u w=0.26u l=0.38u
X5204 cml_tlatch_74.xtail.S1 CKHB3_N cml_tlatch_74.xmux.xp.S1 VSS sg13_lv_nmos ad=89.3f pd=0.85u as=0.1598p ps=1.62u w=0.47u l=0.16u
X5205 B0_2_P B0_2_N cml_tlatch_31.xmux.xp.S1 VSS sg13_lv_nmos ad=56.9f pd=0.74u as=56.9f ps=0.74u w=0.17u l=0.17u
X5206 cml_tlatch_19.xmux.xp.S1 A1_8_P A1_8_N VSS sg13_lv_nmos ad=56.9f pd=0.74u as=56.9f ps=0.74u w=0.17u l=0.17u
X5207 B2_8_N B2_8_P cml_tlatch_81.xmux.xp.S1 VSS sg13_lv_nmos ad=56.9f pd=0.74u as=56.9f ps=0.74u w=0.17u l=0.17u
X5208 cml_tlatch_71.OUTN cml_tlatch_71.OUTP cml_tlatch_71.xmux.xp.S1 VSS sg13_lv_nmos ad=56.9f pd=0.74u as=0.1019p ps=1.34u w=0.17u l=0.17u
X5209 cml_tlatch_78.xmux.xp.S1 MOT19_N MOT19_P VSS sg13_lv_nmos ad=56.9f pd=0.74u as=56.9f ps=0.74u w=0.17u l=0.17u
X5210 VSS POLN cml_tlatch_87.xtail.S1 VSS sg13_lv_nmos ad=2.7982p pd=17.14u as=1.5637p ps=8.61u w=8.23u l=0.13u
X5211 MOT10_P MOT10_N cml_tlatch_43.xmux.xp.S1 VSS sg13_lv_nmos ad=56.9f pd=0.74u as=56.9f ps=0.74u w=0.17u l=0.17u
X5212 cml_tlatch_41.OUTN cml_tlatch_41.OUTP cml_tlatch_41.xmux.xp.S1 VSS sg13_lv_nmos ad=56.9f pd=0.74u as=56.9f ps=0.74u w=0.17u l=0.17u
X5213 cml_tlatch_55.xmux.xn.S1 A2_2_N MOT22_P VSS sg13_lv_nmos ad=63.19999f pd=0.74u as=63.19999f ps=0.74u w=0.26u l=0.38u
X5214 cml_tlatch_61.xtail.S1 CKA2_P cml_tlatch_61.xmux.xn.S1 VSS sg13_lv_nmos ad=89.3f pd=0.85u as=89.3f ps=0.85u w=0.47u l=0.16u
X5215 cml_tlatch_87.OUTP cml_tlatch_87.OUTN cml_tlatch_87.xmux.xp.S1 VSS sg13_lv_nmos ad=56.9f pd=0.74u as=56.9f ps=0.74u w=0.17u l=0.17u
X5216 cml_tlatch_87.OUTN cml_tlatch_87.OUTP cml_tlatch_87.xmux.xp.S1 VSS sg13_lv_nmos ad=56.9f pd=0.74u as=56.9f ps=0.74u w=0.17u l=0.17u
X5217 cml_tlatch_7.xtail.S1 CKB0_P cml_tlatch_7.xmux.xp.S1 VSS sg13_lv_nmos ad=89.3f pd=0.85u as=89.3f ps=0.85u w=0.47u l=0.16u
X5218 cml_tlatch_83.xmux.xp.S1 stub_bi_63.BOTP stub_bi_63.BOTN VSS sg13_lv_nmos ad=56.9f pd=0.74u as=56.9f ps=0.74u w=0.17u l=0.17u
X5219 cml_gate2_0.xamp.xn.S1 ENB1_P GB1_N VSS sg13_lv_nmos ad=0.1007p pd=0.91u as=0.1007p ps=0.91u w=0.53u l=0.13u
X5220 cml_tlatch_69.xmux.xp.S1 CKA3_N cml_tlatch_69.xtail.S1 VSS sg13_lv_nmos ad=89.3f pd=0.85u as=89.3f ps=0.85u w=0.47u l=0.16u
X5221 cml_tlatch_42.xmux.xp.S1 MOT8_N MOT8_P VSS sg13_lv_nmos ad=56.9f pd=0.74u as=56.9f ps=0.74u w=0.17u l=0.17u
X5222 stub_bi_38.BOTN stub_bi_38.BOTP cml_tlatch_46.xmux.xp.S1 VSS sg13_lv_nmos ad=56.9f pd=0.74u as=56.9f ps=0.74u w=0.17u l=0.17u
X5223 cml_tlatch_39.xmux.xp.S1 cml_tlatch_97.INN cml_tlatch_97.INP VSS sg13_lv_nmos ad=56.9f pd=0.74u as=56.9f ps=0.74u w=0.17u l=0.17u
X5224 CKB3_P CK_N hs_to_clk_5.D2 VSS sg13_lv_nmos ad=0.228p pd=1.58u as=0.228p ps=1.58u w=1.2u l=0.2u
X5225 cml_tlatch_86.xmux.xp.S1 cml_tlatch_86.OUTP cml_tlatch_86.OUTN VSS sg13_lv_nmos ad=0.1019p pd=1.34u as=56.9f ps=0.74u w=0.17u l=0.17u
X5226 cml_tlatch_22.xmux.xp.S1 CKA1_N cml_tlatch_22.xtail.S1 VSS sg13_lv_nmos ad=89.3f pd=0.85u as=89.3f ps=0.85u w=0.47u l=0.16u
X5227 cml_tlatch_70.xmux.xn.S1 CKA3_N cml_tlatch_70.xtail.S1 VSS sg13_lv_nmos ad=89.3f pd=0.85u as=89.3f ps=0.85u w=0.47u l=0.16u
X5228 MOT13_P MOT13_N cml_tlatch_5.xmux.xp.S1 VSS sg13_lv_nmos ad=56.9f pd=0.74u as=56.9f ps=0.74u w=0.17u l=0.17u
X5229 MOT23_P MOT23_N cml_tlatch_80.xmux.xp.S1 VSS sg13_lv_nmos ad=56.9f pd=0.74u as=56.9f ps=0.74u w=0.17u l=0.17u
X5230 cml_tlatch_38.OUTP cml_tlatch_38.OUTN cml_tlatch_38.xmux.xp.S1 VSS sg13_lv_nmos ad=56.9f pd=0.74u as=56.9f ps=0.74u w=0.17u l=0.17u
X5231 MOT28_P MOT28_N cml_tlatch_44.xmux.xp.S1 VSS sg13_lv_nmos ad=56.9f pd=0.74u as=0.1019p ps=1.34u w=0.17u l=0.17u
X5232 cml_tlatch_75.xmux.xp.S1 MOT31_N MOT31_P VSS sg13_lv_nmos ad=56.9f pd=0.74u as=56.9f ps=0.74u w=0.17u l=0.17u
X5233 cml_tlatch_65.xmux.xp.S1 CKB3_N cml_tlatch_65.xtail.S1 VSS sg13_lv_nmos ad=89.3f pd=0.85u as=89.3f ps=0.85u w=0.47u l=0.16u
X5234 cml_tlatch_86.OUTP cml_tlatch_86.OUTN cml_tlatch_86.xmux.xp.S1 VSS sg13_lv_nmos ad=56.9f pd=0.74u as=56.9f ps=0.74u w=0.17u l=0.17u
X5235 MOT28_P cml_tlatch_44.INN cml_tlatch_44.xmux.xn.S1 VSS sg13_lv_nmos ad=63.19999f pd=0.74u as=63.19999f ps=0.74u w=0.26u l=0.38u
X5236 stub_bi_38.BOTP VDD VSS rppd l=5.17u w=1u
X5237 cml_tlatch_82.xmux.xp.S1 stub_bi_62.BOTP stub_bi_62.BOTN VSS sg13_lv_nmos ad=56.9f pd=0.74u as=56.9f ps=0.74u w=0.17u l=0.17u
X5238 cml_tlatch_30.xmux.xn.S1 CKB0_P cml_tlatch_30.xtail.S1 VSS sg13_lv_nmos ad=89.3f pd=0.85u as=89.3f ps=0.85u w=0.47u l=0.16u
X5239 cml_tlatch_6.xmux.xn.S1 B1_2_P MOT15_N VSS sg13_lv_nmos ad=63.19999f pd=0.74u as=63.19999f ps=0.74u w=0.26u l=0.38u
X5240 cml_tlatch_97.xmux.xp.S1 cml_tlatch_24.INP cml_tlatch_24.INN VSS sg13_lv_nmos ad=56.9f pd=0.74u as=56.9f ps=0.74u w=0.17u l=0.17u
X5241 cml_tlatch_81.xmux.xn.S1 CKB2_N cml_tlatch_81.xtail.S1 VSS sg13_lv_nmos ad=89.3f pd=0.85u as=89.3f ps=0.85u w=0.47u l=0.16u
X5242 cml_tlatch_62.xmux.xp.S1 MOT24_N MOT24_P VSS sg13_lv_nmos ad=56.9f pd=0.74u as=56.9f ps=0.74u w=0.17u l=0.17u
X5243 cml_tlatch_24.INN cml_tlatch_97.INP cml_tlatch_97.xmux.xn.S1 VSS sg13_lv_nmos ad=63.19999f pd=0.74u as=63.19999f ps=0.74u w=0.26u l=0.38u
X5244 cml_tlatch_97.xtail.S1 POLN VSS VSS sg13_lv_nmos ad=1.5637p pd=8.61u as=2.7982p ps=17.14u w=8.23u l=0.13u
X5245 cml_tlatch_0.xmux.xn.S1 cml_tlatch_99.OUTN cml_tlatch_0.OUTP VSS sg13_lv_nmos ad=63.19999f pd=0.74u as=63.19999f ps=0.74u w=0.26u l=0.38u
X5246 cml_tlatch_34.xtail.S1 CKA0_P cml_tlatch_34.xmux.xp.S1 VSS sg13_lv_nmos ad=89.3f pd=0.85u as=89.3f ps=0.85u w=0.47u l=0.16u
X5247 A3_2_P A3_2_N cml_tlatch_57.xmux.xp.S1 VSS sg13_lv_nmos ad=56.9f pd=0.74u as=56.9f ps=0.74u w=0.17u l=0.17u
X5248 cml_tlatch_2.xmux.xp.S1 CKB0_N cml_tlatch_2.xtail.S1 VSS sg13_lv_nmos ad=89.3f pd=0.85u as=89.3f ps=0.85u w=0.47u l=0.16u
X5249 CKHA1_P VDD VSS rppd l=13.09u w=1u
X5250 cml_tlatch_58.xmux.xp.S1 cml_tlatch_58.OUTP cml_tlatch_58.OUTN VSS sg13_lv_nmos ad=56.9f pd=0.74u as=56.9f ps=0.74u w=0.17u l=0.17u
X5251 cml_tlatch_19.xmux.xp.S1 A1_8_P A1_8_N VSS sg13_lv_nmos ad=56.9f pd=0.74u as=56.9f ps=0.74u w=0.17u l=0.17u
X5252 stub_bi_63.BOTP stub_bi_63.BOTN cml_tlatch_83.xmux.xp.S1 VSS sg13_lv_nmos ad=56.9f pd=0.74u as=56.9f ps=0.74u w=0.17u l=0.17u
X5253 MOT5_N MOT5_P cml_tlatch_16.xmux.xp.S1 VSS sg13_lv_nmos ad=56.9f pd=0.74u as=56.9f ps=0.74u w=0.17u l=0.17u
X5254 cml_tlatch_40.xmux.xp.S1 A1_2_N A1_2_P VSS sg13_lv_nmos ad=56.9f pd=0.74u as=56.9f ps=0.74u w=0.17u l=0.17u
X5255 A1_2_P cml_tlatch_41.OUTN cml_tlatch_40.xmux.xn.S1 VSS sg13_lv_nmos ad=0.1082p pd=1.34u as=63.19999f ps=0.74u w=0.26u l=0.38u
X5256 B1_2_P B1_2_N cml_tlatch_36.xmux.xp.S1 VSS sg13_lv_nmos ad=56.9f pd=0.74u as=56.9f ps=0.74u w=0.17u l=0.17u
X5257 cml_tlatch_12.xmux.xn.S1 CKB1_N cml_tlatch_12.xtail.S1 VSS sg13_lv_nmos ad=89.3f pd=0.85u as=89.3f ps=0.85u w=0.47u l=0.16u
X5258 cml_tlatch_90.xmux.xn.S1 CKB2_N cml_tlatch_90.xtail.S1 VSS sg13_lv_nmos ad=89.3f pd=0.85u as=89.3f ps=0.85u w=0.47u l=0.16u
X5259 cml_tlatch_89.xmux.xn.S1 CKA3_N cml_tlatch_89.xtail.S1 VSS sg13_lv_nmos ad=89.3f pd=0.85u as=89.3f ps=0.85u w=0.47u l=0.16u
X5260 cml_tlatch_87.OUTN cml_tlatch_87.INP cml_tlatch_87.xmux.xn.S1 VSS sg13_lv_nmos ad=63.19999f pd=0.74u as=63.19999f ps=0.74u w=0.26u l=0.38u
X5261 cml_tlatch_43.xmux.xn.S1 CKHA1_P cml_tlatch_43.xtail.S1 VSS sg13_lv_nmos ad=89.3f pd=0.85u as=89.3f ps=0.85u w=0.47u l=0.16u
X5262 cml_tlatch_80.xtail.S1 CKHB2_P cml_tlatch_80.xmux.xn.S1 VSS sg13_lv_nmos ad=89.3f pd=0.85u as=89.3f ps=0.85u w=0.47u l=0.16u
X5263 cml_tlatch_7.OUTP cml_tlatch_7.OUTN cml_tlatch_7.xmux.xp.S1 VSS sg13_lv_nmos ad=56.9f pd=0.74u as=56.9f ps=0.74u w=0.17u l=0.17u
X5264 VSS hs_to_clk_3.sg13_lv_nmos_2HGZLP_0.G VSS VSS sg13_lv_nmos ad=2.071p pd=11.28u as=0 ps=0 w=10.9u l=1.38u
X5265 MOT27_N cml_tlatch_73.INP cml_tlatch_73.xmux.xn.S1 VSS sg13_lv_nmos ad=63.19999f pd=0.74u as=63.19999f ps=0.74u w=0.26u l=0.38u
X5266 cml_tlatch_74.xmux.xp.S1 MOT29_N MOT29_P VSS sg13_lv_nmos ad=56.9f pd=0.74u as=56.9f ps=0.74u w=0.17u l=0.17u
X5267 cml_tlatch_84.xmux.xn.S1 CKB2_P cml_tlatch_84.xtail.S1 VSS sg13_lv_nmos ad=89.3f pd=0.85u as=89.3f ps=0.85u w=0.47u l=0.16u
X5268 cml_tlatch_9.xmux.xp.S1 A0_8_N A0_8_P VSS sg13_lv_nmos ad=56.9f pd=0.74u as=56.9f ps=0.74u w=0.17u l=0.17u
X5269 cml_tlatch_39.xmux.xp.S1 cml_tlatch_97.INN cml_tlatch_97.INP VSS sg13_lv_nmos ad=56.9f pd=0.74u as=56.9f ps=0.74u w=0.17u l=0.17u
X5270 cml_tlatch_19.xmux.xp.S1 A1_8_P A1_8_N VSS sg13_lv_nmos ad=56.9f pd=0.74u as=56.9f ps=0.74u w=0.17u l=0.17u
X5271 cml_tlatch_88.xmux.xn.S1 cml_tlatch_49.OUTN cml_tlatch_74.INP VSS sg13_lv_nmos ad=63.19999f pd=0.74u as=0.1082p ps=1.34u w=0.26u l=0.38u
X5272 cml_tlatch_45.xtail.S1 CKHA3_P cml_tlatch_45.xmux.xn.S1 VSS sg13_lv_nmos ad=89.3f pd=0.85u as=89.3f ps=0.85u w=0.47u l=0.16u
X5273 cml_drvb_0.xrtail.R2 VSS VSS rppd l=2.72u w=1u
X5274 cml_tlatch_49.xmux.xp.S1 CKB3_N cml_tlatch_49.xtail.S1 VSS sg13_lv_nmos ad=89.3f pd=0.85u as=89.3f ps=0.85u w=0.47u l=0.16u
X5275 cml_tlatch_74.INN cml_tlatch_49.OUTP cml_tlatch_88.xmux.xn.S1 VSS sg13_lv_nmos ad=63.19999f pd=0.74u as=63.19999f ps=0.74u w=0.26u l=0.38u
X5276 cml_tlatch_49.OUTN cml_tlatch_49.OUTP cml_tlatch_49.xmux.xp.S1 VSS sg13_lv_nmos ad=56.9f pd=0.74u as=56.9f ps=0.74u w=0.17u l=0.17u
X5277 cml_tlatch_59.xmux.xp.S1 cml_tlatch_91.INP cml_tlatch_91.INN VSS sg13_lv_nmos ad=56.9f pd=0.74u as=56.9f ps=0.74u w=0.17u l=0.17u
X5278 cml_tlatch_77.xmux.xp.S1 MOT17_N MOT17_P VSS sg13_lv_nmos ad=56.9f pd=0.74u as=56.9f ps=0.74u w=0.17u l=0.17u
X5279 cml_tlatch_61.OUTP cml_tlatch_61.OUTN cml_tlatch_61.xmux.xp.S1 VSS sg13_lv_nmos ad=56.9f pd=0.74u as=56.9f ps=0.74u w=0.17u l=0.17u
X5280 MOT25_P MOT25_N cml_tlatch_72.xmux.xp.S1 VSS sg13_lv_nmos ad=56.9f pd=0.74u as=56.9f ps=0.74u w=0.17u l=0.17u
X5281 cml_tlatch_81.xmux.xp.S1 B2_8_N B2_8_P VSS sg13_lv_nmos ad=56.9f pd=0.74u as=56.9f ps=0.74u w=0.17u l=0.17u
X5282 cml_tlatch_48.xmux.xp.S1 stub_bi_43.BOTP stub_bi_43.BOTN VSS sg13_lv_nmos ad=56.9f pd=0.74u as=56.9f ps=0.74u w=0.17u l=0.17u
X5283 cml_tlatch_11.xtail.S1 CKB1_N cml_tlatch_11.xmux.xp.S1 VSS sg13_lv_nmos ad=89.3f pd=0.85u as=89.3f ps=0.85u w=0.47u l=0.16u
X5284 VSS POLN cml_tlatch_79.xtail.S1 VSS sg13_lv_nmos ad=1.5637p pd=8.61u as=1.5637p ps=8.61u w=8.23u l=0.13u
X5285 cml_tlatch_47.xmux.xn.S1 CKB2_N cml_tlatch_47.xtail.S1 VSS sg13_lv_nmos ad=89.3f pd=0.85u as=89.3f ps=0.85u w=0.47u l=0.16u
X5286 cml_tlatch_15.xmux.xp.S1 MOT3_P MOT3_N VSS sg13_lv_nmos ad=56.9f pd=0.74u as=56.9f ps=0.74u w=0.17u l=0.17u
X5287 hs_to_clk_7.D2 CK_N CKA2_N VSS sg13_lv_nmos ad=0.228p pd=1.58u as=0.228p ps=1.58u w=1.2u l=0.2u
X5288 cml_tlatch_42.xmux.xp.S1 MOT8_N MOT8_P VSS sg13_lv_nmos ad=0.1019p pd=1.34u as=56.9f ps=0.74u w=0.17u l=0.17u
X5289 cml_tlatch_39.xmux.xp.S1 cml_tlatch_97.INN cml_tlatch_97.INP VSS sg13_lv_nmos ad=56.9f pd=0.74u as=56.9f ps=0.74u w=0.17u l=0.17u
X5290 stub_bi_17.BOTP stub_bi_17.BOTN cml_tlatch_13.xmux.xp.S1 VSS sg13_lv_nmos ad=56.9f pd=0.74u as=56.9f ps=0.74u w=0.17u l=0.17u
X5291 cml_tlatch_18.OUTP cml_tlatch_23.OUTN cml_tlatch_18.xmux.xn.S1 VSS sg13_lv_nmos ad=63.19999f pd=0.74u as=63.19999f ps=0.74u w=0.26u l=0.38u
X5292 ENB1_N ENB_P cml_drv_0.xrtail.R1 VSS sg13_lv_nmos ad=56.2f pd=0.74u as=56.2f ps=0.74u w=0.16u l=0.19u
X5293 cml_tlatch_10.xmux.xp.S1 CKB1_P cml_tlatch_10.xtail.S1 VSS sg13_lv_nmos ad=89.3f pd=0.85u as=89.3f ps=0.85u w=0.47u l=0.16u
X5294 cml_gate2_5.xrtail.R1 CKB2_N GA2_P VSS sg13_lv_nmos ad=0.1007p pd=0.91u as=0.1007p ps=0.91u w=0.53u l=0.13u
X5295 MOT18_N MOT18_P cml_tlatch_53.xmux.xp.S1 VSS sg13_lv_nmos ad=56.9f pd=0.74u as=56.9f ps=0.74u w=0.17u l=0.17u
X5296 cml_tlatch_44.INN cml_tlatch_44.INP cml_tlatch_89.xmux.xp.S1 VSS sg13_lv_nmos ad=56.9f pd=0.74u as=56.9f ps=0.74u w=0.17u l=0.17u
X5297 cml_tlatch_98.xmux.xp.S1 cml_tlatch_98.OUTP cml_tlatch_98.OUTN VSS sg13_lv_nmos ad=56.9f pd=0.74u as=56.9f ps=0.74u w=0.17u l=0.17u
X5298 cml_tlatch_85.xmux.xp.S1 CKA2_P cml_tlatch_85.xtail.S1 VSS sg13_lv_nmos ad=89.3f pd=0.85u as=89.3f ps=0.85u w=0.47u l=0.16u
X5299 cml_tlatch_71.xmux.xn.S1 cml_tlatch_44.INN cml_tlatch_71.OUTP VSS sg13_lv_nmos ad=63.19999f pd=0.74u as=63.19999f ps=0.74u w=0.26u l=0.38u
X5300 cml_tlatch_41.OUTN D1_P cml_tlatch_41.xmux.xn.S1 VSS sg13_lv_nmos ad=63.19999f pd=0.74u as=63.19999f ps=0.74u w=0.26u l=0.38u
X5301 cml_tlatch_75.xmux.xp.S1 MOT31_N MOT31_P VSS sg13_lv_nmos ad=56.9f pd=0.74u as=56.9f ps=0.74u w=0.17u l=0.17u
X5302 cml_tlatch_88.xmux.xp.S1 CKB3_P cml_tlatch_88.xtail.S1 VSS sg13_lv_nmos ad=89.3f pd=0.85u as=89.3f ps=0.85u w=0.47u l=0.16u
X5303 cml_tlatch_5.INN cml_tlatch_5.INP cml_tlatch_96.xmux.xp.S1 VSS sg13_lv_nmos ad=56.9f pd=0.74u as=56.9f ps=0.74u w=0.17u l=0.17u
X5304 cml_tlatch_75.xtail.S1 CKHB3_N cml_tlatch_75.xmux.xp.S1 VSS sg13_lv_nmos ad=89.3f pd=0.85u as=89.3f ps=0.85u w=0.47u l=0.16u
X5305 MOT15_P MOT15_N cml_tlatch_6.xmux.xp.S1 VSS sg13_lv_nmos ad=56.9f pd=0.74u as=56.9f ps=0.74u w=0.17u l=0.17u
X5306 cml_tlatch_91.OUTN cml_tlatch_91.INP cml_tlatch_91.xmux.xn.S1 VSS sg13_lv_nmos ad=0.1082p pd=1.34u as=63.19999f ps=0.74u w=0.26u l=0.38u
X5307 MOT6_N MOT6_P cml_tlatch_29.xmux.xp.S1 VSS sg13_lv_nmos ad=56.9f pd=0.74u as=56.9f ps=0.74u w=0.17u l=0.17u
X5308 cml_tlatch_72.xmux.xn.S1 B3_8_P MOT25_N VSS sg13_lv_nmos ad=63.19999f pd=0.74u as=63.19999f ps=0.74u w=0.26u l=0.38u
X5309 GB0_P CKA0_N cml_gate2_1.xrtail.R1 VSS sg13_lv_nmos ad=0.1007p pd=0.91u as=0.1007p ps=0.91u w=0.53u l=0.13u
X5310 cml_tlatch_20.xmux.xp.S1 cml_tlatch_20.OUTN cml_tlatch_20.OUTP VSS sg13_lv_nmos ad=56.9f pd=0.74u as=56.9f ps=0.74u w=0.17u l=0.17u
X5311 ENB_P J2_N cml_gate2_8.xamp.xn.S1 VSS sg13_lv_nmos ad=0.1007p pd=0.91u as=0.1007p ps=0.91u w=0.53u l=0.13u
X5312 VSS hs_to_clk_6.sg13_lv_nmos_2HGZLP_0.G VSS VSS sg13_lv_nmos ad=2.071p pd=11.28u as=0 ps=0 w=10.9u l=1.38u
X5313 stub_bi_31.BOTP stub_bi_31.BOTN cml_tlatch_37.xmux.xp.S1 VSS sg13_lv_nmos ad=56.9f pd=0.74u as=56.9f ps=0.74u w=0.17u l=0.17u
X5314 stub_bi_31.BOTP VDD VSS rppd l=5.17u w=1u
X5315 cml_tlatch_86.xmux.xn.S1 CKA2_P cml_tlatch_86.xtail.S1 VSS sg13_lv_nmos ad=89.3f pd=0.85u as=89.3f ps=0.85u w=0.47u l=0.16u
X5316 cml_tlatch_72.xmux.xn.S1 B3_8_P MOT25_N VSS sg13_lv_nmos ad=63.19999f pd=0.74u as=63.19999f ps=0.74u w=0.26u l=0.38u
X5317 cml_tlatch_7.xmux.xn.S1 CKB0_N cml_tlatch_7.xtail.S1 VSS sg13_lv_nmos ad=89.3f pd=0.85u as=89.3f ps=0.85u w=0.47u l=0.16u
X5318 cml_tlatch_21.xmux.xp.S1 CKA1_P cml_tlatch_21.xtail.S1 VSS sg13_lv_nmos ad=89.3f pd=0.85u as=89.3f ps=0.85u w=0.47u l=0.16u
X5319 cml_tlatch_0.xmux.xp.S1 CKA0_N cml_tlatch_0.xtail.S1 VSS sg13_lv_nmos ad=89.3f pd=0.85u as=89.3f ps=0.85u w=0.47u l=0.16u
X5320 cml_tlatch_20.OUTN cml_tlatch_20.OUTP cml_tlatch_20.xmux.xp.S1 VSS sg13_lv_nmos ad=56.9f pd=0.74u as=56.9f ps=0.74u w=0.17u l=0.17u
X5321 cml_tlatch_50.xmux.xp.S1 B3_2_N B3_2_P VSS sg13_lv_nmos ad=56.9f pd=0.74u as=56.9f ps=0.74u w=0.17u l=0.17u
X5322 cml_tlatch_23.xmux.xn.S1 cml_tlatch_0.OUTN cml_tlatch_23.OUTP VSS sg13_lv_nmos ad=63.19999f pd=0.74u as=63.19999f ps=0.74u w=0.26u l=0.38u
X5323 MOT10_P cml_tlatch_43.INN cml_tlatch_43.xmux.xn.S1 VSS sg13_lv_nmos ad=63.19999f pd=0.74u as=63.19999f ps=0.74u w=0.26u l=0.38u
X5324 cml_tlatch_11.xmux.xp.S1 stub_bi_15.BOTN stub_bi_15.BOTP VSS sg13_lv_nmos ad=56.9f pd=0.74u as=56.9f ps=0.74u w=0.17u l=0.17u
X5325 cml_tlatch_94.xmux.xp.S1 J2_N J2_P VSS sg13_lv_nmos ad=56.9f pd=0.74u as=56.9f ps=0.74u w=0.17u l=0.17u
X5326 cml_tlatch_77.xtail.S1 CKHB2_P cml_tlatch_77.xmux.xn.S1 VSS sg13_lv_nmos ad=89.3f pd=0.85u as=89.3f ps=0.85u w=0.47u l=0.16u
X5327 A2_2_N A2_2_P cml_tlatch_60.xmux.xp.S1 VSS sg13_lv_nmos ad=56.9f pd=0.74u as=56.9f ps=0.74u w=0.17u l=0.17u
X5328 MOT0_N MOT0_P cml_tlatch_26.xmux.xp.S1 VSS sg13_lv_nmos ad=56.9f pd=0.74u as=56.9f ps=0.74u w=0.17u l=0.17u
X5329 MOT6_P MOT6_N cml_tlatch_29.xmux.xp.S1 VSS sg13_lv_nmos ad=56.9f pd=0.74u as=56.9f ps=0.74u w=0.17u l=0.17u
X5330 cml_gate2_0.xamp.xn.S1 CKA1_P cml_gate2_0.xrtail.R1 VSS sg13_lv_nmos ad=0.1007p pd=0.91u as=0.1007p ps=0.91u w=0.53u l=0.13u
X5331 stub_bi_43.BOTN D2_N cml_tlatch_48.xmux.xn.S1 VSS sg13_lv_nmos ad=63.19999f pd=0.74u as=63.19999f ps=0.74u w=0.26u l=0.38u
X5332 cml_tlatch_38.OUTN D0_P cml_tlatch_38.xmux.xn.S1 VSS sg13_lv_nmos ad=63.19999f pd=0.74u as=0.1082p ps=1.34u w=0.26u l=0.38u
X5333 cml_tlatch_82.xmux.xn.S1 CKB2_P cml_tlatch_82.xtail.S1 VSS sg13_lv_nmos ad=89.3f pd=0.85u as=89.3f ps=0.85u w=0.47u l=0.16u
X5334 B1_2_P B1_2_N cml_tlatch_36.xmux.xp.S1 VSS sg13_lv_nmos ad=56.9f pd=0.74u as=56.9f ps=0.74u w=0.17u l=0.17u
X5335 VDD cml_tlatch_97.INP VSS rppd l=5.17u w=1u
X5336 cml_tlatch_12.xmux.xp.S1 CKB1_P cml_tlatch_12.xtail.S1 VSS sg13_lv_nmos ad=89.3f pd=0.85u as=89.3f ps=0.85u w=0.47u l=0.16u
X5337 cml_tlatch_69.xmux.xn.S1 CKA3_P cml_tlatch_69.xtail.S1 VSS sg13_lv_nmos ad=89.3f pd=0.85u as=89.3f ps=0.85u w=0.47u l=0.16u
X5338 VSS hs_to_clk_8.sg13_lv_nmos_2HGZLP_0.G VSS VSS sg13_lv_nmos ad=2.071p pd=11.28u as=0 ps=0 w=10.9u l=1.38u
X5339 CKHB1_N GB1_P cml_drvb_0.xrtail.R2 VSS sg13_lv_nmos ad=0.2618p pd=2.22u as=0.1463p ps=1.15u w=0.77u l=0.21u
X5340 cml_tlatch_63.INP cml_tlatch_63.INN cml_tlatch_70.xmux.xp.S1 VSS sg13_lv_nmos ad=56.9f pd=0.74u as=56.9f ps=0.74u w=0.17u l=0.17u
X5341 cml_tlatch_7.OUTP cml_tlatch_7.OUTN cml_tlatch_7.xmux.xp.S1 VSS sg13_lv_nmos ad=56.9f pd=0.74u as=56.9f ps=0.74u w=0.17u l=0.17u
X5342 cml_tlatch_13.xmux.xn.S1 cml_tlatch_5.INN stub_bi_17.BOTN VSS sg13_lv_nmos ad=63.19999f pd=0.74u as=0.1082p ps=1.34u w=0.26u l=0.38u
X5343 cml_tlatch_76.xmux.xp.S1 cml_tlatch_87.INP cml_tlatch_87.INN VSS sg13_lv_nmos ad=56.9f pd=0.74u as=56.9f ps=0.74u w=0.17u l=0.17u
X5344 cml_gate2_6.xamp.xn.S1 CKA3_P cml_gate2_6.xrtail.R1 VSS sg13_lv_nmos ad=0.1007p pd=0.91u as=0.1007p ps=0.91u w=0.53u l=0.13u
X5345 VDD CKHA0_N VSS rppd l=13.09u w=1u
X5346 cml_tlatch_56.xmux.xn.S1 A3_2_N cml_tlatch_56.OUTP VSS sg13_lv_nmos ad=63.19999f pd=0.74u as=63.19999f ps=0.74u w=0.26u l=0.38u
X5347 cml_tlatch_59.xmux.xp.S1 cml_tlatch_91.INP cml_tlatch_91.INN VSS sg13_lv_nmos ad=56.9f pd=0.74u as=56.9f ps=0.74u w=0.17u l=0.17u
X5348 cml_tlatch_99.xtail.S1 CKA0_N cml_tlatch_99.xmux.xn.S1 VSS sg13_lv_nmos ad=89.3f pd=0.85u as=89.3f ps=0.85u w=0.47u l=0.16u
X5349 cml_tlatch_13.xmux.xp.S1 stub_bi_17.BOTP stub_bi_17.BOTN VSS sg13_lv_nmos ad=56.9f pd=0.74u as=56.9f ps=0.74u w=0.17u l=0.17u
X5350 A1_8_P A1_8_N cml_tlatch_19.xmux.xp.S1 VSS sg13_lv_nmos ad=56.9f pd=0.74u as=0.1019p ps=1.34u w=0.17u l=0.17u
X5351 cml_tlatch_43.xmux.xp.S1 MOT10_P MOT10_N VSS sg13_lv_nmos ad=56.9f pd=0.74u as=56.9f ps=0.74u w=0.17u l=0.17u
X5352 CKB1_N hs_to_clk_2.sg13_lv_nmos_2HGZLP_0.G VSS rppd l=4.25u w=1u
X5353 cml_tlatch_8.xmux.xp.S1 cml_tlatch_8.OUTP cml_tlatch_8.OUTN VSS sg13_lv_nmos ad=56.9f pd=0.74u as=56.9f ps=0.74u w=0.17u l=0.17u
X5354 cml_tlatch_19.xmux.xn.S1 CKA1_N cml_tlatch_19.xtail.S1 VSS sg13_lv_nmos ad=89.3f pd=0.85u as=89.3f ps=0.85u w=0.47u l=0.16u
X5355 cml_tlatch_69.OUTP cml_tlatch_69.OUTN cml_tlatch_69.xmux.xp.S1 VSS sg13_lv_nmos ad=56.9f pd=0.74u as=56.9f ps=0.74u w=0.17u l=0.17u
X5356 cml_tlatch_18.OUTN cml_tlatch_18.OUTP cml_tlatch_18.xmux.xp.S1 VSS sg13_lv_nmos ad=56.9f pd=0.74u as=56.9f ps=0.74u w=0.17u l=0.17u
X5357 cml_tlatch_9.xmux.xn.S1 CKA0_N cml_tlatch_9.xtail.S1 VSS sg13_lv_nmos ad=0.1598p pd=1.62u as=89.3f ps=0.85u w=0.47u l=0.16u
X5358 cml_tlatch_41.xmux.xp.S1 cml_tlatch_41.OUTN cml_tlatch_41.OUTP VSS sg13_lv_nmos ad=56.9f pd=0.74u as=56.9f ps=0.74u w=0.17u l=0.17u
X5359 cml_tlatch_28.xmux.xn.S1 cml_tlatch_99.OUTP MOT4_N VSS sg13_lv_nmos ad=63.19999f pd=0.74u as=63.19999f ps=0.74u w=0.26u l=0.38u
X5360 cml_tlatch_23.xmux.xp.S1 cml_tlatch_23.OUTP cml_tlatch_23.OUTN VSS sg13_lv_nmos ad=56.9f pd=0.74u as=56.9f ps=0.74u w=0.17u l=0.17u
X5361 cml_tlatch_32.OUTP cml_tlatch_32.OUTN cml_tlatch_32.xmux.xp.S1 VSS sg13_lv_nmos ad=56.9f pd=0.74u as=56.9f ps=0.74u w=0.17u l=0.17u
X5362 A2_8_P cml_tlatch_86.OUTN cml_tlatch_85.xmux.xn.S1 VSS sg13_lv_nmos ad=63.19999f pd=0.74u as=63.19999f ps=0.74u w=0.26u l=0.38u
X5363 cml_tlatch_85.xmux.xn.S1 CKA2_N cml_tlatch_85.xtail.S1 VSS sg13_lv_nmos ad=0.1598p pd=1.62u as=89.3f ps=0.85u w=0.47u l=0.16u
X5364 cml_tlatch_56.OUTN A3_2_P cml_tlatch_56.xmux.xn.S1 VSS sg13_lv_nmos ad=63.19999f pd=0.74u as=0.1082p ps=1.34u w=0.26u l=0.38u
X5365 cml_tlatch_72.xtail.S1 CKHB3_N cml_tlatch_72.xmux.xp.S1 VSS sg13_lv_nmos ad=89.3f pd=0.85u as=89.3f ps=0.85u w=0.47u l=0.16u
X5366 cml_tlatch_80.xmux.xn.S1 B2_2_N MOT23_P VSS sg13_lv_nmos ad=63.19999f pd=0.74u as=63.19999f ps=0.74u w=0.26u l=0.38u
X5367 MOT11_P VDD VSS rppd l=5.17u w=1u
X5368 cml_tlatch_28.xmux.xn.S1 cml_tlatch_99.OUTP MOT4_N VSS sg13_lv_nmos ad=63.19999f pd=0.74u as=63.19999f ps=0.74u w=0.26u l=0.38u
X5369 cml_tlatch_98.xmux.xp.S1 cml_tlatch_98.OUTP cml_tlatch_98.OUTN VSS sg13_lv_nmos ad=56.9f pd=0.74u as=56.9f ps=0.74u w=0.17u l=0.17u
X5370 cml_tlatch_15.xtail.S1 CKHB0_P cml_tlatch_15.xmux.xn.S1 VSS sg13_lv_nmos ad=89.3f pd=0.85u as=89.3f ps=0.85u w=0.47u l=0.16u
X5371 J1_P J1_N cml_tlatch_95.xmux.xp.S1 VSS sg13_lv_nmos ad=56.9f pd=0.74u as=56.9f ps=0.74u w=0.17u l=0.17u
X5372 cml_tlatch_60.xtail.S1 POLN VSS VSS sg13_lv_nmos ad=1.5637p pd=8.61u as=1.5637p ps=8.61u w=8.23u l=0.13u
X5373 cml_tlatch_14.xmux.xp.S1 MOT1_P MOT1_N VSS sg13_lv_nmos ad=56.9f pd=0.74u as=56.9f ps=0.74u w=0.17u l=0.17u
X5374 cml_tlatch_73.INP cml_tlatch_73.INN cml_tlatch_66.xmux.xp.S1 VSS sg13_lv_nmos ad=56.9f pd=0.74u as=0.1019p ps=1.34u w=0.17u l=0.17u
X5375 MOT3_N cml_tlatch_7.OUTP cml_tlatch_15.xmux.xn.S1 VSS sg13_lv_nmos ad=63.19999f pd=0.74u as=63.19999f ps=0.74u w=0.26u l=0.38u
X5376 cml_tlatch_55.xmux.xp.S1 MOT22_N MOT22_P VSS sg13_lv_nmos ad=56.9f pd=0.74u as=56.9f ps=0.74u w=0.17u l=0.17u
X5377 cml_tlatch_52.xmux.xp.S1 MOT16_P MOT16_N VSS sg13_lv_nmos ad=56.9f pd=0.74u as=56.9f ps=0.74u w=0.17u l=0.17u
X5378 hs_to_clk_4.D2 CK_P CKB2_N VSS sg13_lv_nmos ad=0.408p pd=3.08u as=0.228p ps=1.58u w=1.2u l=0.2u
X5379 VDD hs_to_clk_7.sg13_lv_nmos_2HGZLP_0.G VSS rppd l=0.68u w=1u
X5380 MOT30_P MOT30_N cml_tlatch_45.xmux.xp.S1 VSS sg13_lv_nmos ad=56.9f pd=0.74u as=56.9f ps=0.74u w=0.17u l=0.17u
X5381 cml_tlatch_84.xtail.S1 CKB2_P cml_tlatch_84.xmux.xn.S1 VSS sg13_lv_nmos ad=89.3f pd=0.85u as=0.1598p ps=1.62u w=0.47u l=0.16u
X5382 cml_tlatch_1.xmux.xp.S1 B0_8_N B0_8_P VSS sg13_lv_nmos ad=56.9f pd=0.74u as=56.9f ps=0.74u w=0.17u l=0.17u
X5383 VSS POLN cml_tlatch_23.xtail.S1 VSS sg13_lv_nmos ad=1.5637p pd=8.61u as=1.5637p ps=8.61u w=8.23u l=0.13u
X5384 cml_tlatch_44.xmux.xn.S1 CKHA3_P cml_tlatch_44.xtail.S1 VSS sg13_lv_nmos ad=89.3f pd=0.85u as=89.3f ps=0.85u w=0.47u l=0.16u
X5385 cml_tlatch_36.xtail.S1 CKB1_P cml_tlatch_36.xmux.xp.S1 VSS sg13_lv_nmos ad=0.1598p pd=1.62u as=89.3f ps=0.85u w=0.47u l=0.16u
X5386 MOT4_P MOT4_N cml_tlatch_28.xmux.xp.S1 VSS sg13_lv_nmos ad=56.9f pd=0.74u as=56.9f ps=0.74u w=0.17u l=0.17u
X5387 VSS POLN cml_tlatch_99.xtail.S1 VSS sg13_lv_nmos ad=2.7982p pd=17.14u as=1.5637p ps=8.61u w=8.23u l=0.13u
X5388 cml_tlatch_92.xmux.xn.S1 CKJ_N cml_tlatch_92.xtail.S1 VSS sg13_lv_nmos ad=89.3f pd=0.85u as=89.3f ps=0.85u w=0.47u l=0.16u
X5389 cml_tlatch_25.xmux.xp.S1 MOT14_N MOT14_P VSS sg13_lv_nmos ad=56.9f pd=0.74u as=56.9f ps=0.74u w=0.17u l=0.17u
X5390 cml_tlatch_25.xmux.xp.S1 MOT14_P MOT14_N VSS sg13_lv_nmos ad=56.9f pd=0.74u as=56.9f ps=0.74u w=0.17u l=0.17u
X5391 cml_tlatch_66.xmux.xn.S1 CKB3_N cml_tlatch_66.xtail.S1 VSS sg13_lv_nmos ad=89.3f pd=0.85u as=89.3f ps=0.85u w=0.47u l=0.16u
X5392 cml_tlatch_60.xmux.xp.S1 A2_2_N A2_2_P VSS sg13_lv_nmos ad=56.9f pd=0.74u as=56.9f ps=0.74u w=0.17u l=0.17u
X5393 cml_tlatch_88.xmux.xp.S1 cml_tlatch_74.INN cml_tlatch_74.INP VSS sg13_lv_nmos ad=56.9f pd=0.74u as=56.9f ps=0.74u w=0.17u l=0.17u
X5394 MOT11_P cml_tlatch_4.INN cml_tlatch_4.xmux.xn.S1 VSS sg13_lv_nmos ad=63.19999f pd=0.74u as=63.19999f ps=0.74u w=0.26u l=0.38u
X5395 cml_tlatch_67.xtail.S1 CKB3_P cml_tlatch_67.xmux.xn.S1 VSS sg13_lv_nmos ad=89.3f pd=0.85u as=89.3f ps=0.85u w=0.47u l=0.16u
X5396 cml_tlatch_53.xmux.xp.S1 MOT18_N MOT18_P VSS sg13_lv_nmos ad=56.9f pd=0.74u as=56.9f ps=0.74u w=0.17u l=0.17u
X5397 cml_tlatch_34.xmux.xp.S1 A0_2_P A0_2_N VSS sg13_lv_nmos ad=56.9f pd=0.74u as=56.9f ps=0.74u w=0.17u l=0.17u
X5398 MOT11_N MOT11_P cml_tlatch_4.xmux.xp.S1 VSS sg13_lv_nmos ad=56.9f pd=0.74u as=56.9f ps=0.74u w=0.17u l=0.17u
X5399 cml_tlatch_11.xmux.xp.S1 stub_bi_15.BOTN stub_bi_15.BOTP VSS sg13_lv_nmos ad=56.9f pd=0.74u as=56.9f ps=0.74u w=0.17u l=0.17u
X5400 cml_tlatch_2.OUTP cml_tlatch_2.OUTN cml_tlatch_2.xmux.xp.S1 VSS sg13_lv_nmos ad=56.9f pd=0.74u as=56.9f ps=0.74u w=0.17u l=0.17u
X5401 GB1_P VDD VSS rppd l=7.42u w=1u
X5402 cml_tlatch_22.xmux.xn.S1 CKA1_P cml_tlatch_22.xtail.S1 VSS sg13_lv_nmos ad=0.1598p pd=1.62u as=89.3f ps=0.85u w=0.47u l=0.16u
X5403 cml_tlatch_94.xmux.xp.S1 J2_P J2_N VSS sg13_lv_nmos ad=56.9f pd=0.74u as=56.9f ps=0.74u w=0.17u l=0.17u
X5404 cml_tlatch_12.xmux.xp.S1 cml_tlatch_4.INP cml_tlatch_4.INN VSS sg13_lv_nmos ad=56.9f pd=0.74u as=56.9f ps=0.74u w=0.17u l=0.17u
X5405 cml_tlatch_94.xmux.xp.S1 J2_N J2_P VSS sg13_lv_nmos ad=56.9f pd=0.74u as=56.9f ps=0.74u w=0.17u l=0.17u
X5406 cml_tlatch_31.xmux.xn.S1 CKB0_N cml_tlatch_31.xtail.S1 VSS sg13_lv_nmos ad=89.3f pd=0.85u as=89.3f ps=0.85u w=0.47u l=0.16u
X5407 cml_tlatch_99.xmux.xp.S1 CKA0_P cml_tlatch_99.xtail.S1 VSS sg13_lv_nmos ad=89.3f pd=0.85u as=89.3f ps=0.85u w=0.47u l=0.16u
X5408 MOT0_N MOT0_P cml_tlatch_26.xmux.xp.S1 VSS sg13_lv_nmos ad=56.9f pd=0.74u as=56.9f ps=0.74u w=0.17u l=0.17u
X5409 cml_tlatch_76.xmux.xp.S1 CKA2_N cml_tlatch_76.xtail.S1 VSS sg13_lv_nmos ad=89.3f pd=0.85u as=0.1598p ps=1.62u w=0.47u l=0.16u
X5410 VSS POLN cml_tlatch_55.xtail.S1 VSS sg13_lv_nmos ad=1.5637p pd=8.61u as=1.5637p ps=8.61u w=8.23u l=0.13u
X5411 cml_tlatch_45.xmux.xp.S1 MOT30_P MOT30_N VSS sg13_lv_nmos ad=56.9f pd=0.74u as=56.9f ps=0.74u w=0.17u l=0.17u
X5412 cml_tlatch_9.xmux.xp.S1 CKA0_P cml_tlatch_9.xtail.S1 VSS sg13_lv_nmos ad=89.3f pd=0.85u as=89.3f ps=0.85u w=0.47u l=0.16u
X5413 cml_tlatch_40.xmux.xn.S1 CKA1_N cml_tlatch_40.xtail.S1 VSS sg13_lv_nmos ad=89.3f pd=0.85u as=89.3f ps=0.85u w=0.47u l=0.16u
X5414 A3_8_P A3_8_N cml_tlatch_68.xmux.xp.S1 VSS sg13_lv_nmos ad=56.9f pd=0.74u as=56.9f ps=0.74u w=0.17u l=0.17u
X5415 cml_tlatch_58.OUTP cml_tlatch_58.OUTN cml_tlatch_58.xmux.xp.S1 VSS sg13_lv_nmos ad=56.9f pd=0.74u as=56.9f ps=0.74u w=0.17u l=0.17u
X5416 cml_tlatch_90.xmux.xn.S1 CKB2_N cml_tlatch_90.xtail.S1 VSS sg13_lv_nmos ad=89.3f pd=0.85u as=89.3f ps=0.85u w=0.47u l=0.16u
X5417 cml_tlatch_88.xtail.S1 CKB3_P cml_tlatch_88.xmux.xp.S1 VSS sg13_lv_nmos ad=89.3f pd=0.85u as=89.3f ps=0.85u w=0.47u l=0.16u
X5418 VDD cml_tlatch_43.INN VSS rppd l=5.17u w=1u
X5419 hs_to_clk_2.sg13_lv_nmos_2HGZLP_0.G VDD VSS rppd l=0.68u w=1u
X5420 cml_tlatch_66.xmux.xn.S1 cml_tlatch_67.OUTP cml_tlatch_73.INN VSS sg13_lv_nmos ad=0.1082p pd=1.34u as=63.19999f ps=0.74u w=0.26u l=0.38u
X5421 cml_tlatch_46.xtail.S1 CKB2_P cml_tlatch_46.xmux.xn.S1 VSS sg13_lv_nmos ad=89.3f pd=0.85u as=89.3f ps=0.85u w=0.47u l=0.16u
X5422 cml_tlatch_76.xmux.xp.S1 cml_tlatch_87.INP cml_tlatch_87.INN VSS sg13_lv_nmos ad=56.9f pd=0.74u as=56.9f ps=0.74u w=0.17u l=0.17u
X5423 cml_tlatch_60.xmux.xn.S1 CKA2_N cml_tlatch_60.xtail.S1 VSS sg13_lv_nmos ad=0.1598p pd=1.62u as=89.3f ps=0.85u w=0.47u l=0.16u
X5424 MOT27_N MOT27_P cml_tlatch_73.xmux.xp.S1 VSS sg13_lv_nmos ad=56.9f pd=0.74u as=56.9f ps=0.74u w=0.17u l=0.17u
X5425 stub_bi_49.BOTP stub_bi_49.BOTN cml_tlatch_84.xmux.xp.S1 VSS sg13_lv_nmos ad=56.9f pd=0.74u as=56.9f ps=0.74u w=0.17u l=0.17u
X5426 cml_tlatch_26.xmux.xn.S1 CKHA0_P cml_tlatch_26.xtail.S1 VSS sg13_lv_nmos ad=0.1598p pd=1.62u as=89.3f ps=0.85u w=0.47u l=0.16u
X5427 cml_tlatch_66.xmux.xn.S1 cml_tlatch_67.OUTP cml_tlatch_73.INN VSS sg13_lv_nmos ad=63.19999f pd=0.74u as=63.19999f ps=0.74u w=0.26u l=0.38u
X5428 VDD MOT22_P VSS rppd l=5.17u w=1u
X5429 cml_tlatch_21.xmux.xn.S1 cml_tlatch_22.OUTP cml_tlatch_43.INN VSS sg13_lv_nmos ad=63.19999f pd=0.74u as=63.19999f ps=0.74u w=0.26u l=0.38u
X5430 cml_tlatch_38.xtail.S1 CKA0_N cml_tlatch_38.xmux.xp.S1 VSS sg13_lv_nmos ad=89.3f pd=0.85u as=89.3f ps=0.85u w=0.47u l=0.16u
X5431 cml_tlatch_33.OUTN cml_tlatch_33.OUTP cml_tlatch_33.xmux.xp.S1 VSS sg13_lv_nmos ad=56.9f pd=0.74u as=56.9f ps=0.74u w=0.17u l=0.17u
X5432 cml_tlatch_39.xmux.xp.S1 CKA1_N cml_tlatch_39.xtail.S1 VSS sg13_lv_nmos ad=89.3f pd=0.85u as=0.1598p ps=1.62u w=0.47u l=0.16u
X5433 ENA0_P ENA_N cml_drv_3.xrtail.R1 VSS sg13_lv_nmos ad=56.2f pd=0.74u as=56.2f ps=0.74u w=0.16u l=0.19u
X5434 cml_tlatch_75.xtail.S1 CKHB3_P cml_tlatch_75.xmux.xn.S1 VSS sg13_lv_nmos ad=89.3f pd=0.85u as=89.3f ps=0.85u w=0.47u l=0.16u
X5435 cml_tlatch_31.xmux.xp.S1 B0_2_N B0_2_P VSS sg13_lv_nmos ad=56.9f pd=0.74u as=56.9f ps=0.74u w=0.17u l=0.17u
X5436 MOT8_N MOT8_P cml_tlatch_42.xmux.xp.S1 VSS sg13_lv_nmos ad=56.9f pd=0.74u as=0.1019p ps=1.34u w=0.17u l=0.17u
X5437 A2_8_N A2_8_P cml_tlatch_85.xmux.xp.S1 VSS sg13_lv_nmos ad=56.9f pd=0.74u as=56.9f ps=0.74u w=0.17u l=0.17u
X5438 cml_tlatch_81.xmux.xp.S1 B2_8_P B2_8_N VSS sg13_lv_nmos ad=56.9f pd=0.74u as=56.9f ps=0.74u w=0.17u l=0.17u
X5439 cml_tlatch_18.xmux.xn.S1 cml_tlatch_23.OUTP cml_tlatch_18.OUTN VSS sg13_lv_nmos ad=63.19999f pd=0.74u as=63.19999f ps=0.74u w=0.26u l=0.38u
X5440 cml_tlatch_91.xmux.xp.S1 cml_tlatch_91.OUTP cml_tlatch_91.OUTN VSS sg13_lv_nmos ad=56.9f pd=0.74u as=56.9f ps=0.74u w=0.17u l=0.17u
X5441 cml_tlatch_99.OUTP cml_tlatch_99.OUTN cml_tlatch_99.xmux.xp.S1 VSS sg13_lv_nmos ad=56.9f pd=0.74u as=56.9f ps=0.74u w=0.17u l=0.17u
X5442 cml_tlatch_3.xmux.xn.S1 B1_8_N MOT9_P VSS sg13_lv_nmos ad=63.19999f pd=0.74u as=0.1082p ps=1.34u w=0.26u l=0.38u
X5443 MOT19_P MOT19_N cml_tlatch_78.xmux.xp.S1 VSS sg13_lv_nmos ad=56.9f pd=0.74u as=56.9f ps=0.74u w=0.17u l=0.17u
X5444 cml_tlatch_93.xmux.xn.S1 J2_N CLK_W_N VSS sg13_lv_nmos ad=63.19999f pd=0.74u as=63.19999f ps=0.74u w=0.26u l=0.38u
X5445 VSS POLN hs_to_clk_4.D2 VSS sg13_lv_nmos ad=1.9p pd=10.38u as=3.4p ps=20.68u w=10u l=0.13u
X5446 cml_tlatch_25.xtail.S1 CKHA1_P cml_tlatch_25.xmux.xn.S1 VSS sg13_lv_nmos ad=0.1598p pd=1.62u as=89.3f ps=0.85u w=0.47u l=0.16u
X5447 stub_bi_43.BOTP stub_bi_43.BOTN cml_tlatch_48.xmux.xp.S1 VSS sg13_lv_nmos ad=56.9f pd=0.74u as=56.9f ps=0.74u w=0.17u l=0.17u
X5448 cml_tlatch_41.xmux.xp.S1 cml_tlatch_41.OUTP cml_tlatch_41.OUTN VSS sg13_lv_nmos ad=56.9f pd=0.74u as=56.9f ps=0.74u w=0.17u l=0.17u
X5449 cml_tlatch_73.INN cml_tlatch_73.INP cml_tlatch_66.xmux.xp.S1 VSS sg13_lv_nmos ad=56.9f pd=0.74u as=56.9f ps=0.74u w=0.17u l=0.17u
X5450 cml_tlatch_14.xmux.xp.S1 MOT1_P MOT1_N VSS sg13_lv_nmos ad=0.1019p pd=1.34u as=56.9f ps=0.74u w=0.17u l=0.17u
X5451 cml_tlatch_40.xmux.xp.S1 A1_2_P A1_2_N VSS sg13_lv_nmos ad=56.9f pd=0.74u as=56.9f ps=0.74u w=0.17u l=0.17u
X5452 cml_tlatch_87.xmux.xp.S1 cml_tlatch_87.OUTN cml_tlatch_87.OUTP VSS sg13_lv_nmos ad=56.9f pd=0.74u as=56.9f ps=0.74u w=0.17u l=0.17u
X5453 cml_tlatch_31.xtail.S1 CKB0_P cml_tlatch_31.xmux.xp.S1 VSS sg13_lv_nmos ad=0.1598p pd=1.62u as=89.3f ps=0.85u w=0.47u l=0.16u
X5454 MOT8_P MOT8_N cml_tlatch_42.xmux.xp.S1 VSS sg13_lv_nmos ad=56.9f pd=0.74u as=56.9f ps=0.74u w=0.17u l=0.17u
X5455 cml_tlatch_91.INP cml_tlatch_91.INN cml_tlatch_59.xmux.xp.S1 VSS sg13_lv_nmos ad=56.9f pd=0.74u as=56.9f ps=0.74u w=0.17u l=0.17u
X5456 cml_tlatch_46.xmux.xp.S1 stub_bi_38.BOTP stub_bi_38.BOTN VSS sg13_lv_nmos ad=56.9f pd=0.74u as=56.9f ps=0.74u w=0.17u l=0.17u
X5457 cml_gate2_7.xrtail.R1 CKA2_N GB2_P VSS sg13_lv_nmos ad=0.1007p pd=0.91u as=0.1007p ps=0.91u w=0.53u l=0.13u
X5458 cml_tlatch_47.xmux.xn.S1 stub_bi_43.BOTP B2_2_P VSS sg13_lv_nmos ad=63.19999f pd=0.74u as=63.19999f ps=0.74u w=0.26u l=0.38u
X5459 cml_tlatch_86.OUTN cml_tlatch_86.OUTP cml_tlatch_86.xmux.xp.S1 VSS sg13_lv_nmos ad=56.9f pd=0.74u as=56.9f ps=0.74u w=0.17u l=0.17u
X5460 cml_tlatch_41.OUTP D1_N cml_tlatch_41.xmux.xn.S1 VSS sg13_lv_nmos ad=0.1082p pd=1.34u as=63.19999f ps=0.74u w=0.26u l=0.38u
X5461 cml_tlatch_71.xtail.S1 CKA3_N cml_tlatch_71.xmux.xp.S1 VSS sg13_lv_nmos ad=89.3f pd=0.85u as=89.3f ps=0.85u w=0.47u l=0.16u
X5462 cml_tlatch_1.xmux.xp.S1 B0_8_P B0_8_N VSS sg13_lv_nmos ad=56.9f pd=0.74u as=56.9f ps=0.74u w=0.17u l=0.17u
X5463 A1_8_N cml_tlatch_20.OUTP cml_tlatch_19.xmux.xn.S1 VSS sg13_lv_nmos ad=63.19999f pd=0.74u as=0.1082p ps=1.34u w=0.26u l=0.38u
X5464 cml_tlatch_63.xmux.xn.S1 cml_tlatch_63.INP MOT26_N VSS sg13_lv_nmos ad=0.1082p pd=1.34u as=63.19999f ps=0.74u w=0.26u l=0.38u
X5465 cml_tlatch_81.xmux.xp.S1 CKB2_P cml_tlatch_81.xtail.S1 VSS sg13_lv_nmos ad=89.3f pd=0.85u as=89.3f ps=0.85u w=0.47u l=0.16u
X5466 cml_tlatch_42.xtail.S1 CKHA1_N cml_tlatch_42.xmux.xp.S1 VSS sg13_lv_nmos ad=89.3f pd=0.85u as=89.3f ps=0.85u w=0.47u l=0.16u
X5467 cml_tlatch_88.xmux.xn.S1 cml_tlatch_49.OUTP cml_tlatch_74.INN VSS sg13_lv_nmos ad=63.19999f pd=0.74u as=63.19999f ps=0.74u w=0.26u l=0.38u
X5468 B2_2_P B2_2_N cml_tlatch_47.xmux.xp.S1 VSS sg13_lv_nmos ad=56.9f pd=0.74u as=56.9f ps=0.74u w=0.17u l=0.17u
X5469 cml_gate2_3.xamp.xn.S1 ENA0_P GA0_N VSS sg13_lv_nmos ad=0.1007p pd=0.91u as=0.1802p ps=1.74u w=0.53u l=0.13u
X5470 cml_tlatch_65.OUTP cml_tlatch_65.OUTN cml_tlatch_65.xmux.xp.S1 VSS sg13_lv_nmos ad=56.9f pd=0.74u as=56.9f ps=0.74u w=0.17u l=0.17u
X5471 cml_tlatch_53.xmux.xp.S1 MOT18_N MOT18_P VSS sg13_lv_nmos ad=0.1019p pd=1.34u as=56.9f ps=0.74u w=0.17u l=0.17u
X5472 MOT26_P MOT26_N cml_tlatch_63.xmux.xp.S1 VSS sg13_lv_nmos ad=56.9f pd=0.74u as=56.9f ps=0.74u w=0.17u l=0.17u
X5473 cml_tlatch_20.xmux.xn.S1 cml_tlatch_43.INP cml_tlatch_20.OUTN VSS sg13_lv_nmos ad=63.19999f pd=0.74u as=63.19999f ps=0.74u w=0.26u l=0.38u
X5474 MOT24_P MOT24_N cml_tlatch_62.xmux.xp.S1 VSS sg13_lv_nmos ad=56.9f pd=0.74u as=56.9f ps=0.74u w=0.17u l=0.17u
X5475 cml_tlatch_53.xmux.xn.S1 cml_tlatch_87.OUTN MOT18_P VSS sg13_lv_nmos ad=63.19999f pd=0.74u as=63.19999f ps=0.74u w=0.26u l=0.38u
X5476 cml_tlatch_15.xmux.xn.S1 CKHB0_P cml_tlatch_15.xtail.S1 VSS sg13_lv_nmos ad=89.3f pd=0.85u as=89.3f ps=0.85u w=0.47u l=0.16u
X5477 VDD MOT21_N VSS rppd l=5.17u w=1u
X5478 cml_tlatch_48.xmux.xn.S1 CKB2_P cml_tlatch_48.xtail.S1 VSS sg13_lv_nmos ad=89.3f pd=0.85u as=89.3f ps=0.85u w=0.47u l=0.16u
X5479 cml_tlatch_43.xmux.xp.S1 MOT10_N MOT10_P VSS sg13_lv_nmos ad=56.9f pd=0.74u as=56.9f ps=0.74u w=0.17u l=0.17u
X5480 cml_tlatch_56.xmux.xp.S1 cml_tlatch_56.OUTP cml_tlatch_56.OUTN VSS sg13_lv_nmos ad=0.1019p pd=1.34u as=56.9f ps=0.74u w=0.17u l=0.17u
X5481 cml_tlatch_59.xtail.S1 CKA2_N cml_tlatch_59.xmux.xp.S1 VSS sg13_lv_nmos ad=89.3f pd=0.85u as=89.3f ps=0.85u w=0.47u l=0.16u
X5482 cml_drvb_5.xrtail.R2 VSS VSS rppd l=2.72u w=1u
X5483 cml_tlatch_12.xmux.xp.S1 CKB1_P cml_tlatch_12.xtail.S1 VSS sg13_lv_nmos ad=89.3f pd=0.85u as=89.3f ps=0.85u w=0.47u l=0.16u
X5484 cml_tlatch_71.OUTP cml_tlatch_44.INN cml_tlatch_71.xmux.xn.S1 VSS sg13_lv_nmos ad=0.1082p pd=1.34u as=63.19999f ps=0.74u w=0.26u l=0.38u
X5485 cml_tlatch_57.xmux.xp.S1 A3_2_N A3_2_P VSS sg13_lv_nmos ad=56.9f pd=0.74u as=56.9f ps=0.74u w=0.17u l=0.17u
X5486 cml_tlatch_79.xmux.xp.S1 MOT21_N MOT21_P VSS sg13_lv_nmos ad=56.9f pd=0.74u as=56.9f ps=0.74u w=0.17u l=0.17u
X5487 cml_tlatch_38.xmux.xn.S1 CKA0_P cml_tlatch_38.xtail.S1 VSS sg13_lv_nmos ad=89.3f pd=0.85u as=89.3f ps=0.85u w=0.47u l=0.16u
X5488 MOT7_P MOT7_N cml_tlatch_17.xmux.xp.S1 VSS sg13_lv_nmos ad=56.9f pd=0.74u as=56.9f ps=0.74u w=0.17u l=0.17u
X5489 GB0_P ENB1_N cml_gate2_1.xamp.xn.S1 VSS sg13_lv_nmos ad=0.1007p pd=0.91u as=0.1007p ps=0.91u w=0.53u l=0.13u
X5490 cml_tlatch_8.xtail.S1 CKB0_N cml_tlatch_8.xmux.xp.S1 VSS sg13_lv_nmos ad=89.3f pd=0.85u as=89.3f ps=0.85u w=0.47u l=0.16u
X5491 MOT12_P MOT12_N cml_tlatch_24.xmux.xp.S1 VSS sg13_lv_nmos ad=56.9f pd=0.74u as=56.9f ps=0.74u w=0.17u l=0.17u
X5492 cml_tlatch_92.xtail.S1 CKJ_N cml_tlatch_92.xmux.xn.S1 VSS sg13_lv_nmos ad=89.3f pd=0.85u as=89.3f ps=0.85u w=0.47u l=0.16u
X5493 cml_tlatch_72.xtail.S1 CKHB3_P cml_tlatch_72.xmux.xn.S1 VSS sg13_lv_nmos ad=89.3f pd=0.85u as=89.3f ps=0.85u w=0.47u l=0.16u
X5494 cml_tlatch_66.xtail.S1 CKB3_N cml_tlatch_66.xmux.xn.S1 VSS sg13_lv_nmos ad=89.3f pd=0.85u as=89.3f ps=0.85u w=0.47u l=0.16u
X5495 cml_tlatch_83.xmux.xp.S1 stub_bi_63.BOTN stub_bi_63.BOTP VSS sg13_lv_nmos ad=56.9f pd=0.74u as=56.9f ps=0.74u w=0.17u l=0.17u
X5496 cml_tlatch_0.OUTP cml_tlatch_0.OUTN cml_tlatch_0.xmux.xp.S1 VSS sg13_lv_nmos ad=56.9f pd=0.74u as=56.9f ps=0.74u w=0.17u l=0.17u
X5497 VSS POLN cml_tlatch_17.xtail.S1 VSS sg13_lv_nmos ad=2.7982p pd=17.14u as=1.5637p ps=8.61u w=8.23u l=0.13u
X5498 cml_tlatch_41.xmux.xp.S1 cml_tlatch_41.OUTP cml_tlatch_41.OUTN VSS sg13_lv_nmos ad=56.9f pd=0.74u as=56.9f ps=0.74u w=0.17u l=0.17u
X5499 VSS hs_to_clk_3.sg13_lv_nmos_2HGZLP_0.G VSS VSS sg13_lv_nmos ad=2.071p pd=11.28u as=0 ps=0 w=10.9u l=1.38u
X5500 cml_tlatch_71.xmux.xn.S1 cml_tlatch_44.INP cml_tlatch_71.OUTN VSS sg13_lv_nmos ad=63.19999f pd=0.74u as=63.19999f ps=0.74u w=0.26u l=0.38u
X5501 hs_to_clk_2.D2 POLN VSS VSS sg13_lv_nmos ad=1.9p pd=10.38u as=1.9p ps=10.38u w=10u l=0.13u
X5502 VDD CKHB0_N VSS rppd l=13.09u w=1u
X5503 cml_tlatch_57.xmux.xn.S1 cml_tlatch_58.OUTP A3_2_N VSS sg13_lv_nmos ad=63.19999f pd=0.74u as=63.19999f ps=0.74u w=0.26u l=0.38u
X5504 MOT24_N A3_8_P cml_tlatch_62.xmux.xn.S1 VSS sg13_lv_nmos ad=63.19999f pd=0.74u as=63.19999f ps=0.74u w=0.26u l=0.38u
X5505 stub_bi_38.BOTP B2_2_P cml_tlatch_46.xmux.xn.S1 VSS sg13_lv_nmos ad=63.19999f pd=0.74u as=63.19999f ps=0.74u w=0.26u l=0.38u
X5506 cml_tlatch_31.xmux.xp.S1 B0_2_N B0_2_P VSS sg13_lv_nmos ad=56.9f pd=0.74u as=56.9f ps=0.74u w=0.17u l=0.17u
X5507 cml_tlatch_33.OUTP cml_tlatch_33.OUTN cml_tlatch_33.xmux.xp.S1 VSS sg13_lv_nmos ad=56.9f pd=0.74u as=56.9f ps=0.74u w=0.17u l=0.17u
X5508 cml_tlatch_81.xmux.xp.S1 B2_8_P B2_8_N VSS sg13_lv_nmos ad=56.9f pd=0.74u as=56.9f ps=0.74u w=0.17u l=0.17u
X5509 A0_8_P A0_8_N cml_tlatch_9.xmux.xp.S1 VSS sg13_lv_nmos ad=56.9f pd=0.74u as=56.9f ps=0.74u w=0.17u l=0.17u
X5510 cml_tlatch_55.xmux.xn.S1 CKHA2_P cml_tlatch_55.xtail.S1 VSS sg13_lv_nmos ad=89.3f pd=0.85u as=89.3f ps=0.85u w=0.47u l=0.16u
X5511 MOT16_P A2_8_N cml_tlatch_52.xmux.xn.S1 VSS sg13_lv_nmos ad=63.19999f pd=0.74u as=63.19999f ps=0.74u w=0.26u l=0.38u
X5512 CKJ_P CK_P hs_to_clk_8.D2 VSS sg13_lv_nmos ad=0.228p pd=1.58u as=0.408p ps=3.08u w=1.2u l=0.2u
X5513 cml_tlatch_49.xmux.xp.S1 cml_tlatch_49.OUTP cml_tlatch_49.OUTN VSS sg13_lv_nmos ad=56.9f pd=0.74u as=56.9f ps=0.74u w=0.17u l=0.17u
X5514 cml_tlatch_73.xmux.xp.S1 MOT27_N MOT27_P VSS sg13_lv_nmos ad=56.9f pd=0.74u as=56.9f ps=0.74u w=0.17u l=0.17u
X5515 MOT17_P MOT17_N cml_tlatch_77.xmux.xp.S1 VSS sg13_lv_nmos ad=56.9f pd=0.74u as=56.9f ps=0.74u w=0.17u l=0.17u
X5516 A0_2_N cml_tlatch_38.OUTP cml_tlatch_34.xmux.xn.S1 VSS sg13_lv_nmos ad=63.19999f pd=0.74u as=63.19999f ps=0.74u w=0.26u l=0.38u
X5517 cml_tlatch_51.OUTP cml_tlatch_51.OUTN cml_tlatch_51.xmux.xp.S1 VSS sg13_lv_nmos ad=56.9f pd=0.74u as=56.9f ps=0.74u w=0.17u l=0.17u
X5518 cml_tlatch_72.xmux.xp.S1 MOT25_N MOT25_P VSS sg13_lv_nmos ad=56.9f pd=0.74u as=56.9f ps=0.74u w=0.17u l=0.17u
X5519 cml_tlatch_90.xtail.S1 CKB2_N cml_tlatch_90.xmux.xn.S1 VSS sg13_lv_nmos ad=89.3f pd=0.85u as=0.1598p ps=1.62u w=0.47u l=0.16u
X5520 B2_8_P B2_8_N cml_tlatch_81.xmux.xp.S1 VSS sg13_lv_nmos ad=56.9f pd=0.74u as=56.9f ps=0.74u w=0.17u l=0.17u
X5521 cml_tlatch_15.xtail.S1 CKHB0_N cml_tlatch_15.xmux.xp.S1 VSS sg13_lv_nmos ad=89.3f pd=0.85u as=89.3f ps=0.85u w=0.47u l=0.16u
X5522 cml_tlatch_41.xmux.xp.S1 cml_tlatch_41.OUTP cml_tlatch_41.OUTN VSS sg13_lv_nmos ad=56.9f pd=0.74u as=56.9f ps=0.74u w=0.17u l=0.17u
X5523 cml_tlatch_74.xmux.xn.S1 cml_tlatch_74.INN MOT29_P VSS sg13_lv_nmos ad=63.19999f pd=0.74u as=63.19999f ps=0.74u w=0.26u l=0.38u
X5524 cml_tlatch_57.xmux.xp.S1 A3_2_N A3_2_P VSS sg13_lv_nmos ad=56.9f pd=0.74u as=56.9f ps=0.74u w=0.17u l=0.17u
X5525 MOT11_P MOT11_N cml_tlatch_4.xmux.xp.S1 VSS sg13_lv_nmos ad=56.9f pd=0.74u as=56.9f ps=0.74u w=0.17u l=0.17u
X5526 MOT8_P MOT8_N cml_tlatch_42.xmux.xp.S1 VSS sg13_lv_nmos ad=56.9f pd=0.74u as=56.9f ps=0.74u w=0.17u l=0.17u
X5527 cml_tlatch_46.xmux.xp.S1 stub_bi_38.BOTP stub_bi_38.BOTN VSS sg13_lv_nmos ad=56.9f pd=0.74u as=56.9f ps=0.74u w=0.17u l=0.17u
X5528 cml_tlatch_82.xmux.xp.S1 stub_bi_62.BOTN stub_bi_62.BOTP VSS sg13_lv_nmos ad=0.1019p pd=1.34u as=56.9f ps=0.74u w=0.17u l=0.17u
X5529 cml_tlatch_18.xmux.xn.S1 CKA0_P cml_tlatch_18.xtail.S1 VSS sg13_lv_nmos ad=89.3f pd=0.85u as=89.3f ps=0.85u w=0.47u l=0.16u
X5530 cml_tlatch_36.xtail.S1 CKB1_P cml_tlatch_36.xmux.xp.S1 VSS sg13_lv_nmos ad=89.3f pd=0.85u as=89.3f ps=0.85u w=0.47u l=0.16u
X5531 cml_tlatch_83.xmux.xp.S1 stub_bi_63.BOTN stub_bi_63.BOTP VSS sg13_lv_nmos ad=56.9f pd=0.74u as=56.9f ps=0.74u w=0.17u l=0.17u
X5532 cml_tlatch_43.INP cml_tlatch_43.INN cml_tlatch_21.xmux.xp.S1 VSS sg13_lv_nmos ad=56.9f pd=0.74u as=56.9f ps=0.74u w=0.17u l=0.17u
X5533 stub_bi_55.BOTN stub_bi_55.BOTP cml_tlatch_90.xmux.xp.S1 VSS sg13_lv_nmos ad=56.9f pd=0.74u as=56.9f ps=0.74u w=0.17u l=0.17u
X5534 cml_tlatch_0.xmux.xp.S1 cml_tlatch_0.OUTP cml_tlatch_0.OUTN VSS sg13_lv_nmos ad=56.9f pd=0.74u as=56.9f ps=0.74u w=0.17u l=0.17u
X5535 MOT15_N MOT15_P cml_tlatch_6.xmux.xp.S1 VSS sg13_lv_nmos ad=56.9f pd=0.74u as=56.9f ps=0.74u w=0.17u l=0.17u
X5536 VSS POLN cml_tlatch_67.xtail.S1 VSS sg13_lv_nmos ad=1.5637p pd=8.61u as=1.5637p ps=8.61u w=8.23u l=0.13u
X5537 cml_tlatch_88.xtail.S1 CKB3_N cml_tlatch_88.xmux.xn.S1 VSS sg13_lv_nmos ad=89.3f pd=0.85u as=89.3f ps=0.85u w=0.47u l=0.16u
X5538 MOT22_P A2_2_N cml_tlatch_55.xmux.xn.S1 VSS sg13_lv_nmos ad=63.19999f pd=0.74u as=63.19999f ps=0.74u w=0.26u l=0.38u
X5539 cml_tlatch_80.xmux.xp.S1 MOT23_N MOT23_P VSS sg13_lv_nmos ad=56.9f pd=0.74u as=56.9f ps=0.74u w=0.17u l=0.17u
X5540 cml_tlatch_97.xmux.xn.S1 CKA1_N cml_tlatch_97.xtail.S1 VSS sg13_lv_nmos ad=0.1598p pd=1.62u as=89.3f ps=0.85u w=0.47u l=0.16u
X5541 MOT31_P MOT31_N cml_tlatch_75.xmux.xp.S1 VSS sg13_lv_nmos ad=56.9f pd=0.74u as=56.9f ps=0.74u w=0.17u l=0.17u
X5542 cml_tlatch_37.xmux.xp.S1 CKB1_N cml_tlatch_37.xtail.S1 VSS sg13_lv_nmos ad=89.3f pd=0.85u as=89.3f ps=0.85u w=0.47u l=0.16u
X5543 cml_tlatch_92.xmux.xp.S1 J4_P J4_N VSS sg13_lv_nmos ad=56.9f pd=0.74u as=56.9f ps=0.74u w=0.17u l=0.17u
X5544 GA3_P ENA1_N cml_gate2_4.xamp.xn.S1 VSS sg13_lv_nmos ad=0.1007p pd=0.91u as=0.1007p ps=0.91u w=0.53u l=0.13u
X5545 cml_tlatch_24.INN cml_tlatch_24.INP cml_tlatch_97.xmux.xp.S1 VSS sg13_lv_nmos ad=56.9f pd=0.74u as=56.9f ps=0.74u w=0.17u l=0.17u
X5546 cml_tlatch_61.xmux.xp.S1 CKA2_N cml_tlatch_61.xtail.S1 VSS sg13_lv_nmos ad=89.3f pd=0.85u as=89.3f ps=0.85u w=0.47u l=0.16u
X5547 MOT27_P MOT27_N cml_tlatch_73.xmux.xp.S1 VSS sg13_lv_nmos ad=56.9f pd=0.74u as=56.9f ps=0.74u w=0.17u l=0.17u
X5548 cml_tlatch_6.xmux.xp.S1 MOT15_N MOT15_P VSS sg13_lv_nmos ad=56.9f pd=0.74u as=56.9f ps=0.74u w=0.17u l=0.17u
X5549 cml_tlatch_23.OUTN cml_tlatch_0.OUTP cml_tlatch_23.xmux.xn.S1 VSS sg13_lv_nmos ad=63.19999f pd=0.74u as=0.1082p ps=1.34u w=0.26u l=0.38u
X5550 GA0_P CKB0_N cml_gate2_3.xrtail.R1 VSS sg13_lv_nmos ad=0.1802p pd=1.74u as=0.1007p ps=0.91u w=0.53u l=0.13u
X5551 cml_tlatch_25.xmux.xn.S1 CKHA1_P cml_tlatch_25.xtail.S1 VSS sg13_lv_nmos ad=89.3f pd=0.85u as=89.3f ps=0.85u w=0.47u l=0.16u
X5552 cml_tlatch_71.xmux.xp.S1 cml_tlatch_71.OUTP cml_tlatch_71.OUTN VSS sg13_lv_nmos ad=56.9f pd=0.74u as=56.9f ps=0.74u w=0.17u l=0.17u
X5553 cml_tlatch_24.xmux.xn.S1 CKHA1_P cml_tlatch_24.xtail.S1 VSS sg13_lv_nmos ad=89.3f pd=0.85u as=89.3f ps=0.85u w=0.47u l=0.16u
X5554 cml_tlatch_22.xtail.S1 CKA1_P cml_tlatch_22.xmux.xn.S1 VSS sg13_lv_nmos ad=89.3f pd=0.85u as=89.3f ps=0.85u w=0.47u l=0.16u
X5555 MOT31_N MOT31_P cml_tlatch_75.xmux.xp.S1 VSS sg13_lv_nmos ad=56.9f pd=0.74u as=56.9f ps=0.74u w=0.17u l=0.17u
X5556 MOT3_N MOT3_P cml_tlatch_15.xmux.xp.S1 VSS sg13_lv_nmos ad=56.9f pd=0.74u as=56.9f ps=0.74u w=0.17u l=0.17u
X5557 ENB_N J2_P cml_gate2_8.xamp.xn.S1 VSS sg13_lv_nmos ad=0.1007p pd=0.91u as=0.1007p ps=0.91u w=0.53u l=0.13u
X5558 VSS POLN cml_tlatch_80.xtail.S1 VSS sg13_lv_nmos ad=1.5637p pd=8.61u as=1.5637p ps=8.61u w=8.23u l=0.13u
X5559 cml_tlatch_1.xmux.xn.S1 cml_tlatch_2.OUTP B0_8_N VSS sg13_lv_nmos ad=0.1082p pd=1.34u as=63.19999f ps=0.74u w=0.26u l=0.38u
X5560 cml_tlatch_0.OUTN cml_tlatch_99.OUTP cml_tlatch_0.xmux.xn.S1 VSS sg13_lv_nmos ad=63.19999f pd=0.74u as=63.19999f ps=0.74u w=0.26u l=0.38u
X5561 cml_tlatch_29.xmux.xp.S1 MOT6_N MOT6_P VSS sg13_lv_nmos ad=56.9f pd=0.74u as=56.9f ps=0.74u w=0.17u l=0.17u
X5562 cml_tlatch_97.xtail.S1 CKA1_P cml_tlatch_97.xmux.xp.S1 VSS sg13_lv_nmos ad=89.3f pd=0.85u as=89.3f ps=0.85u w=0.47u l=0.16u
X5563 cml_tlatch_60.xmux.xp.S1 A2_2_P A2_2_N VSS sg13_lv_nmos ad=56.9f pd=0.74u as=56.9f ps=0.74u w=0.17u l=0.17u
X5564 cml_tlatch_26.xmux.xp.S1 MOT0_P MOT0_N VSS sg13_lv_nmos ad=56.9f pd=0.74u as=56.9f ps=0.74u w=0.17u l=0.17u
X5565 A3_8_N A3_8_P cml_tlatch_68.xmux.xp.S1 VSS sg13_lv_nmos ad=56.9f pd=0.74u as=56.9f ps=0.74u w=0.17u l=0.17u
X5566 cml_tlatch_57.xtail.S1 CKA3_P cml_tlatch_57.xmux.xp.S1 VSS sg13_lv_nmos ad=89.3f pd=0.85u as=89.3f ps=0.85u w=0.47u l=0.16u
X5567 cml_tlatch_81.xtail.S1 CKB2_P cml_tlatch_81.xmux.xp.S1 VSS sg13_lv_nmos ad=89.3f pd=0.85u as=89.3f ps=0.85u w=0.47u l=0.16u
X5568 cml_tlatch_30.OUTN cml_tlatch_30.OUTP cml_tlatch_30.xmux.xp.S1 VSS sg13_lv_nmos ad=56.9f pd=0.74u as=56.9f ps=0.74u w=0.17u l=0.17u
X5569 cml_tlatch_16.xmux.xp.S1 MOT5_P MOT5_N VSS sg13_lv_nmos ad=56.9f pd=0.74u as=56.9f ps=0.74u w=0.17u l=0.17u
X5570 cml_tlatch_26.xmux.xn.S1 CKHA0_P cml_tlatch_26.xtail.S1 VSS sg13_lv_nmos ad=89.3f pd=0.85u as=89.3f ps=0.85u w=0.47u l=0.16u
X5571 B1_8_P stub_bi_15.BOTP cml_tlatch_10.xmux.xn.S1 VSS sg13_lv_nmos ad=63.19999f pd=0.74u as=63.19999f ps=0.74u w=0.26u l=0.38u
X5572 cml_tlatch_66.xtail.S1 CKB3_P cml_tlatch_66.xmux.xp.S1 VSS sg13_lv_nmos ad=89.3f pd=0.85u as=89.3f ps=0.85u w=0.47u l=0.16u
X5573 cml_tlatch_36.xmux.xp.S1 B1_2_N B1_2_P VSS sg13_lv_nmos ad=56.9f pd=0.74u as=56.9f ps=0.74u w=0.17u l=0.17u
X5574 cml_tlatch_33.xmux.xp.S1 CKA0_N cml_tlatch_33.xtail.S1 VSS sg13_lv_nmos ad=89.3f pd=0.85u as=89.3f ps=0.85u w=0.47u l=0.16u
X5575 VSS POLN cml_tlatch_14.xtail.S1 VSS sg13_lv_nmos ad=1.5637p pd=8.61u as=1.5637p ps=8.61u w=8.23u l=0.13u
X5576 cml_tlatch_18.OUTP cml_tlatch_18.OUTN cml_tlatch_18.xmux.xp.S1 VSS sg13_lv_nmos ad=56.9f pd=0.74u as=56.9f ps=0.74u w=0.17u l=0.17u
X5577 cml_drv_2.xrtail.R1 ENB_P ENB0_N VSS sg13_lv_nmos ad=56.2f pd=0.74u as=56.2f ps=0.74u w=0.16u l=0.19u
X5578 MOT20_N MOT20_P cml_tlatch_54.xmux.xp.S1 VSS sg13_lv_nmos ad=56.9f pd=0.74u as=56.9f ps=0.74u w=0.17u l=0.17u
X5579 cml_tlatch_0.xtail.S1 CKA0_P cml_tlatch_0.xmux.xn.S1 VSS sg13_lv_nmos ad=89.3f pd=0.85u as=89.3f ps=0.85u w=0.47u l=0.16u
X5580 cml_tlatch_41.xmux.xn.S1 D1_P cml_tlatch_41.OUTN VSS sg13_lv_nmos ad=63.19999f pd=0.74u as=63.19999f ps=0.74u w=0.26u l=0.38u
X5581 cml_tlatch_70.xmux.xp.S1 cml_tlatch_63.INN cml_tlatch_63.INP VSS sg13_lv_nmos ad=56.9f pd=0.74u as=56.9f ps=0.74u w=0.17u l=0.17u
X5582 cml_tlatch_63.INP cml_tlatch_71.OUTN cml_tlatch_70.xmux.xn.S1 VSS sg13_lv_nmos ad=63.19999f pd=0.74u as=63.19999f ps=0.74u w=0.26u l=0.38u
X5583 cml_gate2_4.xamp.xn.S1 CKB3_P cml_gate2_4.xrtail.R1 VSS sg13_lv_nmos ad=0.1802p pd=1.74u as=0.1007p ps=0.91u w=0.53u l=0.13u
X5584 B0_2_N B0_2_P cml_tlatch_31.xmux.xp.S1 VSS sg13_lv_nmos ad=56.9f pd=0.74u as=56.9f ps=0.74u w=0.17u l=0.17u
X5585 cml_tlatch_96.xtail.S1 CKB1_P cml_tlatch_96.xmux.xp.S1 VSS sg13_lv_nmos ad=89.3f pd=0.85u as=89.3f ps=0.85u w=0.47u l=0.16u
X5586 cml_tlatch_56.OUTP cml_tlatch_56.OUTN cml_tlatch_56.xmux.xp.S1 VSS sg13_lv_nmos ad=56.9f pd=0.74u as=56.9f ps=0.74u w=0.17u l=0.17u
X5587 MOT17_P B2_8_N cml_tlatch_77.xmux.xn.S1 VSS sg13_lv_nmos ad=0.1082p pd=1.34u as=63.19999f ps=0.74u w=0.26u l=0.38u
X5588 A0_8_P A0_8_N cml_tlatch_9.xmux.xp.S1 VSS sg13_lv_nmos ad=56.9f pd=0.74u as=56.9f ps=0.74u w=0.17u l=0.17u
X5589 cml_tlatch_65.OUTP cml_tlatch_73.INN cml_tlatch_65.xmux.xn.S1 VSS sg13_lv_nmos ad=63.19999f pd=0.74u as=63.19999f ps=0.74u w=0.26u l=0.38u
X5590 stub_bi_17.BOTN stub_bi_17.BOTP cml_tlatch_13.xmux.xp.S1 VSS sg13_lv_nmos ad=56.9f pd=0.74u as=0.1019p ps=1.34u w=0.17u l=0.17u
X5591 VSS POLN cml_tlatch_36.xtail.S1 VSS sg13_lv_nmos ad=2.7982p pd=17.14u as=1.5637p ps=8.61u w=8.23u l=0.13u
X5592 cml_tlatch_12.xtail.S1 CKB1_P cml_tlatch_12.xmux.xp.S1 VSS sg13_lv_nmos ad=89.3f pd=0.85u as=0.1598p ps=1.62u w=0.47u l=0.16u
X5593 cml_tlatch_87.xmux.xn.S1 cml_tlatch_87.INP cml_tlatch_87.OUTN VSS sg13_lv_nmos ad=63.19999f pd=0.74u as=63.19999f ps=0.74u w=0.26u l=0.38u
X5594 MOT28_N cml_tlatch_44.INP cml_tlatch_44.xmux.xn.S1 VSS sg13_lv_nmos ad=63.19999f pd=0.74u as=63.19999f ps=0.74u w=0.26u l=0.38u
X5595 MOT10_N MOT10_P cml_tlatch_43.xmux.xp.S1 VSS sg13_lv_nmos ad=56.9f pd=0.74u as=56.9f ps=0.74u w=0.17u l=0.17u
X5596 cml_tlatch_27.xtail.S1 CKHA0_N cml_tlatch_27.xmux.xp.S1 VSS sg13_lv_nmos ad=89.3f pd=0.85u as=89.3f ps=0.85u w=0.47u l=0.16u
X5597 cml_tlatch_62.xtail.S1 CKHA3_N cml_tlatch_62.xmux.xp.S1 VSS sg13_lv_nmos ad=0.1598p pd=1.62u as=89.3f ps=0.85u w=0.47u l=0.16u
X5598 cml_tlatch_73.xmux.xn.S1 cml_tlatch_73.INP MOT27_N VSS sg13_lv_nmos ad=63.19999f pd=0.74u as=63.19999f ps=0.74u w=0.26u l=0.38u
X5599 cml_tlatch_18.xmux.xp.S1 cml_tlatch_18.OUTP cml_tlatch_18.OUTN VSS sg13_lv_nmos ad=56.9f pd=0.74u as=56.9f ps=0.74u w=0.17u l=0.17u
X5600 cml_tlatch_69.xmux.xp.S1 cml_tlatch_69.OUTN cml_tlatch_69.OUTP VSS sg13_lv_nmos ad=56.9f pd=0.74u as=56.9f ps=0.74u w=0.17u l=0.17u
X5601 cml_tlatch_73.xmux.xn.S1 cml_tlatch_73.INP MOT27_N VSS sg13_lv_nmos ad=63.19999f pd=0.74u as=63.19999f ps=0.74u w=0.26u l=0.38u
X5602 cml_tlatch_84.xtail.S1 POLN VSS VSS sg13_lv_nmos ad=1.5637p pd=8.61u as=1.5637p ps=8.61u w=8.23u l=0.13u
X5603 cml_tlatch_88.xmux.xp.S1 cml_tlatch_74.INP cml_tlatch_74.INN VSS sg13_lv_nmos ad=56.9f pd=0.74u as=56.9f ps=0.74u w=0.17u l=0.17u
X5604 cml_tlatch_32.OUTN VDD VSS rppd l=5.17u w=1u
X5605 cml_tlatch_6.xtail.S1 CKHB1_P cml_tlatch_6.xmux.xn.S1 VSS sg13_lv_nmos ad=0.1598p pd=1.62u as=89.3f ps=0.85u w=0.47u l=0.16u
X5606 J4_P J4_N cml_tlatch_92.xmux.xp.S1 VSS sg13_lv_nmos ad=56.9f pd=0.74u as=56.9f ps=0.74u w=0.17u l=0.17u
X5607 cml_tlatch_32.xmux.xp.S1 cml_tlatch_32.OUTN cml_tlatch_32.OUTP VSS sg13_lv_nmos ad=56.9f pd=0.74u as=56.9f ps=0.74u w=0.17u l=0.17u
X5608 cml_tlatch_41.xmux.xn.S1 CKA1_P cml_tlatch_41.xtail.S1 VSS sg13_lv_nmos ad=89.3f pd=0.85u as=89.3f ps=0.85u w=0.47u l=0.16u
X5609 MOT12_P cml_tlatch_24.INN cml_tlatch_24.xmux.xn.S1 VSS sg13_lv_nmos ad=63.19999f pd=0.74u as=63.19999f ps=0.74u w=0.26u l=0.38u
X5610 VDD GA2_P VSS rppd l=7.42u w=1u
X5611 cml_tlatch_98.OUTN cml_tlatch_98.OUTP cml_tlatch_98.xmux.xp.S1 VSS sg13_lv_nmos ad=56.9f pd=0.74u as=56.9f ps=0.74u w=0.17u l=0.17u
X5612 cml_tlatch_95.xmux.xp.S1 J1_N J1_P VSS sg13_lv_nmos ad=56.9f pd=0.74u as=56.9f ps=0.74u w=0.17u l=0.17u
X5613 cml_tlatch_78.xtail.S1 CKHB2_P cml_tlatch_78.xmux.xn.S1 VSS sg13_lv_nmos ad=89.3f pd=0.85u as=89.3f ps=0.85u w=0.47u l=0.16u
X5614 MOT1_N MOT1_P cml_tlatch_14.xmux.xp.S1 VSS sg13_lv_nmos ad=56.9f pd=0.74u as=56.9f ps=0.74u w=0.17u l=0.17u
X5615 cml_tlatch_89.xmux.xn.S1 cml_tlatch_56.OUTN cml_tlatch_44.INP VSS sg13_lv_nmos ad=63.19999f pd=0.74u as=63.19999f ps=0.74u w=0.26u l=0.38u
X5616 cml_tlatch_42.xtail.S1 CKHA1_N cml_tlatch_42.xmux.xp.S1 VSS sg13_lv_nmos ad=89.3f pd=0.85u as=89.3f ps=0.85u w=0.47u l=0.16u
X5617 MOT22_P MOT22_N cml_tlatch_55.xmux.xp.S1 VSS sg13_lv_nmos ad=56.9f pd=0.74u as=0.1019p ps=1.34u w=0.17u l=0.17u
X5618 cml_tlatch_61.xmux.xn.S1 CKA2_P cml_tlatch_61.xtail.S1 VSS sg13_lv_nmos ad=0.1598p pd=1.62u as=89.3f ps=0.85u w=0.47u l=0.16u
X5619 cml_tlatch_32.xmux.xn.S1 D0_N cml_tlatch_32.OUTP VSS sg13_lv_nmos ad=63.19999f pd=0.74u as=0.1082p ps=1.34u w=0.26u l=0.38u
X5620 cml_tlatch_91.xmux.xp.S1 CKA2_P cml_tlatch_91.xtail.S1 VSS sg13_lv_nmos ad=89.3f pd=0.85u as=89.3f ps=0.85u w=0.47u l=0.16u
X5621 cml_tlatch_9.xtail.S1 CKA0_N cml_tlatch_9.xmux.xn.S1 VSS sg13_lv_nmos ad=89.3f pd=0.85u as=89.3f ps=0.85u w=0.47u l=0.16u
X5622 cml_tlatch_67.xtail.S1 CKB3_N cml_tlatch_67.xmux.xp.S1 VSS sg13_lv_nmos ad=89.3f pd=0.85u as=89.3f ps=0.85u w=0.47u l=0.16u
X5623 cml_tlatch_20.OUTP cml_tlatch_20.OUTN cml_tlatch_20.xmux.xp.S1 VSS sg13_lv_nmos ad=56.9f pd=0.74u as=56.9f ps=0.74u w=0.17u l=0.17u
X5624 cml_tlatch_85.xtail.S1 CKA2_N cml_tlatch_85.xmux.xn.S1 VSS sg13_lv_nmos ad=89.3f pd=0.85u as=89.3f ps=0.85u w=0.47u l=0.16u
X5625 VSS POLN cml_tlatch_77.xtail.S1 VSS sg13_lv_nmos ad=1.5637p pd=8.61u as=1.5637p ps=8.61u w=8.23u l=0.13u
X5626 stub_bi_17.BOTN stub_bi_17.BOTP cml_tlatch_13.xmux.xp.S1 VSS sg13_lv_nmos ad=56.9f pd=0.74u as=56.9f ps=0.74u w=0.17u l=0.17u
X5627 cml_gate2_1.xamp.xn.S1 ENB1_P GB0_N VSS sg13_lv_nmos ad=0.1007p pd=0.91u as=0.1802p ps=1.74u w=0.53u l=0.13u
X5628 cml_tlatch_64.xmux.xp.S1 B3_8_P B3_8_N VSS sg13_lv_nmos ad=56.9f pd=0.74u as=56.9f ps=0.74u w=0.17u l=0.17u
X5629 cml_tlatch_63.INN cml_tlatch_63.INP cml_tlatch_70.xmux.xp.S1 VSS sg13_lv_nmos ad=56.9f pd=0.74u as=56.9f ps=0.74u w=0.17u l=0.17u
X5630 VSS hs_to_clk_6.sg13_lv_nmos_2HGZLP_0.G VSS VSS sg13_lv_nmos ad=2.071p pd=11.28u as=0 ps=0 w=10.9u l=1.38u
X5631 A2_2_P A2_2_N cml_tlatch_60.xmux.xp.S1 VSS sg13_lv_nmos ad=56.9f pd=0.74u as=56.9f ps=0.74u w=0.17u l=0.17u
X5632 cml_tlatch_3.xmux.xn.S1 B1_8_P MOT9_N VSS sg13_lv_nmos ad=63.19999f pd=0.74u as=63.19999f ps=0.74u w=0.26u l=0.38u
X5633 MOT18_P MOT18_N cml_tlatch_53.xmux.xp.S1 VSS sg13_lv_nmos ad=56.9f pd=0.74u as=56.9f ps=0.74u w=0.17u l=0.17u
X5634 cml_tlatch_91.xmux.xn.S1 cml_tlatch_91.INP cml_tlatch_91.OUTN VSS sg13_lv_nmos ad=63.19999f pd=0.74u as=63.19999f ps=0.74u w=0.26u l=0.38u
X5635 cml_tlatch_2.xmux.xp.S1 cml_tlatch_2.OUTN cml_tlatch_2.OUTP VSS sg13_lv_nmos ad=56.9f pd=0.74u as=56.9f ps=0.74u w=0.17u l=0.17u
X5636 cml_tlatch_38.xmux.xn.S1 CKA0_P cml_tlatch_38.xtail.S1 VSS sg13_lv_nmos ad=89.3f pd=0.85u as=89.3f ps=0.85u w=0.47u l=0.16u
X5637 cml_tlatch_4.xmux.xp.S1 MOT11_P MOT11_N VSS sg13_lv_nmos ad=56.9f pd=0.74u as=56.9f ps=0.74u w=0.17u l=0.17u
X5638 cml_tlatch_24.xmux.xp.S1 MOT12_P MOT12_N VSS sg13_lv_nmos ad=56.9f pd=0.74u as=56.9f ps=0.74u w=0.17u l=0.17u
X5639 cml_tlatch_21.xmux.xp.S1 cml_tlatch_43.INP cml_tlatch_43.INN VSS sg13_lv_nmos ad=56.9f pd=0.74u as=56.9f ps=0.74u w=0.17u l=0.17u
X5640 cml_tlatch_4.INN cml_tlatch_4.INP cml_tlatch_12.xmux.xp.S1 VSS sg13_lv_nmos ad=56.9f pd=0.74u as=56.9f ps=0.74u w=0.17u l=0.17u
X5641 cml_tlatch_36.xmux.xp.S1 CKB1_P cml_tlatch_36.xtail.S1 VSS sg13_lv_nmos ad=89.3f pd=0.85u as=89.3f ps=0.85u w=0.47u l=0.16u
X5642 J2_P J2_N cml_tlatch_94.xmux.xp.S1 VSS sg13_lv_nmos ad=56.9f pd=0.74u as=56.9f ps=0.74u w=0.17u l=0.17u
X5643 cml_tlatch_4.INP cml_tlatch_4.INN cml_tlatch_12.xmux.xp.S1 VSS sg13_lv_nmos ad=56.9f pd=0.74u as=56.9f ps=0.74u w=0.17u l=0.17u
X5644 cml_tlatch_63.xmux.xp.S1 MOT26_P MOT26_N VSS sg13_lv_nmos ad=56.9f pd=0.74u as=56.9f ps=0.74u w=0.17u l=0.17u
X5645 cml_tlatch_81.xtail.S1 CKB2_N cml_tlatch_81.xmux.xn.S1 VSS sg13_lv_nmos ad=89.3f pd=0.85u as=89.3f ps=0.85u w=0.47u l=0.16u
X5646 cml_tlatch_8.xtail.S1 CKB0_N cml_tlatch_8.xmux.xp.S1 VSS sg13_lv_nmos ad=89.3f pd=0.85u as=89.3f ps=0.85u w=0.47u l=0.16u
X5647 cml_tlatch_23.OUTN cml_tlatch_23.OUTP cml_tlatch_23.xmux.xp.S1 VSS sg13_lv_nmos ad=56.9f pd=0.74u as=56.9f ps=0.74u w=0.17u l=0.17u
X5648 cml_tlatch_26.xmux.xp.S1 MOT0_P MOT0_N VSS sg13_lv_nmos ad=56.9f pd=0.74u as=56.9f ps=0.74u w=0.17u l=0.17u
X5649 cml_tlatch_91.xmux.xn.S1 cml_tlatch_91.INP cml_tlatch_91.OUTN VSS sg13_lv_nmos ad=63.19999f pd=0.74u as=63.19999f ps=0.74u w=0.26u l=0.38u
X5650 cml_tlatch_65.xmux.xn.S1 CKB3_P cml_tlatch_65.xtail.S1 VSS sg13_lv_nmos ad=89.3f pd=0.85u as=89.3f ps=0.85u w=0.47u l=0.16u
X5651 MOT25_N B3_8_P cml_tlatch_72.xmux.xn.S1 VSS sg13_lv_nmos ad=63.19999f pd=0.74u as=63.19999f ps=0.74u w=0.26u l=0.38u
X5652 cml_tlatch_64.xmux.xp.S1 B3_8_P B3_8_N VSS sg13_lv_nmos ad=0.1019p pd=1.34u as=56.9f ps=0.74u w=0.17u l=0.17u
X5653 cml_tlatch_49.xmux.xp.S1 cml_tlatch_49.OUTN cml_tlatch_49.OUTP VSS sg13_lv_nmos ad=56.9f pd=0.74u as=56.9f ps=0.74u w=0.17u l=0.17u
X5654 cml_tlatch_23.xtail.S1 CKA0_P cml_tlatch_23.xmux.xp.S1 VSS sg13_lv_nmos ad=89.3f pd=0.85u as=89.3f ps=0.85u w=0.47u l=0.16u
X5655 cml_tlatch_67.OUTP cml_tlatch_67.OUTN cml_tlatch_67.xmux.xp.S1 VSS sg13_lv_nmos ad=56.9f pd=0.74u as=56.9f ps=0.74u w=0.17u l=0.17u
X5656 cml_drvb_7.xrtail.R2 VSS VSS rppd l=2.72u w=1u
X5657 cml_tlatch_93.xmux.xp.S1 CKJ_N cml_tlatch_93.xtail.S1 VSS sg13_lv_nmos ad=89.3f pd=0.85u as=89.3f ps=0.85u w=0.47u l=0.16u
X5658 cml_tlatch_68.xmux.xp.S1 A3_8_N A3_8_P VSS sg13_lv_nmos ad=56.9f pd=0.74u as=56.9f ps=0.74u w=0.17u l=0.17u
X5659 cml_tlatch_47.xmux.xn.S1 stub_bi_43.BOTN B2_2_N VSS sg13_lv_nmos ad=0.1082p pd=1.34u as=63.19999f ps=0.74u w=0.26u l=0.38u
X5660 cml_tlatch_23.OUTP cml_tlatch_0.OUTN cml_tlatch_23.xmux.xn.S1 VSS sg13_lv_nmos ad=63.19999f pd=0.74u as=63.19999f ps=0.74u w=0.26u l=0.38u
X5661 cml_tlatch_58.xmux.xp.S1 cml_tlatch_58.OUTN cml_tlatch_58.OUTP VSS sg13_lv_nmos ad=56.9f pd=0.74u as=56.9f ps=0.74u w=0.17u l=0.17u
X5662 MOT22_P MOT22_N cml_tlatch_55.xmux.xp.S1 VSS sg13_lv_nmos ad=56.9f pd=0.74u as=56.9f ps=0.74u w=0.17u l=0.17u
X5663 cml_tlatch_21.xtail.S1 CKA1_N cml_tlatch_21.xmux.xn.S1 VSS sg13_lv_nmos ad=89.3f pd=0.85u as=89.3f ps=0.85u w=0.47u l=0.16u
X5664 MOT13_P VDD VSS rppd l=5.17u w=1u
X5665 cml_tlatch_78.xmux.xp.S1 CKHB2_N cml_tlatch_78.xtail.S1 VSS sg13_lv_nmos ad=0.1598p pd=1.62u as=89.3f ps=0.85u w=0.47u l=0.16u
X5666 cml_tlatch_38.OUTN cml_tlatch_38.OUTP cml_tlatch_38.xmux.xp.S1 VSS sg13_lv_nmos ad=56.9f pd=0.74u as=56.9f ps=0.74u w=0.17u l=0.17u
X5667 B1_8_N B1_8_P cml_tlatch_10.xmux.xp.S1 VSS sg13_lv_nmos ad=56.9f pd=0.74u as=56.9f ps=0.74u w=0.17u l=0.17u
X5668 cml_tlatch_48.xmux.xn.S1 D2_N stub_bi_43.BOTN VSS sg13_lv_nmos ad=63.19999f pd=0.74u as=63.19999f ps=0.74u w=0.26u l=0.38u
X5669 cml_tlatch_16.xtail.S1 CKHB0_P cml_tlatch_16.xmux.xn.S1 VSS sg13_lv_nmos ad=89.3f pd=0.85u as=89.3f ps=0.85u w=0.47u l=0.16u
X5670 cml_tlatch_87.INN cml_tlatch_87.INP cml_tlatch_76.xmux.xp.S1 VSS sg13_lv_nmos ad=56.9f pd=0.74u as=56.9f ps=0.74u w=0.17u l=0.17u
X5671 cml_tlatch_73.xmux.xp.S1 MOT27_P MOT27_N VSS sg13_lv_nmos ad=56.9f pd=0.74u as=56.9f ps=0.74u w=0.17u l=0.17u
X5672 cml_tlatch_84.xmux.xp.S1 stub_bi_49.BOTN stub_bi_49.BOTP VSS sg13_lv_nmos ad=56.9f pd=0.74u as=56.9f ps=0.74u w=0.17u l=0.17u
X5673 cml_tlatch_49.xmux.xp.S1 cml_tlatch_49.OUTN cml_tlatch_49.OUTP VSS sg13_lv_nmos ad=0.1019p pd=1.34u as=56.9f ps=0.74u w=0.17u l=0.17u
X5674 cml_tlatch_19.xtail.S1 POLN VSS VSS sg13_lv_nmos ad=1.5637p pd=8.61u as=2.7982p ps=17.14u w=8.23u l=0.13u
X5675 cml_gate2_6.xamp.xn.S1 ENB0_N GB3_P VSS sg13_lv_nmos ad=0.1007p pd=0.91u as=0.1802p ps=1.74u w=0.53u l=0.13u
X5676 cml_tlatch_27.xmux.xp.S1 MOT2_N MOT2_P VSS sg13_lv_nmos ad=56.9f pd=0.74u as=56.9f ps=0.74u w=0.17u l=0.17u
X5677 MOT5_N cml_tlatch_98.OUTP cml_tlatch_16.xmux.xn.S1 VSS sg13_lv_nmos ad=63.19999f pd=0.74u as=63.19999f ps=0.74u w=0.26u l=0.38u
X5678 J4_P J4_N cml_tlatch_92.xmux.xp.S1 VSS sg13_lv_nmos ad=56.9f pd=0.74u as=56.9f ps=0.74u w=0.17u l=0.17u
X5679 cml_tlatch_3.xtail.S1 CKHB1_P cml_tlatch_3.xmux.xn.S1 VSS sg13_lv_nmos ad=0.1598p pd=1.62u as=89.3f ps=0.85u w=0.47u l=0.16u
X5680 cml_tlatch_12.xtail.S1 CKB1_N cml_tlatch_12.xmux.xn.S1 VSS sg13_lv_nmos ad=89.3f pd=0.85u as=89.3f ps=0.85u w=0.47u l=0.16u
X5681 GA3_N ENA1_P cml_gate2_4.xamp.xn.S1 VSS sg13_lv_nmos ad=0.1007p pd=0.91u as=0.1007p ps=0.91u w=0.53u l=0.13u
X5682 stub_bi_29.BOTN stub_bi_29.BOTP cml_tlatch_35.xmux.xp.S1 VSS sg13_lv_nmos ad=56.9f pd=0.74u as=56.9f ps=0.74u w=0.17u l=0.17u
X5683 cml_tlatch_2.OUTN cml_tlatch_2.OUTP cml_tlatch_2.xmux.xp.S1 VSS sg13_lv_nmos ad=56.9f pd=0.74u as=0.1019p ps=1.34u w=0.17u l=0.17u
X5684 cml_tlatch_41.OUTP cml_tlatch_41.OUTN cml_tlatch_41.xmux.xp.S1 VSS sg13_lv_nmos ad=56.9f pd=0.74u as=56.9f ps=0.74u w=0.17u l=0.17u
X5685 cml_tlatch_60.xtail.S1 CKA2_N cml_tlatch_60.xmux.xn.S1 VSS sg13_lv_nmos ad=89.3f pd=0.85u as=89.3f ps=0.85u w=0.47u l=0.16u
X5686 cml_tlatch_80.xmux.xn.S1 CKHB2_P cml_tlatch_80.xtail.S1 VSS sg13_lv_nmos ad=89.3f pd=0.85u as=89.3f ps=0.85u w=0.47u l=0.16u
X5687 cml_tlatch_26.xtail.S1 CKHA0_P cml_tlatch_26.xmux.xn.S1 VSS sg13_lv_nmos ad=89.3f pd=0.85u as=89.3f ps=0.85u w=0.47u l=0.16u
X5688 cml_tlatch_91.OUTN cml_tlatch_91.OUTP cml_tlatch_91.xmux.xp.S1 VSS sg13_lv_nmos ad=56.9f pd=0.74u as=56.9f ps=0.74u w=0.17u l=0.17u
X5689 cml_drv_0.xrtail.R1 ENB_P ENB1_N VSS sg13_lv_nmos ad=56.2f pd=0.74u as=56.2f ps=0.74u w=0.16u l=0.19u
X5690 cml_tlatch_56.OUTP A3_2_N cml_tlatch_56.xmux.xn.S1 VSS sg13_lv_nmos ad=63.19999f pd=0.74u as=0.1082p ps=1.34u w=0.26u l=0.38u
X5691 cml_tlatch_32.xmux.xp.S1 cml_tlatch_32.OUTN cml_tlatch_32.OUTP VSS sg13_lv_nmos ad=56.9f pd=0.74u as=56.9f ps=0.74u w=0.17u l=0.17u
X5692 cml_tlatch_54.xmux.xp.S1 MOT20_N MOT20_P VSS sg13_lv_nmos ad=56.9f pd=0.74u as=56.9f ps=0.74u w=0.17u l=0.17u
X5693 cml_tlatch_78.xmux.xp.S1 MOT19_N MOT19_P VSS sg13_lv_nmos ad=56.9f pd=0.74u as=56.9f ps=0.74u w=0.17u l=0.17u
X5694 VSS POLN cml_tlatch_79.xtail.S1 VSS sg13_lv_nmos ad=2.7982p pd=17.14u as=1.5637p ps=8.61u w=8.23u l=0.13u
X5695 MOT13_N MOT13_P cml_tlatch_5.xmux.xp.S1 VSS sg13_lv_nmos ad=56.9f pd=0.74u as=56.9f ps=0.74u w=0.17u l=0.17u
X5696 cml_tlatch_61.OUTN cml_tlatch_61.OUTP cml_tlatch_61.xmux.xp.S1 VSS sg13_lv_nmos ad=56.9f pd=0.74u as=56.9f ps=0.74u w=0.17u l=0.17u
X5697 cml_tlatch_95.xmux.xp.S1 J1_N J1_P VSS sg13_lv_nmos ad=56.9f pd=0.74u as=56.9f ps=0.74u w=0.17u l=0.17u
X5698 cml_tlatch_97.INN A1_2_P cml_tlatch_39.xmux.xn.S1 VSS sg13_lv_nmos ad=63.19999f pd=0.74u as=63.19999f ps=0.74u w=0.26u l=0.38u
X5699 cml_tlatch_48.xmux.xp.S1 stub_bi_43.BOTN stub_bi_43.BOTP VSS sg13_lv_nmos ad=56.9f pd=0.74u as=56.9f ps=0.74u w=0.17u l=0.17u
X5700 cml_tlatch_11.xmux.xp.S1 CKB1_N cml_tlatch_11.xtail.S1 VSS sg13_lv_nmos ad=89.3f pd=0.85u as=89.3f ps=0.85u w=0.47u l=0.16u
X5701 cml_tlatch_47.xtail.S1 CKB2_N cml_tlatch_47.xmux.xn.S1 VSS sg13_lv_nmos ad=89.3f pd=0.85u as=89.3f ps=0.85u w=0.47u l=0.16u
X5702 B3_2_N VDD VSS rppd l=5.17u w=1u
X5703 cml_tlatch_97.xtail.S1 CKA1_N cml_tlatch_97.xmux.xn.S1 VSS sg13_lv_nmos ad=89.3f pd=0.85u as=89.3f ps=0.85u w=0.47u l=0.16u
X5704 cml_tlatch_86.xmux.xp.S1 CKA2_N cml_tlatch_86.xtail.S1 VSS sg13_lv_nmos ad=89.3f pd=0.85u as=89.3f ps=0.85u w=0.47u l=0.16u
X5705 cml_tlatch_65.OUTN cml_tlatch_65.OUTP cml_tlatch_65.xmux.xp.S1 VSS sg13_lv_nmos ad=56.9f pd=0.74u as=56.9f ps=0.74u w=0.17u l=0.17u
X5706 MOT4_N cml_tlatch_99.OUTP cml_tlatch_28.xmux.xn.S1 VSS sg13_lv_nmos ad=63.19999f pd=0.74u as=63.19999f ps=0.74u w=0.26u l=0.38u
X5707 cml_tlatch_86.xmux.xp.S1 cml_tlatch_86.OUTP cml_tlatch_86.OUTN VSS sg13_lv_nmos ad=56.9f pd=0.74u as=56.9f ps=0.74u w=0.17u l=0.17u
X5708 MOT23_P B2_2_N cml_tlatch_80.xmux.xn.S1 VSS sg13_lv_nmos ad=63.19999f pd=0.74u as=63.19999f ps=0.74u w=0.26u l=0.38u
X5709 cml_tlatch_2.xtail.S1 CKB0_P cml_tlatch_2.xmux.xn.S1 VSS sg13_lv_nmos ad=89.3f pd=0.85u as=89.3f ps=0.85u w=0.47u l=0.16u
X5710 MOT24_N MOT24_P cml_tlatch_62.xmux.xp.S1 VSS sg13_lv_nmos ad=56.9f pd=0.74u as=56.9f ps=0.74u w=0.17u l=0.17u
X5711 cml_tlatch_25.xmux.xn.S1 CKHA1_P cml_tlatch_25.xtail.S1 VSS sg13_lv_nmos ad=89.3f pd=0.85u as=89.3f ps=0.85u w=0.47u l=0.16u
X5712 cml_tlatch_66.xmux.xp.S1 cml_tlatch_73.INP cml_tlatch_73.INN VSS sg13_lv_nmos ad=56.9f pd=0.74u as=56.9f ps=0.74u w=0.17u l=0.17u
X5713 MOT29_N MOT29_P cml_tlatch_74.xmux.xp.S1 VSS sg13_lv_nmos ad=56.9f pd=0.74u as=56.9f ps=0.74u w=0.17u l=0.17u
X5714 A2_2_P A2_2_N cml_tlatch_60.xmux.xp.S1 VSS sg13_lv_nmos ad=56.9f pd=0.74u as=56.9f ps=0.74u w=0.17u l=0.17u
X5715 cml_tlatch_27.xmux.xn.S1 CKHA0_P cml_tlatch_27.xtail.S1 VSS sg13_lv_nmos ad=0.1598p pd=1.62u as=89.3f ps=0.85u w=0.47u l=0.16u
X5716 cml_tlatch_87.xmux.xn.S1 CKA2_N cml_tlatch_87.xtail.S1 VSS sg13_lv_nmos ad=89.3f pd=0.85u as=89.3f ps=0.85u w=0.47u l=0.16u
X5717 cml_tlatch_52.xtail.S1 CKHA2_P cml_tlatch_52.xmux.xn.S1 VSS sg13_lv_nmos ad=89.3f pd=0.85u as=89.3f ps=0.85u w=0.47u l=0.16u
X5718 cml_tlatch_47.xmux.xp.S1 B2_2_N B2_2_P VSS sg13_lv_nmos ad=56.9f pd=0.74u as=56.9f ps=0.74u w=0.17u l=0.17u
X5719 MOT3_P MOT3_N cml_tlatch_15.xmux.xp.S1 VSS sg13_lv_nmos ad=56.9f pd=0.74u as=56.9f ps=0.74u w=0.17u l=0.17u
X5720 cml_tlatch_31.xmux.xp.S1 CKB0_P cml_tlatch_31.xtail.S1 VSS sg13_lv_nmos ad=89.3f pd=0.85u as=89.3f ps=0.85u w=0.47u l=0.16u
X5721 MOT1_P MOT1_N cml_tlatch_14.xmux.xp.S1 VSS sg13_lv_nmos ad=56.9f pd=0.74u as=56.9f ps=0.74u w=0.17u l=0.17u
X5722 MOT18_P MOT18_N cml_tlatch_53.xmux.xp.S1 VSS sg13_lv_nmos ad=56.9f pd=0.74u as=56.9f ps=0.74u w=0.17u l=0.17u
X5723 cml_tlatch_63.xmux.xp.S1 MOT26_N MOT26_P VSS sg13_lv_nmos ad=56.9f pd=0.74u as=56.9f ps=0.74u w=0.17u l=0.17u
X5724 cml_tlatch_2.OUTN cml_tlatch_2.OUTP cml_tlatch_2.xmux.xp.S1 VSS sg13_lv_nmos ad=56.9f pd=0.74u as=56.9f ps=0.74u w=0.17u l=0.17u
X5725 GB0_P CKA0_N cml_gate2_1.xrtail.R1 VSS sg13_lv_nmos ad=0.1802p pd=1.74u as=0.1007p ps=0.91u w=0.53u l=0.13u
X5726 cml_tlatch_6.xmux.xn.S1 CKHB1_P cml_tlatch_6.xtail.S1 VSS sg13_lv_nmos ad=89.3f pd=0.85u as=89.3f ps=0.85u w=0.47u l=0.16u
X5727 ENB_P J2_N cml_gate2_8.xamp.xn.S1 VSS sg13_lv_nmos ad=0.1007p pd=0.91u as=0.1007p ps=0.91u w=0.53u l=0.13u
X5728 cml_tlatch_48.xmux.xp.S1 CKB2_N cml_tlatch_48.xtail.S1 VSS sg13_lv_nmos ad=89.3f pd=0.85u as=89.3f ps=0.85u w=0.47u l=0.16u
X5729 cml_tlatch_4.INN cml_tlatch_4.INP cml_tlatch_12.xmux.xp.S1 VSS sg13_lv_nmos ad=56.9f pd=0.74u as=56.9f ps=0.74u w=0.17u l=0.17u
X5730 CLK_W_N CLK_W_P cml_tlatch_93.xmux.xp.S1 VSS sg13_lv_nmos ad=56.9f pd=0.74u as=56.9f ps=0.74u w=0.17u l=0.17u
X5731 VSS POLN hs_to_clk_7.D2 VSS sg13_lv_nmos ad=1.9p pd=10.38u as=3.4p ps=20.68u w=10u l=0.13u
X5732 cml_tlatch_76.xmux.xp.S1 cml_tlatch_87.INN cml_tlatch_87.INP VSS sg13_lv_nmos ad=56.9f pd=0.74u as=56.9f ps=0.74u w=0.17u l=0.17u
X5733 cml_tlatch_4.xmux.xn.S1 cml_tlatch_4.INN MOT11_P VSS sg13_lv_nmos ad=63.19999f pd=0.74u as=0.1082p ps=1.34u w=0.26u l=0.38u
X5734 MOT21_P MOT21_N cml_tlatch_79.xmux.xp.S1 VSS sg13_lv_nmos ad=56.9f pd=0.74u as=56.9f ps=0.74u w=0.17u l=0.17u
X5735 stub_bi_55.BOTP stub_bi_55.BOTN cml_tlatch_90.xmux.xp.S1 VSS sg13_lv_nmos ad=56.9f pd=0.74u as=56.9f ps=0.74u w=0.17u l=0.17u
X5736 cml_tlatch_7.xtail.S1 CKB0_N cml_tlatch_7.xmux.xn.S1 VSS sg13_lv_nmos ad=89.3f pd=0.85u as=89.3f ps=0.85u w=0.47u l=0.16u
X5737 cml_tlatch_94.xmux.xn.S1 J1_N J2_P VSS sg13_lv_nmos ad=63.19999f pd=0.74u as=63.19999f ps=0.74u w=0.26u l=0.38u
X5738 cml_tlatch_17.xmux.xp.S1 MOT7_N MOT7_P VSS sg13_lv_nmos ad=56.9f pd=0.74u as=56.9f ps=0.74u w=0.17u l=0.17u
X5739 cml_tlatch_53.xmux.xp.S1 CKHA2_N cml_tlatch_53.xtail.S1 VSS sg13_lv_nmos ad=89.3f pd=0.85u as=89.3f ps=0.85u w=0.47u l=0.16u
X5740 cml_tlatch_67.xmux.xp.S1 CKB3_N cml_tlatch_67.xtail.S1 VSS sg13_lv_nmos ad=89.3f pd=0.85u as=89.3f ps=0.85u w=0.47u l=0.16u
X5741 cml_tlatch_77.xmux.xn.S1 CKHB2_P cml_tlatch_77.xtail.S1 VSS sg13_lv_nmos ad=89.3f pd=0.85u as=89.3f ps=0.85u w=0.47u l=0.16u
X5742 cml_tlatch_0.xmux.xp.S1 cml_tlatch_0.OUTN cml_tlatch_0.OUTP VSS sg13_lv_nmos ad=56.9f pd=0.74u as=56.9f ps=0.74u w=0.17u l=0.17u
X5743 cml_tlatch_42.xtail.S1 CKHA1_P cml_tlatch_42.xmux.xn.S1 VSS sg13_lv_nmos ad=89.3f pd=0.85u as=89.3f ps=0.85u w=0.47u l=0.16u
X5744 cml_tlatch_22.xmux.xp.S1 cml_tlatch_22.OUTP cml_tlatch_22.OUTN VSS sg13_lv_nmos ad=56.9f pd=0.74u as=56.9f ps=0.74u w=0.17u l=0.17u
X5745 cml_gate2_6.xamp.xn.S1 CKA3_P cml_gate2_6.xrtail.R1 VSS sg13_lv_nmos ad=0.1802p pd=1.74u as=0.1007p ps=0.91u w=0.53u l=0.13u
X5746 MOT17_N MOT17_P cml_tlatch_77.xmux.xp.S1 VSS sg13_lv_nmos ad=56.9f pd=0.74u as=56.9f ps=0.74u w=0.17u l=0.17u
X5747 cml_tlatch_73.INN cml_tlatch_67.OUTP cml_tlatch_66.xmux.xn.S1 VSS sg13_lv_nmos ad=63.19999f pd=0.74u as=63.19999f ps=0.74u w=0.26u l=0.38u
X5748 cml_gate2_7.xamp.xn.S1 ENB0_N GB2_P VSS sg13_lv_nmos ad=0.1007p pd=0.91u as=0.1007p ps=0.91u w=0.53u l=0.13u
X5749 B0_2_P B0_2_N cml_tlatch_31.xmux.xp.S1 VSS sg13_lv_nmos ad=56.9f pd=0.74u as=56.9f ps=0.74u w=0.17u l=0.17u
X5750 B2_8_N B2_8_P cml_tlatch_81.xmux.xp.S1 VSS sg13_lv_nmos ad=56.9f pd=0.74u as=56.9f ps=0.74u w=0.17u l=0.17u
X5751 cml_tlatch_99.xmux.xp.S1 cml_tlatch_99.OUTN cml_tlatch_99.OUTP VSS sg13_lv_nmos ad=56.9f pd=0.74u as=56.9f ps=0.74u w=0.17u l=0.17u
X5752 cml_tlatch_78.xmux.xp.S1 MOT19_N MOT19_P VSS sg13_lv_nmos ad=56.9f pd=0.74u as=56.9f ps=0.74u w=0.17u l=0.17u
X5753 cml_tlatch_90.xmux.xn.S1 stub_bi_38.BOTP stub_bi_55.BOTN VSS sg13_lv_nmos ad=0.1082p pd=1.34u as=63.19999f ps=0.74u w=0.26u l=0.38u
X5754 cml_gate2_3.xrtail.R1 CKB0_N GA0_P VSS sg13_lv_nmos ad=0.1007p pd=0.91u as=0.1007p ps=0.91u w=0.53u l=0.13u
X5755 cml_tlatch_54.xmux.xp.S1 MOT20_N MOT20_P VSS sg13_lv_nmos ad=0.1019p pd=1.34u as=56.9f ps=0.74u w=0.17u l=0.17u
X5756 cml_tlatch_29.xtail.S1 CKHA0_N cml_tlatch_29.xmux.xp.S1 VSS sg13_lv_nmos ad=89.3f pd=0.85u as=89.3f ps=0.85u w=0.47u l=0.16u
X5757 MOT9_N MOT9_P cml_tlatch_3.xmux.xp.S1 VSS sg13_lv_nmos ad=56.9f pd=0.74u as=56.9f ps=0.74u w=0.17u l=0.17u
X5758 cml_drvb_0.xrtail.R2 GB1_N CKHB1_P VSS sg13_lv_nmos ad=0.1463p pd=1.15u as=0.2618p ps=2.22u w=0.77u l=0.21u
X5759 VSS POLN cml_tlatch_5.xtail.S1 VSS sg13_lv_nmos ad=1.5637p pd=8.61u as=1.5637p ps=8.61u w=8.23u l=0.13u
X5760 MOT28_P MOT28_N cml_tlatch_44.xmux.xp.S1 VSS sg13_lv_nmos ad=56.9f pd=0.74u as=56.9f ps=0.74u w=0.17u l=0.17u
X5761 cml_tlatch_46.xmux.xp.S1 CKB2_N cml_tlatch_46.xtail.S1 VSS sg13_lv_nmos ad=89.3f pd=0.85u as=89.3f ps=0.85u w=0.47u l=0.16u
X5762 VDD hs_to_clk_0.sg13_lv_nmos_2HGZLP_0.G VSS rppd l=0.68u w=1u
X5763 cml_tlatch_54.xmux.xn.S1 cml_tlatch_91.OUTN MOT20_P VSS sg13_lv_nmos ad=63.19999f pd=0.74u as=63.19999f ps=0.74u w=0.26u l=0.38u
X5764 cml_tlatch_48.xmux.xp.S1 stub_bi_43.BOTN stub_bi_43.BOTP VSS sg13_lv_nmos ad=56.9f pd=0.74u as=56.9f ps=0.74u w=0.17u l=0.17u
X5765 cml_tlatch_16.xmux.xn.S1 CKHB0_P cml_tlatch_16.xtail.S1 VSS sg13_lv_nmos ad=89.3f pd=0.85u as=89.3f ps=0.85u w=0.47u l=0.16u
X5766 cml_tlatch_86.OUTP cml_tlatch_87.OUTN cml_tlatch_86.xmux.xn.S1 VSS sg13_lv_nmos ad=63.19999f pd=0.74u as=63.19999f ps=0.74u w=0.26u l=0.38u
X5767 stub_bi_38.BOTN stub_bi_38.BOTP cml_tlatch_46.xmux.xp.S1 VSS sg13_lv_nmos ad=56.9f pd=0.74u as=56.9f ps=0.74u w=0.17u l=0.17u
X5768 cml_tlatch_4.xmux.xp.S1 MOT11_N MOT11_P VSS sg13_lv_nmos ad=56.9f pd=0.74u as=56.9f ps=0.74u w=0.17u l=0.17u
X5769 cml_tlatch_24.xmux.xp.S1 MOT12_N MOT12_P VSS sg13_lv_nmos ad=56.9f pd=0.74u as=56.9f ps=0.74u w=0.17u l=0.17u
X5770 cml_gate2_8.xamp.xn.S1 J2_P ENB_N VSS sg13_lv_nmos ad=0.1007p pd=0.91u as=0.1802p ps=1.74u w=0.53u l=0.13u
X5771 cml_tlatch_86.xmux.xp.S1 cml_tlatch_86.OUTP cml_tlatch_86.OUTN VSS sg13_lv_nmos ad=56.9f pd=0.74u as=56.9f ps=0.74u w=0.17u l=0.17u
X5772 cml_tlatch_87.xmux.xp.S1 cml_tlatch_87.OUTP cml_tlatch_87.OUTN VSS sg13_lv_nmos ad=56.9f pd=0.74u as=56.9f ps=0.74u w=0.17u l=0.17u
X5773 B0_8_N B0_8_P cml_tlatch_1.xmux.xp.S1 VSS sg13_lv_nmos ad=56.9f pd=0.74u as=56.9f ps=0.74u w=0.17u l=0.17u
X5774 VSS POLN cml_tlatch_9.xtail.S1 VSS sg13_lv_nmos ad=1.5637p pd=8.61u as=1.5637p ps=8.61u w=8.23u l=0.13u
X5775 cml_tlatch_3.xmux.xn.S1 CKHB1_P cml_tlatch_3.xtail.S1 VSS sg13_lv_nmos ad=89.3f pd=0.85u as=89.3f ps=0.85u w=0.47u l=0.16u
X5776 cml_tlatch_21.xmux.xp.S1 cml_tlatch_43.INN cml_tlatch_43.INP VSS sg13_lv_nmos ad=56.9f pd=0.74u as=56.9f ps=0.74u w=0.17u l=0.17u
X5777 stub_bi_63.BOTN stub_bi_63.BOTP cml_tlatch_83.xmux.xp.S1 VSS sg13_lv_nmos ad=56.9f pd=0.74u as=56.9f ps=0.74u w=0.17u l=0.17u
X5778 cml_tlatch_90.xmux.xp.S1 stub_bi_55.BOTP stub_bi_55.BOTN VSS sg13_lv_nmos ad=56.9f pd=0.74u as=56.9f ps=0.74u w=0.17u l=0.17u
X5779 cml_tlatch_33.OUTP A0_2_N cml_tlatch_33.xmux.xn.S1 VSS sg13_lv_nmos ad=63.19999f pd=0.74u as=0.1082p ps=1.34u w=0.26u l=0.38u
X5780 MOT23_P MOT23_N cml_tlatch_80.xmux.xp.S1 VSS sg13_lv_nmos ad=56.9f pd=0.74u as=0.1019p ps=1.34u w=0.17u l=0.17u
X5781 cml_tlatch_6.xmux.xp.S1 MOT15_P MOT15_N VSS sg13_lv_nmos ad=56.9f pd=0.74u as=56.9f ps=0.74u w=0.17u l=0.17u
X5782 VSS POLN cml_tlatch_23.xtail.S1 VSS sg13_lv_nmos ad=2.7982p pd=17.14u as=1.5637p ps=8.61u w=8.23u l=0.13u
X5783 cml_tlatch_19.xmux.xp.S1 CKA1_P cml_tlatch_19.xtail.S1 VSS sg13_lv_nmos ad=89.3f pd=0.85u as=89.3f ps=0.85u w=0.47u l=0.16u
X5784 cml_tlatch_73.xtail.S1 CKHB3_P cml_tlatch_73.xmux.xn.S1 VSS sg13_lv_nmos ad=89.3f pd=0.85u as=89.3f ps=0.85u w=0.47u l=0.16u
X5785 GB1_P ENB1_N cml_gate2_0.xamp.xn.S1 VSS sg13_lv_nmos ad=0.1007p pd=0.91u as=0.1007p ps=0.91u w=0.53u l=0.13u
X5786 cml_tlatch_35.xmux.xp.S1 stub_bi_29.BOTN stub_bi_29.BOTP VSS sg13_lv_nmos ad=56.9f pd=0.74u as=56.9f ps=0.74u w=0.17u l=0.17u
X5787 hs_to_clk_3.D2 POLN VSS VSS sg13_lv_nmos ad=1.9p pd=10.38u as=1.9p ps=10.38u w=10u l=0.13u
X5788 cml_tlatch_42.xmux.xp.S1 MOT8_P MOT8_N VSS sg13_lv_nmos ad=56.9f pd=0.74u as=56.9f ps=0.74u w=0.17u l=0.17u
X5789 cml_gate2_4.xrtail.R1 CKB3_P cml_gate2_4.xamp.xn.S1 VSS sg13_lv_nmos ad=0.1007p pd=0.91u as=0.1007p ps=0.91u w=0.53u l=0.13u
X5790 cml_tlatch_84.xmux.xn.S1 stub_bi_55.BOTN stub_bi_49.BOTP VSS sg13_lv_nmos ad=63.19999f pd=0.74u as=63.19999f ps=0.74u w=0.26u l=0.38u
X5791 cml_gate2_0.xamp.xn.S1 ENB1_N GB1_P VSS sg13_lv_nmos ad=0.1007p pd=0.91u as=0.1007p ps=0.91u w=0.53u l=0.13u
X5792 cml_tlatch_71.OUTN cml_tlatch_71.OUTP cml_tlatch_71.xmux.xp.S1 VSS sg13_lv_nmos ad=56.9f pd=0.74u as=56.9f ps=0.74u w=0.17u l=0.17u
X5793 cml_tlatch_71.xmux.xn.S1 CKA3_P cml_tlatch_71.xtail.S1 VSS sg13_lv_nmos ad=89.3f pd=0.85u as=89.3f ps=0.85u w=0.47u l=0.16u
X5794 cml_tlatch_8.OUTP cml_tlatch_98.OUTN cml_tlatch_8.xmux.xn.S1 VSS sg13_lv_nmos ad=63.19999f pd=0.74u as=63.19999f ps=0.74u w=0.26u l=0.38u
X5795 stub_bi_62.BOTN stub_bi_62.BOTP cml_tlatch_82.xmux.xp.S1 VSS sg13_lv_nmos ad=56.9f pd=0.74u as=56.9f ps=0.74u w=0.17u l=0.17u
X5796 MOT26_N cml_tlatch_63.INP cml_tlatch_63.xmux.xn.S1 VSS sg13_lv_nmos ad=63.19999f pd=0.74u as=63.19999f ps=0.74u w=0.26u l=0.38u
X5797 cml_tlatch_74.INN cml_tlatch_49.OUTP cml_tlatch_88.xmux.xn.S1 VSS sg13_lv_nmos ad=63.19999f pd=0.74u as=63.19999f ps=0.74u w=0.26u l=0.38u
X5798 stub_bi_49.BOTN stub_bi_49.BOTP cml_tlatch_84.xmux.xp.S1 VSS sg13_lv_nmos ad=56.9f pd=0.74u as=56.9f ps=0.74u w=0.17u l=0.17u
X5799 cml_tlatch_20.OUTN cml_tlatch_43.INP cml_tlatch_20.xmux.xn.S1 VSS sg13_lv_nmos ad=63.19999f pd=0.74u as=63.19999f ps=0.74u w=0.26u l=0.38u
X5800 cml_tlatch_75.xmux.xp.S1 MOT31_P MOT31_N VSS sg13_lv_nmos ad=56.9f pd=0.74u as=56.9f ps=0.74u w=0.17u l=0.17u
X5801 cml_tlatch_20.xmux.xn.S1 CKA1_P cml_tlatch_20.xtail.S1 VSS sg13_lv_nmos ad=89.3f pd=0.85u as=89.3f ps=0.85u w=0.47u l=0.16u
X5802 MOT18_P cml_tlatch_87.OUTN cml_tlatch_53.xmux.xn.S1 VSS sg13_lv_nmos ad=63.19999f pd=0.74u as=63.19999f ps=0.74u w=0.26u l=0.38u
X5803 cml_drv_2.xrtail.R1 ENB_P ENB0_N VSS sg13_lv_nmos ad=56.2f pd=0.74u as=56.2f ps=0.74u w=0.16u l=0.19u
X5804 cml_tlatch_74.xmux.xp.S1 MOT29_N MOT29_P VSS sg13_lv_nmos ad=56.9f pd=0.74u as=56.9f ps=0.74u w=0.17u l=0.17u
X5805 VSS POLN cml_tlatch_55.xtail.S1 VSS sg13_lv_nmos ad=2.7982p pd=17.14u as=1.5637p ps=8.61u w=8.23u l=0.13u
X5806 cml_tlatch_16.xtail.S1 CKHB0_N cml_tlatch_16.xmux.xp.S1 VSS sg13_lv_nmos ad=89.3f pd=0.85u as=89.3f ps=0.85u w=0.47u l=0.16u
X5807 cml_tlatch_67.xmux.xn.S1 CKB3_P cml_tlatch_67.xtail.S1 VSS sg13_lv_nmos ad=89.3f pd=0.85u as=89.3f ps=0.85u w=0.47u l=0.16u
X5808 cml_tlatch_68.xmux.xp.S1 A3_8_P A3_8_N VSS sg13_lv_nmos ad=56.9f pd=0.74u as=56.9f ps=0.74u w=0.17u l=0.17u
X5809 cml_tlatch_30.xmux.xp.S1 cml_tlatch_30.OUTP cml_tlatch_30.OUTN VSS sg13_lv_nmos ad=56.9f pd=0.74u as=56.9f ps=0.74u w=0.17u l=0.17u
X5810 cml_tlatch_99.xtail.S1 CKA0_P cml_tlatch_99.xmux.xp.S1 VSS sg13_lv_nmos ad=89.3f pd=0.85u as=89.3f ps=0.85u w=0.47u l=0.16u
X5811 cml_tlatch_52.xmux.xn.S1 CKHA2_P cml_tlatch_52.xtail.S1 VSS sg13_lv_nmos ad=89.3f pd=0.85u as=89.3f ps=0.85u w=0.47u l=0.16u
X5812 MOT13_P MOT13_N cml_tlatch_5.xmux.xp.S1 VSS sg13_lv_nmos ad=56.9f pd=0.74u as=56.9f ps=0.74u w=0.17u l=0.17u
X5813 cml_tlatch_59.xmux.xn.S1 CKA2_P cml_tlatch_59.xtail.S1 VSS sg13_lv_nmos ad=89.3f pd=0.85u as=89.3f ps=0.85u w=0.47u l=0.16u
X5814 cml_tlatch_0.OUTN cml_tlatch_0.OUTP cml_tlatch_0.xmux.xp.S1 VSS sg13_lv_nmos ad=56.9f pd=0.74u as=56.9f ps=0.74u w=0.17u l=0.17u
X5815 MOT23_P MOT23_N cml_tlatch_80.xmux.xp.S1 VSS sg13_lv_nmos ad=56.9f pd=0.74u as=56.9f ps=0.74u w=0.17u l=0.17u
X5816 cml_tlatch_11.xmux.xn.S1 CKB1_P cml_tlatch_11.xtail.S1 VSS sg13_lv_nmos ad=89.3f pd=0.85u as=89.3f ps=0.85u w=0.47u l=0.16u
X5817 cml_tlatch_8.OUTP cml_tlatch_8.OUTN cml_tlatch_8.xmux.xp.S1 VSS sg13_lv_nmos ad=56.9f pd=0.74u as=0.1019p ps=1.34u w=0.17u l=0.17u
X5818 MOT5_P cml_tlatch_98.OUTN cml_tlatch_16.xmux.xn.S1 VSS sg13_lv_nmos ad=63.19999f pd=0.74u as=0.1082p ps=1.34u w=0.26u l=0.38u
X5819 cml_gate2_9.xrtail.R1 NM1_P cml_gate2_9.xamp.xn.S1 VSS sg13_lv_nmos ad=0.1007p pd=0.91u as=0.1007p ps=0.91u w=0.53u l=0.13u
X5820 cml_tlatch_58.OUTN cml_tlatch_58.OUTP cml_tlatch_58.xmux.xp.S1 VSS sg13_lv_nmos ad=56.9f pd=0.74u as=56.9f ps=0.74u w=0.17u l=0.17u
X5821 cml_tlatch_18.xmux.xp.S1 cml_tlatch_18.OUTN cml_tlatch_18.OUTP VSS sg13_lv_nmos ad=56.9f pd=0.74u as=56.9f ps=0.74u w=0.17u l=0.17u
X5822 cml_tlatch_33.xmux.xn.S1 CKA0_P cml_tlatch_33.xtail.S1 VSS sg13_lv_nmos ad=89.3f pd=0.85u as=89.3f ps=0.85u w=0.47u l=0.16u
X5823 A1_8_N A1_8_P cml_tlatch_19.xmux.xp.S1 VSS sg13_lv_nmos ad=56.9f pd=0.74u as=56.9f ps=0.74u w=0.17u l=0.17u
X5824 cml_tlatch_48.xtail.S1 CKB2_N cml_tlatch_48.xmux.xp.S1 VSS sg13_lv_nmos ad=89.3f pd=0.85u as=89.3f ps=0.85u w=0.47u l=0.16u
X5825 cml_tlatch_99.OUTN cml_tlatch_33.OUTP cml_tlatch_99.xmux.xn.S1 VSS sg13_lv_nmos ad=0.1082p pd=1.34u as=63.19999f ps=0.74u w=0.26u l=0.38u
X5826 cml_tlatch_9.xtail.S1 CKA0_P cml_tlatch_9.xmux.xp.S1 VSS sg13_lv_nmos ad=89.3f pd=0.85u as=89.3f ps=0.85u w=0.47u l=0.16u
X5827 cml_tlatch_71.xmux.xn.S1 cml_tlatch_44.INN cml_tlatch_71.OUTP VSS sg13_lv_nmos ad=63.19999f pd=0.74u as=63.19999f ps=0.74u w=0.26u l=0.38u
X5828 stub_bi_38.BOTN B2_2_N cml_tlatch_46.xmux.xn.S1 VSS sg13_lv_nmos ad=63.19999f pd=0.74u as=63.19999f ps=0.74u w=0.26u l=0.38u
X5829 A1_2_P cml_tlatch_41.OUTN cml_tlatch_40.xmux.xn.S1 VSS sg13_lv_nmos ad=63.19999f pd=0.74u as=0.1082p ps=1.34u w=0.26u l=0.38u
X5830 cml_tlatch_50.xmux.xp.S1 B3_2_P B3_2_N VSS sg13_lv_nmos ad=56.9f pd=0.74u as=56.9f ps=0.74u w=0.17u l=0.17u
X5831 cml_tlatch_31.xmux.xp.S1 B0_2_P B0_2_N VSS sg13_lv_nmos ad=56.9f pd=0.74u as=56.9f ps=0.74u w=0.17u l=0.17u
X5832 cml_tlatch_7.OUTN VDD VSS rppd l=5.17u w=1u
X5833 VSS hs_to_clk_3.sg13_lv_nmos_2HGZLP_0.G VSS VSS sg13_lv_nmos ad=2.071p pd=11.28u as=0 ps=0 w=10.9u l=1.38u
X5834 cml_tlatch_56.xmux.xp.S1 cml_tlatch_56.OUTN cml_tlatch_56.OUTP VSS sg13_lv_nmos ad=56.9f pd=0.74u as=56.9f ps=0.74u w=0.17u l=0.17u
X5835 cml_tlatch_99.OUTN cml_tlatch_33.OUTP cml_tlatch_99.xmux.xn.S1 VSS sg13_lv_nmos ad=63.19999f pd=0.74u as=63.19999f ps=0.74u w=0.26u l=0.38u
X5836 cml_tlatch_40.xmux.xn.S1 cml_tlatch_41.OUTP A1_2_N VSS sg13_lv_nmos ad=63.19999f pd=0.74u as=63.19999f ps=0.74u w=0.26u l=0.38u
X5837 cml_tlatch_93.xmux.xp.S1 CLK_W_N CLK_W_P VSS sg13_lv_nmos ad=56.9f pd=0.74u as=56.9f ps=0.74u w=0.17u l=0.17u
X5838 cml_tlatch_62.xmux.xn.S1 CKHA3_P cml_tlatch_62.xtail.S1 VSS sg13_lv_nmos ad=89.3f pd=0.85u as=89.3f ps=0.85u w=0.47u l=0.16u
X5839 cml_tlatch_46.xmux.xn.S1 CKB2_P cml_tlatch_46.xtail.S1 VSS sg13_lv_nmos ad=89.3f pd=0.85u as=89.3f ps=0.85u w=0.47u l=0.16u
X5840 MOT9_N MOT9_P cml_tlatch_3.xmux.xp.S1 VSS sg13_lv_nmos ad=56.9f pd=0.74u as=56.9f ps=0.74u w=0.17u l=0.17u
X5841 cml_tlatch_21.xmux.xp.S1 cml_tlatch_43.INN cml_tlatch_43.INP VSS sg13_lv_nmos ad=56.9f pd=0.74u as=56.9f ps=0.74u w=0.17u l=0.17u
X5842 cml_tlatch_56.xmux.xn.S1 CKA3_P cml_tlatch_56.xtail.S1 VSS sg13_lv_nmos ad=89.3f pd=0.85u as=89.3f ps=0.85u w=0.47u l=0.16u
X5843 GB3_N ENB0_P cml_gate2_6.xamp.xn.S1 VSS sg13_lv_nmos ad=0.1007p pd=0.91u as=0.1007p ps=0.91u w=0.53u l=0.13u
X5844 cml_tlatch_71.OUTN cml_tlatch_44.INP cml_tlatch_71.xmux.xn.S1 VSS sg13_lv_nmos ad=63.19999f pd=0.74u as=63.19999f ps=0.74u w=0.26u l=0.38u
X5845 MOT29_P MOT29_N cml_tlatch_74.xmux.xp.S1 VSS sg13_lv_nmos ad=56.9f pd=0.74u as=56.9f ps=0.74u w=0.17u l=0.17u
X5846 cml_tlatch_97.INP cml_tlatch_97.INN cml_tlatch_39.xmux.xp.S1 VSS sg13_lv_nmos ad=56.9f pd=0.74u as=56.9f ps=0.74u w=0.17u l=0.17u
X5847 A1_8_N A1_8_P cml_tlatch_19.xmux.xp.S1 VSS sg13_lv_nmos ad=56.9f pd=0.74u as=56.9f ps=0.74u w=0.17u l=0.17u
X5848 cml_tlatch_65.OUTN cml_tlatch_73.INP cml_tlatch_65.xmux.xn.S1 VSS sg13_lv_nmos ad=63.19999f pd=0.74u as=63.19999f ps=0.74u w=0.26u l=0.38u
X5849 cml_tlatch_38.xmux.xp.S1 CKA0_N cml_tlatch_38.xtail.S1 VSS sg13_lv_nmos ad=89.3f pd=0.85u as=89.3f ps=0.85u w=0.47u l=0.16u
X5850 A3_2_P A3_2_N cml_tlatch_57.xmux.xp.S1 VSS sg13_lv_nmos ad=56.9f pd=0.74u as=56.9f ps=0.74u w=0.17u l=0.17u
X5851 cml_tlatch_18.xmux.xp.S1 CKA0_N cml_tlatch_18.xtail.S1 VSS sg13_lv_nmos ad=89.3f pd=0.85u as=89.3f ps=0.85u w=0.47u l=0.16u
X5852 cml_tlatch_5.xmux.xn.S1 cml_tlatch_5.INN MOT13_P VSS sg13_lv_nmos ad=0.1082p pd=1.34u as=63.19999f ps=0.74u w=0.26u l=0.38u
X5853 cml_tlatch_18.OUTN cml_tlatch_18.OUTP cml_tlatch_18.xmux.xp.S1 VSS sg13_lv_nmos ad=56.9f pd=0.74u as=0.1019p ps=1.34u w=0.17u l=0.17u
X5854 cml_tlatch_52.xmux.xn.S1 A2_8_N MOT16_P VSS sg13_lv_nmos ad=63.19999f pd=0.74u as=63.19999f ps=0.74u w=0.26u l=0.38u
X5855 stub_bi_43.BOTN stub_bi_43.BOTP cml_tlatch_48.xmux.xp.S1 VSS sg13_lv_nmos ad=56.9f pd=0.74u as=56.9f ps=0.74u w=0.17u l=0.17u
X5856 stub_bi_63.BOTP stub_bi_63.BOTN cml_tlatch_83.xmux.xp.S1 VSS sg13_lv_nmos ad=56.9f pd=0.74u as=56.9f ps=0.74u w=0.17u l=0.17u
X5857 MOT5_N MOT5_P cml_tlatch_16.xmux.xp.S1 VSS sg13_lv_nmos ad=56.9f pd=0.74u as=56.9f ps=0.74u w=0.17u l=0.17u
X5858 cml_tlatch_21.xmux.xp.S1 cml_tlatch_43.INN cml_tlatch_43.INP VSS sg13_lv_nmos ad=56.9f pd=0.74u as=56.9f ps=0.74u w=0.17u l=0.17u
X5859 cml_tlatch_24.INP cml_tlatch_24.INN cml_tlatch_97.xmux.xp.S1 VSS sg13_lv_nmos ad=56.9f pd=0.74u as=0.1019p ps=1.34u w=0.17u l=0.17u
X5860 cml_tlatch_8.OUTP cml_tlatch_8.OUTN cml_tlatch_8.xmux.xp.S1 VSS sg13_lv_nmos ad=56.9f pd=0.74u as=56.9f ps=0.74u w=0.17u l=0.17u
X5861 cml_tlatch_6.xmux.xp.S1 MOT15_P MOT15_N VSS sg13_lv_nmos ad=0.1019p pd=1.34u as=56.9f ps=0.74u w=0.17u l=0.17u
X5862 cml_gate2_2.xrtail.R1 CKB1_N GA1_P VSS sg13_lv_nmos ad=0.1007p pd=0.91u as=0.1007p ps=0.91u w=0.53u l=0.13u
X5863 cml_tlatch_97.INP cml_tlatch_97.INN cml_tlatch_39.xmux.xp.S1 VSS sg13_lv_nmos ad=56.9f pd=0.74u as=56.9f ps=0.74u w=0.17u l=0.17u
X5864 cml_tlatch_2.xtail.S1 CKB0_P cml_tlatch_2.xmux.xn.S1 VSS sg13_lv_nmos ad=89.3f pd=0.85u as=89.3f ps=0.85u w=0.47u l=0.16u
X5865 cml_tlatch_62.xmux.xp.S1 CKHA3_N cml_tlatch_62.xtail.S1 VSS sg13_lv_nmos ad=89.3f pd=0.85u as=89.3f ps=0.85u w=0.47u l=0.16u
X5866 ENB_P NS1_N cml_gate2_8.xrtail.R1 VSS sg13_lv_nmos ad=0.1802p pd=1.74u as=0.1007p ps=0.91u w=0.53u l=0.13u
X5867 cml_tlatch_87.xmux.xp.S1 CKA2_P cml_tlatch_87.xtail.S1 VSS sg13_lv_nmos ad=89.3f pd=0.85u as=89.3f ps=0.85u w=0.47u l=0.16u
X5868 cml_tlatch_27.xmux.xn.S1 CKHA0_P cml_tlatch_27.xtail.S1 VSS sg13_lv_nmos ad=89.3f pd=0.85u as=89.3f ps=0.85u w=0.47u l=0.16u
X5869 J1_P J4_P cml_tlatch_95.xmux.xn.S1 VSS sg13_lv_nmos ad=63.19999f pd=0.74u as=63.19999f ps=0.74u w=0.26u l=0.38u
X5870 cml_gate2_9.xamp.xn.S1 J1_P ENA_N VSS sg13_lv_nmos ad=0.1007p pd=0.91u as=0.1007p ps=0.91u w=0.53u l=0.13u
X5871 cml_tlatch_68.xmux.xn.S1 cml_tlatch_69.OUTN A3_8_P VSS sg13_lv_nmos ad=63.19999f pd=0.74u as=63.19999f ps=0.74u w=0.26u l=0.38u
X5872 cml_tlatch_53.xmux.xp.S1 MOT18_P MOT18_N VSS sg13_lv_nmos ad=56.9f pd=0.74u as=56.9f ps=0.74u w=0.17u l=0.17u
X5873 cml_tlatch_82.xmux.xp.S1 CKB2_N cml_tlatch_82.xtail.S1 VSS sg13_lv_nmos ad=89.3f pd=0.85u as=89.3f ps=0.85u w=0.47u l=0.16u
X5874 cml_tlatch_13.xtail.S1 CKB1_P cml_tlatch_13.xmux.xn.S1 VSS sg13_lv_nmos ad=89.3f pd=0.85u as=89.3f ps=0.85u w=0.47u l=0.16u
X5875 cml_tlatch_6.xmux.xn.S1 CKHB1_P cml_tlatch_6.xtail.S1 VSS sg13_lv_nmos ad=89.3f pd=0.85u as=89.3f ps=0.85u w=0.47u l=0.16u
X5876 cml_tlatch_55.xmux.xn.S1 A2_2_N MOT22_P VSS sg13_lv_nmos ad=63.19999f pd=0.74u as=63.19999f ps=0.74u w=0.26u l=0.38u
X5877 stub_bi_62.BOTN stub_bi_62.BOTP cml_tlatch_82.xmux.xp.S1 VSS sg13_lv_nmos ad=56.9f pd=0.74u as=56.9f ps=0.74u w=0.17u l=0.17u
X5878 cml_tlatch_20.xmux.xp.S1 cml_tlatch_20.OUTN cml_tlatch_20.OUTP VSS sg13_lv_nmos ad=56.9f pd=0.74u as=56.9f ps=0.74u w=0.17u l=0.17u
X5879 ENA1_N ENA_P cml_drv_1.xrtail.R1 VSS sg13_lv_nmos ad=56.2f pd=0.74u as=56.2f ps=0.74u w=0.16u l=0.19u
X5880 cml_tlatch_70.xmux.xp.S1 cml_tlatch_63.INP cml_tlatch_63.INN VSS sg13_lv_nmos ad=56.9f pd=0.74u as=56.9f ps=0.74u w=0.17u l=0.17u
X5881 MOT22_N A2_2_P cml_tlatch_55.xmux.xn.S1 VSS sg13_lv_nmos ad=63.19999f pd=0.74u as=63.19999f ps=0.74u w=0.26u l=0.38u
X5882 MOT19_P stub_bi_63.BOTP cml_tlatch_78.xmux.xn.S1 VSS sg13_lv_nmos ad=0.1082p pd=1.34u as=63.19999f ps=0.74u w=0.26u l=0.38u
X5883 cml_tlatch_96.xmux.xp.S1 cml_tlatch_5.INP cml_tlatch_5.INN VSS sg13_lv_nmos ad=56.9f pd=0.74u as=56.9f ps=0.74u w=0.17u l=0.17u
X5884 cml_tlatch_86.OUTN cml_tlatch_87.OUTP cml_tlatch_86.xmux.xn.S1 VSS sg13_lv_nmos ad=0.1082p pd=1.34u as=63.19999f ps=0.74u w=0.26u l=0.38u
X5885 B3_2_P B3_2_N cml_tlatch_50.xmux.xp.S1 VSS sg13_lv_nmos ad=56.9f pd=0.74u as=0.1019p ps=1.34u w=0.17u l=0.17u
X5886 cml_tlatch_61.xtail.S1 CKA2_P cml_tlatch_61.xmux.xn.S1 VSS sg13_lv_nmos ad=89.3f pd=0.85u as=89.3f ps=0.85u w=0.47u l=0.16u
X5887 cml_gate2_5.xrtail.R1 CKB2_P cml_gate2_5.xamp.xn.S1 VSS sg13_lv_nmos ad=0.1007p pd=0.91u as=0.1007p ps=0.91u w=0.53u l=0.13u
X5888 cml_tlatch_4.xtail.S1 CKHB1_N cml_tlatch_4.xmux.xp.S1 VSS sg13_lv_nmos ad=89.3f pd=0.85u as=89.3f ps=0.85u w=0.47u l=0.16u
X5889 cml_tlatch_50.xtail.S1 CKB3_P cml_tlatch_50.xmux.xp.S1 VSS sg13_lv_nmos ad=89.3f pd=0.85u as=0.1598p ps=1.62u w=0.47u l=0.16u
X5890 cml_tlatch_51.xmux.xp.S1 cml_tlatch_51.OUTP cml_tlatch_51.OUTN VSS sg13_lv_nmos ad=56.9f pd=0.74u as=56.9f ps=0.74u w=0.17u l=0.17u
X5891 MOT12_N MOT12_P cml_tlatch_24.xmux.xp.S1 VSS sg13_lv_nmos ad=56.9f pd=0.74u as=56.9f ps=0.74u w=0.17u l=0.17u
X5892 VSS POLN cml_tlatch_25.xtail.S1 VSS sg13_lv_nmos ad=1.5637p pd=8.61u as=1.5637p ps=8.61u w=8.23u l=0.13u
X5893 cml_tlatch_28.xtail.S1 CKHA0_N cml_tlatch_28.xmux.xp.S1 VSS sg13_lv_nmos ad=89.3f pd=0.85u as=89.3f ps=0.85u w=0.47u l=0.16u
X5894 cml_tlatch_68.xmux.xp.S1 A3_8_P A3_8_N VSS sg13_lv_nmos ad=56.9f pd=0.74u as=56.9f ps=0.74u w=0.17u l=0.17u
X5895 cml_tlatch_30.xmux.xp.S1 cml_tlatch_30.OUTP cml_tlatch_30.OUTN VSS sg13_lv_nmos ad=56.9f pd=0.74u as=56.9f ps=0.74u w=0.17u l=0.17u
X5896 B3_8_N B3_8_P cml_tlatch_64.xmux.xp.S1 VSS sg13_lv_nmos ad=56.9f pd=0.74u as=56.9f ps=0.74u w=0.17u l=0.17u
X5897 cml_tlatch_39.xmux.xp.S1 CKA1_N cml_tlatch_39.xtail.S1 VSS sg13_lv_nmos ad=89.3f pd=0.85u as=89.3f ps=0.85u w=0.47u l=0.16u
X5898 cml_tlatch_22.xmux.xp.S1 CKA1_N cml_tlatch_22.xtail.S1 VSS sg13_lv_nmos ad=89.3f pd=0.85u as=89.3f ps=0.85u w=0.47u l=0.16u
X5899 cml_tlatch_67.xmux.xp.S1 cml_tlatch_67.OUTN cml_tlatch_67.OUTP VSS sg13_lv_nmos ad=56.9f pd=0.74u as=56.9f ps=0.74u w=0.17u l=0.17u
X5900 A3_8_P A3_8_N cml_tlatch_68.xmux.xp.S1 VSS sg13_lv_nmos ad=56.9f pd=0.74u as=56.9f ps=0.74u w=0.17u l=0.17u
X5901 cml_tlatch_48.xtail.S1 CKB2_P cml_tlatch_48.xmux.xn.S1 VSS sg13_lv_nmos ad=89.3f pd=0.85u as=89.3f ps=0.85u w=0.47u l=0.16u
X5902 MOT8_N A1_8_P cml_tlatch_42.xmux.xn.S1 VSS sg13_lv_nmos ad=63.19999f pd=0.74u as=63.19999f ps=0.74u w=0.26u l=0.38u
X5903 VSS hs_to_clk_8.sg13_lv_nmos_2HGZLP_0.G VSS VSS sg13_lv_nmos ad=2.071p pd=11.28u as=0 ps=0 w=10.9u l=1.38u
X5904 cml_tlatch_56.xtail.S1 POLN VSS VSS sg13_lv_nmos ad=1.5637p pd=8.61u as=1.5637p ps=8.61u w=8.23u l=0.13u
X5905 cml_tlatch_51.xmux.xp.S1 cml_tlatch_51.OUTP cml_tlatch_51.OUTN VSS sg13_lv_nmos ad=0.1019p pd=1.34u as=56.9f ps=0.74u w=0.17u l=0.17u
X5906 cml_tlatch_59.xmux.xp.S1 CKA2_N cml_tlatch_59.xtail.S1 VSS sg13_lv_nmos ad=0.1598p pd=1.62u as=89.3f ps=0.85u w=0.47u l=0.16u
X5907 cml_tlatch_10.xmux.xp.S1 B1_8_P B1_8_N VSS sg13_lv_nmos ad=56.9f pd=0.74u as=56.9f ps=0.74u w=0.17u l=0.17u
X5908 cml_tlatch_90.xtail.S1 CKB2_P cml_tlatch_90.xmux.xp.S1 VSS sg13_lv_nmos ad=89.3f pd=0.85u as=89.3f ps=0.85u w=0.47u l=0.16u
X5909 cml_tlatch_38.xmux.xp.S1 cml_tlatch_38.OUTP cml_tlatch_38.OUTN VSS sg13_lv_nmos ad=56.9f pd=0.74u as=56.9f ps=0.74u w=0.17u l=0.17u
X5910 cml_tlatch_79.xtail.S1 CKHB2_P cml_tlatch_79.xmux.xn.S1 VSS sg13_lv_nmos ad=89.3f pd=0.85u as=89.3f ps=0.85u w=0.47u l=0.16u
X5911 cml_tlatch_67.OUTN cml_tlatch_67.OUTP cml_tlatch_67.xmux.xp.S1 VSS sg13_lv_nmos ad=56.9f pd=0.74u as=56.9f ps=0.74u w=0.17u l=0.17u
X5912 cml_tlatch_56.xmux.xp.S1 cml_tlatch_56.OUTN cml_tlatch_56.OUTP VSS sg13_lv_nmos ad=56.9f pd=0.74u as=56.9f ps=0.74u w=0.17u l=0.17u
X5913 cml_tlatch_49.OUTP cml_tlatch_49.OUTN cml_tlatch_49.xmux.xp.S1 VSS sg13_lv_nmos ad=56.9f pd=0.74u as=56.9f ps=0.74u w=0.17u l=0.17u
X5914 VDD ENA0_N VSS rppd l=8.13u w=1u
X5915 cml_tlatch_60.xtail.S1 CKA2_P cml_tlatch_60.xmux.xp.S1 VSS sg13_lv_nmos ad=89.3f pd=0.85u as=89.3f ps=0.85u w=0.47u l=0.16u
X5916 MOT2_P MOT2_N cml_tlatch_27.xmux.xp.S1 VSS sg13_lv_nmos ad=56.9f pd=0.74u as=56.9f ps=0.74u w=0.17u l=0.17u
X5917 cml_tlatch_13.xmux.xp.S1 CKB1_N cml_tlatch_13.xtail.S1 VSS sg13_lv_nmos ad=89.3f pd=0.85u as=89.3f ps=0.85u w=0.47u l=0.16u
X5918 stub_bi_31.BOTP stub_bi_31.BOTN cml_tlatch_37.xmux.xp.S1 VSS sg13_lv_nmos ad=56.9f pd=0.74u as=56.9f ps=0.74u w=0.17u l=0.17u
X5919 cml_drv_0.xrtail.R1 ENB_P ENB1_N VSS sg13_lv_nmos ad=56.2f pd=0.74u as=56.2f ps=0.74u w=0.16u l=0.19u
X5920 cml_tlatch_69.xmux.xp.S1 cml_tlatch_69.OUTP cml_tlatch_69.OUTN VSS sg13_lv_nmos ad=0.1019p pd=1.34u as=56.9f ps=0.74u w=0.17u l=0.17u
X5921 cml_tlatch_10.xmux.xn.S1 stub_bi_15.BOTP B1_8_P VSS sg13_lv_nmos ad=63.19999f pd=0.74u as=0.1082p ps=1.34u w=0.26u l=0.38u
X5922 cml_tlatch_92.xmux.xp.S1 J4_N J4_P VSS sg13_lv_nmos ad=56.9f pd=0.74u as=56.9f ps=0.74u w=0.17u l=0.17u
X5923 cml_tlatch_70.xmux.xp.S1 cml_tlatch_63.INP cml_tlatch_63.INN VSS sg13_lv_nmos ad=56.9f pd=0.74u as=56.9f ps=0.74u w=0.17u l=0.17u
X5924 cml_tlatch_44.INP cml_tlatch_44.INN cml_tlatch_89.xmux.xp.S1 VSS sg13_lv_nmos ad=56.9f pd=0.74u as=56.9f ps=0.74u w=0.17u l=0.17u
X5925 cml_gate2_2.xamp.xn.S1 CKB1_P cml_gate2_2.xrtail.R1 VSS sg13_lv_nmos ad=0.1802p pd=1.74u as=0.1007p ps=0.91u w=0.53u l=0.13u
X5926 cml_tlatch_29.xtail.S1 CKHA0_N cml_tlatch_29.xmux.xp.S1 VSS sg13_lv_nmos ad=89.3f pd=0.85u as=89.3f ps=0.85u w=0.47u l=0.16u
X5927 cml_tlatch_41.OUTN D1_P cml_tlatch_41.xmux.xn.S1 VSS sg13_lv_nmos ad=63.19999f pd=0.74u as=63.19999f ps=0.74u w=0.26u l=0.38u
X5928 cml_tlatch_70.xmux.xn.S1 cml_tlatch_71.OUTN cml_tlatch_63.INP VSS sg13_lv_nmos ad=63.19999f pd=0.74u as=63.19999f ps=0.74u w=0.26u l=0.38u
X5929 cml_tlatch_41.xtail.S1 POLN VSS VSS sg13_lv_nmos ad=1.5637p pd=8.61u as=2.7982p ps=17.14u w=8.23u l=0.13u
X5930 cml_tlatch_35.xmux.xp.S1 stub_bi_29.BOTP stub_bi_29.BOTN VSS sg13_lv_nmos ad=56.9f pd=0.74u as=56.9f ps=0.74u w=0.17u l=0.17u
X5931 VSS POLN cml_tlatch_78.xtail.S1 VSS sg13_lv_nmos ad=1.5637p pd=8.61u as=1.5637p ps=8.61u w=8.23u l=0.13u
X5932 VSS cml_drv_1.xrtail.R1 VSS rppd l=5.65u w=1u
X5933 cml_tlatch_78.xtail.S1 CKHB2_N cml_tlatch_78.xmux.xp.S1 VSS sg13_lv_nmos ad=89.3f pd=0.85u as=89.3f ps=0.85u w=0.47u l=0.16u
X5934 cml_tlatch_67.OUTP cml_tlatch_67.OUTN cml_tlatch_67.xmux.xp.S1 VSS sg13_lv_nmos ad=56.9f pd=0.74u as=56.9f ps=0.74u w=0.17u l=0.17u
X5935 cml_tlatch_19.xmux.xp.S1 A1_8_N A1_8_P VSS sg13_lv_nmos ad=56.9f pd=0.74u as=56.9f ps=0.74u w=0.17u l=0.17u
X5936 stub_bi_43.BOTN stub_bi_43.BOTP cml_tlatch_48.xmux.xp.S1 VSS sg13_lv_nmos ad=56.9f pd=0.74u as=56.9f ps=0.74u w=0.17u l=0.17u
X5937 cml_gate2_1.xrtail.R1 CKA0_N GB0_P VSS sg13_lv_nmos ad=0.1007p pd=0.91u as=0.1007p ps=0.91u w=0.53u l=0.13u
X5938 cml_tlatch_41.xmux.xp.S1 cml_tlatch_41.OUTN cml_tlatch_41.OUTP VSS sg13_lv_nmos ad=56.9f pd=0.74u as=56.9f ps=0.74u w=0.17u l=0.17u
X5939 cml_tlatch_74.INN cml_tlatch_74.INP cml_tlatch_88.xmux.xp.S1 VSS sg13_lv_nmos ad=56.9f pd=0.74u as=56.9f ps=0.74u w=0.17u l=0.17u
X5940 cml_tlatch_44.xmux.xn.S1 cml_tlatch_44.INP MOT28_N VSS sg13_lv_nmos ad=63.19999f pd=0.74u as=63.19999f ps=0.74u w=0.26u l=0.38u
X5941 cml_tlatch_17.xtail.S1 CKHB0_N cml_tlatch_17.xmux.xp.S1 VSS sg13_lv_nmos ad=89.3f pd=0.85u as=89.3f ps=0.85u w=0.47u l=0.16u
X5942 cml_tlatch_4.xmux.xn.S1 cml_tlatch_4.INP MOT11_N VSS sg13_lv_nmos ad=63.19999f pd=0.74u as=63.19999f ps=0.74u w=0.26u l=0.38u
X5943 cml_tlatch_92.xmux.xp.S1 J4_N J4_P VSS sg13_lv_nmos ad=0.1019p pd=1.34u as=56.9f ps=0.74u w=0.17u l=0.17u
X5944 cml_tlatch_32.OUTP cml_tlatch_32.OUTN cml_tlatch_32.xmux.xp.S1 VSS sg13_lv_nmos ad=56.9f pd=0.74u as=56.9f ps=0.74u w=0.17u l=0.17u
X5945 MOT20_P MOT20_N cml_tlatch_54.xmux.xp.S1 VSS sg13_lv_nmos ad=56.9f pd=0.74u as=56.9f ps=0.74u w=0.17u l=0.17u
X5946 cml_tlatch_5.xmux.xp.S1 MOT13_P MOT13_N VSS sg13_lv_nmos ad=56.9f pd=0.74u as=56.9f ps=0.74u w=0.17u l=0.17u
X5947 cml_tlatch_87.OUTN cml_tlatch_87.INP cml_tlatch_87.xmux.xn.S1 VSS sg13_lv_nmos ad=63.19999f pd=0.74u as=0.1082p ps=1.34u w=0.26u l=0.38u
X5948 cml_tlatch_44.xmux.xn.S1 cml_tlatch_44.INP MOT28_N VSS sg13_lv_nmos ad=63.19999f pd=0.74u as=63.19999f ps=0.74u w=0.26u l=0.38u
X5949 cml_tlatch_3.xmux.xn.S1 CKHB1_P cml_tlatch_3.xtail.S1 VSS sg13_lv_nmos ad=89.3f pd=0.85u as=89.3f ps=0.85u w=0.47u l=0.16u
X5950 cml_tlatch_99.xmux.xn.S1 cml_tlatch_33.OUTN cml_tlatch_99.OUTP VSS sg13_lv_nmos ad=63.19999f pd=0.74u as=63.19999f ps=0.74u w=0.26u l=0.38u
X5951 cml_tlatch_96.xmux.xn.S1 stub_bi_29.BOTN cml_tlatch_5.INN VSS sg13_lv_nmos ad=63.19999f pd=0.74u as=63.19999f ps=0.74u w=0.26u l=0.38u
X5952 J1_P J1_N cml_tlatch_95.xmux.xp.S1 VSS sg13_lv_nmos ad=56.9f pd=0.74u as=56.9f ps=0.74u w=0.17u l=0.17u
X5953 cml_tlatch_93.xmux.xn.S1 CKJ_P cml_tlatch_93.xtail.S1 VSS sg13_lv_nmos ad=89.3f pd=0.85u as=89.3f ps=0.85u w=0.47u l=0.16u
X5954 cml_tlatch_44.xmux.xp.S1 MOT28_P MOT28_N VSS sg13_lv_nmos ad=56.9f pd=0.74u as=56.9f ps=0.74u w=0.17u l=0.17u
X5955 cml_tlatch_8.OUTP cml_tlatch_98.OUTN cml_tlatch_8.xmux.xn.S1 VSS sg13_lv_nmos ad=63.19999f pd=0.74u as=63.19999f ps=0.74u w=0.26u l=0.38u
X5956 MOT27_N cml_tlatch_73.INP cml_tlatch_73.xmux.xn.S1 VSS sg13_lv_nmos ad=63.19999f pd=0.74u as=63.19999f ps=0.74u w=0.26u l=0.38u
X5957 cml_tlatch_97.xmux.xn.S1 cml_tlatch_97.INN cml_tlatch_24.INP VSS sg13_lv_nmos ad=63.19999f pd=0.74u as=63.19999f ps=0.74u w=0.26u l=0.38u
X5958 cml_tlatch_89.xmux.xn.S1 CKA3_N cml_tlatch_89.xtail.S1 VSS sg13_lv_nmos ad=89.3f pd=0.85u as=89.3f ps=0.85u w=0.47u l=0.16u
X5959 cml_tlatch_63.xtail.S1 CKHA3_N cml_tlatch_63.xmux.xp.S1 VSS sg13_lv_nmos ad=89.3f pd=0.85u as=89.3f ps=0.85u w=0.47u l=0.16u
X5960 cml_drvb_1.xrtail.R2 VSS VSS rppd l=2.72u w=1u
X5961 cml_tlatch_65.xmux.xp.S1 cml_tlatch_65.OUTP cml_tlatch_65.OUTN VSS sg13_lv_nmos ad=56.9f pd=0.74u as=56.9f ps=0.74u w=0.17u l=0.17u
X5962 cml_tlatch_45.xtail.S1 CKHA3_P cml_tlatch_45.xmux.xn.S1 VSS sg13_lv_nmos ad=89.3f pd=0.85u as=0.1598p ps=1.62u w=0.47u l=0.16u
X5963 MOT16_N MOT16_P cml_tlatch_52.xmux.xp.S1 VSS sg13_lv_nmos ad=56.9f pd=0.74u as=56.9f ps=0.74u w=0.17u l=0.17u
X5964 cml_tlatch_79.xmux.xp.S1 CKHB2_N cml_tlatch_79.xtail.S1 VSS sg13_lv_nmos ad=0.1598p pd=1.62u as=89.3f ps=0.85u w=0.47u l=0.16u
X5965 cml_tlatch_13.xmux.xp.S1 stub_bi_17.BOTP stub_bi_17.BOTN VSS sg13_lv_nmos ad=56.9f pd=0.74u as=56.9f ps=0.74u w=0.17u l=0.17u
X5966 cml_tlatch_45.xmux.xp.S1 MOT30_N MOT30_P VSS sg13_lv_nmos ad=56.9f pd=0.74u as=56.9f ps=0.74u w=0.17u l=0.17u
X5967 cml_tlatch_62.xmux.xp.S1 MOT24_P MOT24_N VSS sg13_lv_nmos ad=56.9f pd=0.74u as=56.9f ps=0.74u w=0.17u l=0.17u
X5968 cml_tlatch_60.xmux.xp.S1 A2_2_N A2_2_P VSS sg13_lv_nmos ad=56.9f pd=0.74u as=56.9f ps=0.74u w=0.17u l=0.17u
X5969 cml_tlatch_51.OUTN D3_P cml_tlatch_51.xmux.xn.S1 VSS sg13_lv_nmos ad=63.19999f pd=0.74u as=63.19999f ps=0.74u w=0.26u l=0.38u
X5970 cml_tlatch_74.xmux.xp.S1 MOT29_P MOT29_N VSS sg13_lv_nmos ad=56.9f pd=0.74u as=56.9f ps=0.74u w=0.17u l=0.17u
X5971 cml_tlatch_15.xmux.xp.S1 MOT3_N MOT3_P VSS sg13_lv_nmos ad=56.9f pd=0.74u as=56.9f ps=0.74u w=0.17u l=0.17u
X5972 cml_tlatch_28.xmux.xp.S1 MOT4_N MOT4_P VSS sg13_lv_nmos ad=56.9f pd=0.74u as=56.9f ps=0.74u w=0.17u l=0.17u
X5973 cml_tlatch_88.xmux.xn.S1 CKB3_N cml_tlatch_88.xtail.S1 VSS sg13_lv_nmos ad=89.3f pd=0.85u as=89.3f ps=0.85u w=0.47u l=0.16u
X5974 A0_2_P cml_tlatch_38.OUTN cml_tlatch_34.xmux.xn.S1 VSS sg13_lv_nmos ad=63.19999f pd=0.74u as=0.1082p ps=1.34u w=0.26u l=0.38u
X5975 cml_tlatch_32.xmux.xn.S1 D0_P cml_tlatch_32.OUTN VSS sg13_lv_nmos ad=0.1082p pd=1.34u as=63.19999f ps=0.74u w=0.26u l=0.38u
X5976 MOT6_P A0_2_N cml_tlatch_29.xmux.xn.S1 VSS sg13_lv_nmos ad=0.1082p pd=1.34u as=63.19999f ps=0.74u w=0.26u l=0.38u
X5977 cml_gate2_6.xrtail.R1 CKA3_P cml_gate2_6.xamp.xn.S1 VSS sg13_lv_nmos ad=0.1007p pd=0.91u as=0.1007p ps=0.91u w=0.53u l=0.13u
X5978 cml_tlatch_53.xmux.xp.S1 MOT18_N MOT18_P VSS sg13_lv_nmos ad=56.9f pd=0.74u as=56.9f ps=0.74u w=0.17u l=0.17u
X5979 cml_tlatch_4.xtail.S1 CKHB1_P cml_tlatch_4.xmux.xn.S1 VSS sg13_lv_nmos ad=0.1598p pd=1.62u as=89.3f ps=0.85u w=0.47u l=0.16u
X5980 cml_tlatch_64.xtail.S1 CKB3_N cml_tlatch_64.xmux.xn.S1 VSS sg13_lv_nmos ad=89.3f pd=0.85u as=89.3f ps=0.85u w=0.47u l=0.16u
X5981 cml_tlatch_2.xmux.xp.S1 cml_tlatch_2.OUTP cml_tlatch_2.OUTN VSS sg13_lv_nmos ad=56.9f pd=0.74u as=56.9f ps=0.74u w=0.17u l=0.17u
X5982 cml_tlatch_12.xmux.xp.S1 cml_tlatch_4.INP cml_tlatch_4.INN VSS sg13_lv_nmos ad=56.9f pd=0.74u as=56.9f ps=0.74u w=0.17u l=0.17u
X5983 A0_8_N A0_8_P cml_tlatch_9.xmux.xp.S1 VSS sg13_lv_nmos ad=56.9f pd=0.74u as=56.9f ps=0.74u w=0.17u l=0.17u
X5984 cml_tlatch_23.xmux.xp.S1 cml_tlatch_23.OUTP cml_tlatch_23.OUTN VSS sg13_lv_nmos ad=56.9f pd=0.74u as=56.9f ps=0.74u w=0.17u l=0.17u
X5985 cml_tlatch_93.xmux.xp.S1 CLK_W_P CLK_W_N VSS sg13_lv_nmos ad=56.9f pd=0.74u as=56.9f ps=0.74u w=0.17u l=0.17u
X5986 MOT9_N B1_8_P cml_tlatch_3.xmux.xn.S1 VSS sg13_lv_nmos ad=63.19999f pd=0.74u as=63.19999f ps=0.74u w=0.26u l=0.38u
X5987 cml_tlatch_87.INP cml_tlatch_87.INN cml_tlatch_76.xmux.xp.S1 VSS sg13_lv_nmos ad=56.9f pd=0.74u as=0.1019p ps=1.34u w=0.17u l=0.17u
X5988 cml_tlatch_27.xtail.S1 CKHA0_P cml_tlatch_27.xmux.xn.S1 VSS sg13_lv_nmos ad=89.3f pd=0.85u as=89.3f ps=0.85u w=0.47u l=0.16u
X5989 J2_N J2_P cml_tlatch_94.xmux.xp.S1 VSS sg13_lv_nmos ad=56.9f pd=0.74u as=56.9f ps=0.74u w=0.17u l=0.17u
X5990 cml_tlatch_98.xmux.xn.S1 CKB0_N cml_tlatch_98.xtail.S1 VSS sg13_lv_nmos ad=89.3f pd=0.85u as=89.3f ps=0.85u w=0.47u l=0.16u
X5991 cml_tlatch_85.xmux.xp.S1 CKA2_P cml_tlatch_85.xtail.S1 VSS sg13_lv_nmos ad=89.3f pd=0.85u as=0.1598p ps=1.62u w=0.47u l=0.16u
X5992 B2_2_N B2_2_P cml_tlatch_47.xmux.xp.S1 VSS sg13_lv_nmos ad=56.9f pd=0.74u as=56.9f ps=0.74u w=0.17u l=0.17u
X5993 cml_tlatch_11.xmux.xn.S1 CKB1_P cml_tlatch_11.xtail.S1 VSS sg13_lv_nmos ad=89.3f pd=0.85u as=89.3f ps=0.85u w=0.47u l=0.16u
X5994 cml_tlatch_79.xmux.xp.S1 MOT21_N MOT21_P VSS sg13_lv_nmos ad=56.9f pd=0.74u as=56.9f ps=0.74u w=0.17u l=0.17u
X5995 VSS POLN cml_tlatch_80.xtail.S1 VSS sg13_lv_nmos ad=2.7982p pd=17.14u as=1.5637p ps=8.61u w=8.23u l=0.13u
X5996 cml_tlatch_82.xtail.S1 CKB2_N cml_tlatch_82.xmux.xp.S1 VSS sg13_lv_nmos ad=89.3f pd=0.85u as=89.3f ps=0.85u w=0.47u l=0.16u
X5997 cml_tlatch_90.xmux.xp.S1 stub_bi_55.BOTN stub_bi_55.BOTP VSS sg13_lv_nmos ad=56.9f pd=0.74u as=56.9f ps=0.74u w=0.17u l=0.17u
X5998 cml_tlatch_1.xmux.xp.S1 B0_8_N B0_8_P VSS sg13_lv_nmos ad=56.9f pd=0.74u as=56.9f ps=0.74u w=0.17u l=0.17u
X5999 cml_tlatch_39.xmux.xn.S1 A1_2_P cml_tlatch_97.INN VSS sg13_lv_nmos ad=63.19999f pd=0.74u as=63.19999f ps=0.74u w=0.26u l=0.38u
X6000 stub_bi_15.BOTN cml_tlatch_4.INN cml_tlatch_11.xmux.xn.S1 VSS sg13_lv_nmos ad=63.19999f pd=0.74u as=63.19999f ps=0.74u w=0.26u l=0.38u
X6001 cml_tlatch_35.xtail.S1 POLN VSS VSS sg13_lv_nmos ad=1.5637p pd=8.61u as=2.7982p ps=17.14u w=8.23u l=0.13u
X6002 cml_tlatch_91.OUTN cml_tlatch_91.INP cml_tlatch_91.xmux.xn.S1 VSS sg13_lv_nmos ad=63.19999f pd=0.74u as=63.19999f ps=0.74u w=0.26u l=0.38u
X6003 cml_tlatch_32.OUTN cml_tlatch_32.OUTP cml_tlatch_32.xmux.xp.S1 VSS sg13_lv_nmos ad=56.9f pd=0.74u as=0.1019p ps=1.34u w=0.17u l=0.17u
X6004 MOT2_P MOT2_N cml_tlatch_27.xmux.xp.S1 VSS sg13_lv_nmos ad=56.9f pd=0.74u as=56.9f ps=0.74u w=0.17u l=0.17u
X6005 cml_tlatch_25.xmux.xp.S1 MOT14_P MOT14_N VSS sg13_lv_nmos ad=56.9f pd=0.74u as=56.9f ps=0.74u w=0.17u l=0.17u
X6006 cml_tlatch_14.xtail.S1 CKHB0_N cml_tlatch_14.xmux.xp.S1 VSS sg13_lv_nmos ad=89.3f pd=0.85u as=89.3f ps=0.85u w=0.47u l=0.16u
X6007 cml_tlatch_62.xmux.xn.S1 CKHA3_P cml_tlatch_62.xtail.S1 VSS sg13_lv_nmos ad=89.3f pd=0.85u as=89.3f ps=0.85u w=0.47u l=0.16u
X6008 cml_tlatch_83.xtail.S1 CKB2_N cml_tlatch_83.xmux.xn.S1 VSS sg13_lv_nmos ad=89.3f pd=0.85u as=89.3f ps=0.85u w=0.47u l=0.16u
X6009 cml_tlatch_61.OUTN D2_P cml_tlatch_61.xmux.xn.S1 VSS sg13_lv_nmos ad=0.1082p pd=1.34u as=63.19999f ps=0.74u w=0.26u l=0.38u
X6010 cml_tlatch_0.OUTP cml_tlatch_0.OUTN cml_tlatch_0.xmux.xp.S1 VSS sg13_lv_nmos ad=56.9f pd=0.74u as=0.1019p ps=1.34u w=0.17u l=0.17u
X6011 B2_2_N stub_bi_43.BOTN cml_tlatch_47.xmux.xn.S1 VSS sg13_lv_nmos ad=63.19999f pd=0.74u as=63.19999f ps=0.74u w=0.26u l=0.38u
X6012 cml_tlatch_23.xmux.xn.S1 cml_tlatch_0.OUTN cml_tlatch_23.OUTP VSS sg13_lv_nmos ad=63.19999f pd=0.74u as=63.19999f ps=0.74u w=0.26u l=0.38u
X6013 cml_tlatch_33.xtail.S1 CKA0_N cml_tlatch_33.xmux.xp.S1 VSS sg13_lv_nmos ad=89.3f pd=0.85u as=89.3f ps=0.85u w=0.47u l=0.16u
X6014 cml_tlatch_77.xmux.xp.S1 MOT17_P MOT17_N VSS sg13_lv_nmos ad=56.9f pd=0.74u as=56.9f ps=0.74u w=0.17u l=0.17u
X6015 cml_tlatch_53.xtail.S1 CKHA2_P cml_tlatch_53.xmux.xn.S1 VSS sg13_lv_nmos ad=89.3f pd=0.85u as=89.3f ps=0.85u w=0.47u l=0.16u
X6016 cml_tlatch_1.xmux.xp.S1 CKB0_P cml_tlatch_1.xtail.S1 VSS sg13_lv_nmos ad=89.3f pd=0.85u as=89.3f ps=0.85u w=0.47u l=0.16u
X6017 cml_tlatch_34.xmux.xn.S1 CKA0_N cml_tlatch_34.xtail.S1 VSS sg13_lv_nmos ad=89.3f pd=0.85u as=89.3f ps=0.85u w=0.47u l=0.16u
X6018 cml_tlatch_28.xmux.xn.S1 CKHA0_P cml_tlatch_28.xtail.S1 VSS sg13_lv_nmos ad=0.1598p pd=1.62u as=89.3f ps=0.85u w=0.47u l=0.16u
X6019 cml_tlatch_99.OUTP cml_tlatch_99.OUTN cml_tlatch_99.xmux.xp.S1 VSS sg13_lv_nmos ad=56.9f pd=0.74u as=56.9f ps=0.74u w=0.17u l=0.17u
X6020 MOT5_P MOT5_N cml_tlatch_16.xmux.xp.S1 VSS sg13_lv_nmos ad=56.9f pd=0.74u as=56.9f ps=0.74u w=0.17u l=0.17u
X6021 ENA_P J1_N cml_gate2_9.xamp.xn.S1 VSS sg13_lv_nmos ad=0.1007p pd=0.91u as=0.1007p ps=0.91u w=0.53u l=0.13u
X6022 MOT20_P MOT20_N cml_tlatch_54.xmux.xp.S1 VSS sg13_lv_nmos ad=56.9f pd=0.74u as=56.9f ps=0.74u w=0.17u l=0.17u
X6023 cml_tlatch_3.xmux.xp.S1 MOT9_P MOT9_N VSS sg13_lv_nmos ad=56.9f pd=0.74u as=56.9f ps=0.74u w=0.17u l=0.17u
X6024 cml_tlatch_44.xmux.xp.S1 MOT28_N MOT28_P VSS sg13_lv_nmos ad=56.9f pd=0.74u as=56.9f ps=0.74u w=0.17u l=0.17u
X6025 cml_tlatch_87.INP cml_tlatch_87.INN cml_tlatch_76.xmux.xp.S1 VSS sg13_lv_nmos ad=56.9f pd=0.74u as=56.9f ps=0.74u w=0.17u l=0.17u
X6026 cml_tlatch_97.INP A1_2_N cml_tlatch_39.xmux.xn.S1 VSS sg13_lv_nmos ad=63.19999f pd=0.74u as=63.19999f ps=0.74u w=0.26u l=0.38u
X6027 cml_tlatch_65.OUTP cml_tlatch_65.OUTN cml_tlatch_65.xmux.xp.S1 VSS sg13_lv_nmos ad=56.9f pd=0.74u as=56.9f ps=0.74u w=0.17u l=0.17u
X6028 stub_bi_43.BOTP stub_bi_43.BOTN cml_tlatch_48.xmux.xp.S1 VSS sg13_lv_nmos ad=56.9f pd=0.74u as=56.9f ps=0.74u w=0.17u l=0.17u
X6029 cml_tlatch_96.xtail.S1 CKB1_N cml_tlatch_96.xmux.xn.S1 VSS sg13_lv_nmos ad=89.3f pd=0.85u as=89.3f ps=0.85u w=0.47u l=0.16u
X6030 cml_tlatch_50.xtail.S1 CKB3_N cml_tlatch_50.xmux.xn.S1 VSS sg13_lv_nmos ad=89.3f pd=0.85u as=89.3f ps=0.85u w=0.47u l=0.16u
X6031 cml_tlatch_90.xmux.xp.S1 stub_bi_55.BOTN stub_bi_55.BOTP VSS sg13_lv_nmos ad=56.9f pd=0.74u as=56.9f ps=0.74u w=0.17u l=0.17u
X6032 cml_tlatch_27.xmux.xp.S1 CKHA0_N cml_tlatch_27.xtail.S1 VSS sg13_lv_nmos ad=89.3f pd=0.85u as=89.3f ps=0.85u w=0.47u l=0.16u
X6033 cml_tlatch_87.xmux.xp.S1 CKA2_P cml_tlatch_87.xtail.S1 VSS sg13_lv_nmos ad=89.3f pd=0.85u as=89.3f ps=0.85u w=0.47u l=0.16u
X6034 cml_tlatch_32.xtail.S1 CKB0_N cml_tlatch_32.xmux.xp.S1 VSS sg13_lv_nmos ad=89.3f pd=0.85u as=89.3f ps=0.85u w=0.47u l=0.16u
X6035 cml_tlatch_32.OUTN cml_tlatch_32.OUTP cml_tlatch_32.xmux.xp.S1 VSS sg13_lv_nmos ad=56.9f pd=0.74u as=56.9f ps=0.74u w=0.17u l=0.17u
X6036 MOT10_P MOT10_N cml_tlatch_43.xmux.xp.S1 VSS sg13_lv_nmos ad=56.9f pd=0.74u as=0.1019p ps=1.34u w=0.17u l=0.17u
X6037 cml_tlatch_11.xmux.xp.S1 stub_bi_15.BOTP stub_bi_15.BOTN VSS sg13_lv_nmos ad=56.9f pd=0.74u as=56.9f ps=0.74u w=0.17u l=0.17u
X6038 cml_tlatch_87.OUTN cml_tlatch_87.OUTP cml_tlatch_87.xmux.xp.S1 VSS sg13_lv_nmos ad=56.9f pd=0.74u as=56.9f ps=0.74u w=0.17u l=0.17u
X6039 cml_tlatch_87.OUTP cml_tlatch_87.OUTN cml_tlatch_87.xmux.xp.S1 VSS sg13_lv_nmos ad=56.9f pd=0.74u as=56.9f ps=0.74u w=0.17u l=0.17u
X6040 cml_tlatch_83.xmux.xp.S1 stub_bi_63.BOTP stub_bi_63.BOTN VSS sg13_lv_nmos ad=56.9f pd=0.74u as=56.9f ps=0.74u w=0.17u l=0.17u
X6041 cml_tlatch_1.xmux.xp.S1 B0_8_P B0_8_N VSS sg13_lv_nmos ad=56.9f pd=0.74u as=56.9f ps=0.74u w=0.17u l=0.17u
X6042 cml_gate2_0.xrtail.R1 CKA1_N GB1_P VSS sg13_lv_nmos ad=0.1007p pd=0.91u as=0.1007p ps=0.91u w=0.53u l=0.13u
X6043 stub_bi_55.BOTN stub_bi_55.BOTP cml_tlatch_90.xmux.xp.S1 VSS sg13_lv_nmos ad=56.9f pd=0.74u as=56.9f ps=0.74u w=0.17u l=0.17u
X6044 cml_tlatch_98.xtail.S1 CKB0_P cml_tlatch_98.xmux.xp.S1 VSS sg13_lv_nmos ad=0.1598p pd=1.62u as=89.3f ps=0.85u w=0.47u l=0.16u
X6045 cml_tlatch_29.xmux.xp.S1 CKHA0_N cml_tlatch_29.xtail.S1 VSS sg13_lv_nmos ad=89.3f pd=0.85u as=0.1598p ps=1.62u w=0.47u l=0.16u
X6046 cml_tlatch_62.xmux.xp.S1 MOT24_P MOT24_N VSS sg13_lv_nmos ad=56.9f pd=0.74u as=56.9f ps=0.74u w=0.17u l=0.17u
X6047 cml_tlatch_54.xmux.xp.S1 CKHA2_N cml_tlatch_54.xtail.S1 VSS sg13_lv_nmos ad=89.3f pd=0.85u as=89.3f ps=0.85u w=0.47u l=0.16u
X6048 cml_tlatch_68.xtail.S1 CKA3_P cml_tlatch_68.xmux.xp.S1 VSS sg13_lv_nmos ad=89.3f pd=0.85u as=89.3f ps=0.85u w=0.47u l=0.16u
X6049 MOT15_N MOT15_P cml_tlatch_6.xmux.xp.S1 VSS sg13_lv_nmos ad=56.9f pd=0.74u as=56.9f ps=0.74u w=0.17u l=0.17u
X6050 cml_tlatch_15.xmux.xp.S1 MOT3_N MOT3_P VSS sg13_lv_nmos ad=0.1019p pd=1.34u as=56.9f ps=0.74u w=0.17u l=0.17u
X6051 cml_tlatch_41.OUTP D1_N cml_tlatch_41.xmux.xn.S1 VSS sg13_lv_nmos ad=63.19999f pd=0.74u as=0.1082p ps=1.34u w=0.26u l=0.38u
X6052 stub_bi_29.BOTP stub_bi_29.BOTN cml_tlatch_35.xmux.xp.S1 VSS sg13_lv_nmos ad=56.9f pd=0.74u as=0.1019p ps=1.34u w=0.17u l=0.17u
X6053 cml_tlatch_78.xmux.xn.S1 CKHB2_P cml_tlatch_78.xtail.S1 VSS sg13_lv_nmos ad=89.3f pd=0.85u as=89.3f ps=0.85u w=0.47u l=0.16u
X6054 cml_tlatch_14.xmux.xp.S1 MOT1_N MOT1_P VSS sg13_lv_nmos ad=56.9f pd=0.74u as=56.9f ps=0.74u w=0.17u l=0.17u
X6055 MOT8_N MOT8_P cml_tlatch_42.xmux.xp.S1 VSS sg13_lv_nmos ad=56.9f pd=0.74u as=56.9f ps=0.74u w=0.17u l=0.17u
X6056 cml_tlatch_65.xmux.xn.S1 cml_tlatch_73.INP cml_tlatch_65.OUTN VSS sg13_lv_nmos ad=63.19999f pd=0.74u as=63.19999f ps=0.74u w=0.26u l=0.38u
X6057 cml_tlatch_80.xmux.xn.S1 B2_2_N MOT23_P VSS sg13_lv_nmos ad=63.19999f pd=0.74u as=63.19999f ps=0.74u w=0.26u l=0.38u
X6058 A2_8_N A2_8_P cml_tlatch_85.xmux.xp.S1 VSS sg13_lv_nmos ad=56.9f pd=0.74u as=56.9f ps=0.74u w=0.17u l=0.17u
X6059 cml_tlatch_2.xmux.xp.S1 cml_tlatch_2.OUTP cml_tlatch_2.OUTN VSS sg13_lv_nmos ad=56.9f pd=0.74u as=56.9f ps=0.74u w=0.17u l=0.17u
X6060 VSS POLN cml_tlatch_77.xtail.S1 VSS sg13_lv_nmos ad=2.7982p pd=17.14u as=1.5637p ps=8.61u w=8.23u l=0.13u
X6061 cml_tlatch_43.xtail.S1 CKHA1_P cml_tlatch_43.xmux.xn.S1 VSS sg13_lv_nmos ad=89.3f pd=0.85u as=89.3f ps=0.85u w=0.47u l=0.16u
X6062 cml_tlatch_41.xmux.xp.S1 CKA1_N cml_tlatch_41.xtail.S1 VSS sg13_lv_nmos ad=89.3f pd=0.85u as=89.3f ps=0.85u w=0.47u l=0.16u
X6063 A1_2_P A1_2_N cml_tlatch_40.xmux.xp.S1 VSS sg13_lv_nmos ad=56.9f pd=0.74u as=56.9f ps=0.74u w=0.17u l=0.17u
X6064 cml_tlatch_93.xmux.xp.S1 CLK_W_P CLK_W_N VSS sg13_lv_nmos ad=56.9f pd=0.74u as=56.9f ps=0.74u w=0.17u l=0.17u
X6065 cml_tlatch_71.xmux.xp.S1 cml_tlatch_71.OUTP cml_tlatch_71.OUTN VSS sg13_lv_nmos ad=56.9f pd=0.74u as=56.9f ps=0.74u w=0.17u l=0.17u
X6066 MOT16_P MOT16_N cml_tlatch_52.xmux.xp.S1 VSS sg13_lv_nmos ad=56.9f pd=0.74u as=56.9f ps=0.74u w=0.17u l=0.17u
X6067 MOT23_N B2_2_P cml_tlatch_80.xmux.xn.S1 VSS sg13_lv_nmos ad=63.19999f pd=0.74u as=63.19999f ps=0.74u w=0.26u l=0.38u
X6068 cml_tlatch_93.xtail.S1 CKJ_P cml_tlatch_93.xmux.xn.S1 VSS sg13_lv_nmos ad=89.3f pd=0.85u as=89.3f ps=0.85u w=0.47u l=0.16u
X6069 cml_tlatch_33.xmux.xn.S1 A0_2_P cml_tlatch_33.OUTN VSS sg13_lv_nmos ad=63.19999f pd=0.74u as=63.19999f ps=0.74u w=0.26u l=0.38u
X6070 VSS POLN hs_to_clk_8.D2 VSS sg13_lv_nmos ad=1.9p pd=10.38u as=1.9p ps=10.38u w=10u l=0.13u
X6071 cml_gate2_7.xrtail.R1 CKA2_P cml_gate2_7.xamp.xn.S1 VSS sg13_lv_nmos ad=0.1007p pd=0.91u as=0.1007p ps=0.91u w=0.53u l=0.13u
X6072 MOT31_N MOT31_P cml_tlatch_75.xmux.xp.S1 VSS sg13_lv_nmos ad=56.9f pd=0.74u as=56.9f ps=0.74u w=0.17u l=0.17u
X6073 cml_tlatch_52.xmux.xn.S1 A2_8_P MOT16_N VSS sg13_lv_nmos ad=63.19999f pd=0.74u as=63.19999f ps=0.74u w=0.26u l=0.38u
X6074 cml_tlatch_79.xmux.xp.S1 MOT21_N MOT21_P VSS sg13_lv_nmos ad=56.9f pd=0.74u as=56.9f ps=0.74u w=0.17u l=0.17u
X6075 cml_tlatch_91.INP cml_tlatch_91.INN cml_tlatch_59.xmux.xp.S1 VSS sg13_lv_nmos ad=56.9f pd=0.74u as=56.9f ps=0.74u w=0.17u l=0.17u
X6076 VSS POLN cml_tlatch_66.xtail.S1 VSS sg13_lv_nmos ad=2.7982p pd=17.14u as=1.5637p ps=8.61u w=8.23u l=0.13u
X6077 B3_8_N cml_tlatch_65.OUTP cml_tlatch_64.xmux.xn.S1 VSS sg13_lv_nmos ad=63.19999f pd=0.74u as=63.19999f ps=0.74u w=0.26u l=0.38u
X6078 cml_tlatch_55.xmux.xp.S1 CKHA2_N cml_tlatch_55.xtail.S1 VSS sg13_lv_nmos ad=89.3f pd=0.85u as=89.3f ps=0.85u w=0.47u l=0.16u
X6079 VSS POLN cml_tlatch_6.xtail.S1 VSS sg13_lv_nmos ad=1.5637p pd=8.61u as=1.5637p ps=8.61u w=8.23u l=0.13u
X6080 cml_tlatch_74.xmux.xn.S1 cml_tlatch_74.INN MOT29_P VSS sg13_lv_nmos ad=63.19999f pd=0.74u as=0.1082p ps=1.34u w=0.26u l=0.38u
X6081 A3_8_P cml_tlatch_69.OUTN cml_tlatch_68.xmux.xn.S1 VSS sg13_lv_nmos ad=0.1082p pd=1.34u as=63.19999f ps=0.74u w=0.26u l=0.38u
X6082 cml_tlatch_51.OUTP cml_tlatch_51.OUTN cml_tlatch_51.xmux.xp.S1 VSS sg13_lv_nmos ad=56.9f pd=0.74u as=56.9f ps=0.74u w=0.17u l=0.17u
X6083 cml_tlatch_5.xmux.xp.S1 MOT13_N MOT13_P VSS sg13_lv_nmos ad=56.9f pd=0.74u as=56.9f ps=0.74u w=0.17u l=0.17u
X6084 cml_tlatch_65.xtail.S1 CKB3_P cml_tlatch_65.xmux.xn.S1 VSS sg13_lv_nmos ad=89.3f pd=0.85u as=89.3f ps=0.85u w=0.47u l=0.16u
X6085 cml_tlatch_60.xtail.S1 CKA2_P cml_tlatch_60.xmux.xp.S1 VSS sg13_lv_nmos ad=89.3f pd=0.85u as=89.3f ps=0.85u w=0.47u l=0.16u
X6086 cml_tlatch_23.xmux.xp.S1 CKA0_P cml_tlatch_23.xtail.S1 VSS sg13_lv_nmos ad=89.3f pd=0.85u as=89.3f ps=0.85u w=0.47u l=0.16u
X6087 cml_tlatch_22.OUTN cml_tlatch_22.OUTP cml_tlatch_22.xmux.xp.S1 VSS sg13_lv_nmos ad=56.9f pd=0.74u as=56.9f ps=0.74u w=0.17u l=0.17u
X6088 cml_gate2_9.xamp.xn.S1 NM1_P cml_gate2_9.xrtail.R1 VSS sg13_lv_nmos ad=0.1007p pd=0.91u as=0.1007p ps=0.91u w=0.53u l=0.13u
X6089 cml_tlatch_4.xmux.xn.S1 CKHB1_P cml_tlatch_4.xtail.S1 VSS sg13_lv_nmos ad=89.3f pd=0.85u as=89.3f ps=0.85u w=0.47u l=0.16u
X6090 stub_bi_29.BOTP stub_bi_29.BOTN cml_tlatch_35.xmux.xp.S1 VSS sg13_lv_nmos ad=56.9f pd=0.74u as=56.9f ps=0.74u w=0.17u l=0.17u
X6091 cml_gate2_8.xrtail.R1 NS1_N ENB_P VSS sg13_lv_nmos ad=0.1007p pd=0.91u as=0.1007p ps=0.91u w=0.53u l=0.13u
X6092 cml_tlatch_58.xmux.xp.S1 cml_tlatch_58.OUTP cml_tlatch_58.OUTN VSS sg13_lv_nmos ad=56.9f pd=0.74u as=56.9f ps=0.74u w=0.17u l=0.17u
X6093 cml_tlatch_55.xmux.xn.S1 A2_2_P MOT22_N VSS sg13_lv_nmos ad=63.19999f pd=0.74u as=63.19999f ps=0.74u w=0.26u l=0.38u
X6094 cml_tlatch_18.OUTP cml_tlatch_18.OUTN cml_tlatch_18.xmux.xp.S1 VSS sg13_lv_nmos ad=56.9f pd=0.74u as=56.9f ps=0.74u w=0.17u l=0.17u
X6095 VSS hs_to_clk_3.sg13_lv_nmos_2HGZLP_0.G VSS VSS sg13_lv_nmos ad=2.071p pd=11.28u as=0 ps=0 w=10.9u l=1.38u
X6096 cml_tlatch_37.xmux.xp.S1 stub_bi_31.BOTP stub_bi_31.BOTN VSS sg13_lv_nmos ad=56.9f pd=0.74u as=56.9f ps=0.74u w=0.17u l=0.17u
X6097 MOT25_N MOT25_P cml_tlatch_72.xmux.xp.S1 VSS sg13_lv_nmos ad=56.9f pd=0.74u as=56.9f ps=0.74u w=0.17u l=0.17u
X6098 cml_tlatch_1.xmux.xn.S1 cml_tlatch_2.OUTN B0_8_P VSS sg13_lv_nmos ad=63.19999f pd=0.74u as=0.1082p ps=1.34u w=0.26u l=0.38u
X6099 B0_2_N B0_2_P cml_tlatch_31.xmux.xp.S1 VSS sg13_lv_nmos ad=56.9f pd=0.74u as=56.9f ps=0.74u w=0.17u l=0.17u
X6100 cml_tlatch_4.INN stub_bi_17.BOTN cml_tlatch_12.xmux.xn.S1 VSS sg13_lv_nmos ad=63.19999f pd=0.74u as=63.19999f ps=0.74u w=0.26u l=0.38u
X6101 cml_tlatch_74.xtail.S1 CKHB3_P cml_tlatch_74.xmux.xn.S1 VSS sg13_lv_nmos ad=89.3f pd=0.85u as=89.3f ps=0.85u w=0.47u l=0.16u
X6102 MOT1_P B0_8_N cml_tlatch_14.xmux.xn.S1 VSS sg13_lv_nmos ad=63.19999f pd=0.74u as=63.19999f ps=0.74u w=0.26u l=0.38u
X6103 cml_tlatch_99.xmux.xp.S1 cml_tlatch_99.OUTP cml_tlatch_99.OUTN VSS sg13_lv_nmos ad=56.9f pd=0.74u as=56.9f ps=0.74u w=0.17u l=0.17u
X6104 cml_tlatch_41.OUTN cml_tlatch_41.OUTP cml_tlatch_41.xmux.xp.S1 VSS sg13_lv_nmos ad=56.9f pd=0.74u as=56.9f ps=0.74u w=0.17u l=0.17u
X6105 cml_tlatch_47.xtail.S1 CKB2_P cml_tlatch_47.xmux.xp.S1 VSS sg13_lv_nmos ad=0.1598p pd=1.62u as=89.3f ps=0.85u w=0.47u l=0.16u
X6106 cml_gate2_0.xamp.xn.S1 CKA1_P cml_gate2_0.xrtail.R1 VSS sg13_lv_nmos ad=0.1802p pd=1.74u as=0.1007p ps=0.91u w=0.53u l=0.13u
X6107 VSS POLN cml_tlatch_89.xtail.S1 VSS sg13_lv_nmos ad=2.7982p pd=17.14u as=1.5637p ps=8.61u w=8.23u l=0.13u
X6108 GA3_N ENA1_P cml_gate2_4.xamp.xn.S1 VSS sg13_lv_nmos ad=0.1007p pd=0.91u as=0.1007p ps=0.91u w=0.53u l=0.13u
X6109 cml_tlatch_17.xtail.S1 CKHB0_N cml_tlatch_17.xmux.xp.S1 VSS sg13_lv_nmos ad=89.3f pd=0.85u as=89.3f ps=0.85u w=0.47u l=0.16u
X6110 cml_tlatch_3.xmux.xp.S1 MOT9_P MOT9_N VSS sg13_lv_nmos ad=56.9f pd=0.74u as=56.9f ps=0.74u w=0.17u l=0.17u
X6111 cml_tlatch_11.xtail.S1 CKB1_P cml_tlatch_11.xmux.xn.S1 VSS sg13_lv_nmos ad=89.3f pd=0.85u as=0.1598p ps=1.62u w=0.47u l=0.16u
X6112 cml_tlatch_92.xmux.xn.S1 CLK_W_P J4_P VSS sg13_lv_nmos ad=63.19999f pd=0.74u as=63.19999f ps=0.74u w=0.26u l=0.38u
X6113 cml_tlatch_66.xmux.xn.S1 cml_tlatch_67.OUTP cml_tlatch_73.INN VSS sg13_lv_nmos ad=63.19999f pd=0.74u as=63.19999f ps=0.74u w=0.26u l=0.38u
X6114 cml_tlatch_19.xmux.xp.S1 A1_8_P A1_8_N VSS sg13_lv_nmos ad=56.9f pd=0.74u as=56.9f ps=0.74u w=0.17u l=0.17u
X6115 cml_tlatch_57.xmux.xp.S1 A3_2_N A3_2_P VSS sg13_lv_nmos ad=56.9f pd=0.74u as=56.9f ps=0.74u w=0.17u l=0.17u
X6116 cml_tlatch_49.OUTN cml_tlatch_49.OUTP cml_tlatch_49.xmux.xp.S1 VSS sg13_lv_nmos ad=56.9f pd=0.74u as=56.9f ps=0.74u w=0.17u l=0.17u
X6117 cml_tlatch_0.xtail.S1 CKA0_N cml_tlatch_0.xmux.xp.S1 VSS sg13_lv_nmos ad=89.3f pd=0.85u as=89.3f ps=0.85u w=0.47u l=0.16u
X6118 cml_tlatch_90.xtail.S1 POLN VSS VSS sg13_lv_nmos ad=1.5637p pd=8.61u as=2.7982p ps=17.14u w=8.23u l=0.13u
X6119 cml_tlatch_41.OUTN cml_tlatch_41.OUTP cml_tlatch_41.xmux.xp.S1 VSS sg13_lv_nmos ad=56.9f pd=0.74u as=56.9f ps=0.74u w=0.17u l=0.17u
X6120 MOT20_P cml_tlatch_91.OUTN cml_tlatch_54.xmux.xn.S1 VSS sg13_lv_nmos ad=63.19999f pd=0.74u as=63.19999f ps=0.74u w=0.26u l=0.38u
X6121 cml_tlatch_87.OUTN cml_tlatch_87.OUTP cml_tlatch_87.xmux.xp.S1 VSS sg13_lv_nmos ad=56.9f pd=0.74u as=56.9f ps=0.74u w=0.17u l=0.17u
X6122 stub_bi_55.BOTN stub_bi_38.BOTP cml_tlatch_90.xmux.xn.S1 VSS sg13_lv_nmos ad=63.19999f pd=0.74u as=63.19999f ps=0.74u w=0.26u l=0.38u
X6123 cml_tlatch_83.xmux.xp.S1 stub_bi_63.BOTP stub_bi_63.BOTN VSS sg13_lv_nmos ad=56.9f pd=0.74u as=56.9f ps=0.74u w=0.17u l=0.17u
X6124 cml_tlatch_83.xmux.xp.S1 stub_bi_63.BOTN stub_bi_63.BOTP VSS sg13_lv_nmos ad=56.9f pd=0.74u as=56.9f ps=0.74u w=0.17u l=0.17u
X6125 cml_tlatch_42.xmux.xp.S1 MOT8_N MOT8_P VSS sg13_lv_nmos ad=56.9f pd=0.74u as=56.9f ps=0.74u w=0.17u l=0.17u
X6126 MOT15_N MOT15_P cml_tlatch_6.xmux.xp.S1 VSS sg13_lv_nmos ad=56.9f pd=0.74u as=56.9f ps=0.74u w=0.17u l=0.17u
X6127 cml_tlatch_39.xmux.xp.S1 cml_tlatch_97.INN cml_tlatch_97.INP VSS sg13_lv_nmos ad=56.9f pd=0.74u as=56.9f ps=0.74u w=0.17u l=0.17u
X6128 cml_tlatch_8.xmux.xp.S1 cml_tlatch_8.OUTN cml_tlatch_8.OUTP VSS sg13_lv_nmos ad=56.9f pd=0.74u as=56.9f ps=0.74u w=0.17u l=0.17u
X6129 MOT18_N MOT18_P cml_tlatch_53.xmux.xp.S1 VSS sg13_lv_nmos ad=56.9f pd=0.74u as=56.9f ps=0.74u w=0.17u l=0.17u
X6130 cml_tlatch_53.xmux.xn.S1 CKHA2_P cml_tlatch_53.xtail.S1 VSS sg13_lv_nmos ad=89.3f pd=0.85u as=89.3f ps=0.85u w=0.47u l=0.16u
X6131 cml_tlatch_44.INN cml_tlatch_44.INP cml_tlatch_89.xmux.xp.S1 VSS sg13_lv_nmos ad=56.9f pd=0.74u as=56.9f ps=0.74u w=0.17u l=0.17u
X6132 cml_tlatch_33.OUTP cml_tlatch_33.OUTN cml_tlatch_33.xmux.xp.S1 VSS sg13_lv_nmos ad=56.9f pd=0.74u as=56.9f ps=0.74u w=0.17u l=0.17u
X6133 VSS hs_to_clk_1.sg13_lv_nmos_2HGZLP_0.G VSS VSS sg13_lv_nmos ad=3.706p pd=22.48u as=0 ps=0 w=10.9u l=1.38u
X6134 cml_tlatch_75.xtail.S1 CKHB3_P cml_tlatch_75.xmux.xn.S1 VSS sg13_lv_nmos ad=89.3f pd=0.85u as=0.1598p ps=1.62u w=0.47u l=0.16u
X6135 VSS POLN cml_tlatch_3.xtail.S1 VSS sg13_lv_nmos ad=1.5637p pd=8.61u as=1.5637p ps=8.61u w=8.23u l=0.13u
X6136 cml_tlatch_75.xmux.xp.S1 MOT31_N MOT31_P VSS sg13_lv_nmos ad=56.9f pd=0.74u as=56.9f ps=0.74u w=0.17u l=0.17u
X6137 cml_tlatch_84.xmux.xn.S1 stub_bi_55.BOTP stub_bi_49.BOTN VSS sg13_lv_nmos ad=63.19999f pd=0.74u as=63.19999f ps=0.74u w=0.26u l=0.38u
X6138 cml_tlatch_22.xmux.xp.S1 cml_tlatch_22.OUTN cml_tlatch_22.OUTP VSS sg13_lv_nmos ad=56.9f pd=0.74u as=56.9f ps=0.74u w=0.17u l=0.17u
X6139 cml_tlatch_82.xmux.xp.S1 stub_bi_62.BOTP stub_bi_62.BOTN VSS sg13_lv_nmos ad=56.9f pd=0.74u as=56.9f ps=0.74u w=0.17u l=0.17u
X6140 cml_tlatch_19.xtail.S1 CKA1_N cml_tlatch_19.xmux.xn.S1 VSS sg13_lv_nmos ad=89.3f pd=0.85u as=89.3f ps=0.85u w=0.47u l=0.16u
X6141 cml_tlatch_97.xmux.xp.S1 cml_tlatch_24.INP cml_tlatch_24.INN VSS sg13_lv_nmos ad=56.9f pd=0.74u as=56.9f ps=0.74u w=0.17u l=0.17u
X6142 A1_2_N cml_tlatch_41.OUTP cml_tlatch_40.xmux.xn.S1 VSS sg13_lv_nmos ad=0.1082p pd=1.34u as=63.19999f ps=0.74u w=0.26u l=0.38u
X6143 cml_tlatch_5.INN cml_tlatch_5.INP cml_tlatch_96.xmux.xp.S1 VSS sg13_lv_nmos ad=56.9f pd=0.74u as=56.9f ps=0.74u w=0.17u l=0.17u
X6144 MOT7_P B0_2_N cml_tlatch_17.xmux.xn.S1 VSS sg13_lv_nmos ad=0.1082p pd=1.34u as=63.19999f ps=0.74u w=0.26u l=0.38u
X6145 cml_tlatch_73.xmux.xp.S1 CKHB3_N cml_tlatch_73.xtail.S1 VSS sg13_lv_nmos ad=89.3f pd=0.85u as=89.3f ps=0.85u w=0.47u l=0.16u
X6146 cml_tlatch_87.xmux.xn.S1 cml_tlatch_87.INP cml_tlatch_87.OUTN VSS sg13_lv_nmos ad=63.19999f pd=0.74u as=63.19999f ps=0.74u w=0.26u l=0.38u
X6147 cml_tlatch_63.xmux.xn.S1 CKHA3_P cml_tlatch_63.xtail.S1 VSS sg13_lv_nmos ad=89.3f pd=0.85u as=89.3f ps=0.85u w=0.47u l=0.16u
X6148 MOT12_N VDD VSS rppd l=5.17u w=1u
X6149 cml_tlatch_8.xmux.xn.S1 cml_tlatch_98.OUTN cml_tlatch_8.OUTP VSS sg13_lv_nmos ad=63.19999f pd=0.74u as=63.19999f ps=0.74u w=0.26u l=0.38u
X6150 cml_tlatch_31.xtail.S1 CKB0_P cml_tlatch_31.xmux.xp.S1 VSS sg13_lv_nmos ad=89.3f pd=0.85u as=89.3f ps=0.85u w=0.47u l=0.16u
X6151 A3_8_N A3_8_P cml_tlatch_68.xmux.xp.S1 VSS sg13_lv_nmos ad=56.9f pd=0.74u as=56.9f ps=0.74u w=0.17u l=0.17u
X6152 cml_tlatch_88.xmux.xn.S1 cml_tlatch_49.OUTP cml_tlatch_74.INN VSS sg13_lv_nmos ad=63.19999f pd=0.74u as=0.1082p ps=1.34u w=0.26u l=0.38u
X6153 cml_tlatch_71.xtail.S1 CKA3_N cml_tlatch_71.xmux.xp.S1 VSS sg13_lv_nmos ad=89.3f pd=0.85u as=89.3f ps=0.85u w=0.47u l=0.16u
X6154 cml_tlatch_30.OUTN cml_tlatch_30.OUTP cml_tlatch_30.xmux.xp.S1 VSS sg13_lv_nmos ad=56.9f pd=0.74u as=56.9f ps=0.74u w=0.17u l=0.17u
X6155 cml_tlatch_10.xtail.S1 CKB1_N cml_tlatch_10.xmux.xn.S1 VSS sg13_lv_nmos ad=89.3f pd=0.85u as=89.3f ps=0.85u w=0.47u l=0.16u
X6156 cml_tlatch_69.xtail.S1 POLN VSS VSS sg13_lv_nmos ad=1.5637p pd=8.61u as=2.7982p ps=17.14u w=8.23u l=0.13u
X6157 cml_tlatch_53.xmux.xn.S1 cml_tlatch_87.OUTN MOT18_P VSS sg13_lv_nmos ad=63.19999f pd=0.74u as=63.19999f ps=0.74u w=0.26u l=0.38u
X6158 cml_tlatch_0.xmux.xp.S1 cml_tlatch_0.OUTP cml_tlatch_0.OUTN VSS sg13_lv_nmos ad=56.9f pd=0.74u as=56.9f ps=0.74u w=0.17u l=0.17u
X6159 cml_tlatch_85.xtail.S1 CKA2_N cml_tlatch_85.xmux.xn.S1 VSS sg13_lv_nmos ad=89.3f pd=0.85u as=89.3f ps=0.85u w=0.47u l=0.16u
X6160 cml_tlatch_14.xtail.S1 CKHB0_N cml_tlatch_14.xmux.xp.S1 VSS sg13_lv_nmos ad=89.3f pd=0.85u as=89.3f ps=0.85u w=0.47u l=0.16u
X6161 cml_tlatch_58.xmux.xp.S1 cml_tlatch_58.OUTP cml_tlatch_58.OUTN VSS sg13_lv_nmos ad=56.9f pd=0.74u as=56.9f ps=0.74u w=0.17u l=0.17u
X6162 cml_gate2_3.xamp.xn.S1 CKB0_P cml_gate2_3.xrtail.R1 VSS sg13_lv_nmos ad=0.1007p pd=0.91u as=0.1007p ps=0.91u w=0.53u l=0.13u
X6163 cml_tlatch_19.xmux.xp.S1 A1_8_P A1_8_N VSS sg13_lv_nmos ad=56.9f pd=0.74u as=56.9f ps=0.74u w=0.17u l=0.17u
X6164 cml_tlatch_51.OUTN cml_tlatch_51.OUTP cml_tlatch_51.xmux.xp.S1 VSS sg13_lv_nmos ad=56.9f pd=0.74u as=56.9f ps=0.74u w=0.17u l=0.17u
X6165 B1_8_N B1_8_P cml_tlatch_10.xmux.xp.S1 VSS sg13_lv_nmos ad=56.9f pd=0.74u as=56.9f ps=0.74u w=0.17u l=0.17u
X6166 cml_tlatch_92.xmux.xp.S1 J4_P J4_N VSS sg13_lv_nmos ad=56.9f pd=0.74u as=56.9f ps=0.74u w=0.17u l=0.17u
X6167 cml_tlatch_38.OUTN cml_tlatch_38.OUTP cml_tlatch_38.xmux.xp.S1 VSS sg13_lv_nmos ad=56.9f pd=0.74u as=0.1019p ps=1.34u w=0.17u l=0.17u
X6168 MOT9_P MOT9_N cml_tlatch_3.xmux.xp.S1 VSS sg13_lv_nmos ad=56.9f pd=0.74u as=56.9f ps=0.74u w=0.17u l=0.17u
X6169 cml_tlatch_51.xmux.xn.S1 D3_P cml_tlatch_51.OUTN VSS sg13_lv_nmos ad=63.19999f pd=0.74u as=63.19999f ps=0.74u w=0.26u l=0.38u
X6170 B1_2_P B1_2_N cml_tlatch_36.xmux.xp.S1 VSS sg13_lv_nmos ad=56.9f pd=0.74u as=56.9f ps=0.74u w=0.17u l=0.17u
X6171 B0_2_N B0_2_P cml_tlatch_31.xmux.xp.S1 VSS sg13_lv_nmos ad=56.9f pd=0.74u as=56.9f ps=0.74u w=0.17u l=0.17u
X6172 cml_tlatch_49.xmux.xn.S1 CKB3_P cml_tlatch_49.xtail.S1 VSS sg13_lv_nmos ad=89.3f pd=0.85u as=89.3f ps=0.85u w=0.47u l=0.16u
X6173 cml_tlatch_56.OUTP cml_tlatch_56.OUTN cml_tlatch_56.xmux.xp.S1 VSS sg13_lv_nmos ad=56.9f pd=0.74u as=56.9f ps=0.74u w=0.17u l=0.17u
X6174 cml_tlatch_53.xtail.S1 CKHA2_N cml_tlatch_53.xmux.xp.S1 VSS sg13_lv_nmos ad=89.3f pd=0.85u as=89.3f ps=0.85u w=0.47u l=0.16u
X6175 cml_tlatch_27.xmux.xp.S1 MOT2_N MOT2_P VSS sg13_lv_nmos ad=56.9f pd=0.74u as=56.9f ps=0.74u w=0.17u l=0.17u
X6176 cml_tlatch_28.xmux.xn.S1 CKHA0_P cml_tlatch_28.xtail.S1 VSS sg13_lv_nmos ad=89.3f pd=0.85u as=89.3f ps=0.85u w=0.47u l=0.16u
X6177 cml_tlatch_37.xmux.xp.S1 stub_bi_31.BOTN stub_bi_31.BOTP VSS sg13_lv_nmos ad=56.9f pd=0.74u as=56.9f ps=0.74u w=0.17u l=0.17u
X6178 cml_tlatch_54.xmux.xp.S1 MOT20_P MOT20_N VSS sg13_lv_nmos ad=56.9f pd=0.74u as=56.9f ps=0.74u w=0.17u l=0.17u
X6179 cml_tlatch_7.OUTP cml_tlatch_7.OUTN cml_tlatch_7.xmux.xp.S1 VSS sg13_lv_nmos ad=56.9f pd=0.74u as=56.9f ps=0.74u w=0.17u l=0.17u
X6180 cml_tlatch_63.INP cml_tlatch_63.INN cml_tlatch_70.xmux.xp.S1 VSS sg13_lv_nmos ad=56.9f pd=0.74u as=56.9f ps=0.74u w=0.17u l=0.17u
X6181 cml_tlatch_71.OUTP cml_tlatch_44.INN cml_tlatch_71.xmux.xn.S1 VSS sg13_lv_nmos ad=63.19999f pd=0.74u as=63.19999f ps=0.74u w=0.26u l=0.38u
X6182 VSS POLN cml_tlatch_96.xtail.S1 VSS sg13_lv_nmos ad=1.5637p pd=8.61u as=1.5637p ps=8.61u w=8.23u l=0.13u
X6183 cml_tlatch_89.xmux.xp.S1 cml_tlatch_44.INN cml_tlatch_44.INP VSS sg13_lv_nmos ad=56.9f pd=0.74u as=56.9f ps=0.74u w=0.17u l=0.17u
X6184 GA2_P ENA1_N cml_gate2_5.xamp.xn.S1 VSS sg13_lv_nmos ad=0.1802p pd=1.74u as=0.1007p ps=0.91u w=0.53u l=0.13u
X6185 cml_tlatch_9.xmux.xp.S1 A0_8_N A0_8_P VSS sg13_lv_nmos ad=56.9f pd=0.74u as=56.9f ps=0.74u w=0.17u l=0.17u
X6186 cml_tlatch_39.xmux.xp.S1 cml_tlatch_97.INN cml_tlatch_97.INP VSS sg13_lv_nmos ad=56.9f pd=0.74u as=56.9f ps=0.74u w=0.17u l=0.17u
X6187 cml_tlatch_55.xtail.S1 CKHA2_N cml_tlatch_55.xmux.xp.S1 VSS sg13_lv_nmos ad=89.3f pd=0.85u as=89.3f ps=0.85u w=0.47u l=0.16u
X6188 stub_bi_29.BOTN stub_bi_29.BOTP cml_tlatch_35.xmux.xp.S1 VSS sg13_lv_nmos ad=56.9f pd=0.74u as=56.9f ps=0.74u w=0.17u l=0.17u
X6189 cml_tlatch_42.xmux.xn.S1 CKHA1_P cml_tlatch_42.xtail.S1 VSS sg13_lv_nmos ad=89.3f pd=0.85u as=89.3f ps=0.85u w=0.47u l=0.16u
X6190 VSS POLN cml_tlatch_59.xtail.S1 VSS sg13_lv_nmos ad=1.5637p pd=8.61u as=1.5637p ps=8.61u w=8.23u l=0.13u
X6191 cml_tlatch_59.xtail.S1 CKA2_N cml_tlatch_59.xmux.xp.S1 VSS sg13_lv_nmos ad=89.3f pd=0.85u as=89.3f ps=0.85u w=0.47u l=0.16u
X6192 cml_tlatch_99.xmux.xn.S1 cml_tlatch_33.OUTP cml_tlatch_99.OUTN VSS sg13_lv_nmos ad=63.19999f pd=0.74u as=63.19999f ps=0.74u w=0.26u l=0.38u
X6193 CKA3_N CK_N hs_to_clk_6.D2 VSS sg13_lv_nmos ad=0.408p pd=3.08u as=0.228p ps=1.58u w=1.2u l=0.2u
X6194 cml_tlatch_59.xmux.xp.S1 cml_tlatch_91.INP cml_tlatch_91.INN VSS sg13_lv_nmos ad=56.9f pd=0.74u as=56.9f ps=0.74u w=0.17u l=0.17u
X6195 ENB0_N VDD VSS rppd l=8.13u w=1u
X6196 A1_8_P A1_8_N cml_tlatch_19.xmux.xp.S1 VSS sg13_lv_nmos ad=56.9f pd=0.74u as=56.9f ps=0.74u w=0.17u l=0.17u
X6197 MOT25_P MOT25_N cml_tlatch_72.xmux.xp.S1 VSS sg13_lv_nmos ad=56.9f pd=0.74u as=56.9f ps=0.74u w=0.17u l=0.17u
X6198 cml_tlatch_81.xmux.xp.S1 B2_8_N B2_8_P VSS sg13_lv_nmos ad=56.9f pd=0.74u as=56.9f ps=0.74u w=0.17u l=0.17u
X6199 GA2_N ENA1_P cml_gate2_5.xamp.xn.S1 VSS sg13_lv_nmos ad=0.1007p pd=0.91u as=0.1007p ps=0.91u w=0.53u l=0.13u
X6200 cml_tlatch_48.xmux.xp.S1 stub_bi_43.BOTP stub_bi_43.BOTN VSS sg13_lv_nmos ad=56.9f pd=0.74u as=56.9f ps=0.74u w=0.17u l=0.17u
X6201 cml_tlatch_29.xmux.xp.S1 MOT6_N MOT6_P VSS sg13_lv_nmos ad=56.9f pd=0.74u as=56.9f ps=0.74u w=0.17u l=0.17u
X6202 cml_tlatch_32.xtail.S1 CKB0_N cml_tlatch_32.xmux.xp.S1 VSS sg13_lv_nmos ad=89.3f pd=0.85u as=89.3f ps=0.85u w=0.47u l=0.16u
X6203 cml_tlatch_40.xtail.S1 CKA1_N cml_tlatch_40.xmux.xn.S1 VSS sg13_lv_nmos ad=89.3f pd=0.85u as=89.3f ps=0.85u w=0.47u l=0.16u
X6204 cml_tlatch_5.xtail.S1 CKHB1_N cml_tlatch_5.xmux.xp.S1 VSS sg13_lv_nmos ad=89.3f pd=0.85u as=89.3f ps=0.85u w=0.47u l=0.16u
X6205 VSS hs_to_clk_3.sg13_lv_nmos_2HGZLP_0.G VSS VSS sg13_lv_nmos ad=3.706p pd=22.48u as=0 ps=0 w=10.9u l=1.38u
X6206 cml_tlatch_72.xtail.S1 CKHB3_P cml_tlatch_72.xmux.xn.S1 VSS sg13_lv_nmos ad=89.3f pd=0.85u as=0.1598p ps=1.62u w=0.47u l=0.16u
X6207 cml_tlatch_69.OUTP cml_tlatch_69.OUTN cml_tlatch_69.xmux.xp.S1 VSS sg13_lv_nmos ad=56.9f pd=0.74u as=56.9f ps=0.74u w=0.17u l=0.17u
X6208 cml_tlatch_8.xmux.xp.S1 cml_tlatch_8.OUTN cml_tlatch_8.OUTP VSS sg13_lv_nmos ad=56.9f pd=0.74u as=56.9f ps=0.74u w=0.17u l=0.17u
X6209 MOT13_P cml_tlatch_5.INN cml_tlatch_5.xmux.xn.S1 VSS sg13_lv_nmos ad=63.19999f pd=0.74u as=63.19999f ps=0.74u w=0.26u l=0.38u
X6210 cml_tlatch_45.xtail.S1 CKHA3_N cml_tlatch_45.xmux.xp.S1 VSS sg13_lv_nmos ad=89.3f pd=0.85u as=89.3f ps=0.85u w=0.47u l=0.16u
X6211 cml_tlatch_46.xtail.S1 CKB2_N cml_tlatch_46.xmux.xp.S1 VSS sg13_lv_nmos ad=89.3f pd=0.85u as=89.3f ps=0.85u w=0.47u l=0.16u
X6212 cml_tlatch_7.xmux.xn.S1 cml_tlatch_8.OUTP cml_tlatch_7.OUTN VSS sg13_lv_nmos ad=0.1082p pd=1.34u as=63.19999f ps=0.74u w=0.26u l=0.38u
X6213 cml_tlatch_71.OUTP cml_tlatch_71.OUTN cml_tlatch_71.xmux.xp.S1 VSS sg13_lv_nmos ad=56.9f pd=0.74u as=56.9f ps=0.74u w=0.17u l=0.17u
X6214 MOT13_P cml_tlatch_5.INN cml_tlatch_5.xmux.xn.S1 VSS sg13_lv_nmos ad=63.19999f pd=0.74u as=63.19999f ps=0.74u w=0.26u l=0.38u
X6215 cml_tlatch_63.xmux.xp.S1 MOT26_P MOT26_N VSS sg13_lv_nmos ad=56.9f pd=0.74u as=56.9f ps=0.74u w=0.17u l=0.17u
X6216 cml_tlatch_98.xmux.xp.S1 cml_tlatch_98.OUTP cml_tlatch_98.OUTN VSS sg13_lv_nmos ad=56.9f pd=0.74u as=56.9f ps=0.74u w=0.17u l=0.17u
X6217 VSS POLN cml_tlatch_9.xtail.S1 VSS sg13_lv_nmos ad=2.7982p pd=17.14u as=1.5637p ps=8.61u w=8.23u l=0.13u
X6218 cml_tlatch_88.xmux.xp.S1 cml_tlatch_74.INP cml_tlatch_74.INN VSS sg13_lv_nmos ad=56.9f pd=0.74u as=56.9f ps=0.74u w=0.17u l=0.17u
X6219 cml_tlatch_36.xtail.S1 CKB1_N cml_tlatch_36.xmux.xn.S1 VSS sg13_lv_nmos ad=89.3f pd=0.85u as=89.3f ps=0.85u w=0.47u l=0.16u
X6220 cml_tlatch_17.xmux.xp.S1 CKHB0_N cml_tlatch_17.xtail.S1 VSS sg13_lv_nmos ad=89.3f pd=0.85u as=0.1598p ps=1.62u w=0.47u l=0.16u
X6221 MOT10_N cml_tlatch_43.INP cml_tlatch_43.xmux.xn.S1 VSS sg13_lv_nmos ad=63.19999f pd=0.74u as=63.19999f ps=0.74u w=0.26u l=0.38u
X6222 cml_tlatch_20.xmux.xp.S1 CKA1_N cml_tlatch_20.xtail.S1 VSS sg13_lv_nmos ad=89.3f pd=0.85u as=89.3f ps=0.85u w=0.47u l=0.16u
X6223 cml_tlatch_60.xtail.S1 CKA2_N cml_tlatch_60.xmux.xn.S1 VSS sg13_lv_nmos ad=89.3f pd=0.85u as=89.3f ps=0.85u w=0.47u l=0.16u
X6224 cml_tlatch_55.xmux.xp.S1 MOT22_N MOT22_P VSS sg13_lv_nmos ad=56.9f pd=0.74u as=56.9f ps=0.74u w=0.17u l=0.17u
X6225 stub_bi_17.BOTN stub_bi_17.BOTP cml_tlatch_13.xmux.xp.S1 VSS sg13_lv_nmos ad=56.9f pd=0.74u as=56.9f ps=0.74u w=0.17u l=0.17u
X6226 ENA0_P ENA_N cml_drv_3.xrtail.R1 VSS sg13_lv_nmos ad=56.2f pd=0.74u as=56.2f ps=0.74u w=0.16u l=0.19u
X6227 MOT10_N MOT10_P cml_tlatch_43.xmux.xp.S1 VSS sg13_lv_nmos ad=56.9f pd=0.74u as=56.9f ps=0.74u w=0.17u l=0.17u
X6228 cml_tlatch_95.xmux.xn.S1 J4_P J1_P VSS sg13_lv_nmos ad=63.19999f pd=0.74u as=63.19999f ps=0.74u w=0.26u l=0.38u
X6229 cml_tlatch_5.INN cml_tlatch_5.INP cml_tlatch_96.xmux.xp.S1 VSS sg13_lv_nmos ad=56.9f pd=0.74u as=56.9f ps=0.74u w=0.17u l=0.17u
X6230 cml_tlatch_64.xtail.S1 CKB3_P cml_tlatch_64.xmux.xp.S1 VSS sg13_lv_nmos ad=89.3f pd=0.85u as=89.3f ps=0.85u w=0.47u l=0.16u
X6231 hs_to_clk_3.D2 POLN VSS VSS sg13_lv_nmos ad=3.4p pd=20.68u as=1.9p ps=10.38u w=10u l=0.13u
X6232 MOT3_P MOT3_N cml_tlatch_15.xmux.xp.S1 VSS sg13_lv_nmos ad=56.9f pd=0.74u as=56.9f ps=0.74u w=0.17u l=0.17u
X6233 cml_tlatch_30.xtail.S1 CKB0_N cml_tlatch_30.xmux.xp.S1 VSS sg13_lv_nmos ad=0.1598p pd=1.62u as=89.3f ps=0.85u w=0.47u l=0.16u
X6234 MOT4_P MOT4_N cml_tlatch_28.xmux.xp.S1 VSS sg13_lv_nmos ad=56.9f pd=0.74u as=56.9f ps=0.74u w=0.17u l=0.17u
X6235 cml_gate2_0.xamp.xn.S1 ENB1_N GB1_P VSS sg13_lv_nmos ad=0.1007p pd=0.91u as=0.1007p ps=0.91u w=0.53u l=0.13u
X6236 cml_tlatch_9.xmux.xp.S1 A0_8_P A0_8_N VSS sg13_lv_nmos ad=56.9f pd=0.74u as=56.9f ps=0.74u w=0.17u l=0.17u
X6237 cml_tlatch_23.OUTN cml_tlatch_23.OUTP cml_tlatch_23.xmux.xp.S1 VSS sg13_lv_nmos ad=56.9f pd=0.74u as=56.9f ps=0.74u w=0.17u l=0.17u
X6238 cml_tlatch_86.xmux.xn.S1 cml_tlatch_87.OUTP cml_tlatch_86.OUTN VSS sg13_lv_nmos ad=63.19999f pd=0.74u as=63.19999f ps=0.74u w=0.26u l=0.38u
X6239 cml_tlatch_79.xtail.S1 CKHB2_N cml_tlatch_79.xmux.xp.S1 VSS sg13_lv_nmos ad=89.3f pd=0.85u as=89.3f ps=0.85u w=0.47u l=0.16u
X6240 cml_tlatch_51.xtail.S1 CKB3_P cml_tlatch_51.xmux.xn.S1 VSS sg13_lv_nmos ad=89.3f pd=0.85u as=89.3f ps=0.85u w=0.47u l=0.16u
X6241 cml_tlatch_2.OUTP cml_tlatch_2.OUTN cml_tlatch_2.xmux.xp.S1 VSS sg13_lv_nmos ad=56.9f pd=0.74u as=56.9f ps=0.74u w=0.17u l=0.17u
X6242 cml_tlatch_11.xmux.xp.S1 stub_bi_15.BOTN stub_bi_15.BOTP VSS sg13_lv_nmos ad=56.9f pd=0.74u as=56.9f ps=0.74u w=0.17u l=0.17u
X6243 cml_tlatch_94.xmux.xp.S1 J2_P J2_N VSS sg13_lv_nmos ad=56.9f pd=0.74u as=56.9f ps=0.74u w=0.17u l=0.17u
X6244 cml_tlatch_94.xmux.xp.S1 J2_N J2_P VSS sg13_lv_nmos ad=56.9f pd=0.74u as=56.9f ps=0.74u w=0.17u l=0.17u
X6245 cml_tlatch_86.xmux.xn.S1 cml_tlatch_87.OUTP cml_tlatch_86.OUTN VSS sg13_lv_nmos ad=63.19999f pd=0.74u as=63.19999f ps=0.74u w=0.26u l=0.38u
X6246 cml_tlatch_66.xmux.xp.S1 cml_tlatch_73.INN cml_tlatch_73.INP VSS sg13_lv_nmos ad=56.9f pd=0.74u as=56.9f ps=0.74u w=0.17u l=0.17u
X6247 MOT26_N MOT26_P cml_tlatch_63.xmux.xp.S1 VSS sg13_lv_nmos ad=56.9f pd=0.74u as=56.9f ps=0.74u w=0.17u l=0.17u
X6248 cml_tlatch_80.xmux.xp.S1 CKHB2_N cml_tlatch_80.xtail.S1 VSS sg13_lv_nmos ad=89.3f pd=0.85u as=89.3f ps=0.85u w=0.47u l=0.16u
X6249 cml_tlatch_47.xmux.xp.S1 B2_2_P B2_2_N VSS sg13_lv_nmos ad=56.9f pd=0.74u as=56.9f ps=0.74u w=0.17u l=0.17u
X6250 cml_tlatch_34.xmux.xp.S1 A0_2_N A0_2_P VSS sg13_lv_nmos ad=56.9f pd=0.74u as=56.9f ps=0.74u w=0.17u l=0.17u
X6251 MOT0_N MOT0_P cml_tlatch_26.xmux.xp.S1 VSS sg13_lv_nmos ad=56.9f pd=0.74u as=56.9f ps=0.74u w=0.17u l=0.17u
X6252 cml_tlatch_83.xtail.S1 CKB2_P cml_tlatch_83.xmux.xp.S1 VSS sg13_lv_nmos ad=89.3f pd=0.85u as=89.3f ps=0.85u w=0.47u l=0.16u
X6253 B0_8_P B0_8_N cml_tlatch_1.xmux.xp.S1 VSS sg13_lv_nmos ad=56.9f pd=0.74u as=56.9f ps=0.74u w=0.17u l=0.17u
X6254 cml_tlatch_4.xmux.xn.S1 CKHB1_P cml_tlatch_4.xtail.S1 VSS sg13_lv_nmos ad=89.3f pd=0.85u as=89.3f ps=0.85u w=0.47u l=0.16u
X6255 cml_tlatch_94.xmux.xn.S1 CKJ_N cml_tlatch_94.xtail.S1 VSS sg13_lv_nmos ad=89.3f pd=0.85u as=89.3f ps=0.85u w=0.47u l=0.16u
X6256 cml_tlatch_50.xtail.S1 POLN VSS VSS sg13_lv_nmos ad=1.5637p pd=8.61u as=1.5637p ps=8.61u w=8.23u l=0.13u
X6257 cml_drv_2.xrtail.R1 ENB_N ENB0_P VSS sg13_lv_nmos ad=56.2f pd=0.74u as=56.2f ps=0.74u w=0.16u l=0.19u
X6258 cml_tlatch_61.xmux.xp.S1 CKA2_N cml_tlatch_61.xtail.S1 VSS sg13_lv_nmos ad=89.3f pd=0.85u as=0.1598p ps=1.62u w=0.47u l=0.16u
X6259 cml_tlatch_24.INP cml_tlatch_97.INN cml_tlatch_97.xmux.xn.S1 VSS sg13_lv_nmos ad=0.1082p pd=1.34u as=63.19999f ps=0.74u w=0.26u l=0.38u
X6260 cml_tlatch_58.OUTP cml_tlatch_58.OUTN cml_tlatch_58.xmux.xp.S1 VSS sg13_lv_nmos ad=56.9f pd=0.74u as=56.9f ps=0.74u w=0.17u l=0.17u
X6261 cml_tlatch_27.xmux.xp.S1 MOT2_N MOT2_P VSS sg13_lv_nmos ad=56.9f pd=0.74u as=56.9f ps=0.74u w=0.17u l=0.17u
X6262 cml_tlatch_39.xtail.S1 POLN VSS VSS sg13_lv_nmos ad=1.5637p pd=8.61u as=1.5637p ps=8.61u w=8.23u l=0.13u
X6263 cml_tlatch_44.xtail.S1 CKHA3_N cml_tlatch_44.xmux.xp.S1 VSS sg13_lv_nmos ad=89.3f pd=0.85u as=89.3f ps=0.85u w=0.47u l=0.16u
X6264 cml_tlatch_63.INN cml_tlatch_63.INP cml_tlatch_70.xmux.xp.S1 VSS sg13_lv_nmos ad=56.9f pd=0.74u as=56.9f ps=0.74u w=0.17u l=0.17u
X6265 A2_8_N cml_tlatch_86.OUTP cml_tlatch_85.xmux.xn.S1 VSS sg13_lv_nmos ad=63.19999f pd=0.74u as=63.19999f ps=0.74u w=0.26u l=0.38u
X6266 cml_tlatch_66.xmux.xp.S1 cml_tlatch_73.INN cml_tlatch_73.INP VSS sg13_lv_nmos ad=0.1019p pd=1.34u as=56.9f ps=0.74u w=0.17u l=0.17u
X6267 cml_tlatch_80.xmux.xn.S1 B2_2_P MOT23_N VSS sg13_lv_nmos ad=63.19999f pd=0.74u as=63.19999f ps=0.74u w=0.26u l=0.38u
X6268 stub_bi_49.BOTP stub_bi_49.BOTN cml_tlatch_84.xmux.xp.S1 VSS sg13_lv_nmos ad=56.9f pd=0.74u as=56.9f ps=0.74u w=0.17u l=0.17u
X6269 cml_tlatch_7.xtail.S1 CKB0_P cml_tlatch_7.xmux.xp.S1 VSS sg13_lv_nmos ad=89.3f pd=0.85u as=89.3f ps=0.85u w=0.47u l=0.16u
X6270 cml_tlatch_33.xtail.S1 CKA0_P cml_tlatch_33.xmux.xn.S1 VSS sg13_lv_nmos ad=89.3f pd=0.85u as=89.3f ps=0.85u w=0.47u l=0.16u
X6271 cml_tlatch_4.xmux.xp.S1 MOT11_P MOT11_N VSS sg13_lv_nmos ad=56.9f pd=0.74u as=56.9f ps=0.74u w=0.17u l=0.17u
X6272 stub_bi_38.BOTP stub_bi_38.BOTN cml_tlatch_46.xmux.xp.S1 VSS sg13_lv_nmos ad=56.9f pd=0.74u as=56.9f ps=0.74u w=0.17u l=0.17u
X6273 cml_tlatch_4.INP cml_tlatch_4.INN cml_tlatch_12.xmux.xp.S1 VSS sg13_lv_nmos ad=56.9f pd=0.74u as=56.9f ps=0.74u w=0.17u l=0.17u
X6274 cml_tlatch_16.xmux.xp.S1 MOT5_N MOT5_P VSS sg13_lv_nmos ad=56.9f pd=0.74u as=56.9f ps=0.74u w=0.17u l=0.17u
X6275 GB3_N ENB0_P cml_gate2_6.xamp.xn.S1 VSS sg13_lv_nmos ad=0.1007p pd=0.91u as=0.1007p ps=0.91u w=0.53u l=0.13u
X6276 cml_tlatch_1.xmux.xn.S1 CKB0_N cml_tlatch_1.xtail.S1 VSS sg13_lv_nmos ad=89.3f pd=0.85u as=89.3f ps=0.85u w=0.47u l=0.16u
X6277 cml_tlatch_54.xmux.xp.S1 MOT20_N MOT20_P VSS sg13_lv_nmos ad=56.9f pd=0.74u as=56.9f ps=0.74u w=0.17u l=0.17u
X6278 cml_tlatch_14.xmux.xp.S1 CKHB0_N cml_tlatch_14.xtail.S1 VSS sg13_lv_nmos ad=89.3f pd=0.85u as=0.1598p ps=1.62u w=0.47u l=0.16u
X6279 cml_tlatch_5.xtail.S1 CKHB1_P cml_tlatch_5.xmux.xn.S1 VSS sg13_lv_nmos ad=0.1598p pd=1.62u as=89.3f ps=0.85u w=0.47u l=0.16u
X6280 cml_tlatch_69.OUTP cml_tlatch_69.OUTN cml_tlatch_69.xmux.xp.S1 VSS sg13_lv_nmos ad=56.9f pd=0.74u as=56.9f ps=0.74u w=0.17u l=0.17u
X6281 cml_tlatch_65.xmux.xp.S1 cml_tlatch_65.OUTN cml_tlatch_65.OUTP VSS sg13_lv_nmos ad=56.9f pd=0.74u as=56.9f ps=0.74u w=0.17u l=0.17u
X6282 cml_tlatch_63.INP cml_tlatch_71.OUTN cml_tlatch_70.xmux.xn.S1 VSS sg13_lv_nmos ad=63.19999f pd=0.74u as=0.1082p ps=1.34u w=0.26u l=0.38u
X6283 cml_tlatch_91.xmux.xp.S1 cml_tlatch_91.OUTP cml_tlatch_91.OUTN VSS sg13_lv_nmos ad=56.9f pd=0.74u as=56.9f ps=0.74u w=0.17u l=0.17u
X6284 cml_tlatch_24.xmux.xn.S1 cml_tlatch_24.INP MOT12_N VSS sg13_lv_nmos ad=63.19999f pd=0.74u as=63.19999f ps=0.74u w=0.26u l=0.38u
X6285 MOT11_N cml_tlatch_4.INP cml_tlatch_4.xmux.xn.S1 VSS sg13_lv_nmos ad=63.19999f pd=0.74u as=63.19999f ps=0.74u w=0.26u l=0.38u
X6286 cml_tlatch_32.xmux.xp.S1 cml_tlatch_32.OUTP cml_tlatch_32.OUTN VSS sg13_lv_nmos ad=56.9f pd=0.74u as=56.9f ps=0.74u w=0.17u l=0.17u
X6287 cml_tlatch_18.xtail.S1 CKA0_N cml_tlatch_18.xmux.xp.S1 VSS sg13_lv_nmos ad=89.3f pd=0.85u as=89.3f ps=0.85u w=0.47u l=0.16u
X6288 cml_tlatch_28.xtail.S1 CKHA0_P cml_tlatch_28.xmux.xn.S1 VSS sg13_lv_nmos ad=89.3f pd=0.85u as=89.3f ps=0.85u w=0.47u l=0.16u
X6289 stub_bi_15.BOTN stub_bi_15.BOTP cml_tlatch_11.xmux.xp.S1 VSS sg13_lv_nmos ad=56.9f pd=0.74u as=56.9f ps=0.74u w=0.17u l=0.17u
X6290 VDD cml_tlatch_69.OUTP VSS rppd l=5.17u w=1u
X6291 MOT28_N cml_tlatch_44.INP cml_tlatch_44.xmux.xn.S1 VSS sg13_lv_nmos ad=63.19999f pd=0.74u as=63.19999f ps=0.74u w=0.26u l=0.38u
X6292 cml_tlatch_14.xmux.xp.S1 MOT1_P MOT1_N VSS sg13_lv_nmos ad=56.9f pd=0.74u as=56.9f ps=0.74u w=0.17u l=0.17u
X6293 cml_tlatch_73.INN cml_tlatch_73.INP cml_tlatch_66.xmux.xp.S1 VSS sg13_lv_nmos ad=56.9f pd=0.74u as=0.1019p ps=1.34u w=0.17u l=0.17u
X6294 cml_tlatch_99.OUTP cml_tlatch_33.OUTN cml_tlatch_99.xmux.xn.S1 VSS sg13_lv_nmos ad=63.19999f pd=0.74u as=63.19999f ps=0.74u w=0.26u l=0.38u
X6295 cml_tlatch_32.xtail.S1 CKB0_P cml_tlatch_32.xmux.xn.S1 VSS sg13_lv_nmos ad=89.3f pd=0.85u as=89.3f ps=0.85u w=0.47u l=0.16u
X6296 cml_tlatch_69.xmux.xn.S1 cml_tlatch_63.INN cml_tlatch_69.OUTP VSS sg13_lv_nmos ad=63.19999f pd=0.74u as=63.19999f ps=0.74u w=0.26u l=0.38u
X6297 cml_tlatch_52.xmux.xp.S1 MOT16_P MOT16_N VSS sg13_lv_nmos ad=56.9f pd=0.74u as=56.9f ps=0.74u w=0.17u l=0.17u
X6298 VSS POLN cml_tlatch_18.xtail.S1 VSS sg13_lv_nmos ad=1.5637p pd=8.61u as=1.5637p ps=8.61u w=8.23u l=0.13u
X6299 MOT30_P MOT30_N cml_tlatch_45.xmux.xp.S1 VSS sg13_lv_nmos ad=56.9f pd=0.74u as=56.9f ps=0.74u w=0.17u l=0.17u
X6300 MOT24_N MOT24_P cml_tlatch_62.xmux.xp.S1 VSS sg13_lv_nmos ad=56.9f pd=0.74u as=56.9f ps=0.74u w=0.17u l=0.17u
X6301 ENB1_N VDD VSS rppd l=8.13u w=1u
X6302 CKHB3_P VDD VSS rppd l=13.09u w=1u
X6303 cml_tlatch_26.xmux.xn.S1 A0_8_N MOT0_P VSS sg13_lv_nmos ad=63.19999f pd=0.74u as=63.19999f ps=0.74u w=0.26u l=0.38u
X6304 MOT4_P MOT4_N cml_tlatch_28.xmux.xp.S1 VSS sg13_lv_nmos ad=56.9f pd=0.74u as=56.9f ps=0.74u w=0.17u l=0.17u
X6305 cml_tlatch_77.xmux.xp.S1 CKHB2_N cml_tlatch_77.xtail.S1 VSS sg13_lv_nmos ad=89.3f pd=0.85u as=89.3f ps=0.85u w=0.47u l=0.16u
X6306 cml_tlatch_42.xmux.xp.S1 MOT8_P MOT8_N VSS sg13_lv_nmos ad=56.9f pd=0.74u as=56.9f ps=0.74u w=0.17u l=0.17u
X6307 cml_tlatch_63.xmux.xn.S1 CKHA3_P cml_tlatch_63.xtail.S1 VSS sg13_lv_nmos ad=89.3f pd=0.85u as=89.3f ps=0.85u w=0.47u l=0.16u
X6308 cml_tlatch_85.xmux.xp.S1 A2_8_P A2_8_N VSS sg13_lv_nmos ad=56.9f pd=0.74u as=56.9f ps=0.74u w=0.17u l=0.17u
X6309 cml_tlatch_58.xtail.S1 CKA3_N cml_tlatch_58.xmux.xp.S1 VSS sg13_lv_nmos ad=89.3f pd=0.85u as=89.3f ps=0.85u w=0.47u l=0.16u
X6310 B2_2_P B2_2_N cml_tlatch_47.xmux.xp.S1 VSS sg13_lv_nmos ad=56.9f pd=0.74u as=56.9f ps=0.74u w=0.17u l=0.17u
X6311 cml_tlatch_40.xmux.xp.S1 A1_2_N A1_2_P VSS sg13_lv_nmos ad=56.9f pd=0.74u as=56.9f ps=0.74u w=0.17u l=0.17u
X6312 cml_tlatch_13.xmux.xn.S1 CKB1_P cml_tlatch_13.xtail.S1 VSS sg13_lv_nmos ad=89.3f pd=0.85u as=89.3f ps=0.85u w=0.47u l=0.16u
X6313 CLK_W_N CLK_W_P cml_tlatch_93.xmux.xp.S1 VSS sg13_lv_nmos ad=56.9f pd=0.74u as=56.9f ps=0.74u w=0.17u l=0.17u
X6314 cml_tlatch_98.xmux.xp.S1 CKB0_P cml_tlatch_98.xtail.S1 VSS sg13_lv_nmos ad=89.3f pd=0.85u as=89.3f ps=0.85u w=0.47u l=0.16u
X6315 cml_tlatch_76.xmux.xn.S1 CKA2_P cml_tlatch_76.xtail.S1 VSS sg13_lv_nmos ad=89.3f pd=0.85u as=89.3f ps=0.85u w=0.47u l=0.16u
X6316 cml_tlatch_61.OUTN cml_tlatch_61.OUTP cml_tlatch_61.xmux.xp.S1 VSS sg13_lv_nmos ad=56.9f pd=0.74u as=56.9f ps=0.74u w=0.17u l=0.17u
X6317 cml_tlatch_29.xmux.xn.S1 A0_2_N MOT6_P VSS sg13_lv_nmos ad=63.19999f pd=0.74u as=63.19999f ps=0.74u w=0.26u l=0.38u
X6318 MOT26_P MOT26_N cml_tlatch_63.xmux.xp.S1 VSS sg13_lv_nmos ad=56.9f pd=0.74u as=56.9f ps=0.74u w=0.17u l=0.17u
X6319 cml_gate2_5.xrtail.R1 CKB2_P cml_gate2_5.xamp.xn.S1 VSS sg13_lv_nmos ad=0.1007p pd=0.91u as=0.1007p ps=0.91u w=0.53u l=0.13u
X6320 cml_tlatch_10.xtail.S1 CKB1_N cml_tlatch_10.xmux.xn.S1 VSS sg13_lv_nmos ad=89.3f pd=0.85u as=89.3f ps=0.85u w=0.47u l=0.16u
X6321 cml_tlatch_54.xtail.S1 CKHA2_P cml_tlatch_54.xmux.xn.S1 VSS sg13_lv_nmos ad=89.3f pd=0.85u as=89.3f ps=0.85u w=0.47u l=0.16u
X6322 VSS POLN cml_tlatch_47.xtail.S1 VSS sg13_lv_nmos ad=2.7982p pd=17.14u as=1.5637p ps=8.61u w=8.23u l=0.13u
X6323 cml_tlatch_94.xmux.xp.S1 J2_P J2_N VSS sg13_lv_nmos ad=56.9f pd=0.74u as=56.9f ps=0.74u w=0.17u l=0.17u
X6324 A1_2_N A1_2_P cml_tlatch_40.xmux.xp.S1 VSS sg13_lv_nmos ad=56.9f pd=0.74u as=0.1019p ps=1.34u w=0.17u l=0.17u
X6325 ENA1_P ENA_N cml_drv_1.xrtail.R1 VSS sg13_lv_nmos ad=56.2f pd=0.74u as=56.2f ps=0.74u w=0.16u l=0.19u
X6326 cml_tlatch_29.xmux.xn.S1 A0_2_N MOT6_P VSS sg13_lv_nmos ad=63.19999f pd=0.74u as=63.19999f ps=0.74u w=0.26u l=0.38u
X6327 cml_tlatch_39.xmux.xn.S1 A1_2_N cml_tlatch_97.INP VSS sg13_lv_nmos ad=63.19999f pd=0.74u as=63.19999f ps=0.74u w=0.26u l=0.38u
X6328 cml_tlatch_59.xmux.xp.S1 cml_tlatch_91.INN cml_tlatch_91.INP VSS sg13_lv_nmos ad=56.9f pd=0.74u as=56.9f ps=0.74u w=0.17u l=0.17u
X6329 cml_tlatch_4.xmux.xp.S1 CKHB1_N cml_tlatch_4.xtail.S1 VSS sg13_lv_nmos ad=89.3f pd=0.85u as=89.3f ps=0.85u w=0.47u l=0.16u
X6330 cml_tlatch_18.OUTN cml_tlatch_23.OUTP cml_tlatch_18.xmux.xn.S1 VSS sg13_lv_nmos ad=63.19999f pd=0.74u as=0.1082p ps=1.34u w=0.26u l=0.38u
X6331 cml_tlatch_58.OUTP cml_tlatch_58.OUTN cml_tlatch_58.xmux.xp.S1 VSS sg13_lv_nmos ad=56.9f pd=0.74u as=56.9f ps=0.74u w=0.17u l=0.17u
X6332 cml_tlatch_91.xmux.xp.S1 CKA2_P cml_tlatch_91.xtail.S1 VSS sg13_lv_nmos ad=89.3f pd=0.85u as=89.3f ps=0.85u w=0.47u l=0.16u
X6333 cml_tlatch_64.xmux.xp.S1 B3_8_N B3_8_P VSS sg13_lv_nmos ad=56.9f pd=0.74u as=56.9f ps=0.74u w=0.17u l=0.17u
X6334 CLK_W_N J2_N cml_tlatch_93.xmux.xn.S1 VSS sg13_lv_nmos ad=63.19999f pd=0.74u as=0.1082p ps=1.34u w=0.26u l=0.38u
X6335 cml_tlatch_51.xmux.xp.S1 cml_tlatch_51.OUTN cml_tlatch_51.OUTP VSS sg13_lv_nmos ad=56.9f pd=0.74u as=56.9f ps=0.74u w=0.17u l=0.17u
X6336 cml_tlatch_64.xmux.xp.S1 CKB3_P cml_tlatch_64.xtail.S1 VSS sg13_lv_nmos ad=89.3f pd=0.85u as=89.3f ps=0.85u w=0.47u l=0.16u
X6337 cml_tlatch_18.xtail.S1 CKA0_P cml_tlatch_18.xmux.xn.S1 VSS sg13_lv_nmos ad=89.3f pd=0.85u as=89.3f ps=0.85u w=0.47u l=0.16u
X6338 cml_tlatch_28.xmux.xp.S1 CKHA0_N cml_tlatch_28.xtail.S1 VSS sg13_lv_nmos ad=89.3f pd=0.85u as=89.3f ps=0.85u w=0.47u l=0.16u
X6339 cml_tlatch_3.xmux.xn.S1 B1_8_P MOT9_N VSS sg13_lv_nmos ad=63.19999f pd=0.74u as=0.1082p ps=1.34u w=0.26u l=0.38u
X6340 cml_tlatch_26.xtail.S1 POLN VSS VSS sg13_lv_nmos ad=1.5637p pd=8.61u as=2.7982p ps=17.14u w=8.23u l=0.13u
X6341 cml_gate2_1.xamp.xn.S1 CKA0_P cml_gate2_1.xrtail.R1 VSS sg13_lv_nmos ad=0.1007p pd=0.91u as=0.1007p ps=0.91u w=0.53u l=0.13u
X6342 MOT12_P MOT12_N cml_tlatch_24.xmux.xp.S1 VSS sg13_lv_nmos ad=56.9f pd=0.74u as=0.1019p ps=1.34u w=0.17u l=0.17u
X6343 cml_tlatch_93.xmux.xn.S1 J2_P CLK_W_P VSS sg13_lv_nmos ad=63.19999f pd=0.74u as=63.19999f ps=0.74u w=0.26u l=0.38u
X6344 cml_tlatch_39.xmux.xn.S1 CKA1_P cml_tlatch_39.xtail.S1 VSS sg13_lv_nmos ad=89.3f pd=0.85u as=89.3f ps=0.85u w=0.47u l=0.16u
X6345 cml_tlatch_97.INN A1_2_P cml_tlatch_39.xmux.xn.S1 VSS sg13_lv_nmos ad=63.19999f pd=0.74u as=63.19999f ps=0.74u w=0.26u l=0.38u
X6346 stub_bi_49.BOTP stub_bi_49.BOTN cml_tlatch_84.xmux.xp.S1 VSS sg13_lv_nmos ad=56.9f pd=0.74u as=56.9f ps=0.74u w=0.17u l=0.17u
X6347 cml_tlatch_22.xmux.xp.S1 cml_tlatch_22.OUTP cml_tlatch_22.OUTN VSS sg13_lv_nmos ad=56.9f pd=0.74u as=56.9f ps=0.74u w=0.17u l=0.17u
X6348 MOT1_P MOT1_N cml_tlatch_14.xmux.xp.S1 VSS sg13_lv_nmos ad=56.9f pd=0.74u as=56.9f ps=0.74u w=0.17u l=0.17u
X6349 stub_bi_31.BOTN stub_bi_31.BOTP cml_tlatch_37.xmux.xp.S1 VSS sg13_lv_nmos ad=56.9f pd=0.74u as=56.9f ps=0.74u w=0.17u l=0.17u
X6350 cml_tlatch_11.xmux.xn.S1 cml_tlatch_4.INN stub_bi_15.BOTN VSS sg13_lv_nmos ad=63.19999f pd=0.74u as=0.1082p ps=1.34u w=0.26u l=0.38u
X6351 cml_tlatch_90.xmux.xp.S1 CKB2_P cml_tlatch_90.xtail.S1 VSS sg13_lv_nmos ad=89.3f pd=0.85u as=89.3f ps=0.85u w=0.47u l=0.16u
X6352 cml_tlatch_61.xmux.xn.S1 D2_P cml_tlatch_61.OUTN VSS sg13_lv_nmos ad=63.19999f pd=0.74u as=63.19999f ps=0.74u w=0.26u l=0.38u
X6353 cml_tlatch_16.xmux.xp.S1 MOT5_N MOT5_P VSS sg13_lv_nmos ad=0.1019p pd=1.34u as=56.9f ps=0.74u w=0.17u l=0.17u
X6354 cml_tlatch_79.xmux.xn.S1 CKHB2_P cml_tlatch_79.xtail.S1 VSS sg13_lv_nmos ad=89.3f pd=0.85u as=89.3f ps=0.85u w=0.47u l=0.16u
X6355 cml_tlatch_99.OUTN cml_tlatch_99.OUTP cml_tlatch_99.xmux.xp.S1 VSS sg13_lv_nmos ad=56.9f pd=0.74u as=56.9f ps=0.74u w=0.17u l=0.17u
X6356 cml_tlatch_89.xmux.xp.S1 CKA3_P cml_tlatch_89.xtail.S1 VSS sg13_lv_nmos ad=89.3f pd=0.85u as=89.3f ps=0.85u w=0.47u l=0.16u
X6357 cml_tlatch_47.xmux.xn.S1 stub_bi_43.BOTN B2_2_N VSS sg13_lv_nmos ad=63.19999f pd=0.74u as=63.19999f ps=0.74u w=0.26u l=0.38u
X6358 MOT9_N MOT9_P cml_tlatch_3.xmux.xp.S1 VSS sg13_lv_nmos ad=56.9f pd=0.74u as=56.9f ps=0.74u w=0.17u l=0.17u
X6359 cml_tlatch_80.xtail.S1 CKHB2_N cml_tlatch_80.xmux.xp.S1 VSS sg13_lv_nmos ad=89.3f pd=0.85u as=89.3f ps=0.85u w=0.47u l=0.16u
X6360 cml_tlatch_35.xmux.xn.S1 CKB1_P cml_tlatch_35.xtail.S1 VSS sg13_lv_nmos ad=89.3f pd=0.85u as=89.3f ps=0.85u w=0.47u l=0.16u
X6361 cml_tlatch_61.xmux.xn.S1 D2_P cml_tlatch_61.OUTN VSS sg13_lv_nmos ad=63.19999f pd=0.74u as=63.19999f ps=0.74u w=0.26u l=0.38u
X6362 VSS POLN cml_tlatch_78.xtail.S1 VSS sg13_lv_nmos ad=2.7982p pd=17.14u as=1.5637p ps=8.61u w=8.23u l=0.13u
X6363 cml_tlatch_83.xmux.xp.S1 CKB2_P cml_tlatch_83.xtail.S1 VSS sg13_lv_nmos ad=89.3f pd=0.85u as=89.3f ps=0.85u w=0.47u l=0.16u
X6364 cml_tlatch_76.xmux.xp.S1 cml_tlatch_87.INN cml_tlatch_87.INP VSS sg13_lv_nmos ad=56.9f pd=0.74u as=56.9f ps=0.74u w=0.17u l=0.17u
X6365 cml_tlatch_31.xmux.xp.S1 B0_2_N B0_2_P VSS sg13_lv_nmos ad=56.9f pd=0.74u as=56.9f ps=0.74u w=0.17u l=0.17u
X6366 cml_tlatch_24.xtail.S1 CKHA1_P cml_tlatch_24.xmux.xn.S1 VSS sg13_lv_nmos ad=89.3f pd=0.85u as=89.3f ps=0.85u w=0.47u l=0.16u
X6367 hs_to_clk_7.D2 CK_P CKA2_P VSS sg13_lv_nmos ad=0.228p pd=1.58u as=0.228p ps=1.58u w=1.2u l=0.2u
X6368 cml_tlatch_81.xmux.xp.S1 B2_8_P B2_8_N VSS sg13_lv_nmos ad=56.9f pd=0.74u as=56.9f ps=0.74u w=0.17u l=0.17u
X6369 cml_drv_0.xrtail.R1 ENB_N ENB1_P VSS sg13_lv_nmos ad=56.2f pd=0.74u as=56.2f ps=0.74u w=0.16u l=0.19u
X6370 cml_tlatch_70.xmux.xp.S1 CKA3_P cml_tlatch_70.xtail.S1 VSS sg13_lv_nmos ad=89.3f pd=0.85u as=0.1598p ps=1.62u w=0.47u l=0.16u
X6371 cml_tlatch_94.xtail.S1 CKJ_N cml_tlatch_94.xmux.xn.S1 VSS sg13_lv_nmos ad=89.3f pd=0.85u as=89.3f ps=0.85u w=0.47u l=0.16u
X6372 cml_tlatch_45.xtail.S1 CKHA3_N cml_tlatch_45.xmux.xp.S1 VSS sg13_lv_nmos ad=89.3f pd=0.85u as=89.3f ps=0.85u w=0.47u l=0.16u
X6373 stub_bi_55.BOTP stub_bi_55.BOTN cml_tlatch_90.xmux.xp.S1 VSS sg13_lv_nmos ad=56.9f pd=0.74u as=56.9f ps=0.74u w=0.17u l=0.17u
X6374 cml_tlatch_23.xtail.S1 CKA0_N cml_tlatch_23.xmux.xn.S1 VSS sg13_lv_nmos ad=89.3f pd=0.85u as=89.3f ps=0.85u w=0.47u l=0.16u
X6375 cml_tlatch_49.xmux.xp.S1 cml_tlatch_49.OUTP cml_tlatch_49.OUTN VSS sg13_lv_nmos ad=56.9f pd=0.74u as=56.9f ps=0.74u w=0.17u l=0.17u
X6376 GB2_N ENB0_P cml_gate2_7.xamp.xn.S1 VSS sg13_lv_nmos ad=0.1007p pd=0.91u as=0.1007p ps=0.91u w=0.53u l=0.13u
X6377 MOT19_P MOT19_N cml_tlatch_78.xmux.xp.S1 VSS sg13_lv_nmos ad=56.9f pd=0.74u as=56.9f ps=0.74u w=0.17u l=0.17u
X6378 cml_tlatch_17.xmux.xp.S1 MOT7_N MOT7_P VSS sg13_lv_nmos ad=56.9f pd=0.74u as=56.9f ps=0.74u w=0.17u l=0.17u
X6379 cml_tlatch_32.xmux.xp.S1 cml_tlatch_32.OUTP cml_tlatch_32.OUTN VSS sg13_lv_nmos ad=56.9f pd=0.74u as=56.9f ps=0.74u w=0.17u l=0.17u
X6380 cml_tlatch_87.INN cml_tlatch_91.OUTP cml_tlatch_76.xmux.xn.S1 VSS sg13_lv_nmos ad=63.19999f pd=0.74u as=63.19999f ps=0.74u w=0.26u l=0.38u
X6381 cml_tlatch_41.xmux.xp.S1 cml_tlatch_41.OUTP cml_tlatch_41.OUTN VSS sg13_lv_nmos ad=56.9f pd=0.74u as=56.9f ps=0.74u w=0.17u l=0.17u
X6382 cml_tlatch_87.xmux.xp.S1 cml_tlatch_87.OUTP cml_tlatch_87.OUTN VSS sg13_lv_nmos ad=56.9f pd=0.74u as=56.9f ps=0.74u w=0.17u l=0.17u
X6383 cml_tlatch_53.xmux.xn.S1 cml_tlatch_87.OUTP MOT18_N VSS sg13_lv_nmos ad=63.19999f pd=0.74u as=63.19999f ps=0.74u w=0.26u l=0.38u
X6384 cml_tlatch_36.xtail.S1 CKB1_N cml_tlatch_36.xmux.xn.S1 VSS sg13_lv_nmos ad=89.3f pd=0.85u as=89.3f ps=0.85u w=0.47u l=0.16u
X6385 cml_tlatch_75.xtail.S1 CKHB3_N cml_tlatch_75.xmux.xp.S1 VSS sg13_lv_nmos ad=89.3f pd=0.85u as=89.3f ps=0.85u w=0.47u l=0.16u
X6386 stub_bi_63.BOTN stub_bi_63.BOTP cml_tlatch_83.xmux.xp.S1 VSS sg13_lv_nmos ad=56.9f pd=0.74u as=56.9f ps=0.74u w=0.17u l=0.17u
X6387 cml_tlatch_40.xmux.xp.S1 A1_2_N A1_2_P VSS sg13_lv_nmos ad=56.9f pd=0.74u as=56.9f ps=0.74u w=0.17u l=0.17u
X6388 MOT8_P MOT8_N cml_tlatch_42.xmux.xp.S1 VSS sg13_lv_nmos ad=56.9f pd=0.74u as=56.9f ps=0.74u w=0.17u l=0.17u
X6389 cml_tlatch_91.xtail.S1 POLN VSS VSS sg13_lv_nmos ad=1.5637p pd=8.61u as=1.5637p ps=8.61u w=8.23u l=0.13u
X6390 MOT11_P MOT11_N cml_tlatch_4.xmux.xp.S1 VSS sg13_lv_nmos ad=56.9f pd=0.74u as=56.9f ps=0.74u w=0.17u l=0.17u
X6391 cml_tlatch_46.xmux.xp.S1 stub_bi_38.BOTP stub_bi_38.BOTN VSS sg13_lv_nmos ad=56.9f pd=0.74u as=56.9f ps=0.74u w=0.17u l=0.17u
X6392 cml_tlatch_49.OUTN B3_2_P cml_tlatch_49.xmux.xn.S1 VSS sg13_lv_nmos ad=63.19999f pd=0.74u as=63.19999f ps=0.74u w=0.26u l=0.38u
X6393 cml_tlatch_86.xmux.xn.S1 CKA2_P cml_tlatch_86.xtail.S1 VSS sg13_lv_nmos ad=89.3f pd=0.85u as=89.3f ps=0.85u w=0.47u l=0.16u
X6394 A3_2_N A3_2_P cml_tlatch_57.xmux.xp.S1 VSS sg13_lv_nmos ad=56.9f pd=0.74u as=56.9f ps=0.74u w=0.17u l=0.17u
X6395 cml_tlatch_89.xmux.xp.S1 cml_tlatch_44.INP cml_tlatch_44.INN VSS sg13_lv_nmos ad=56.9f pd=0.74u as=56.9f ps=0.74u w=0.17u l=0.17u
X6396 cml_tlatch_53.xmux.xp.S1 MOT18_P MOT18_N VSS sg13_lv_nmos ad=56.9f pd=0.74u as=56.9f ps=0.74u w=0.17u l=0.17u
X6397 cml_tlatch_33.xmux.xp.S1 cml_tlatch_33.OUTN cml_tlatch_33.OUTP VSS sg13_lv_nmos ad=56.9f pd=0.74u as=56.9f ps=0.74u w=0.17u l=0.17u
X6398 cml_tlatch_80.xmux.xp.S1 MOT23_N MOT23_P VSS sg13_lv_nmos ad=56.9f pd=0.74u as=56.9f ps=0.74u w=0.17u l=0.17u
X6399 ENA0_N ENA_P cml_drv_3.xrtail.R1 VSS sg13_lv_nmos ad=56.2f pd=0.74u as=56.2f ps=0.74u w=0.16u l=0.19u
X6400 cml_tlatch_5.xmux.xn.S1 CKHB1_P cml_tlatch_5.xtail.S1 VSS sg13_lv_nmos ad=89.3f pd=0.85u as=89.3f ps=0.85u w=0.47u l=0.16u
X6401 cml_tlatch_40.xmux.xp.S1 A1_2_N A1_2_P VSS sg13_lv_nmos ad=56.9f pd=0.74u as=56.9f ps=0.74u w=0.17u l=0.17u
X6402 cml_tlatch_49.OUTN cml_tlatch_49.OUTP cml_tlatch_49.xmux.xp.S1 VSS sg13_lv_nmos ad=56.9f pd=0.74u as=56.9f ps=0.74u w=0.17u l=0.17u
X6403 cml_tlatch_68.xmux.xn.S1 CKA3_N cml_tlatch_68.xtail.S1 VSS sg13_lv_nmos ad=89.3f pd=0.85u as=89.3f ps=0.85u w=0.47u l=0.16u
X6404 cml_tlatch_8.xmux.xn.S1 CKB0_P cml_tlatch_8.xtail.S1 VSS sg13_lv_nmos ad=89.3f pd=0.85u as=89.3f ps=0.85u w=0.47u l=0.16u
X6405 MOT3_P cml_tlatch_7.OUTN cml_tlatch_15.xmux.xn.S1 VSS sg13_lv_nmos ad=63.19999f pd=0.74u as=63.19999f ps=0.74u w=0.26u l=0.38u
X6406 cml_tlatch_41.xtail.S1 CKA1_P cml_tlatch_41.xmux.xn.S1 VSS sg13_lv_nmos ad=89.3f pd=0.85u as=89.3f ps=0.85u w=0.47u l=0.16u
X6407 VDD CLK_W_P VSS rppd l=5.17u w=1u
X6408 cml_tlatch_65.OUTN cml_tlatch_73.INP cml_tlatch_65.xmux.xn.S1 VSS sg13_lv_nmos ad=63.19999f pd=0.74u as=63.19999f ps=0.74u w=0.26u l=0.38u
X6409 GA3_P CKB3_N cml_gate2_4.xrtail.R1 VSS sg13_lv_nmos ad=0.1007p pd=0.91u as=0.1007p ps=0.91u w=0.53u l=0.13u
X6410 cml_tlatch_33.OUTN A0_2_P cml_tlatch_33.xmux.xn.S1 VSS sg13_lv_nmos ad=63.19999f pd=0.74u as=63.19999f ps=0.74u w=0.26u l=0.38u
X6411 cml_tlatch_43.xmux.xp.S1 MOT10_N MOT10_P VSS sg13_lv_nmos ad=56.9f pd=0.74u as=56.9f ps=0.74u w=0.17u l=0.17u
X6412 cml_tlatch_43.xmux.xp.S1 CKHA1_N cml_tlatch_43.xtail.S1 VSS sg13_lv_nmos ad=89.3f pd=0.85u as=89.3f ps=0.85u w=0.47u l=0.16u
X6413 cml_tlatch_86.xmux.xp.S1 CKA2_N cml_tlatch_86.xtail.S1 VSS sg13_lv_nmos ad=89.3f pd=0.85u as=0.1598p ps=1.62u w=0.47u l=0.16u
X6414 cml_gate2_5.xamp.xn.S1 ENA1_P GA2_N VSS sg13_lv_nmos ad=0.1007p pd=0.91u as=0.1802p ps=1.74u w=0.53u l=0.13u
X6415 cml_tlatch_64.xmux.xn.S1 CKB3_N cml_tlatch_64.xtail.S1 VSS sg13_lv_nmos ad=89.3f pd=0.85u as=89.3f ps=0.85u w=0.47u l=0.16u
X6416 MOT2_N MOT2_P cml_tlatch_27.xmux.xp.S1 VSS sg13_lv_nmos ad=56.9f pd=0.74u as=56.9f ps=0.74u w=0.17u l=0.17u
X6417 MOT16_N A2_8_P cml_tlatch_52.xmux.xn.S1 VSS sg13_lv_nmos ad=63.19999f pd=0.74u as=63.19999f ps=0.74u w=0.26u l=0.38u
X6418 cml_tlatch_91.INN A2_2_P cml_tlatch_59.xmux.xn.S1 VSS sg13_lv_nmos ad=0.1082p pd=1.34u as=63.19999f ps=0.74u w=0.26u l=0.38u
X6419 cml_tlatch_0.OUTN cml_tlatch_0.OUTP cml_tlatch_0.xmux.xp.S1 VSS sg13_lv_nmos ad=56.9f pd=0.74u as=56.9f ps=0.74u w=0.17u l=0.17u
X6420 stub_bi_15.BOTP VDD VSS rppd l=5.17u w=1u
X6421 cml_tlatch_77.xtail.S1 CKHB2_N cml_tlatch_77.xmux.xp.S1 VSS sg13_lv_nmos ad=89.3f pd=0.85u as=89.3f ps=0.85u w=0.47u l=0.16u
X6422 cml_tlatch_35.xmux.xp.S1 stub_bi_29.BOTN stub_bi_29.BOTP VSS sg13_lv_nmos ad=56.9f pd=0.74u as=56.9f ps=0.74u w=0.17u l=0.17u
X6423 cml_tlatch_58.OUTN cml_tlatch_58.OUTP cml_tlatch_58.xmux.xp.S1 VSS sg13_lv_nmos ad=56.9f pd=0.74u as=56.9f ps=0.74u w=0.17u l=0.17u
X6424 cml_tlatch_37.xtail.S1 CKB1_P cml_tlatch_37.xmux.xn.S1 VSS sg13_lv_nmos ad=89.3f pd=0.85u as=89.3f ps=0.85u w=0.47u l=0.16u
X6425 J4_N J4_P cml_tlatch_92.xmux.xp.S1 VSS sg13_lv_nmos ad=56.9f pd=0.74u as=56.9f ps=0.74u w=0.17u l=0.17u
X6426 cml_tlatch_87.xmux.xn.S1 CKA2_N cml_tlatch_87.xtail.S1 VSS sg13_lv_nmos ad=89.3f pd=0.85u as=89.3f ps=0.85u w=0.47u l=0.16u
X6427 cml_tlatch_3.xmux.xp.S1 MOT9_N MOT9_P VSS sg13_lv_nmos ad=56.9f pd=0.74u as=56.9f ps=0.74u w=0.17u l=0.17u
X6428 cml_tlatch_89.xmux.xp.S1 cml_tlatch_44.INP cml_tlatch_44.INN VSS sg13_lv_nmos ad=56.9f pd=0.74u as=56.9f ps=0.74u w=0.17u l=0.17u
X6429 cml_tlatch_61.xtail.S1 CKA2_P cml_tlatch_61.xmux.xn.S1 VSS sg13_lv_nmos ad=89.3f pd=0.85u as=89.3f ps=0.85u w=0.47u l=0.16u
X6430 cml_tlatch_62.xmux.xp.S1 MOT24_N MOT24_P VSS sg13_lv_nmos ad=56.9f pd=0.74u as=56.9f ps=0.74u w=0.17u l=0.17u
X6431 cml_tlatch_38.xmux.xp.S1 cml_tlatch_38.OUTN cml_tlatch_38.OUTP VSS sg13_lv_nmos ad=56.9f pd=0.74u as=56.9f ps=0.74u w=0.17u l=0.17u
X6432 cml_tlatch_74.xtail.S1 POLN VSS VSS sg13_lv_nmos ad=1.5637p pd=8.61u as=2.7982p ps=17.14u w=8.23u l=0.13u
X6433 cml_tlatch_7.xtail.S1 CKB0_P cml_tlatch_7.xmux.xp.S1 VSS sg13_lv_nmos ad=89.3f pd=0.85u as=89.3f ps=0.85u w=0.47u l=0.16u
X6434 cml_tlatch_68.xmux.xn.S1 cml_tlatch_69.OUTN A3_8_P VSS sg13_lv_nmos ad=63.19999f pd=0.74u as=63.19999f ps=0.74u w=0.26u l=0.38u
X6435 cml_tlatch_86.xmux.xp.S1 cml_tlatch_86.OUTN cml_tlatch_86.OUTP VSS sg13_lv_nmos ad=56.9f pd=0.74u as=56.9f ps=0.74u w=0.17u l=0.17u
X6436 cml_tlatch_99.OUTN cml_tlatch_99.OUTP cml_tlatch_99.xmux.xp.S1 VSS sg13_lv_nmos ad=56.9f pd=0.74u as=56.9f ps=0.74u w=0.17u l=0.17u
X6437 stub_bi_63.BOTN stub_bi_49.BOTP cml_tlatch_83.xmux.xn.S1 VSS sg13_lv_nmos ad=63.19999f pd=0.74u as=63.19999f ps=0.74u w=0.26u l=0.38u
X6438 cml_tlatch_41.xmux.xp.S1 cml_tlatch_41.OUTP cml_tlatch_41.OUTN VSS sg13_lv_nmos ad=56.9f pd=0.74u as=56.9f ps=0.74u w=0.17u l=0.17u
X6439 cml_tlatch_54.xmux.xn.S1 CKHA2_P cml_tlatch_54.xtail.S1 VSS sg13_lv_nmos ad=89.3f pd=0.85u as=89.3f ps=0.85u w=0.47u l=0.16u
X6440 VSS hs_to_clk_1.sg13_lv_nmos_2HGZLP_0.G VSS VSS sg13_lv_nmos ad=2.071p pd=11.28u as=0 ps=0 w=10.9u l=1.38u
X6441 stub_bi_31.BOTP stub_bi_31.BOTN cml_tlatch_37.xmux.xp.S1 VSS sg13_lv_nmos ad=56.9f pd=0.74u as=56.9f ps=0.74u w=0.17u l=0.17u
X6442 MOT20_N MOT20_P cml_tlatch_54.xmux.xp.S1 VSS sg13_lv_nmos ad=56.9f pd=0.74u as=56.9f ps=0.74u w=0.17u l=0.17u
X6443 cml_tlatch_70.xmux.xp.S1 cml_tlatch_63.INN cml_tlatch_63.INP VSS sg13_lv_nmos ad=56.9f pd=0.74u as=56.9f ps=0.74u w=0.17u l=0.17u
X6444 cml_tlatch_28.xtail.S1 POLN VSS VSS sg13_lv_nmos ad=1.5637p pd=8.61u as=2.7982p ps=17.14u w=8.23u l=0.13u
X6445 cml_tlatch_44.INP cml_tlatch_44.INN cml_tlatch_89.xmux.xp.S1 VSS sg13_lv_nmos ad=56.9f pd=0.74u as=56.9f ps=0.74u w=0.17u l=0.17u
X6446 cml_tlatch_72.xtail.S1 CKHB3_N cml_tlatch_72.xmux.xp.S1 VSS sg13_lv_nmos ad=89.3f pd=0.85u as=89.3f ps=0.85u w=0.47u l=0.16u
X6447 A0_8_P A0_8_N cml_tlatch_9.xmux.xp.S1 VSS sg13_lv_nmos ad=56.9f pd=0.74u as=56.9f ps=0.74u w=0.17u l=0.17u
X6448 VSS POLN cml_tlatch_4.xtail.S1 VSS sg13_lv_nmos ad=1.5637p pd=8.61u as=1.5637p ps=8.61u w=8.23u l=0.13u
X6449 A1_8_N A1_8_P cml_tlatch_19.xmux.xp.S1 VSS sg13_lv_nmos ad=56.9f pd=0.74u as=56.9f ps=0.74u w=0.17u l=0.17u
X6450 cml_tlatch_83.xmux.xn.S1 CKB2_N cml_tlatch_83.xtail.S1 VSS sg13_lv_nmos ad=89.3f pd=0.85u as=89.3f ps=0.85u w=0.47u l=0.16u
X6451 MOT22_N A2_2_P cml_tlatch_55.xmux.xn.S1 VSS sg13_lv_nmos ad=63.19999f pd=0.74u as=63.19999f ps=0.74u w=0.26u l=0.38u
X6452 cml_tlatch_12.xmux.xn.S1 stub_bi_17.BOTN cml_tlatch_4.INN VSS sg13_lv_nmos ad=63.19999f pd=0.74u as=63.19999f ps=0.74u w=0.26u l=0.38u
X6453 cml_tlatch_70.xmux.xn.S1 CKA3_N cml_tlatch_70.xtail.S1 VSS sg13_lv_nmos ad=89.3f pd=0.85u as=89.3f ps=0.85u w=0.47u l=0.16u
X6454 cml_tlatch_30.xmux.xn.S1 B0_2_N cml_tlatch_30.OUTP VSS sg13_lv_nmos ad=0.1082p pd=1.34u as=63.19999f ps=0.74u w=0.26u l=0.38u
X6455 cml_tlatch_94.xtail.S1 CKJ_P cml_tlatch_94.xmux.xp.S1 VSS sg13_lv_nmos ad=89.3f pd=0.85u as=89.3f ps=0.85u w=0.47u l=0.16u
X6456 cml_tlatch_91.INN cml_tlatch_91.INP cml_tlatch_59.xmux.xp.S1 VSS sg13_lv_nmos ad=56.9f pd=0.74u as=0.1019p ps=1.34u w=0.17u l=0.17u
X6457 cml_tlatch_43.INP cml_tlatch_43.INN cml_tlatch_21.xmux.xp.S1 VSS sg13_lv_nmos ad=56.9f pd=0.74u as=56.9f ps=0.74u w=0.17u l=0.17u
X6458 cml_tlatch_72.xmux.xp.S1 MOT25_N MOT25_P VSS sg13_lv_nmos ad=56.9f pd=0.74u as=56.9f ps=0.74u w=0.17u l=0.17u
X6459 B2_8_P B2_8_N cml_tlatch_81.xmux.xp.S1 VSS sg13_lv_nmos ad=56.9f pd=0.74u as=56.9f ps=0.74u w=0.17u l=0.17u
X6460 VSS hs_to_clk_3.sg13_lv_nmos_2HGZLP_0.G VSS VSS sg13_lv_nmos ad=2.071p pd=11.28u as=0 ps=0 w=10.9u l=1.38u
X6461 cml_tlatch_57.xmux.xn.S1 CKA3_N cml_tlatch_57.xtail.S1 VSS sg13_lv_nmos ad=89.3f pd=0.85u as=89.3f ps=0.85u w=0.47u l=0.16u
X6462 hs_to_clk_4.D2 CK_P CKB2_N VSS sg13_lv_nmos ad=0.228p pd=1.58u as=0.408p ps=3.08u w=1.2u l=0.2u
X6463 MOT6_P MOT6_N cml_tlatch_29.xmux.xp.S1 VSS sg13_lv_nmos ad=56.9f pd=0.74u as=56.9f ps=0.74u w=0.17u l=0.17u
X6464 cml_tlatch_12.xmux.xn.S1 stub_bi_17.BOTN cml_tlatch_4.INN VSS sg13_lv_nmos ad=63.19999f pd=0.74u as=63.19999f ps=0.74u w=0.26u l=0.38u
X6465 cml_tlatch_30.xmux.xn.S1 CKB0_P cml_tlatch_30.xtail.S1 VSS sg13_lv_nmos ad=89.3f pd=0.85u as=89.3f ps=0.85u w=0.47u l=0.16u
X6466 cml_tlatch_44.xmux.xn.S1 CKHA3_P cml_tlatch_44.xtail.S1 VSS sg13_lv_nmos ad=89.3f pd=0.85u as=89.3f ps=0.85u w=0.47u l=0.16u
X6467 cml_tlatch_74.xmux.xp.S1 CKHB3_N cml_tlatch_74.xtail.S1 VSS sg13_lv_nmos ad=89.3f pd=0.85u as=89.3f ps=0.85u w=0.47u l=0.16u
X6468 cml_tlatch_34.xtail.S1 CKA0_N cml_tlatch_34.xmux.xn.S1 VSS sg13_lv_nmos ad=89.3f pd=0.85u as=89.3f ps=0.85u w=0.47u l=0.16u
X6469 MOT11_P MOT11_N cml_tlatch_4.xmux.xp.S1 VSS sg13_lv_nmos ad=56.9f pd=0.74u as=56.9f ps=0.74u w=0.17u l=0.17u
X6470 hs_to_clk_4.D2 CK_N CKB2_P VSS sg13_lv_nmos ad=0.408p pd=3.08u as=0.228p ps=1.58u w=1.2u l=0.2u
X6471 cml_tlatch_32.xtail.S1 CKB0_P cml_tlatch_32.xmux.xn.S1 VSS sg13_lv_nmos ad=89.3f pd=0.85u as=89.3f ps=0.85u w=0.47u l=0.16u
X6472 cml_tlatch_18.xmux.xp.S1 cml_tlatch_18.OUTP cml_tlatch_18.OUTN VSS sg13_lv_nmos ad=56.9f pd=0.74u as=56.9f ps=0.74u w=0.17u l=0.17u
X6473 cml_tlatch_97.INP cml_tlatch_97.INN cml_tlatch_39.xmux.xp.S1 VSS sg13_lv_nmos ad=56.9f pd=0.74u as=56.9f ps=0.74u w=0.17u l=0.17u
X6474 B3_2_P cml_tlatch_51.OUTN cml_tlatch_50.xmux.xn.S1 VSS sg13_lv_nmos ad=63.19999f pd=0.74u as=63.19999f ps=0.74u w=0.26u l=0.38u
X6475 cml_tlatch_43.INN cml_tlatch_43.INP cml_tlatch_21.xmux.xp.S1 VSS sg13_lv_nmos ad=56.9f pd=0.74u as=56.9f ps=0.74u w=0.17u l=0.17u
X6476 cml_tlatch_43.INP cml_tlatch_43.INN cml_tlatch_21.xmux.xp.S1 VSS sg13_lv_nmos ad=56.9f pd=0.74u as=56.9f ps=0.74u w=0.17u l=0.17u
X6477 cml_tlatch_96.xmux.xn.S1 CKB1_N cml_tlatch_96.xtail.S1 VSS sg13_lv_nmos ad=89.3f pd=0.85u as=89.3f ps=0.85u w=0.47u l=0.16u
X6478 cml_tlatch_53.xmux.xp.S1 MOT18_P MOT18_N VSS sg13_lv_nmos ad=56.9f pd=0.74u as=56.9f ps=0.74u w=0.17u l=0.17u
X6479 cml_tlatch_54.xmux.xn.S1 cml_tlatch_91.OUTN MOT20_P VSS sg13_lv_nmos ad=63.19999f pd=0.74u as=63.19999f ps=0.74u w=0.26u l=0.38u
X6480 cml_tlatch_97.xmux.xp.S1 cml_tlatch_24.INN cml_tlatch_24.INP VSS sg13_lv_nmos ad=56.9f pd=0.74u as=56.9f ps=0.74u w=0.17u l=0.17u
X6481 cml_tlatch_50.xmux.xn.S1 CKB3_N cml_tlatch_50.xtail.S1 VSS sg13_lv_nmos ad=89.3f pd=0.85u as=89.3f ps=0.85u w=0.47u l=0.16u
X6482 cml_tlatch_69.xtail.S1 CKA3_N cml_tlatch_69.xmux.xp.S1 VSS sg13_lv_nmos ad=89.3f pd=0.85u as=89.3f ps=0.85u w=0.47u l=0.16u
X6483 cml_tlatch_90.xmux.xn.S1 stub_bi_38.BOTP stub_bi_55.BOTN VSS sg13_lv_nmos ad=63.19999f pd=0.74u as=63.19999f ps=0.74u w=0.26u l=0.38u
X6484 VSS hs_to_clk_4.sg13_lv_nmos_2HGZLP_0.G VSS VSS sg13_lv_nmos ad=2.071p pd=11.28u as=0 ps=0 w=10.9u l=1.38u
X6485 cml_tlatch_91.xmux.xn.S1 CKA2_N cml_tlatch_91.xtail.S1 VSS sg13_lv_nmos ad=89.3f pd=0.85u as=89.3f ps=0.85u w=0.47u l=0.16u
X6486 cml_tlatch_30.OUTP cml_tlatch_30.OUTN cml_tlatch_30.xmux.xp.S1 VSS sg13_lv_nmos ad=56.9f pd=0.74u as=0.1019p ps=1.34u w=0.17u l=0.17u
X6487 MOT31_P MOT31_N cml_tlatch_75.xmux.xp.S1 VSS sg13_lv_nmos ad=56.9f pd=0.74u as=56.9f ps=0.74u w=0.17u l=0.17u
X6488 cml_tlatch_22.OUTP cml_tlatch_22.OUTN cml_tlatch_22.xmux.xp.S1 VSS sg13_lv_nmos ad=56.9f pd=0.74u as=56.9f ps=0.74u w=0.17u l=0.17u
X6489 cml_tlatch_93.xmux.xp.S1 CLK_W_N CLK_W_P VSS sg13_lv_nmos ad=56.9f pd=0.74u as=56.9f ps=0.74u w=0.17u l=0.17u
X6490 cml_tlatch_2.xmux.xp.S1 CKB0_N cml_tlatch_2.xtail.S1 VSS sg13_lv_nmos ad=89.3f pd=0.85u as=89.3f ps=0.85u w=0.47u l=0.16u
X6491 cml_tlatch_92.xmux.xp.S1 J4_P J4_N VSS sg13_lv_nmos ad=56.9f pd=0.74u as=56.9f ps=0.74u w=0.17u l=0.17u
X6492 cml_tlatch_7.xmux.xp.S1 cml_tlatch_7.OUTN cml_tlatch_7.OUTP VSS sg13_lv_nmos ad=56.9f pd=0.74u as=56.9f ps=0.74u w=0.17u l=0.17u
X6493 cml_tlatch_43.xmux.xp.S1 MOT10_P MOT10_N VSS sg13_lv_nmos ad=56.9f pd=0.74u as=56.9f ps=0.74u w=0.17u l=0.17u
X6494 J2_N J1_P cml_tlatch_94.xmux.xn.S1 VSS sg13_lv_nmos ad=63.19999f pd=0.74u as=63.19999f ps=0.74u w=0.26u l=0.38u
X6495 cml_tlatch_96.xmux.xp.S1 cml_tlatch_5.INP cml_tlatch_5.INN VSS sg13_lv_nmos ad=56.9f pd=0.74u as=56.9f ps=0.74u w=0.17u l=0.17u
X6496 B1_8_N stub_bi_15.BOTN cml_tlatch_10.xmux.xn.S1 VSS sg13_lv_nmos ad=63.19999f pd=0.74u as=63.19999f ps=0.74u w=0.26u l=0.38u
X6497 hs_to_clk_2.D2 POLN VSS VSS sg13_lv_nmos ad=3.4p pd=20.68u as=1.9p ps=10.38u w=10u l=0.13u
X6498 cml_tlatch_54.xtail.S1 CKHA2_N cml_tlatch_54.xmux.xp.S1 VSS sg13_lv_nmos ad=89.3f pd=0.85u as=89.3f ps=0.85u w=0.47u l=0.16u
X6499 cml_tlatch_28.xmux.xp.S1 MOT4_N MOT4_P VSS sg13_lv_nmos ad=56.9f pd=0.74u as=56.9f ps=0.74u w=0.17u l=0.17u
X6500 cml_tlatch_91.INN cml_tlatch_91.INP cml_tlatch_59.xmux.xp.S1 VSS sg13_lv_nmos ad=56.9f pd=0.74u as=56.9f ps=0.74u w=0.17u l=0.17u
X6501 cml_tlatch_20.OUTP cml_tlatch_20.OUTN cml_tlatch_20.xmux.xp.S1 VSS sg13_lv_nmos ad=56.9f pd=0.74u as=56.9f ps=0.74u w=0.17u l=0.17u
X6502 cml_tlatch_67.OUTN cml_tlatch_67.OUTP cml_tlatch_67.xmux.xp.S1 VSS sg13_lv_nmos ad=56.9f pd=0.74u as=56.9f ps=0.74u w=0.17u l=0.17u
X6503 cml_tlatch_61.xmux.xp.S1 cml_tlatch_61.OUTN cml_tlatch_61.OUTP VSS sg13_lv_nmos ad=56.9f pd=0.74u as=56.9f ps=0.74u w=0.17u l=0.17u
X6504 cml_tlatch_51.xtail.S1 CKB3_N cml_tlatch_51.xmux.xp.S1 VSS sg13_lv_nmos ad=89.3f pd=0.85u as=89.3f ps=0.85u w=0.47u l=0.16u
X6505 A0_8_N A0_8_P cml_tlatch_9.xmux.xp.S1 VSS sg13_lv_nmos ad=56.9f pd=0.74u as=56.9f ps=0.74u w=0.17u l=0.17u
X6506 cml_gate2_7.xrtail.R1 CKA2_P cml_gate2_7.xamp.xn.S1 VSS sg13_lv_nmos ad=0.1007p pd=0.91u as=0.1007p ps=0.91u w=0.53u l=0.13u
X6507 MOT17_N B2_8_P cml_tlatch_77.xmux.xn.S1 VSS sg13_lv_nmos ad=0.1082p pd=1.34u as=63.19999f ps=0.74u w=0.26u l=0.38u
X6508 cml_tlatch_17.xmux.xn.S1 B0_2_N MOT7_P VSS sg13_lv_nmos ad=63.19999f pd=0.74u as=63.19999f ps=0.74u w=0.26u l=0.38u
X6509 cml_tlatch_43.xmux.xn.S1 CKHA1_P cml_tlatch_43.xtail.S1 VSS sg13_lv_nmos ad=89.3f pd=0.85u as=89.3f ps=0.85u w=0.47u l=0.16u
X6510 hs_to_clk_7.sg13_lv_nmos_2HGZLP_0.G CKA2_N VSS rppd l=4.25u w=1u
X6511 cml_tlatch_13.xmux.xp.S1 stub_bi_17.BOTN stub_bi_17.BOTP VSS sg13_lv_nmos ad=56.9f pd=0.74u as=56.9f ps=0.74u w=0.17u l=0.17u
X6512 cml_tlatch_84.xmux.xn.S1 CKB2_P cml_tlatch_84.xtail.S1 VSS sg13_lv_nmos ad=89.3f pd=0.85u as=89.3f ps=0.85u w=0.47u l=0.16u
X6513 stub_bi_15.BOTP stub_bi_15.BOTN cml_tlatch_11.xmux.xp.S1 VSS sg13_lv_nmos ad=56.9f pd=0.74u as=0.1019p ps=1.34u w=0.17u l=0.17u
X6514 cml_tlatch_2.xmux.xp.S1 cml_tlatch_2.OUTN cml_tlatch_2.OUTP VSS sg13_lv_nmos ad=56.9f pd=0.74u as=56.9f ps=0.74u w=0.17u l=0.17u
X6515 cml_tlatch_17.xmux.xn.S1 B0_2_N MOT7_P VSS sg13_lv_nmos ad=63.19999f pd=0.74u as=63.19999f ps=0.74u w=0.26u l=0.38u
X6516 cml_tlatch_69.OUTP cml_tlatch_63.INN cml_tlatch_69.xmux.xn.S1 VSS sg13_lv_nmos ad=0.1082p pd=1.34u as=63.19999f ps=0.74u w=0.26u l=0.38u
X6517 cml_tlatch_30.xmux.xp.S1 CKB0_N cml_tlatch_30.xtail.S1 VSS sg13_lv_nmos ad=89.3f pd=0.85u as=89.3f ps=0.85u w=0.47u l=0.16u
X6518 B2_2_N B2_2_P cml_tlatch_47.xmux.xp.S1 VSS sg13_lv_nmos ad=56.9f pd=0.74u as=56.9f ps=0.74u w=0.17u l=0.17u
X6519 A0_2_P A0_2_N cml_tlatch_34.xmux.xp.S1 VSS sg13_lv_nmos ad=56.9f pd=0.74u as=56.9f ps=0.74u w=0.17u l=0.17u
X6520 cml_tlatch_26.xmux.xp.S1 MOT0_P MOT0_N VSS sg13_lv_nmos ad=56.9f pd=0.74u as=56.9f ps=0.74u w=0.17u l=0.17u
X6521 cml_tlatch_19.xmux.xp.S1 CKA1_P cml_tlatch_19.xtail.S1 VSS sg13_lv_nmos ad=89.3f pd=0.85u as=89.3f ps=0.85u w=0.47u l=0.16u
X6522 J4_N J4_P cml_tlatch_92.xmux.xp.S1 VSS sg13_lv_nmos ad=56.9f pd=0.74u as=56.9f ps=0.74u w=0.17u l=0.17u
X6523 cml_tlatch_73.xtail.S1 CKHB3_P cml_tlatch_73.xmux.xn.S1 VSS sg13_lv_nmos ad=89.3f pd=0.85u as=0.1598p ps=1.62u w=0.47u l=0.16u
X6524 cml_tlatch_1.xmux.xp.S1 B0_8_N B0_8_P VSS sg13_lv_nmos ad=56.9f pd=0.74u as=56.9f ps=0.74u w=0.17u l=0.17u
X6525 cml_tlatch_64.xmux.xp.S1 B3_8_P B3_8_N VSS sg13_lv_nmos ad=56.9f pd=0.74u as=56.9f ps=0.74u w=0.17u l=0.17u
X6526 cml_tlatch_30.OUTP cml_tlatch_30.OUTN cml_tlatch_30.xmux.xp.S1 VSS sg13_lv_nmos ad=56.9f pd=0.74u as=56.9f ps=0.74u w=0.17u l=0.17u
X6527 cml_tlatch_70.xmux.xp.S1 cml_tlatch_63.INP cml_tlatch_63.INN VSS sg13_lv_nmos ad=56.9f pd=0.74u as=56.9f ps=0.74u w=0.17u l=0.17u
X6528 cml_gate2_8.xrtail.R1 NS1_N ENB_P VSS sg13_lv_nmos ad=0.1007p pd=0.91u as=0.1007p ps=0.91u w=0.53u l=0.13u
X6529 cml_tlatch_70.xmux.xp.S1 cml_tlatch_63.INN cml_tlatch_63.INP VSS sg13_lv_nmos ad=56.9f pd=0.74u as=56.9f ps=0.74u w=0.17u l=0.17u
X6530 cml_tlatch_44.xmux.xp.S1 MOT28_P MOT28_N VSS sg13_lv_nmos ad=56.9f pd=0.74u as=56.9f ps=0.74u w=0.17u l=0.17u
X6531 cml_tlatch_73.INP cml_tlatch_73.INN cml_tlatch_66.xmux.xp.S1 VSS sg13_lv_nmos ad=56.9f pd=0.74u as=56.9f ps=0.74u w=0.17u l=0.17u
X6532 cml_tlatch_10.xmux.xp.S1 CKB1_P cml_tlatch_10.xtail.S1 VSS sg13_lv_nmos ad=89.3f pd=0.85u as=89.3f ps=0.85u w=0.47u l=0.16u
X6533 cml_tlatch_35.xmux.xn.S1 CKB1_P cml_tlatch_35.xtail.S1 VSS sg13_lv_nmos ad=89.3f pd=0.85u as=89.3f ps=0.85u w=0.47u l=0.16u
X6534 cml_tlatch_26.xmux.xp.S1 CKHA0_N cml_tlatch_26.xtail.S1 VSS sg13_lv_nmos ad=89.3f pd=0.85u as=89.3f ps=0.85u w=0.47u l=0.16u
X6535 VSS hs_to_clk_8.sg13_lv_nmos_2HGZLP_0.G VSS VSS sg13_lv_nmos ad=2.071p pd=11.28u as=0 ps=0 w=10.9u l=1.38u
X6536 cml_tlatch_49.xmux.xp.S1 cml_tlatch_49.OUTN cml_tlatch_49.OUTP VSS sg13_lv_nmos ad=56.9f pd=0.74u as=56.9f ps=0.74u w=0.17u l=0.17u
X6537 cml_tlatch_89.xmux.xn.S1 cml_tlatch_56.OUTP cml_tlatch_44.INN VSS sg13_lv_nmos ad=63.19999f pd=0.74u as=63.19999f ps=0.74u w=0.26u l=0.38u
X6538 cml_tlatch_51.OUTN D3_P cml_tlatch_51.xmux.xn.S1 VSS sg13_lv_nmos ad=63.19999f pd=0.74u as=63.19999f ps=0.74u w=0.26u l=0.38u
X6539 MOT12_N MOT12_P cml_tlatch_24.xmux.xp.S1 VSS sg13_lv_nmos ad=56.9f pd=0.74u as=56.9f ps=0.74u w=0.17u l=0.17u
X6540 cml_tlatch_12.xmux.xp.S1 cml_tlatch_4.INN cml_tlatch_4.INP VSS sg13_lv_nmos ad=56.9f pd=0.74u as=56.9f ps=0.74u w=0.17u l=0.17u
X6541 cml_tlatch_67.xmux.xn.S1 cml_tlatch_74.INP cml_tlatch_67.OUTN VSS sg13_lv_nmos ad=0.1082p pd=1.34u as=63.19999f ps=0.74u w=0.26u l=0.38u
X6542 MOT5_P MOT5_N cml_tlatch_16.xmux.xp.S1 VSS sg13_lv_nmos ad=56.9f pd=0.74u as=56.9f ps=0.74u w=0.17u l=0.17u
X6543 cml_tlatch_67.xmux.xn.S1 cml_tlatch_74.INP cml_tlatch_67.OUTN VSS sg13_lv_nmos ad=63.19999f pd=0.74u as=63.19999f ps=0.74u w=0.26u l=0.38u
X6544 stub_bi_15.BOTP stub_bi_15.BOTN cml_tlatch_11.xmux.xp.S1 VSS sg13_lv_nmos ad=56.9f pd=0.74u as=56.9f ps=0.74u w=0.17u l=0.17u
X6545 cml_tlatch_49.xtail.S1 CKB3_N cml_tlatch_49.xmux.xp.S1 VSS sg13_lv_nmos ad=89.3f pd=0.85u as=89.3f ps=0.85u w=0.47u l=0.16u
X6546 cml_tlatch_67.xmux.xp.S1 cml_tlatch_67.OUTN cml_tlatch_67.OUTP VSS sg13_lv_nmos ad=56.9f pd=0.74u as=56.9f ps=0.74u w=0.17u l=0.17u
X6547 cml_tlatch_69.xmux.xp.S1 cml_tlatch_69.OUTN cml_tlatch_69.OUTP VSS sg13_lv_nmos ad=56.9f pd=0.74u as=56.9f ps=0.74u w=0.17u l=0.17u
X6548 cml_tlatch_75.xtail.S1 CKHB3_N cml_tlatch_75.xmux.xp.S1 VSS sg13_lv_nmos ad=89.3f pd=0.85u as=89.3f ps=0.85u w=0.47u l=0.16u
X6549 cml_tlatch_74.xmux.xn.S1 cml_tlatch_74.INP MOT29_N VSS sg13_lv_nmos ad=0.1082p pd=1.34u as=63.19999f ps=0.74u w=0.26u l=0.38u
X6550 cml_tlatch_41.OUTP cml_tlatch_41.OUTN cml_tlatch_41.xmux.xp.S1 VSS sg13_lv_nmos ad=56.9f pd=0.74u as=56.9f ps=0.74u w=0.17u l=0.17u
X6551 cml_tlatch_22.xmux.xn.S1 cml_tlatch_24.INP cml_tlatch_22.OUTN VSS sg13_lv_nmos ad=63.19999f pd=0.74u as=63.19999f ps=0.74u w=0.26u l=0.38u
X6552 cml_tlatch_91.OUTN cml_tlatch_91.OUTP cml_tlatch_91.xmux.xp.S1 VSS sg13_lv_nmos ad=56.9f pd=0.74u as=56.9f ps=0.74u w=0.17u l=0.17u
X6553 MOT24_P A3_8_N cml_tlatch_62.xmux.xn.S1 VSS sg13_lv_nmos ad=63.19999f pd=0.74u as=63.19999f ps=0.74u w=0.26u l=0.38u
X6554 cml_tlatch_32.xmux.xp.S1 cml_tlatch_32.OUTN cml_tlatch_32.OUTP VSS sg13_lv_nmos ad=56.9f pd=0.74u as=56.9f ps=0.74u w=0.17u l=0.17u
X6555 cml_tlatch_11.xmux.xn.S1 cml_tlatch_4.INP stub_bi_15.BOTP VSS sg13_lv_nmos ad=63.19999f pd=0.74u as=63.19999f ps=0.74u w=0.26u l=0.38u
X6556 cml_tlatch_86.xmux.xn.S1 CKA2_P cml_tlatch_86.xtail.S1 VSS sg13_lv_nmos ad=89.3f pd=0.85u as=89.3f ps=0.85u w=0.47u l=0.16u
X6557 cml_tlatch_21.xmux.xp.S1 CKA1_P cml_tlatch_21.xtail.S1 VSS sg13_lv_nmos ad=89.3f pd=0.85u as=89.3f ps=0.85u w=0.47u l=0.16u
X6558 cml_tlatch_40.xtail.S1 CKA1_P cml_tlatch_40.xmux.xp.S1 VSS sg13_lv_nmos ad=89.3f pd=0.85u as=89.3f ps=0.85u w=0.47u l=0.16u
X6559 cml_tlatch_11.xmux.xp.S1 stub_bi_15.BOTP stub_bi_15.BOTN VSS sg13_lv_nmos ad=56.9f pd=0.74u as=56.9f ps=0.74u w=0.17u l=0.17u
X6560 cml_tlatch_95.xmux.xp.S1 J1_N J1_P VSS sg13_lv_nmos ad=56.9f pd=0.74u as=56.9f ps=0.74u w=0.17u l=0.17u
X6561 VSS POLN cml_tlatch_68.xtail.S1 VSS sg13_lv_nmos ad=2.7982p pd=17.14u as=1.5637p ps=8.61u w=8.23u l=0.13u
X6562 MOT28_N MOT28_P cml_tlatch_44.xmux.xp.S1 VSS sg13_lv_nmos ad=56.9f pd=0.74u as=56.9f ps=0.74u w=0.17u l=0.17u
X6563 cml_tlatch_2.xmux.xn.S1 cml_tlatch_7.OUTN cml_tlatch_2.OUTP VSS sg13_lv_nmos ad=63.19999f pd=0.74u as=0.1082p ps=1.34u w=0.26u l=0.38u
X6564 cml_tlatch_0.xmux.xp.S1 CKA0_N cml_tlatch_0.xtail.S1 VSS sg13_lv_nmos ad=0.1598p pd=1.62u as=89.3f ps=0.85u w=0.47u l=0.16u
X6565 MOT1_N MOT1_P cml_tlatch_14.xmux.xp.S1 VSS sg13_lv_nmos ad=56.9f pd=0.74u as=56.9f ps=0.74u w=0.17u l=0.17u
X6566 cml_tlatch_95.xmux.xn.S1 CKJ_P cml_tlatch_95.xtail.S1 VSS sg13_lv_nmos ad=89.3f pd=0.85u as=89.3f ps=0.85u w=0.47u l=0.16u
X6567 GA0_P ENA0_N cml_gate2_3.xamp.xn.S1 VSS sg13_lv_nmos ad=0.1007p pd=0.91u as=0.1007p ps=0.91u w=0.53u l=0.13u
X6568 MOT16_N MOT16_P cml_tlatch_52.xmux.xp.S1 VSS sg13_lv_nmos ad=56.9f pd=0.74u as=0.1019p ps=1.34u w=0.17u l=0.17u
X6569 cml_tlatch_5.xmux.xn.S1 CKHB1_P cml_tlatch_5.xtail.S1 VSS sg13_lv_nmos ad=89.3f pd=0.85u as=89.3f ps=0.85u w=0.47u l=0.16u
X6570 cml_tlatch_5.xmux.xn.S1 cml_tlatch_5.INN MOT13_P VSS sg13_lv_nmos ad=63.19999f pd=0.74u as=63.19999f ps=0.74u w=0.26u l=0.38u
X6571 cml_tlatch_65.OUTN cml_tlatch_65.OUTP cml_tlatch_65.xmux.xp.S1 VSS sg13_lv_nmos ad=56.9f pd=0.74u as=56.9f ps=0.74u w=0.17u l=0.17u
X6572 cml_tlatch_81.xtail.S1 POLN VSS VSS sg13_lv_nmos ad=1.5637p pd=8.61u as=2.7982p ps=17.14u w=8.23u l=0.13u
X6573 cml_tlatch_28.xmux.xp.S1 MOT4_N MOT4_P VSS sg13_lv_nmos ad=56.9f pd=0.74u as=56.9f ps=0.74u w=0.17u l=0.17u
X6574 ENA1_P ENA_N cml_drv_1.xrtail.R1 VSS sg13_lv_nmos ad=56.2f pd=0.74u as=0.1012p ps=1.34u w=0.16u l=0.19u
X6575 MOT30_P A3_2_N cml_tlatch_45.xmux.xn.S1 VSS sg13_lv_nmos ad=63.19999f pd=0.74u as=63.19999f ps=0.74u w=0.26u l=0.38u
X6576 cml_tlatch_45.xtail.S1 POLN VSS VSS sg13_lv_nmos ad=1.5637p pd=8.61u as=2.7982p ps=17.14u w=8.23u l=0.13u
X6577 A2_8_N A2_8_P cml_tlatch_85.xmux.xp.S1 VSS sg13_lv_nmos ad=56.9f pd=0.74u as=56.9f ps=0.74u w=0.17u l=0.17u
X6578 cml_tlatch_64.xmux.xp.S1 B3_8_P B3_8_N VSS sg13_lv_nmos ad=56.9f pd=0.74u as=56.9f ps=0.74u w=0.17u l=0.17u
X6579 A2_2_P A2_2_N cml_tlatch_60.xmux.xp.S1 VSS sg13_lv_nmos ad=56.9f pd=0.74u as=56.9f ps=0.74u w=0.17u l=0.17u
X6580 cml_tlatch_47.xmux.xp.S1 B2_2_N B2_2_P VSS sg13_lv_nmos ad=56.9f pd=0.74u as=56.9f ps=0.74u w=0.17u l=0.17u
X6581 VSS hs_to_clk_1.sg13_lv_nmos_2HGZLP_0.G VSS VSS sg13_lv_nmos ad=2.071p pd=11.28u as=0 ps=0 w=10.9u l=1.38u
X6582 cml_tlatch_5.xmux.xp.S1 MOT13_P MOT13_N VSS sg13_lv_nmos ad=56.9f pd=0.74u as=56.9f ps=0.74u w=0.17u l=0.17u
X6583 MOT18_P MOT18_N cml_tlatch_53.xmux.xp.S1 VSS sg13_lv_nmos ad=56.9f pd=0.74u as=56.9f ps=0.74u w=0.17u l=0.17u
X6584 cml_tlatch_2.OUTP VDD VSS rppd l=5.17u w=1u
X6585 cml_tlatch_63.xmux.xp.S1 MOT26_N MOT26_P VSS sg13_lv_nmos ad=56.9f pd=0.74u as=56.9f ps=0.74u w=0.17u l=0.17u
X6586 cml_tlatch_61.xmux.xp.S1 cml_tlatch_61.OUTP cml_tlatch_61.OUTN VSS sg13_lv_nmos ad=56.9f pd=0.74u as=56.9f ps=0.74u w=0.17u l=0.17u
X6587 cml_tlatch_2.xmux.xp.S1 cml_tlatch_2.OUTN cml_tlatch_2.OUTP VSS sg13_lv_nmos ad=56.9f pd=0.74u as=56.9f ps=0.74u w=0.17u l=0.17u
X6588 cml_tlatch_4.INN cml_tlatch_4.INP cml_tlatch_12.xmux.xp.S1 VSS sg13_lv_nmos ad=56.9f pd=0.74u as=56.9f ps=0.74u w=0.17u l=0.17u
X6589 J2_N J2_P cml_tlatch_94.xmux.xp.S1 VSS sg13_lv_nmos ad=56.9f pd=0.74u as=56.9f ps=0.74u w=0.17u l=0.17u
X6590 J2_P J2_N cml_tlatch_94.xmux.xp.S1 VSS sg13_lv_nmos ad=56.9f pd=0.74u as=56.9f ps=0.74u w=0.17u l=0.17u
X6591 cml_gate2_8.xamp.xn.S1 NS1_P cml_gate2_8.xrtail.R1 VSS sg13_lv_nmos ad=0.1007p pd=0.91u as=0.1007p ps=0.91u w=0.53u l=0.13u
X6592 A0_2_P A0_2_N cml_tlatch_34.xmux.xp.S1 VSS sg13_lv_nmos ad=56.9f pd=0.74u as=56.9f ps=0.74u w=0.17u l=0.17u
X6593 GB3_P CKA3_N cml_gate2_6.xrtail.R1 VSS sg13_lv_nmos ad=0.1007p pd=0.91u as=0.1007p ps=0.91u w=0.53u l=0.13u
X6594 cml_gate2_9.xamp.xn.S1 J1_N ENA_P VSS sg13_lv_nmos ad=0.1007p pd=0.91u as=0.1802p ps=1.74u w=0.53u l=0.13u
X6595 cml_tlatch_49.xmux.xp.S1 cml_tlatch_49.OUTN cml_tlatch_49.OUTP VSS sg13_lv_nmos ad=56.9f pd=0.74u as=56.9f ps=0.74u w=0.17u l=0.17u
X6596 cml_tlatch_91.INP cml_tlatch_91.INN cml_tlatch_59.xmux.xp.S1 VSS sg13_lv_nmos ad=56.9f pd=0.74u as=56.9f ps=0.74u w=0.17u l=0.17u
X6597 cml_tlatch_49.xmux.xn.S1 B3_2_P cml_tlatch_49.OUTN VSS sg13_lv_nmos ad=63.19999f pd=0.74u as=63.19999f ps=0.74u w=0.26u l=0.38u
X6598 cml_gate2_7.xamp.xn.S1 ENB0_P GB2_N VSS sg13_lv_nmos ad=0.1007p pd=0.91u as=0.1802p ps=1.74u w=0.53u l=0.13u
X6599 cml_tlatch_37.xtail.S1 CKB1_P cml_tlatch_37.xmux.xn.S1 VSS sg13_lv_nmos ad=89.3f pd=0.85u as=89.3f ps=0.85u w=0.47u l=0.16u
X6600 cml_tlatch_68.xmux.xp.S1 A3_8_N A3_8_P VSS sg13_lv_nmos ad=56.9f pd=0.74u as=56.9f ps=0.74u w=0.17u l=0.17u
X6601 cml_tlatch_7.OUTP cml_tlatch_8.OUTN cml_tlatch_7.xmux.xn.S1 VSS sg13_lv_nmos ad=63.19999f pd=0.74u as=63.19999f ps=0.74u w=0.26u l=0.38u
X6602 B3_8_P B3_8_N cml_tlatch_64.xmux.xp.S1 VSS sg13_lv_nmos ad=56.9f pd=0.74u as=56.9f ps=0.74u w=0.17u l=0.17u
X6603 cml_tlatch_58.xmux.xp.S1 cml_tlatch_58.OUTN cml_tlatch_58.OUTP VSS sg13_lv_nmos ad=56.9f pd=0.74u as=56.9f ps=0.74u w=0.17u l=0.17u
X6604 MOT22_P MOT22_N cml_tlatch_55.xmux.xp.S1 VSS sg13_lv_nmos ad=56.9f pd=0.74u as=56.9f ps=0.74u w=0.17u l=0.17u
X6605 cml_tlatch_86.OUTN cml_tlatch_87.OUTP cml_tlatch_86.xmux.xn.S1 VSS sg13_lv_nmos ad=63.19999f pd=0.74u as=63.19999f ps=0.74u w=0.26u l=0.38u
X6606 VSS POLN hs_to_clk_5.D2 VSS sg13_lv_nmos ad=1.9p pd=10.38u as=1.9p ps=10.38u w=10u l=0.13u
X6607 MOT16_N MOT16_P cml_tlatch_52.xmux.xp.S1 VSS sg13_lv_nmos ad=56.9f pd=0.74u as=56.9f ps=0.74u w=0.17u l=0.17u
X6608 cml_tlatch_45.xmux.xp.S1 MOT30_N MOT30_P VSS sg13_lv_nmos ad=56.9f pd=0.74u as=56.9f ps=0.74u w=0.17u l=0.17u
X6609 cml_gate2_3.xamp.xn.S1 CKB0_P cml_gate2_3.xrtail.R1 VSS sg13_lv_nmos ad=0.1802p pd=1.74u as=0.1007p ps=0.91u w=0.53u l=0.13u
X6610 cml_tlatch_39.xmux.xp.S1 cml_tlatch_97.INP cml_tlatch_97.INN VSS sg13_lv_nmos ad=56.9f pd=0.74u as=56.9f ps=0.74u w=0.17u l=0.17u
X6611 cml_tlatch_40.xtail.S1 CKA1_P cml_tlatch_40.xmux.xp.S1 VSS sg13_lv_nmos ad=89.3f pd=0.85u as=89.3f ps=0.85u w=0.47u l=0.16u
X6612 cml_tlatch_84.xmux.xp.S1 stub_bi_49.BOTN stub_bi_49.BOTP VSS sg13_lv_nmos ad=56.9f pd=0.74u as=56.9f ps=0.74u w=0.17u l=0.17u
X6613 cml_tlatch_72.xtail.S1 CKHB3_N cml_tlatch_72.xmux.xp.S1 VSS sg13_lv_nmos ad=89.3f pd=0.85u as=89.3f ps=0.85u w=0.47u l=0.16u
X6614 cml_tlatch_37.xmux.xp.S1 stub_bi_31.BOTP stub_bi_31.BOTN VSS sg13_lv_nmos ad=56.9f pd=0.74u as=56.9f ps=0.74u w=0.17u l=0.17u
X6615 cml_tlatch_51.xmux.xp.S1 CKB3_N cml_tlatch_51.xtail.S1 VSS sg13_lv_nmos ad=89.3f pd=0.85u as=89.3f ps=0.85u w=0.47u l=0.16u
X6616 MOT14_N MOT14_P cml_tlatch_25.xmux.xp.S1 VSS sg13_lv_nmos ad=56.9f pd=0.74u as=56.9f ps=0.74u w=0.17u l=0.17u
X6617 cml_tlatch_0.xmux.xp.S1 cml_tlatch_0.OUTN cml_tlatch_0.OUTP VSS sg13_lv_nmos ad=56.9f pd=0.74u as=56.9f ps=0.74u w=0.17u l=0.17u
X6618 cml_tlatch_27.xmux.xn.S1 cml_tlatch_23.OUTN MOT2_P VSS sg13_lv_nmos ad=63.19999f pd=0.74u as=63.19999f ps=0.74u w=0.26u l=0.38u
X6619 cml_tlatch_94.xtail.S1 CKJ_P cml_tlatch_94.xmux.xp.S1 VSS sg13_lv_nmos ad=89.3f pd=0.85u as=89.3f ps=0.85u w=0.47u l=0.16u
X6620 MOT31_P VDD VSS rppd l=5.17u w=1u
X6621 VSS POLN cml_tlatch_96.xtail.S1 VSS sg13_lv_nmos ad=2.7982p pd=17.14u as=1.5637p ps=8.61u w=8.23u l=0.13u
X6622 cml_tlatch_84.xtail.S1 CKB2_P cml_tlatch_84.xmux.xn.S1 VSS sg13_lv_nmos ad=89.3f pd=0.85u as=89.3f ps=0.85u w=0.47u l=0.16u
X6623 cml_tlatch_49.xtail.S1 CKB3_P cml_tlatch_49.xmux.xn.S1 VSS sg13_lv_nmos ad=89.3f pd=0.85u as=89.3f ps=0.85u w=0.47u l=0.16u
X6624 cml_tlatch_29.xtail.S1 CKHA0_P cml_tlatch_29.xmux.xn.S1 VSS sg13_lv_nmos ad=89.3f pd=0.85u as=89.3f ps=0.85u w=0.47u l=0.16u
X6625 cml_tlatch_44.xmux.xn.S1 CKHA3_P cml_tlatch_44.xtail.S1 VSS sg13_lv_nmos ad=89.3f pd=0.85u as=89.3f ps=0.85u w=0.47u l=0.16u
X6626 cml_tlatch_87.INP cml_tlatch_87.INN cml_tlatch_76.xmux.xp.S1 VSS sg13_lv_nmos ad=56.9f pd=0.74u as=56.9f ps=0.74u w=0.17u l=0.17u
X6627 MOT23_N B2_2_P cml_tlatch_80.xmux.xn.S1 VSS sg13_lv_nmos ad=63.19999f pd=0.74u as=63.19999f ps=0.74u w=0.26u l=0.38u
X6628 B2_8_N B2_8_P cml_tlatch_81.xmux.xp.S1 VSS sg13_lv_nmos ad=56.9f pd=0.74u as=0.1019p ps=1.34u w=0.17u l=0.17u
X6629 cml_tlatch_99.xmux.xn.S1 CKA0_N cml_tlatch_99.xtail.S1 VSS sg13_lv_nmos ad=89.3f pd=0.85u as=89.3f ps=0.85u w=0.47u l=0.16u
X6630 CKHB0_P GB0_N cml_drvb_1.xrtail.R2 VSS sg13_lv_nmos ad=0.2618p pd=2.22u as=0.1463p ps=1.15u w=0.77u l=0.21u
X6631 cml_tlatch_91.OUTN cml_tlatch_91.OUTP cml_tlatch_91.xmux.xp.S1 VSS sg13_lv_nmos ad=56.9f pd=0.74u as=56.9f ps=0.74u w=0.17u l=0.17u
X6632 cml_tlatch_99.xmux.xp.S1 cml_tlatch_99.OUTN cml_tlatch_99.OUTP VSS sg13_lv_nmos ad=56.9f pd=0.74u as=56.9f ps=0.74u w=0.17u l=0.17u
X6633 cml_tlatch_92.xmux.xn.S1 CKJ_N cml_tlatch_92.xtail.S1 VSS sg13_lv_nmos ad=89.3f pd=0.85u as=89.3f ps=0.85u w=0.47u l=0.16u
X6634 cml_tlatch_90.xmux.xp.S1 stub_bi_55.BOTN stub_bi_55.BOTP VSS sg13_lv_nmos ad=56.9f pd=0.74u as=56.9f ps=0.74u w=0.17u l=0.17u
X6635 cml_tlatch_43.INP cml_tlatch_22.OUTN cml_tlatch_21.xmux.xn.S1 VSS sg13_lv_nmos ad=63.19999f pd=0.74u as=63.19999f ps=0.74u w=0.26u l=0.38u
X6636 cml_tlatch_78.xmux.xp.S1 MOT19_N MOT19_P VSS sg13_lv_nmos ad=56.9f pd=0.74u as=56.9f ps=0.74u w=0.17u l=0.17u
X6637 MOT7_P MOT7_N cml_tlatch_17.xmux.xp.S1 VSS sg13_lv_nmos ad=56.9f pd=0.74u as=56.9f ps=0.74u w=0.17u l=0.17u
X6638 MOT28_P MOT28_N cml_tlatch_44.xmux.xp.S1 VSS sg13_lv_nmos ad=56.9f pd=0.74u as=56.9f ps=0.74u w=0.17u l=0.17u
X6639 MOT30_N MOT30_P cml_tlatch_45.xmux.xp.S1 VSS sg13_lv_nmos ad=56.9f pd=0.74u as=56.9f ps=0.74u w=0.17u l=0.17u
X6640 cml_tlatch_48.xmux.xp.S1 stub_bi_43.BOTN stub_bi_43.BOTP VSS sg13_lv_nmos ad=56.9f pd=0.74u as=56.9f ps=0.74u w=0.17u l=0.17u
X6641 cml_tlatch_31.xmux.xn.S1 cml_tlatch_32.OUTN B0_2_P VSS sg13_lv_nmos ad=0.1082p pd=1.34u as=63.19999f ps=0.74u w=0.26u l=0.38u
X6642 VSS POLN cml_tlatch_10.xtail.S1 VSS sg13_lv_nmos ad=1.5637p pd=8.61u as=1.5637p ps=8.61u w=8.23u l=0.13u
X6643 MOT12_N cml_tlatch_24.INP cml_tlatch_24.xmux.xn.S1 VSS sg13_lv_nmos ad=63.19999f pd=0.74u as=63.19999f ps=0.74u w=0.26u l=0.38u
X6644 cml_tlatch_4.xmux.xp.S1 MOT11_N MOT11_P VSS sg13_lv_nmos ad=56.9f pd=0.74u as=56.9f ps=0.74u w=0.17u l=0.17u
X6645 cml_tlatch_35.xtail.S1 CKB1_P cml_tlatch_35.xmux.xn.S1 VSS sg13_lv_nmos ad=89.3f pd=0.85u as=0.1598p ps=1.62u w=0.47u l=0.16u
X6646 stub_bi_38.BOTN stub_bi_38.BOTP cml_tlatch_46.xmux.xp.S1 VSS sg13_lv_nmos ad=56.9f pd=0.74u as=0.1019p ps=1.34u w=0.17u l=0.17u
X6647 cml_tlatch_31.xmux.xn.S1 CKB0_N cml_tlatch_31.xtail.S1 VSS sg13_lv_nmos ad=89.3f pd=0.85u as=89.3f ps=0.85u w=0.47u l=0.16u
X6648 cml_tlatch_5.xmux.xp.S1 CKHB1_N cml_tlatch_5.xtail.S1 VSS sg13_lv_nmos ad=89.3f pd=0.85u as=89.3f ps=0.85u w=0.47u l=0.16u
X6649 cml_tlatch_86.xmux.xp.S1 cml_tlatch_86.OUTP cml_tlatch_86.OUTN VSS sg13_lv_nmos ad=56.9f pd=0.74u as=56.9f ps=0.74u w=0.17u l=0.17u
X6650 cml_tlatch_70.xtail.S1 CKA3_P cml_tlatch_70.xmux.xp.S1 VSS sg13_lv_nmos ad=89.3f pd=0.85u as=89.3f ps=0.85u w=0.47u l=0.16u
X6651 J2_P J1_N cml_tlatch_94.xmux.xn.S1 VSS sg13_lv_nmos ad=63.19999f pd=0.74u as=0.1082p ps=1.34u w=0.26u l=0.38u
X6652 cml_tlatch_77.xmux.xp.S1 MOT17_P MOT17_N VSS sg13_lv_nmos ad=56.9f pd=0.74u as=56.9f ps=0.74u w=0.17u l=0.17u
X6653 B0_8_N B0_8_P cml_tlatch_1.xmux.xp.S1 VSS sg13_lv_nmos ad=56.9f pd=0.74u as=56.9f ps=0.74u w=0.17u l=0.17u
X6654 cml_tlatch_57.xmux.xp.S1 A3_2_P A3_2_N VSS sg13_lv_nmos ad=56.9f pd=0.74u as=56.9f ps=0.74u w=0.17u l=0.17u
X6655 cml_tlatch_4.xmux.xn.S1 cml_tlatch_4.INP MOT11_N VSS sg13_lv_nmos ad=63.19999f pd=0.74u as=0.1082p ps=1.34u w=0.26u l=0.38u
X6656 cml_tlatch_33.OUTP cml_tlatch_33.OUTN cml_tlatch_33.xmux.xp.S1 VSS sg13_lv_nmos ad=56.9f pd=0.74u as=0.1019p ps=1.34u w=0.17u l=0.17u
X6657 cml_tlatch_9.xmux.xp.S1 CKA0_P cml_tlatch_9.xtail.S1 VSS sg13_lv_nmos ad=89.3f pd=0.85u as=89.3f ps=0.85u w=0.47u l=0.16u
X6658 cml_tlatch_65.xtail.S1 CKB3_N cml_tlatch_65.xmux.xp.S1 VSS sg13_lv_nmos ad=89.3f pd=0.85u as=89.3f ps=0.85u w=0.47u l=0.16u
X6659 cml_tlatch_90.xmux.xn.S1 CKB2_N cml_tlatch_90.xtail.S1 VSS sg13_lv_nmos ad=89.3f pd=0.85u as=89.3f ps=0.85u w=0.47u l=0.16u
X6660 cml_tlatch_33.xmux.xp.S1 cml_tlatch_33.OUTP cml_tlatch_33.OUTN VSS sg13_lv_nmos ad=56.9f pd=0.74u as=56.9f ps=0.74u w=0.17u l=0.17u
X6661 B1_8_P B1_8_N cml_tlatch_10.xmux.xp.S1 VSS sg13_lv_nmos ad=56.9f pd=0.74u as=56.9f ps=0.74u w=0.17u l=0.17u
X6662 A2_2_P cml_tlatch_61.OUTN cml_tlatch_60.xmux.xn.S1 VSS sg13_lv_nmos ad=63.19999f pd=0.74u as=63.19999f ps=0.74u w=0.26u l=0.38u
X6663 cml_tlatch_47.xmux.xp.S1 B2_2_N B2_2_P VSS sg13_lv_nmos ad=56.9f pd=0.74u as=56.9f ps=0.74u w=0.17u l=0.17u
X6664 cml_tlatch_99.xmux.xn.S1 cml_tlatch_33.OUTN cml_tlatch_99.OUTP VSS sg13_lv_nmos ad=63.19999f pd=0.74u as=63.19999f ps=0.74u w=0.26u l=0.38u
X6665 cml_tlatch_63.xmux.xp.S1 MOT26_N MOT26_P VSS sg13_lv_nmos ad=56.9f pd=0.74u as=56.9f ps=0.74u w=0.17u l=0.17u
X6666 cml_tlatch_2.OUTN cml_tlatch_2.OUTP cml_tlatch_2.xmux.xp.S1 VSS sg13_lv_nmos ad=56.9f pd=0.74u as=56.9f ps=0.74u w=0.17u l=0.17u
X6667 cml_tlatch_58.xmux.xn.S1 CKA3_P cml_tlatch_58.xtail.S1 VSS sg13_lv_nmos ad=89.3f pd=0.85u as=89.3f ps=0.85u w=0.47u l=0.16u
X6668 cml_tlatch_52.xmux.xp.S1 MOT16_N MOT16_P VSS sg13_lv_nmos ad=56.9f pd=0.74u as=56.9f ps=0.74u w=0.17u l=0.17u
X6669 cml_tlatch_37.xmux.xn.S1 D1_P stub_bi_31.BOTP VSS sg13_lv_nmos ad=63.19999f pd=0.74u as=63.19999f ps=0.74u w=0.26u l=0.38u
X6670 cml_tlatch_71.OUTN cml_tlatch_71.OUTP cml_tlatch_71.xmux.xp.S1 VSS sg13_lv_nmos ad=56.9f pd=0.74u as=56.9f ps=0.74u w=0.17u l=0.17u
X6671 cml_tlatch_71.xtail.S1 POLN VSS VSS sg13_lv_nmos ad=1.5637p pd=8.61u as=2.7982p ps=17.14u w=8.23u l=0.13u
X6672 MOT23_N MOT23_P cml_tlatch_80.xmux.xp.S1 VSS sg13_lv_nmos ad=56.9f pd=0.74u as=56.9f ps=0.74u w=0.17u l=0.17u
X6673 cml_tlatch_38.xtail.S1 CKA0_N cml_tlatch_38.xmux.xp.S1 VSS sg13_lv_nmos ad=89.3f pd=0.85u as=89.3f ps=0.85u w=0.47u l=0.16u
X6674 cml_tlatch_95.xtail.S1 CKJ_P cml_tlatch_95.xmux.xn.S1 VSS sg13_lv_nmos ad=89.3f pd=0.85u as=89.3f ps=0.85u w=0.47u l=0.16u
X6675 cml_tlatch_63.xtail.S1 CKHA3_N cml_tlatch_63.xmux.xp.S1 VSS sg13_lv_nmos ad=89.3f pd=0.85u as=89.3f ps=0.85u w=0.47u l=0.16u
X6676 MOT10_P MOT10_N cml_tlatch_43.xmux.xp.S1 VSS sg13_lv_nmos ad=56.9f pd=0.74u as=56.9f ps=0.74u w=0.17u l=0.17u
X6677 cml_tlatch_56.OUTN cml_tlatch_56.OUTP cml_tlatch_56.xmux.xp.S1 VSS sg13_lv_nmos ad=56.9f pd=0.74u as=56.9f ps=0.74u w=0.17u l=0.17u
X6678 stub_bi_49.BOTN stub_bi_49.BOTP cml_tlatch_84.xmux.xp.S1 VSS sg13_lv_nmos ad=56.9f pd=0.74u as=56.9f ps=0.74u w=0.17u l=0.17u
X6679 cml_tlatch_87.OUTP cml_tlatch_87.OUTN cml_tlatch_87.xmux.xp.S1 VSS sg13_lv_nmos ad=56.9f pd=0.74u as=56.9f ps=0.74u w=0.17u l=0.17u
X6680 cml_tlatch_27.xmux.xp.S1 MOT2_P MOT2_N VSS sg13_lv_nmos ad=56.9f pd=0.74u as=56.9f ps=0.74u w=0.17u l=0.17u
X6681 cml_tlatch_51.OUTP D3_N cml_tlatch_51.xmux.xn.S1 VSS sg13_lv_nmos ad=63.19999f pd=0.74u as=63.19999f ps=0.74u w=0.26u l=0.38u
X6682 cml_tlatch_63.INN cml_tlatch_71.OUTP cml_tlatch_70.xmux.xn.S1 VSS sg13_lv_nmos ad=63.19999f pd=0.74u as=63.19999f ps=0.74u w=0.26u l=0.38u
X6683 MOT21_P MOT21_N cml_tlatch_79.xmux.xp.S1 VSS sg13_lv_nmos ad=56.9f pd=0.74u as=56.9f ps=0.74u w=0.17u l=0.17u
X6684 cml_tlatch_90.xmux.xn.S1 stub_bi_38.BOTN stub_bi_55.BOTP VSS sg13_lv_nmos ad=0.1082p pd=1.34u as=63.19999f ps=0.74u w=0.26u l=0.38u
X6685 MOT6_P A0_2_N cml_tlatch_29.xmux.xn.S1 VSS sg13_lv_nmos ad=63.19999f pd=0.74u as=63.19999f ps=0.74u w=0.26u l=0.38u
X6686 cml_tlatch_97.INP A1_2_N cml_tlatch_39.xmux.xn.S1 VSS sg13_lv_nmos ad=63.19999f pd=0.74u as=63.19999f ps=0.74u w=0.26u l=0.38u
X6687 cml_tlatch_76.xtail.S1 CKA2_N cml_tlatch_76.xmux.xp.S1 VSS sg13_lv_nmos ad=89.3f pd=0.85u as=89.3f ps=0.85u w=0.47u l=0.16u
X6688 VDD A0_2_N VSS rppd l=5.17u w=1u
X6689 cml_tlatch_51.xmux.xn.S1 CKB3_P cml_tlatch_51.xtail.S1 VSS sg13_lv_nmos ad=89.3f pd=0.85u as=89.3f ps=0.85u w=0.47u l=0.16u
X6690 cml_gate2_1.xamp.xn.S1 ENB1_N GB0_P VSS sg13_lv_nmos ad=0.1007p pd=0.91u as=0.1802p ps=1.74u w=0.53u l=0.13u
X6691 stub_bi_29.BOTP stub_bi_29.BOTN cml_tlatch_35.xmux.xp.S1 VSS sg13_lv_nmos ad=56.9f pd=0.74u as=56.9f ps=0.74u w=0.17u l=0.17u
X6692 VDD cml_tlatch_0.OUTP VSS rppd l=5.17u w=1u
X6693 cml_tlatch_26.xmux.xp.S1 CKHA0_N cml_tlatch_26.xtail.S1 VSS sg13_lv_nmos ad=89.3f pd=0.85u as=89.3f ps=0.85u w=0.47u l=0.16u
X6694 MOT13_P MOT13_N cml_tlatch_5.xmux.xp.S1 VSS sg13_lv_nmos ad=56.9f pd=0.74u as=56.9f ps=0.74u w=0.17u l=0.17u
X6695 cml_tlatch_88.xmux.xp.S1 CKB3_P cml_tlatch_88.xtail.S1 VSS sg13_lv_nmos ad=89.3f pd=0.85u as=89.3f ps=0.85u w=0.47u l=0.16u
X6696 cml_tlatch_38.OUTP cml_tlatch_38.OUTN cml_tlatch_38.xmux.xp.S1 VSS sg13_lv_nmos ad=56.9f pd=0.74u as=56.9f ps=0.74u w=0.17u l=0.17u
X6697 GA0_N ENA0_P cml_gate2_3.xamp.xn.S1 VSS sg13_lv_nmos ad=0.1007p pd=0.91u as=0.1007p ps=0.91u w=0.53u l=0.13u
X6698 cml_tlatch_86.OUTP cml_tlatch_86.OUTN cml_tlatch_86.xmux.xp.S1 VSS sg13_lv_nmos ad=56.9f pd=0.74u as=56.9f ps=0.74u w=0.17u l=0.17u
X6699 cml_tlatch_57.xmux.xp.S1 CKA3_P cml_tlatch_57.xtail.S1 VSS sg13_lv_nmos ad=0.1598p pd=1.62u as=89.3f ps=0.85u w=0.47u l=0.16u
X6700 cml_tlatch_54.xmux.xp.S1 MOT20_P MOT20_N VSS sg13_lv_nmos ad=56.9f pd=0.74u as=56.9f ps=0.74u w=0.17u l=0.17u
X6701 cml_tlatch_84.xtail.S1 CKB2_N cml_tlatch_84.xmux.xp.S1 VSS sg13_lv_nmos ad=89.3f pd=0.85u as=89.3f ps=0.85u w=0.47u l=0.16u
X6702 cml_tlatch_72.xmux.xp.S1 MOT25_P MOT25_N VSS sg13_lv_nmos ad=56.9f pd=0.74u as=56.9f ps=0.74u w=0.17u l=0.17u
X6703 cml_tlatch_71.xtail.S1 CKA3_N cml_tlatch_71.xmux.xp.S1 VSS sg13_lv_nmos ad=89.3f pd=0.85u as=89.3f ps=0.85u w=0.47u l=0.16u
X6704 cml_tlatch_9.xmux.xp.S1 A0_8_N A0_8_P VSS sg13_lv_nmos ad=56.9f pd=0.74u as=56.9f ps=0.74u w=0.17u l=0.17u
X6705 cml_tlatch_99.xmux.xp.S1 cml_tlatch_99.OUTN cml_tlatch_99.OUTP VSS sg13_lv_nmos ad=0.1019p pd=1.34u as=56.9f ps=0.74u w=0.17u l=0.17u
X6706 cml_tlatch_39.xtail.S1 CKA1_N cml_tlatch_39.xmux.xp.S1 VSS sg13_lv_nmos ad=89.3f pd=0.85u as=89.3f ps=0.85u w=0.47u l=0.16u
X6707 cml_tlatch_87.INP cml_tlatch_91.OUTN cml_tlatch_76.xmux.xn.S1 VSS sg13_lv_nmos ad=63.19999f pd=0.74u as=63.19999f ps=0.74u w=0.26u l=0.38u
X6708 MOT27_P MOT27_N cml_tlatch_73.xmux.xp.S1 VSS sg13_lv_nmos ad=56.9f pd=0.74u as=56.9f ps=0.74u w=0.17u l=0.17u
X6709 cml_tlatch_41.OUTN cml_tlatch_41.OUTP cml_tlatch_41.xmux.xp.S1 VSS sg13_lv_nmos ad=56.9f pd=0.74u as=56.9f ps=0.74u w=0.17u l=0.17u
X6710 cml_tlatch_61.OUTN D2_P cml_tlatch_61.xmux.xn.S1 VSS sg13_lv_nmos ad=63.19999f pd=0.74u as=63.19999f ps=0.74u w=0.26u l=0.38u
X6711 VDD J2_N VSS rppd l=5.17u w=1u
X6712 A3_2_P A3_2_N cml_tlatch_57.xmux.xp.S1 VSS sg13_lv_nmos ad=56.9f pd=0.74u as=56.9f ps=0.74u w=0.17u l=0.17u
X6713 cml_tlatch_4.xmux.xp.S1 MOT11_N MOT11_P VSS sg13_lv_nmos ad=56.9f pd=0.74u as=56.9f ps=0.74u w=0.17u l=0.17u
X6714 cml_tlatch_24.xmux.xp.S1 MOT12_N MOT12_P VSS sg13_lv_nmos ad=56.9f pd=0.74u as=56.9f ps=0.74u w=0.17u l=0.17u
X6715 cml_tlatch_49.OUTP B3_2_N cml_tlatch_49.xmux.xn.S1 VSS sg13_lv_nmos ad=63.19999f pd=0.74u as=63.19999f ps=0.74u w=0.26u l=0.38u
X6716 cml_tlatch_24.xmux.xp.S1 CKHA1_N cml_tlatch_24.xtail.S1 VSS sg13_lv_nmos ad=89.3f pd=0.85u as=89.3f ps=0.85u w=0.47u l=0.16u
X6717 cml_tlatch_76.xmux.xn.S1 cml_tlatch_91.OUTP cml_tlatch_87.INN VSS sg13_lv_nmos ad=63.19999f pd=0.74u as=63.19999f ps=0.74u w=0.26u l=0.38u
X6718 stub_bi_62.BOTP stub_bi_62.BOTN cml_tlatch_82.xmux.xp.S1 VSS sg13_lv_nmos ad=56.9f pd=0.74u as=56.9f ps=0.74u w=0.17u l=0.17u
X6719 MOT4_N MOT4_P cml_tlatch_28.xmux.xp.S1 VSS sg13_lv_nmos ad=56.9f pd=0.74u as=56.9f ps=0.74u w=0.17u l=0.17u
X6720 cml_tlatch_74.INN VDD VSS rppd l=5.17u w=1u
X6721 VSS hs_to_clk_4.sg13_lv_nmos_2HGZLP_0.G VSS VSS sg13_lv_nmos ad=2.071p pd=11.28u as=0 ps=0 w=10.9u l=1.38u
X6722 stub_bi_63.BOTP stub_bi_63.BOTN cml_tlatch_83.xmux.xp.S1 VSS sg13_lv_nmos ad=56.9f pd=0.74u as=56.9f ps=0.74u w=0.17u l=0.17u
X6723 cml_tlatch_21.xmux.xp.S1 cml_tlatch_43.INP cml_tlatch_43.INN VSS sg13_lv_nmos ad=56.9f pd=0.74u as=56.9f ps=0.74u w=0.17u l=0.17u
X6724 cml_tlatch_21.xmux.xp.S1 cml_tlatch_43.INN cml_tlatch_43.INP VSS sg13_lv_nmos ad=56.9f pd=0.74u as=56.9f ps=0.74u w=0.17u l=0.17u
X6725 cml_tlatch_35.xtail.S1 CKB1_N cml_tlatch_35.xmux.xp.S1 VSS sg13_lv_nmos ad=89.3f pd=0.85u as=89.3f ps=0.85u w=0.47u l=0.16u
X6726 cml_tlatch_94.xmux.xp.S1 CKJ_P cml_tlatch_94.xtail.S1 VSS sg13_lv_nmos ad=89.3f pd=0.85u as=0.1598p ps=1.62u w=0.47u l=0.16u
X6727 cml_tlatch_24.INP cml_tlatch_24.INN cml_tlatch_97.xmux.xp.S1 VSS sg13_lv_nmos ad=56.9f pd=0.74u as=56.9f ps=0.74u w=0.17u l=0.17u
X6728 MOT18_N cml_tlatch_87.OUTP cml_tlatch_53.xmux.xn.S1 VSS sg13_lv_nmos ad=63.19999f pd=0.74u as=63.19999f ps=0.74u w=0.26u l=0.38u
X6729 cml_tlatch_90.xmux.xp.S1 stub_bi_55.BOTP stub_bi_55.BOTN VSS sg13_lv_nmos ad=56.9f pd=0.74u as=56.9f ps=0.74u w=0.17u l=0.17u
X6730 cml_tlatch_59.xtail.S1 CKA2_N cml_tlatch_59.xmux.xp.S1 VSS sg13_lv_nmos ad=89.3f pd=0.85u as=89.3f ps=0.85u w=0.47u l=0.16u
X6731 VSS POLN cml_tlatch_18.xtail.S1 VSS sg13_lv_nmos ad=2.7982p pd=17.14u as=1.5637p ps=8.61u w=8.23u l=0.13u
X6732 cml_tlatch_6.xmux.xp.S1 MOT15_P MOT15_N VSS sg13_lv_nmos ad=56.9f pd=0.74u as=56.9f ps=0.74u w=0.17u l=0.17u
X6733 CLK_W_P CLK_W_N cml_tlatch_93.xmux.xp.S1 VSS sg13_lv_nmos ad=56.9f pd=0.74u as=56.9f ps=0.74u w=0.17u l=0.17u
X6734 cml_tlatch_81.xmux.xn.S1 stub_bi_62.BOTP B2_8_P VSS sg13_lv_nmos ad=63.19999f pd=0.74u as=63.19999f ps=0.74u w=0.26u l=0.38u
X6735 cml_tlatch_92.xtail.S1 CKJ_N cml_tlatch_92.xmux.xn.S1 VSS sg13_lv_nmos ad=89.3f pd=0.85u as=89.3f ps=0.85u w=0.47u l=0.16u
X6736 cml_tlatch_7.OUTP cml_tlatch_8.OUTN cml_tlatch_7.xmux.xn.S1 VSS sg13_lv_nmos ad=63.19999f pd=0.74u as=63.19999f ps=0.74u w=0.26u l=0.38u
X6737 cml_tlatch_75.xtail.S1 POLN VSS VSS sg13_lv_nmos ad=1.5637p pd=8.61u as=2.7982p ps=17.14u w=8.23u l=0.13u
X6738 cml_gate2_4.xamp.xn.S1 ENA1_N GA3_P VSS sg13_lv_nmos ad=0.1007p pd=0.91u as=0.1802p ps=1.74u w=0.53u l=0.13u
X6739 MOT31_P B3_2_N cml_tlatch_75.xmux.xn.S1 VSS sg13_lv_nmos ad=63.19999f pd=0.74u as=63.19999f ps=0.74u w=0.26u l=0.38u
X6740 cml_tlatch_71.OUTN cml_tlatch_71.OUTP cml_tlatch_71.xmux.xp.S1 VSS sg13_lv_nmos ad=56.9f pd=0.74u as=56.9f ps=0.74u w=0.17u l=0.17u
X6741 cml_tlatch_67.xmux.xp.S1 cml_tlatch_67.OUTP cml_tlatch_67.OUTN VSS sg13_lv_nmos ad=56.9f pd=0.74u as=56.9f ps=0.74u w=0.17u l=0.17u
X6742 cml_tlatch_61.OUTP cml_tlatch_61.OUTN cml_tlatch_61.xmux.xp.S1 VSS sg13_lv_nmos ad=56.9f pd=0.74u as=56.9f ps=0.74u w=0.17u l=0.17u
X6743 A1_2_N cml_tlatch_41.OUTP cml_tlatch_40.xmux.xn.S1 VSS sg13_lv_nmos ad=63.19999f pd=0.74u as=0.1082p ps=1.34u w=0.26u l=0.38u
X6744 cml_tlatch_27.xmux.xp.S1 MOT2_P MOT2_N VSS sg13_lv_nmos ad=0.1019p pd=1.34u as=56.9f ps=0.74u w=0.17u l=0.17u
X6745 cml_tlatch_95.xtail.S1 CKJ_N cml_tlatch_95.xmux.xp.S1 VSS sg13_lv_nmos ad=89.3f pd=0.85u as=89.3f ps=0.85u w=0.47u l=0.16u
X6746 cml_tlatch_91.INP A2_2_N cml_tlatch_59.xmux.xn.S1 VSS sg13_lv_nmos ad=0.1082p pd=1.34u as=63.19999f ps=0.74u w=0.26u l=0.38u
X6747 VDD GA0_P VSS rppd l=7.42u w=1u
X6748 stub_bi_17.BOTP stub_bi_17.BOTN cml_tlatch_13.xmux.xp.S1 VSS sg13_lv_nmos ad=56.9f pd=0.74u as=56.9f ps=0.74u w=0.17u l=0.17u
X6749 cml_tlatch_98.xtail.S1 CKB0_P cml_tlatch_98.xmux.xp.S1 VSS sg13_lv_nmos ad=89.3f pd=0.85u as=89.3f ps=0.85u w=0.47u l=0.16u
X6750 cml_tlatch_68.xtail.S1 CKA3_P cml_tlatch_68.xmux.xp.S1 VSS sg13_lv_nmos ad=89.3f pd=0.85u as=89.3f ps=0.85u w=0.47u l=0.16u
X6751 cml_tlatch_65.xmux.xn.S1 cml_tlatch_73.INP cml_tlatch_65.OUTN VSS sg13_lv_nmos ad=63.19999f pd=0.74u as=0.1082p ps=1.34u w=0.26u l=0.38u
X6752 cml_tlatch_55.xmux.xn.S1 CKHA2_P cml_tlatch_55.xtail.S1 VSS sg13_lv_nmos ad=0.1598p pd=1.62u as=89.3f ps=0.85u w=0.47u l=0.16u
X6753 cml_tlatch_68.xmux.xp.S1 A3_8_P A3_8_N VSS sg13_lv_nmos ad=56.9f pd=0.74u as=56.9f ps=0.74u w=0.17u l=0.17u
X6754 cml_tlatch_82.xtail.S1 CKB2_P cml_tlatch_82.xmux.xn.S1 VSS sg13_lv_nmos ad=89.3f pd=0.85u as=89.3f ps=0.85u w=0.47u l=0.16u
X6755 cml_tlatch_65.xmux.xp.S1 CKB3_N cml_tlatch_65.xtail.S1 VSS sg13_lv_nmos ad=89.3f pd=0.85u as=89.3f ps=0.85u w=0.47u l=0.16u
X6756 cml_tlatch_90.xtail.S1 CKB2_N cml_tlatch_90.xmux.xn.S1 VSS sg13_lv_nmos ad=89.3f pd=0.85u as=89.3f ps=0.85u w=0.47u l=0.16u
X6757 cml_tlatch_30.xmux.xp.S1 cml_tlatch_30.OUTP cml_tlatch_30.OUTN VSS sg13_lv_nmos ad=56.9f pd=0.74u as=56.9f ps=0.74u w=0.17u l=0.17u
X6758 cml_tlatch_44.INN cml_tlatch_44.INP cml_tlatch_89.xmux.xp.S1 VSS sg13_lv_nmos ad=56.9f pd=0.74u as=56.9f ps=0.74u w=0.17u l=0.17u
X6759 MOT13_P MOT13_N cml_tlatch_5.xmux.xp.S1 VSS sg13_lv_nmos ad=56.9f pd=0.74u as=56.9f ps=0.74u w=0.17u l=0.17u
X6760 cml_tlatch_33.xmux.xn.S1 A0_2_P cml_tlatch_33.OUTN VSS sg13_lv_nmos ad=63.19999f pd=0.74u as=63.19999f ps=0.74u w=0.26u l=0.38u
X6761 MOT23_P MOT23_N cml_tlatch_80.xmux.xp.S1 VSS sg13_lv_nmos ad=56.9f pd=0.74u as=56.9f ps=0.74u w=0.17u l=0.17u
X6762 cml_tlatch_30.xmux.xp.S1 cml_tlatch_30.OUTN cml_tlatch_30.OUTP VSS sg13_lv_nmos ad=56.9f pd=0.74u as=56.9f ps=0.74u w=0.17u l=0.17u
X6763 cml_tlatch_38.OUTP cml_tlatch_38.OUTN cml_tlatch_38.xmux.xp.S1 VSS sg13_lv_nmos ad=56.9f pd=0.74u as=56.9f ps=0.74u w=0.17u l=0.17u
X6764 cml_tlatch_75.xmux.xp.S1 MOT31_N MOT31_P VSS sg13_lv_nmos ad=56.9f pd=0.74u as=56.9f ps=0.74u w=0.17u l=0.17u
X6765 cml_tlatch_52.xmux.xn.S1 A2_8_P MOT16_N VSS sg13_lv_nmos ad=63.19999f pd=0.74u as=63.19999f ps=0.74u w=0.26u l=0.38u
X6766 cml_tlatch_59.xmux.xn.S1 A2_2_P cml_tlatch_91.INN VSS sg13_lv_nmos ad=63.19999f pd=0.74u as=63.19999f ps=0.74u w=0.26u l=0.38u
X6767 cml_gate2_1.xamp.xn.S1 CKA0_P cml_gate2_1.xrtail.R1 VSS sg13_lv_nmos ad=0.1802p pd=1.74u as=0.1007p ps=0.91u w=0.53u l=0.13u
X6768 cml_tlatch_41.xmux.xp.S1 CKA1_N cml_tlatch_41.xtail.S1 VSS sg13_lv_nmos ad=89.3f pd=0.85u as=89.3f ps=0.85u w=0.47u l=0.16u
X6769 cml_tlatch_98.OUTN cml_tlatch_30.OUTP cml_tlatch_98.xmux.xn.S1 VSS sg13_lv_nmos ad=63.19999f pd=0.74u as=63.19999f ps=0.74u w=0.26u l=0.38u
X6770 cml_tlatch_10.xmux.xp.S1 B1_8_P B1_8_N VSS sg13_lv_nmos ad=56.9f pd=0.74u as=56.9f ps=0.74u w=0.17u l=0.17u
X6771 cml_tlatch_51.xmux.xp.S1 cml_tlatch_51.OUTP cml_tlatch_51.OUTN VSS sg13_lv_nmos ad=56.9f pd=0.74u as=56.9f ps=0.74u w=0.17u l=0.17u
X6772 cml_tlatch_54.xmux.xp.S1 MOT20_P MOT20_N VSS sg13_lv_nmos ad=56.9f pd=0.74u as=56.9f ps=0.74u w=0.17u l=0.17u
X6773 cml_tlatch_38.xmux.xp.S1 cml_tlatch_38.OUTP cml_tlatch_38.OUTN VSS sg13_lv_nmos ad=56.9f pd=0.74u as=56.9f ps=0.74u w=0.17u l=0.17u
X6774 cml_tlatch_63.INP cml_tlatch_63.INN cml_tlatch_70.xmux.xp.S1 VSS sg13_lv_nmos ad=56.9f pd=0.74u as=56.9f ps=0.74u w=0.17u l=0.17u
X6775 cml_tlatch_59.xmux.xn.S1 A2_2_P cml_tlatch_91.INN VSS sg13_lv_nmos ad=63.19999f pd=0.74u as=63.19999f ps=0.74u w=0.26u l=0.38u
X6776 cml_tlatch_66.xmux.xn.S1 CKB3_N cml_tlatch_66.xtail.S1 VSS sg13_lv_nmos ad=89.3f pd=0.85u as=89.3f ps=0.85u w=0.47u l=0.16u
X6777 cml_tlatch_18.xmux.xn.S1 CKA0_P cml_tlatch_18.xtail.S1 VSS sg13_lv_nmos ad=0.1598p pd=1.62u as=89.3f ps=0.85u w=0.47u l=0.16u
X6778 cml_tlatch_50.xmux.xp.S1 B3_2_N B3_2_P VSS sg13_lv_nmos ad=56.9f pd=0.74u as=56.9f ps=0.74u w=0.17u l=0.17u
X6779 cml_tlatch_9.xmux.xp.S1 A0_8_N A0_8_P VSS sg13_lv_nmos ad=56.9f pd=0.74u as=56.9f ps=0.74u w=0.17u l=0.17u
X6780 cml_tlatch_56.xmux.xp.S1 cml_tlatch_56.OUTN cml_tlatch_56.OUTP VSS sg13_lv_nmos ad=56.9f pd=0.74u as=56.9f ps=0.74u w=0.17u l=0.17u
X6781 cml_tlatch_93.xmux.xp.S1 CLK_W_N CLK_W_P VSS sg13_lv_nmos ad=56.9f pd=0.74u as=56.9f ps=0.74u w=0.17u l=0.17u
X6782 A3_8_P cml_tlatch_69.OUTN cml_tlatch_68.xmux.xn.S1 VSS sg13_lv_nmos ad=63.19999f pd=0.74u as=63.19999f ps=0.74u w=0.26u l=0.38u
X6783 cml_tlatch_34.xtail.S1 CKA0_P cml_tlatch_34.xmux.xp.S1 VSS sg13_lv_nmos ad=89.3f pd=0.85u as=89.3f ps=0.85u w=0.47u l=0.16u
X6784 cml_tlatch_24.xmux.xp.S1 MOT12_P MOT12_N VSS sg13_lv_nmos ad=56.9f pd=0.74u as=56.9f ps=0.74u w=0.17u l=0.17u
X6785 cml_tlatch_21.xmux.xp.S1 cml_tlatch_43.INP cml_tlatch_43.INN VSS sg13_lv_nmos ad=56.9f pd=0.74u as=56.9f ps=0.74u w=0.17u l=0.17u
X6786 cml_tlatch_21.xmux.xp.S1 cml_tlatch_43.INN cml_tlatch_43.INP VSS sg13_lv_nmos ad=56.9f pd=0.74u as=56.9f ps=0.74u w=0.17u l=0.17u
X6787 J1_N J4_N cml_tlatch_95.xmux.xn.S1 VSS sg13_lv_nmos ad=63.19999f pd=0.74u as=63.19999f ps=0.74u w=0.26u l=0.38u
X6788 cml_tlatch_4.INP cml_tlatch_4.INN cml_tlatch_12.xmux.xp.S1 VSS sg13_lv_nmos ad=56.9f pd=0.74u as=56.9f ps=0.74u w=0.17u l=0.17u
X6789 cml_tlatch_68.xmux.xn.S1 cml_tlatch_69.OUTP A3_8_N VSS sg13_lv_nmos ad=63.19999f pd=0.74u as=63.19999f ps=0.74u w=0.26u l=0.38u
X6790 MOT21_P stub_bi_55.BOTP cml_tlatch_79.xmux.xn.S1 VSS sg13_lv_nmos ad=63.19999f pd=0.74u as=0.1082p ps=1.34u w=0.26u l=0.38u
X6791 B1_8_P VDD VSS rppd l=5.17u w=1u
X6792 cml_tlatch_17.xtail.S1 CKHB0_P cml_tlatch_17.xmux.xn.S1 VSS sg13_lv_nmos ad=89.3f pd=0.85u as=89.3f ps=0.85u w=0.47u l=0.16u
X6793 cml_tlatch_37.xmux.xp.S1 CKB1_N cml_tlatch_37.xtail.S1 VSS sg13_lv_nmos ad=89.3f pd=0.85u as=89.3f ps=0.85u w=0.47u l=0.16u
X6794 cml_tlatch_35.xmux.xp.S1 stub_bi_29.BOTP stub_bi_29.BOTN VSS sg13_lv_nmos ad=56.9f pd=0.74u as=56.9f ps=0.74u w=0.17u l=0.17u
X6795 GA1_N ENA0_P cml_gate2_2.xamp.xn.S1 VSS sg13_lv_nmos ad=0.1007p pd=0.91u as=0.1007p ps=0.91u w=0.53u l=0.13u
X6796 cml_tlatch_50.xmux.xp.S1 B3_2_N B3_2_P VSS sg13_lv_nmos ad=0.1019p pd=1.34u as=56.9f ps=0.74u w=0.17u l=0.17u
X6797 cml_tlatch_55.xmux.xn.S1 A2_2_P MOT22_N VSS sg13_lv_nmos ad=63.19999f pd=0.74u as=63.19999f ps=0.74u w=0.26u l=0.38u
X6798 cml_tlatch_31.xmux.xn.S1 cml_tlatch_32.OUTP B0_2_N VSS sg13_lv_nmos ad=63.19999f pd=0.74u as=0.1082p ps=1.34u w=0.26u l=0.38u
X6799 CKJ_N CK_N hs_to_clk_8.D2 VSS sg13_lv_nmos ad=0.408p pd=3.08u as=0.228p ps=1.58u w=1.2u l=0.2u
X6800 cml_tlatch_74.INN cml_tlatch_74.INP cml_tlatch_88.xmux.xp.S1 VSS sg13_lv_nmos ad=56.9f pd=0.74u as=0.1019p ps=1.34u w=0.17u l=0.17u
X6801 MOT19_N stub_bi_63.BOTN cml_tlatch_78.xmux.xn.S1 VSS sg13_lv_nmos ad=0.1082p pd=1.34u as=63.19999f ps=0.74u w=0.26u l=0.38u
X6802 cml_tlatch_24.xmux.xn.S1 CKHA1_P cml_tlatch_24.xtail.S1 VSS sg13_lv_nmos ad=89.3f pd=0.85u as=89.3f ps=0.85u w=0.47u l=0.16u
X6803 cml_tlatch_15.xmux.xp.S1 CKHB0_N cml_tlatch_15.xtail.S1 VSS sg13_lv_nmos ad=0.1598p pd=1.62u as=89.3f ps=0.85u w=0.47u l=0.16u
X6804 cml_tlatch_21.xmux.xp.S1 cml_tlatch_43.INP cml_tlatch_43.INN VSS sg13_lv_nmos ad=56.9f pd=0.74u as=56.9f ps=0.74u w=0.17u l=0.17u
X6805 cml_tlatch_4.INN stub_bi_17.BOTN cml_tlatch_12.xmux.xn.S1 VSS sg13_lv_nmos ad=63.19999f pd=0.74u as=63.19999f ps=0.74u w=0.26u l=0.38u
X6806 cml_tlatch_70.xtail.S1 CKA3_P cml_tlatch_70.xmux.xp.S1 VSS sg13_lv_nmos ad=89.3f pd=0.85u as=89.3f ps=0.85u w=0.47u l=0.16u
X6807 cml_tlatch_72.xtail.S1 POLN VSS VSS sg13_lv_nmos ad=1.5637p pd=8.61u as=2.7982p ps=17.14u w=8.23u l=0.13u
X6808 B1_2_P B1_2_N cml_tlatch_36.xmux.xp.S1 VSS sg13_lv_nmos ad=56.9f pd=0.74u as=56.9f ps=0.74u w=0.17u l=0.17u
X6809 cml_tlatch_8.OUTP cml_tlatch_8.OUTN cml_tlatch_8.xmux.xp.S1 VSS sg13_lv_nmos ad=56.9f pd=0.74u as=56.9f ps=0.74u w=0.17u l=0.17u
X6810 J1_N J1_P cml_tlatch_95.xmux.xp.S1 VSS sg13_lv_nmos ad=56.9f pd=0.74u as=56.9f ps=0.74u w=0.17u l=0.17u
X6811 CLK_W_P CLK_W_N cml_tlatch_93.xmux.xp.S1 VSS sg13_lv_nmos ad=56.9f pd=0.74u as=56.9f ps=0.74u w=0.17u l=0.17u
X6812 cml_tlatch_74.xtail.S1 CKHB3_P cml_tlatch_74.xmux.xn.S1 VSS sg13_lv_nmos ad=89.3f pd=0.85u as=0.1598p ps=1.62u w=0.47u l=0.16u
X6813 cml_tlatch_7.OUTP cml_tlatch_7.OUTN cml_tlatch_7.xmux.xp.S1 VSS sg13_lv_nmos ad=56.9f pd=0.74u as=56.9f ps=0.74u w=0.17u l=0.17u
X6814 cml_gate2_3.xrtail.R1 CKB0_P cml_gate2_3.xamp.xn.S1 VSS sg13_lv_nmos ad=0.1007p pd=0.91u as=0.1007p ps=0.91u w=0.53u l=0.13u
X6815 cml_tlatch_92.xtail.S1 CKJ_P cml_tlatch_92.xmux.xp.S1 VSS sg13_lv_nmos ad=89.3f pd=0.85u as=89.3f ps=0.85u w=0.47u l=0.16u
X6816 cml_gate2_9.xrtail.R1 NM1_N ENA_P VSS sg13_lv_nmos ad=0.1007p pd=0.91u as=0.1007p ps=0.91u w=0.53u l=0.13u
X6817 cml_tlatch_65.xmux.xp.S1 cml_tlatch_65.OUTP cml_tlatch_65.OUTN VSS sg13_lv_nmos ad=56.9f pd=0.74u as=56.9f ps=0.74u w=0.17u l=0.17u
X6818 VSS POLN cml_tlatch_58.xtail.S1 VSS sg13_lv_nmos ad=2.7982p pd=17.14u as=1.5637p ps=8.61u w=8.23u l=0.13u
X6819 cml_tlatch_66.xtail.S1 CKB3_P cml_tlatch_66.xmux.xp.S1 VSS sg13_lv_nmos ad=0.1598p pd=1.62u as=89.3f ps=0.85u w=0.47u l=0.16u
X6820 cml_tlatch_59.xmux.xp.S1 cml_tlatch_91.INP cml_tlatch_91.INN VSS sg13_lv_nmos ad=56.9f pd=0.74u as=56.9f ps=0.74u w=0.17u l=0.17u
X6821 cml_tlatch_20.xmux.xp.S1 cml_tlatch_20.OUTN cml_tlatch_20.OUTP VSS sg13_lv_nmos ad=56.9f pd=0.74u as=56.9f ps=0.74u w=0.17u l=0.17u
X6822 cml_tlatch_13.xmux.xp.S1 stub_bi_17.BOTP stub_bi_17.BOTN VSS sg13_lv_nmos ad=56.9f pd=0.74u as=56.9f ps=0.74u w=0.17u l=0.17u
X6823 VDD cml_tlatch_56.OUTP VSS rppd l=5.17u w=1u
X6824 A1_8_P A1_8_N cml_tlatch_19.xmux.xp.S1 VSS sg13_lv_nmos ad=56.9f pd=0.74u as=56.9f ps=0.74u w=0.17u l=0.17u
X6825 cml_tlatch_0.xtail.S1 CKA0_N cml_tlatch_0.xmux.xp.S1 VSS sg13_lv_nmos ad=89.3f pd=0.85u as=89.3f ps=0.85u w=0.47u l=0.16u
X6826 cml_tlatch_93.xtail.S1 POLN VSS VSS sg13_lv_nmos ad=1.5637p pd=8.61u as=2.7982p ps=17.14u w=8.23u l=0.13u
X6827 cml_tlatch_94.xmux.xn.S1 J1_P J2_N VSS sg13_lv_nmos ad=63.19999f pd=0.74u as=63.19999f ps=0.74u w=0.26u l=0.38u
X6828 cml_tlatch_85.xtail.S1 POLN VSS VSS sg13_lv_nmos ad=1.5637p pd=8.61u as=1.5637p ps=8.61u w=8.23u l=0.13u
X6829 cml_tlatch_52.xtail.S1 CKHA2_N cml_tlatch_52.xmux.xp.S1 VSS sg13_lv_nmos ad=89.3f pd=0.85u as=89.3f ps=0.85u w=0.47u l=0.16u
X6830 cml_tlatch_48.xtail.S1 POLN VSS VSS sg13_lv_nmos ad=1.5637p pd=8.61u as=2.7982p ps=17.14u w=8.23u l=0.13u
X6831 cml_gate2_5.xamp.xn.S1 ENA1_N GA2_P VSS sg13_lv_nmos ad=0.1007p pd=0.91u as=0.1007p ps=0.91u w=0.53u l=0.13u
X6832 cml_tlatch_51.xmux.xp.S1 cml_tlatch_51.OUTP cml_tlatch_51.OUTN VSS sg13_lv_nmos ad=56.9f pd=0.74u as=56.9f ps=0.74u w=0.17u l=0.17u
X6833 cml_tlatch_2.OUTP cml_tlatch_2.OUTN cml_tlatch_2.xmux.xp.S1 VSS sg13_lv_nmos ad=56.9f pd=0.74u as=56.9f ps=0.74u w=0.17u l=0.17u
X6834 cml_tlatch_61.OUTN cml_tlatch_61.OUTP cml_tlatch_61.xmux.xp.S1 VSS sg13_lv_nmos ad=56.9f pd=0.74u as=56.9f ps=0.74u w=0.17u l=0.17u
X6835 cml_tlatch_22.xmux.xn.S1 CKA1_P cml_tlatch_22.xtail.S1 VSS sg13_lv_nmos ad=89.3f pd=0.85u as=89.3f ps=0.85u w=0.47u l=0.16u
X6836 cml_tlatch_10.xmux.xn.S1 stub_bi_15.BOTN B1_8_N VSS sg13_lv_nmos ad=63.19999f pd=0.74u as=0.1082p ps=1.34u w=0.26u l=0.38u
X6837 cml_tlatch_23.xmux.xp.S1 cml_tlatch_23.OUTP cml_tlatch_23.OUTN VSS sg13_lv_nmos ad=56.9f pd=0.74u as=56.9f ps=0.74u w=0.17u l=0.17u
X6838 cml_drvb_2.xrtail.R2 GA1_N CKHA1_P VSS sg13_lv_nmos ad=0.1463p pd=1.15u as=0.2618p ps=2.22u w=0.77u l=0.21u
X6839 B1_2_P VDD VSS rppd l=5.17u w=1u
X6840 B3_8_N B3_8_P cml_tlatch_64.xmux.xp.S1 VSS sg13_lv_nmos ad=56.9f pd=0.74u as=56.9f ps=0.74u w=0.17u l=0.17u
X6841 cml_tlatch_98.xmux.xp.S1 cml_tlatch_98.OUTP cml_tlatch_98.OUTN VSS sg13_lv_nmos ad=56.9f pd=0.74u as=56.9f ps=0.74u w=0.17u l=0.17u
X6842 cml_tlatch_65.OUTN cml_tlatch_65.OUTP cml_tlatch_65.xmux.xp.S1 VSS sg13_lv_nmos ad=56.9f pd=0.74u as=56.9f ps=0.74u w=0.17u l=0.17u
X6843 cml_tlatch_30.xmux.xp.S1 cml_tlatch_30.OUTN cml_tlatch_30.OUTP VSS sg13_lv_nmos ad=56.9f pd=0.74u as=56.9f ps=0.74u w=0.17u l=0.17u
X6844 ENB0_N ENB_P cml_drv_2.xrtail.R1 VSS sg13_lv_nmos ad=0.1012p pd=1.34u as=56.2f ps=0.74u w=0.16u l=0.19u
X6845 A3_8_P A3_8_N cml_tlatch_68.xmux.xp.S1 VSS sg13_lv_nmos ad=56.9f pd=0.74u as=56.9f ps=0.74u w=0.17u l=0.17u
X6846 MOT7_P B0_2_N cml_tlatch_17.xmux.xn.S1 VSS sg13_lv_nmos ad=63.19999f pd=0.74u as=63.19999f ps=0.74u w=0.26u l=0.38u
X6847 cml_tlatch_55.xmux.xp.S1 MOT22_N MOT22_P VSS sg13_lv_nmos ad=56.9f pd=0.74u as=56.9f ps=0.74u w=0.17u l=0.17u
X6848 cml_tlatch_8.xmux.xn.S1 cml_tlatch_98.OUTP cml_tlatch_8.OUTN VSS sg13_lv_nmos ad=63.19999f pd=0.74u as=0.1082p ps=1.34u w=0.26u l=0.38u
X6849 MOT26_P cml_tlatch_63.INN cml_tlatch_63.xmux.xn.S1 VSS sg13_lv_nmos ad=63.19999f pd=0.74u as=63.19999f ps=0.74u w=0.26u l=0.38u
X6850 cml_tlatch_14.xtail.S1 CKHB0_P cml_tlatch_14.xmux.xn.S1 VSS sg13_lv_nmos ad=89.3f pd=0.85u as=89.3f ps=0.85u w=0.47u l=0.16u
X6851 cml_tlatch_97.xmux.xp.S1 CKA1_P cml_tlatch_97.xtail.S1 VSS sg13_lv_nmos ad=89.3f pd=0.85u as=89.3f ps=0.85u w=0.47u l=0.16u
X6852 cml_tlatch_10.xmux.xp.S1 B1_8_P B1_8_N VSS sg13_lv_nmos ad=56.9f pd=0.74u as=56.9f ps=0.74u w=0.17u l=0.17u
X6853 cml_tlatch_57.xmux.xp.S1 CKA3_P cml_tlatch_57.xtail.S1 VSS sg13_lv_nmos ad=89.3f pd=0.85u as=89.3f ps=0.85u w=0.47u l=0.16u
X6854 cml_tlatch_69.xmux.xn.S1 cml_tlatch_63.INN cml_tlatch_69.OUTP VSS sg13_lv_nmos ad=63.19999f pd=0.74u as=63.19999f ps=0.74u w=0.26u l=0.38u
X6855 cml_tlatch_49.OUTP cml_tlatch_49.OUTN cml_tlatch_49.xmux.xp.S1 VSS sg13_lv_nmos ad=56.9f pd=0.74u as=56.9f ps=0.74u w=0.17u l=0.17u
X6856 MOT2_P MOT2_N cml_tlatch_27.xmux.xp.S1 VSS sg13_lv_nmos ad=56.9f pd=0.74u as=56.9f ps=0.74u w=0.17u l=0.17u
X6857 cml_tlatch_24.INP cml_tlatch_97.INN cml_tlatch_97.xmux.xn.S1 VSS sg13_lv_nmos ad=63.19999f pd=0.74u as=0.1082p ps=1.34u w=0.26u l=0.38u
X6858 cml_tlatch_74.xtail.S1 POLN VSS VSS sg13_lv_nmos ad=1.5637p pd=8.61u as=1.5637p ps=8.61u w=8.23u l=0.13u
X6859 GB0_N ENB1_P cml_gate2_1.xamp.xn.S1 VSS sg13_lv_nmos ad=0.1007p pd=0.91u as=0.1007p ps=0.91u w=0.53u l=0.13u
X6860 cml_tlatch_25.xmux.xp.S1 MOT14_P MOT14_N VSS sg13_lv_nmos ad=56.9f pd=0.74u as=56.9f ps=0.74u w=0.17u l=0.17u
X6861 cml_tlatch_25.xtail.S1 CKHA1_N cml_tlatch_25.xmux.xp.S1 VSS sg13_lv_nmos ad=89.3f pd=0.85u as=0.1598p ps=1.62u w=0.47u l=0.16u
X6862 cml_tlatch_61.OUTP D2_N cml_tlatch_61.xmux.xn.S1 VSS sg13_lv_nmos ad=63.19999f pd=0.74u as=63.19999f ps=0.74u w=0.26u l=0.38u
X6863 cml_tlatch_97.xmux.xn.S1 cml_tlatch_97.INP cml_tlatch_24.INN VSS sg13_lv_nmos ad=63.19999f pd=0.74u as=63.19999f ps=0.74u w=0.26u l=0.38u
X6864 GA1_P ENA0_N cml_gate2_2.xamp.xn.S1 VSS sg13_lv_nmos ad=0.1007p pd=0.91u as=0.1007p ps=0.91u w=0.53u l=0.13u
X6865 cml_tlatch_67.xmux.xn.S1 cml_tlatch_74.INN cml_tlatch_67.OUTP VSS sg13_lv_nmos ad=0.1082p pd=1.34u as=63.19999f ps=0.74u w=0.26u l=0.38u
X6866 cml_tlatch_88.xmux.xp.S1 cml_tlatch_74.INN cml_tlatch_74.INP VSS sg13_lv_nmos ad=56.9f pd=0.74u as=56.9f ps=0.74u w=0.17u l=0.17u
X6867 B1_2_P stub_bi_31.BOTP cml_tlatch_36.xmux.xn.S1 VSS sg13_lv_nmos ad=63.19999f pd=0.74u as=63.19999f ps=0.74u w=0.26u l=0.38u
X6868 cml_tlatch_35.xmux.xp.S1 stub_bi_29.BOTP stub_bi_29.BOTN VSS sg13_lv_nmos ad=56.9f pd=0.74u as=56.9f ps=0.74u w=0.17u l=0.17u
X6869 cml_tlatch_96.xmux.xp.S1 CKB1_P cml_tlatch_96.xtail.S1 VSS sg13_lv_nmos ad=89.3f pd=0.85u as=89.3f ps=0.85u w=0.47u l=0.16u
X6870 cml_tlatch_67.xmux.xn.S1 cml_tlatch_74.INN cml_tlatch_67.OUTP VSS sg13_lv_nmos ad=63.19999f pd=0.74u as=63.19999f ps=0.74u w=0.26u l=0.38u
X6871 VSS cml_gate2_4.xrtail.R1 VSS rppd l=4.86u w=1u
X6872 MOT11_N MOT11_P cml_tlatch_4.xmux.xp.S1 VSS sg13_lv_nmos ad=56.9f pd=0.74u as=56.9f ps=0.74u w=0.17u l=0.17u
X6873 cml_tlatch_11.xmux.xp.S1 stub_bi_15.BOTN stub_bi_15.BOTP VSS sg13_lv_nmos ad=56.9f pd=0.74u as=56.9f ps=0.74u w=0.17u l=0.17u
X6874 cml_tlatch_67.OUTP cml_tlatch_67.OUTN cml_tlatch_67.xmux.xp.S1 VSS sg13_lv_nmos ad=56.9f pd=0.74u as=56.9f ps=0.74u w=0.17u l=0.17u
X6875 cml_tlatch_19.xmux.xp.S1 A1_8_N A1_8_P VSS sg13_lv_nmos ad=0.1019p pd=1.34u as=56.9f ps=0.74u w=0.17u l=0.17u
X6876 cml_tlatch_51.xmux.xn.S1 D3_P cml_tlatch_51.OUTN VSS sg13_lv_nmos ad=63.19999f pd=0.74u as=0.1082p ps=1.34u w=0.26u l=0.38u
X6877 cml_tlatch_82.xmux.xn.S1 CKB2_P cml_tlatch_82.xtail.S1 VSS sg13_lv_nmos ad=89.3f pd=0.85u as=89.3f ps=0.85u w=0.47u l=0.16u
X6878 cml_gate2_2.xamp.xn.S1 ENA0_N GA1_P VSS sg13_lv_nmos ad=0.1007p pd=0.91u as=0.1007p ps=0.91u w=0.53u l=0.13u
X6879 cml_tlatch_41.xmux.xp.S1 cml_tlatch_41.OUTN cml_tlatch_41.OUTP VSS sg13_lv_nmos ad=56.9f pd=0.74u as=56.9f ps=0.74u w=0.17u l=0.17u
X6880 cml_tlatch_22.xmux.xn.S1 cml_tlatch_24.INN cml_tlatch_22.OUTP VSS sg13_lv_nmos ad=63.19999f pd=0.74u as=63.19999f ps=0.74u w=0.26u l=0.38u
X6881 cml_tlatch_91.xmux.xp.S1 cml_tlatch_91.OUTP cml_tlatch_91.OUTN VSS sg13_lv_nmos ad=56.9f pd=0.74u as=56.9f ps=0.74u w=0.17u l=0.17u
X6882 cml_tlatch_99.OUTP cml_tlatch_99.OUTN cml_tlatch_99.xmux.xp.S1 VSS sg13_lv_nmos ad=56.9f pd=0.74u as=56.9f ps=0.74u w=0.17u l=0.17u
X6883 cml_tlatch_69.xmux.xn.S1 CKA3_P cml_tlatch_69.xtail.S1 VSS sg13_lv_nmos ad=89.3f pd=0.85u as=0.1598p ps=1.62u w=0.47u l=0.16u
X6884 MOT20_P MOT20_N cml_tlatch_54.xmux.xp.S1 VSS sg13_lv_nmos ad=56.9f pd=0.74u as=56.9f ps=0.74u w=0.17u l=0.17u
X6885 cml_tlatch_45.xmux.xp.S1 MOT30_P MOT30_N VSS sg13_lv_nmos ad=56.9f pd=0.74u as=56.9f ps=0.74u w=0.17u l=0.17u
X6886 cml_tlatch_44.xmux.xp.S1 MOT28_N MOT28_P VSS sg13_lv_nmos ad=56.9f pd=0.74u as=56.9f ps=0.74u w=0.17u l=0.17u
X6887 MOT6_N A0_2_P cml_tlatch_29.xmux.xn.S1 VSS sg13_lv_nmos ad=0.1082p pd=1.34u as=63.19999f ps=0.74u w=0.26u l=0.38u
X6888 cml_tlatch_35.xtail.S1 CKB1_N cml_tlatch_35.xmux.xp.S1 VSS sg13_lv_nmos ad=89.3f pd=0.85u as=89.3f ps=0.85u w=0.47u l=0.16u
X6889 J1_P J1_N cml_tlatch_95.xmux.xp.S1 VSS sg13_lv_nmos ad=56.9f pd=0.74u as=56.9f ps=0.74u w=0.17u l=0.17u
X6890 cml_tlatch_67.OUTN cml_tlatch_74.INP cml_tlatch_67.xmux.xn.S1 VSS sg13_lv_nmos ad=63.19999f pd=0.74u as=63.19999f ps=0.74u w=0.26u l=0.38u
X6891 stub_bi_43.BOTP stub_bi_43.BOTN cml_tlatch_48.xmux.xp.S1 VSS sg13_lv_nmos ad=56.9f pd=0.74u as=0.1019p ps=1.34u w=0.17u l=0.17u
X6892 VSS POLN hs_to_clk_6.D2 VSS sg13_lv_nmos ad=1.9p pd=10.38u as=1.9p ps=10.38u w=10u l=0.13u
X6893 cml_tlatch_36.xmux.xp.S1 CKB1_P cml_tlatch_36.xtail.S1 VSS sg13_lv_nmos ad=89.3f pd=0.85u as=89.3f ps=0.85u w=0.47u l=0.16u
X6894 GA3_N VDD VSS rppd l=7.42u w=1u
X6895 cml_tlatch_62.xmux.xn.S1 A3_8_N MOT24_P VSS sg13_lv_nmos ad=63.19999f pd=0.74u as=63.19999f ps=0.74u w=0.26u l=0.38u
X6896 MOT29_N cml_tlatch_74.INP cml_tlatch_74.xmux.xn.S1 VSS sg13_lv_nmos ad=63.19999f pd=0.74u as=63.19999f ps=0.74u w=0.26u l=0.38u
X6897 cml_tlatch_76.xmux.xp.S1 cml_tlatch_87.INP cml_tlatch_87.INN VSS sg13_lv_nmos ad=56.9f pd=0.74u as=56.9f ps=0.74u w=0.17u l=0.17u
X6898 MOT27_N MOT27_P cml_tlatch_73.xmux.xp.S1 VSS sg13_lv_nmos ad=56.9f pd=0.74u as=56.9f ps=0.74u w=0.17u l=0.17u
X6899 cml_tlatch_86.OUTN cml_tlatch_86.OUTP cml_tlatch_86.xmux.xp.S1 VSS sg13_lv_nmos ad=56.9f pd=0.74u as=0.1019p ps=1.34u w=0.17u l=0.17u
X6900 GB3_P ENB0_N cml_gate2_6.xamp.xn.S1 VSS sg13_lv_nmos ad=0.1007p pd=0.91u as=0.1007p ps=0.91u w=0.53u l=0.13u
X6901 VSS POLN cml_tlatch_37.xtail.S1 VSS sg13_lv_nmos ad=1.5637p pd=8.61u as=1.5637p ps=8.61u w=8.23u l=0.13u
X6902 MOT17_N MOT17_P cml_tlatch_77.xmux.xp.S1 VSS sg13_lv_nmos ad=56.9f pd=0.74u as=56.9f ps=0.74u w=0.17u l=0.17u
X6903 cml_tlatch_1.xmux.xp.S1 B0_8_P B0_8_N VSS sg13_lv_nmos ad=56.9f pd=0.74u as=56.9f ps=0.74u w=0.17u l=0.17u
X6904 cml_tlatch_23.xtail.S1 CKA0_P cml_tlatch_23.xmux.xp.S1 VSS sg13_lv_nmos ad=89.3f pd=0.85u as=89.3f ps=0.85u w=0.47u l=0.16u
X6905 A3_2_N A3_2_P cml_tlatch_57.xmux.xp.S1 VSS sg13_lv_nmos ad=56.9f pd=0.74u as=56.9f ps=0.74u w=0.17u l=0.17u
X6906 cml_tlatch_93.xmux.xp.S1 CKJ_N cml_tlatch_93.xtail.S1 VSS sg13_lv_nmos ad=0.1598p pd=1.62u as=89.3f ps=0.85u w=0.47u l=0.16u
X6907 cml_tlatch_62.xmux.xp.S1 MOT24_P MOT24_N VSS sg13_lv_nmos ad=56.9f pd=0.74u as=56.9f ps=0.74u w=0.17u l=0.17u
X6908 cml_tlatch_42.xmux.xp.S1 CKHA1_N cml_tlatch_42.xtail.S1 VSS sg13_lv_nmos ad=89.3f pd=0.85u as=89.3f ps=0.85u w=0.47u l=0.16u
X6909 cml_tlatch_33.OUTN cml_tlatch_33.OUTP cml_tlatch_33.xmux.xp.S1 VSS sg13_lv_nmos ad=56.9f pd=0.74u as=56.9f ps=0.74u w=0.17u l=0.17u
X6910 VDD cml_tlatch_63.INN VSS rppd l=5.17u w=1u
X6911 B2_2_P B2_2_N cml_tlatch_47.xmux.xp.S1 VSS sg13_lv_nmos ad=56.9f pd=0.74u as=56.9f ps=0.74u w=0.17u l=0.17u
X6912 cml_tlatch_9.xmux.xn.S1 CKA0_N cml_tlatch_9.xtail.S1 VSS sg13_lv_nmos ad=89.3f pd=0.85u as=89.3f ps=0.85u w=0.47u l=0.16u
X6913 cml_tlatch_15.xmux.xp.S1 MOT3_N MOT3_P VSS sg13_lv_nmos ad=56.9f pd=0.74u as=56.9f ps=0.74u w=0.17u l=0.17u
X6914 cml_tlatch_53.xmux.xp.S1 MOT18_N MOT18_P VSS sg13_lv_nmos ad=56.9f pd=0.74u as=56.9f ps=0.74u w=0.17u l=0.17u
X6915 cml_tlatch_28.xmux.xn.S1 cml_tlatch_99.OUTN MOT4_P VSS sg13_lv_nmos ad=63.19999f pd=0.74u as=63.19999f ps=0.74u w=0.26u l=0.38u
X6916 cml_tlatch_45.xmux.xn.S1 A3_2_N MOT30_P VSS sg13_lv_nmos ad=63.19999f pd=0.74u as=63.19999f ps=0.74u w=0.26u l=0.38u
X6917 MOT26_P MOT26_N cml_tlatch_63.xmux.xp.S1 VSS sg13_lv_nmos ad=56.9f pd=0.74u as=56.9f ps=0.74u w=0.17u l=0.17u
X6918 cml_tlatch_95.xtail.S1 CKJ_N cml_tlatch_95.xmux.xp.S1 VSS sg13_lv_nmos ad=89.3f pd=0.85u as=89.3f ps=0.85u w=0.47u l=0.16u
X6919 cml_tlatch_2.xmux.xp.S1 cml_tlatch_2.OUTP cml_tlatch_2.OUTN VSS sg13_lv_nmos ad=56.9f pd=0.74u as=56.9f ps=0.74u w=0.17u l=0.17u
X6920 cml_tlatch_59.xmux.xn.S1 CKA2_P cml_tlatch_59.xtail.S1 VSS sg13_lv_nmos ad=89.3f pd=0.85u as=89.3f ps=0.85u w=0.47u l=0.16u
X6921 cml_tlatch_23.xmux.xp.S1 cml_tlatch_23.OUTP cml_tlatch_23.OUTN VSS sg13_lv_nmos ad=0.1019p pd=1.34u as=56.9f ps=0.74u w=0.17u l=0.17u
X6922 cml_tlatch_38.OUTP D0_N cml_tlatch_38.xmux.xn.S1 VSS sg13_lv_nmos ad=0.1082p pd=1.34u as=63.19999f ps=0.74u w=0.26u l=0.38u
X6923 MOT16_P MOT16_N cml_tlatch_52.xmux.xp.S1 VSS sg13_lv_nmos ad=56.9f pd=0.74u as=56.9f ps=0.74u w=0.17u l=0.17u
X6924 VSS POLN cml_tlatch_16.xtail.S1 VSS sg13_lv_nmos ad=1.5637p pd=8.61u as=1.5637p ps=8.61u w=8.23u l=0.13u
X6925 cml_gate2_2.xrtail.R1 CKB1_P cml_gate2_2.xamp.xn.S1 VSS sg13_lv_nmos ad=0.1007p pd=0.91u as=0.1007p ps=0.91u w=0.53u l=0.13u
X6926 cml_tlatch_93.xmux.xp.S1 CLK_W_P CLK_W_N VSS sg13_lv_nmos ad=56.9f pd=0.74u as=56.9f ps=0.74u w=0.17u l=0.17u
X6927 cml_tlatch_49.xmux.xn.S1 B3_2_N cml_tlatch_49.OUTP VSS sg13_lv_nmos ad=63.19999f pd=0.74u as=63.19999f ps=0.74u w=0.26u l=0.38u
X6928 cml_tlatch_45.xmux.xn.S1 A3_2_N MOT30_P VSS sg13_lv_nmos ad=63.19999f pd=0.74u as=63.19999f ps=0.74u w=0.26u l=0.38u
X6929 cml_tlatch_43.xmux.xp.S1 MOT10_N MOT10_P VSS sg13_lv_nmos ad=56.9f pd=0.74u as=56.9f ps=0.74u w=0.17u l=0.17u
X6930 VDD CLK_W_N VSS rppd l=5.17u w=1u
X6931 cml_tlatch_38.OUTP D0_N cml_tlatch_38.xmux.xn.S1 VSS sg13_lv_nmos ad=63.19999f pd=0.74u as=63.19999f ps=0.74u w=0.26u l=0.38u
X6932 cml_tlatch_84.xmux.xp.S1 stub_bi_49.BOTP stub_bi_49.BOTN VSS sg13_lv_nmos ad=56.9f pd=0.74u as=56.9f ps=0.74u w=0.17u l=0.17u
X6933 cml_tlatch_38.xtail.S1 CKA0_P cml_tlatch_38.xmux.xn.S1 VSS sg13_lv_nmos ad=89.3f pd=0.85u as=89.3f ps=0.85u w=0.47u l=0.16u
X6934 cml_tlatch_21.xmux.xn.S1 cml_tlatch_22.OUTN cml_tlatch_43.INP VSS sg13_lv_nmos ad=63.19999f pd=0.74u as=63.19999f ps=0.74u w=0.26u l=0.38u
X6935 cml_tlatch_87.xmux.xp.S1 cml_tlatch_87.OUTN cml_tlatch_87.OUTP VSS sg13_lv_nmos ad=56.9f pd=0.74u as=56.9f ps=0.74u w=0.17u l=0.17u
X6936 MOT2_N MOT2_P cml_tlatch_27.xmux.xp.S1 VSS sg13_lv_nmos ad=56.9f pd=0.74u as=56.9f ps=0.74u w=0.17u l=0.17u
X6937 cml_tlatch_20.xmux.xp.S1 CKA1_N cml_tlatch_20.xtail.S1 VSS sg13_lv_nmos ad=89.3f pd=0.85u as=89.3f ps=0.85u w=0.47u l=0.16u
X6938 cml_tlatch_40.xmux.xp.S1 A1_2_P A1_2_N VSS sg13_lv_nmos ad=56.9f pd=0.74u as=56.9f ps=0.74u w=0.17u l=0.17u
X6939 cml_tlatch_79.xmux.xp.S1 MOT21_N MOT21_P VSS sg13_lv_nmos ad=56.9f pd=0.74u as=56.9f ps=0.74u w=0.17u l=0.17u
X6940 cml_tlatch_81.xmux.xn.S1 CKB2_N cml_tlatch_81.xtail.S1 VSS sg13_lv_nmos ad=89.3f pd=0.85u as=89.3f ps=0.85u w=0.47u l=0.16u
X6941 cml_tlatch_1.xmux.xp.S1 B0_8_N B0_8_P VSS sg13_lv_nmos ad=0.1019p pd=1.34u as=56.9f ps=0.74u w=0.17u l=0.17u
X6942 cml_tlatch_80.xmux.xn.S1 CKHB2_P cml_tlatch_80.xtail.S1 VSS sg13_lv_nmos ad=0.1598p pd=1.62u as=89.3f ps=0.85u w=0.47u l=0.16u
X6943 cml_tlatch_26.xtail.S1 CKHA0_P cml_tlatch_26.xmux.xn.S1 VSS sg13_lv_nmos ad=89.3f pd=0.85u as=89.3f ps=0.85u w=0.47u l=0.16u
X6944 cml_tlatch_68.xmux.xn.S1 CKA3_N cml_tlatch_68.xtail.S1 VSS sg13_lv_nmos ad=89.3f pd=0.85u as=89.3f ps=0.85u w=0.47u l=0.16u
X6945 cml_tlatch_86.OUTN cml_tlatch_86.OUTP cml_tlatch_86.xmux.xp.S1 VSS sg13_lv_nmos ad=56.9f pd=0.74u as=56.9f ps=0.74u w=0.17u l=0.17u
X6946 cml_tlatch_97.INN cml_tlatch_97.INP cml_tlatch_39.xmux.xp.S1 VSS sg13_lv_nmos ad=56.9f pd=0.74u as=56.9f ps=0.74u w=0.17u l=0.17u
X6947 cml_tlatch_30.xtail.S1 CKB0_N cml_tlatch_30.xmux.xp.S1 VSS sg13_lv_nmos ad=89.3f pd=0.85u as=89.3f ps=0.85u w=0.47u l=0.16u
X6948 cml_tlatch_7.xmux.xn.S1 cml_tlatch_8.OUTN cml_tlatch_7.OUTP VSS sg13_lv_nmos ad=63.19999f pd=0.74u as=63.19999f ps=0.74u w=0.26u l=0.38u
X6949 cml_tlatch_25.xmux.xp.S1 MOT14_P MOT14_N VSS sg13_lv_nmos ad=0.1019p pd=1.34u as=56.9f ps=0.74u w=0.17u l=0.17u
X6950 cml_tlatch_49.OUTN B3_2_P cml_tlatch_49.xmux.xn.S1 VSS sg13_lv_nmos ad=63.19999f pd=0.74u as=63.19999f ps=0.74u w=0.26u l=0.38u
X6951 cml_tlatch_5.xmux.xp.S1 MOT13_N MOT13_P VSS sg13_lv_nmos ad=56.9f pd=0.74u as=56.9f ps=0.74u w=0.17u l=0.17u
X6952 cml_tlatch_21.xmux.xn.S1 CKA1_N cml_tlatch_21.xtail.S1 VSS sg13_lv_nmos ad=89.3f pd=0.85u as=89.3f ps=0.85u w=0.47u l=0.16u
X6953 cml_tlatch_52.xmux.xp.S1 CKHA2_N cml_tlatch_52.xtail.S1 VSS sg13_lv_nmos ad=89.3f pd=0.85u as=89.3f ps=0.85u w=0.47u l=0.16u
X6954 cml_tlatch_11.xmux.xp.S1 CKB1_N cml_tlatch_11.xtail.S1 VSS sg13_lv_nmos ad=89.3f pd=0.85u as=89.3f ps=0.85u w=0.47u l=0.16u
X6955 cml_tlatch_22.OUTN cml_tlatch_22.OUTP cml_tlatch_22.xmux.xp.S1 VSS sg13_lv_nmos ad=56.9f pd=0.74u as=56.9f ps=0.74u w=0.17u l=0.17u
X6956 cml_tlatch_86.xmux.xp.S1 cml_tlatch_86.OUTN cml_tlatch_86.OUTP VSS sg13_lv_nmos ad=56.9f pd=0.74u as=56.9f ps=0.74u w=0.17u l=0.17u
X6957 MOT25_N MOT25_P cml_tlatch_72.xmux.xp.S1 VSS sg13_lv_nmos ad=56.9f pd=0.74u as=56.9f ps=0.74u w=0.17u l=0.17u
X6958 ENB1_N ENB_P cml_drv_0.xrtail.R1 VSS sg13_lv_nmos ad=0.1012p pd=1.34u as=56.2f ps=0.74u w=0.16u l=0.19u
X6959 cml_tlatch_99.OUTP cml_tlatch_99.OUTN cml_tlatch_99.xmux.xp.S1 VSS sg13_lv_nmos ad=56.9f pd=0.74u as=56.9f ps=0.74u w=0.17u l=0.17u
X6960 cml_tlatch_56.xmux.xp.S1 CKA3_N cml_tlatch_56.xtail.S1 VSS sg13_lv_nmos ad=89.3f pd=0.85u as=89.3f ps=0.85u w=0.47u l=0.16u
X6961 cml_tlatch_62.xmux.xp.S1 CKHA3_N cml_tlatch_62.xtail.S1 VSS sg13_lv_nmos ad=89.3f pd=0.85u as=89.3f ps=0.85u w=0.47u l=0.16u
X6962 cml_tlatch_12.xmux.xn.S1 CKB1_N cml_tlatch_12.xtail.S1 VSS sg13_lv_nmos ad=89.3f pd=0.85u as=89.3f ps=0.85u w=0.47u l=0.16u
X6963 hs_to_clk_7.D2 POLN VSS VSS sg13_lv_nmos ad=3.4p pd=20.68u as=1.9p ps=10.38u w=10u l=0.13u
X6964 cml_tlatch_3.xmux.xp.S1 MOT9_P MOT9_N VSS sg13_lv_nmos ad=56.9f pd=0.74u as=56.9f ps=0.74u w=0.17u l=0.17u
X6965 cml_tlatch_44.xmux.xp.S1 MOT28_N MOT28_P VSS sg13_lv_nmos ad=56.9f pd=0.74u as=56.9f ps=0.74u w=0.17u l=0.17u
X6966 cml_tlatch_15.xmux.xp.S1 CKHB0_N cml_tlatch_15.xtail.S1 VSS sg13_lv_nmos ad=89.3f pd=0.85u as=89.3f ps=0.85u w=0.47u l=0.16u
X6967 cml_tlatch_84.xmux.xp.S1 stub_bi_49.BOTP stub_bi_49.BOTN VSS sg13_lv_nmos ad=56.9f pd=0.74u as=56.9f ps=0.74u w=0.17u l=0.17u
X6968 GB1_N ENB1_P cml_gate2_0.xamp.xn.S1 VSS sg13_lv_nmos ad=0.1007p pd=0.91u as=0.1007p ps=0.91u w=0.53u l=0.13u
X6969 cml_tlatch_80.xmux.xn.S1 B2_2_P MOT23_N VSS sg13_lv_nmos ad=63.19999f pd=0.74u as=63.19999f ps=0.74u w=0.26u l=0.38u
X6970 cml_tlatch_24.INN cml_tlatch_24.INP cml_tlatch_97.xmux.xp.S1 VSS sg13_lv_nmos ad=56.9f pd=0.74u as=56.9f ps=0.74u w=0.17u l=0.17u
X6971 cml_tlatch_57.xmux.xp.S1 A3_2_N A3_2_P VSS sg13_lv_nmos ad=56.9f pd=0.74u as=56.9f ps=0.74u w=0.17u l=0.17u
X6972 cml_tlatch_72.xmux.xn.S1 B3_8_N MOT25_P VSS sg13_lv_nmos ad=0.1082p pd=1.34u as=63.19999f ps=0.74u w=0.26u l=0.38u
X6973 MOT11_P MOT11_N cml_tlatch_4.xmux.xp.S1 VSS sg13_lv_nmos ad=56.9f pd=0.74u as=56.9f ps=0.74u w=0.17u l=0.17u
X6974 MOT12_P MOT12_N cml_tlatch_24.xmux.xp.S1 VSS sg13_lv_nmos ad=56.9f pd=0.74u as=56.9f ps=0.74u w=0.17u l=0.17u
X6975 cml_tlatch_44.xtail.S1 CKHA3_N cml_tlatch_44.xmux.xp.S1 VSS sg13_lv_nmos ad=89.3f pd=0.85u as=89.3f ps=0.85u w=0.47u l=0.16u
X6976 cml_tlatch_32.OUTN cml_tlatch_32.OUTP cml_tlatch_32.xmux.xp.S1 VSS sg13_lv_nmos ad=56.9f pd=0.74u as=56.9f ps=0.74u w=0.17u l=0.17u
X6977 cml_tlatch_49.xmux.xp.S1 CKB3_N cml_tlatch_49.xtail.S1 VSS sg13_lv_nmos ad=89.3f pd=0.85u as=89.3f ps=0.85u w=0.47u l=0.16u
X6978 stub_bi_63.BOTP stub_bi_49.BOTN cml_tlatch_83.xmux.xn.S1 VSS sg13_lv_nmos ad=63.19999f pd=0.74u as=63.19999f ps=0.74u w=0.26u l=0.38u
X6979 cml_tlatch_28.xmux.xp.S1 MOT4_P MOT4_N VSS sg13_lv_nmos ad=56.9f pd=0.74u as=56.9f ps=0.74u w=0.17u l=0.17u
X6980 cml_tlatch_87.OUTN cml_tlatch_87.OUTP cml_tlatch_87.xmux.xp.S1 VSS sg13_lv_nmos ad=56.9f pd=0.74u as=56.9f ps=0.74u w=0.17u l=0.17u
X6981 cml_tlatch_83.xmux.xp.S1 stub_bi_63.BOTN stub_bi_63.BOTP VSS sg13_lv_nmos ad=56.9f pd=0.74u as=56.9f ps=0.74u w=0.17u l=0.17u
X6982 cml_tlatch_92.xtail.S1 CKJ_P cml_tlatch_92.xmux.xp.S1 VSS sg13_lv_nmos ad=89.3f pd=0.85u as=89.3f ps=0.85u w=0.47u l=0.16u
X6983 cml_tlatch_83.xmux.xp.S1 stub_bi_63.BOTP stub_bi_63.BOTN VSS sg13_lv_nmos ad=56.9f pd=0.74u as=56.9f ps=0.74u w=0.17u l=0.17u
X6984 cml_tlatch_1.xmux.xp.S1 B0_8_P B0_8_N VSS sg13_lv_nmos ad=56.9f pd=0.74u as=56.9f ps=0.74u w=0.17u l=0.17u
X6985 A1_2_P A1_2_N cml_tlatch_40.xmux.xp.S1 VSS sg13_lv_nmos ad=56.9f pd=0.74u as=56.9f ps=0.74u w=0.17u l=0.17u
X6986 stub_bi_55.BOTN stub_bi_55.BOTP cml_tlatch_90.xmux.xp.S1 VSS sg13_lv_nmos ad=56.9f pd=0.74u as=56.9f ps=0.74u w=0.17u l=0.17u
X6987 cml_drv_1.xrtail.R1 ENA_N ENA1_P VSS sg13_lv_nmos ad=56.2f pd=0.74u as=56.2f ps=0.74u w=0.16u l=0.19u
X6988 cml_tlatch_33.OUTN cml_tlatch_33.OUTP cml_tlatch_33.xmux.xp.S1 VSS sg13_lv_nmos ad=56.9f pd=0.74u as=56.9f ps=0.74u w=0.17u l=0.17u
X6989 MOT15_N MOT15_P cml_tlatch_6.xmux.xp.S1 VSS sg13_lv_nmos ad=56.9f pd=0.74u as=56.9f ps=0.74u w=0.17u l=0.17u
X6990 cml_tlatch_47.xmux.xn.S1 CKB2_N cml_tlatch_47.xtail.S1 VSS sg13_lv_nmos ad=89.3f pd=0.85u as=89.3f ps=0.85u w=0.47u l=0.16u
X6991 cml_tlatch_97.xmux.xn.S1 CKA1_N cml_tlatch_97.xtail.S1 VSS sg13_lv_nmos ad=89.3f pd=0.85u as=89.3f ps=0.85u w=0.47u l=0.16u
X6992 cml_gate2_1.xrtail.R1 CKA0_P cml_gate2_1.xamp.xn.S1 VSS sg13_lv_nmos ad=0.1007p pd=0.91u as=0.1007p ps=0.91u w=0.53u l=0.13u
X6993 cml_tlatch_57.xmux.xn.S1 CKA3_N cml_tlatch_57.xtail.S1 VSS sg13_lv_nmos ad=89.3f pd=0.85u as=89.3f ps=0.85u w=0.47u l=0.16u
X6994 A3_8_N cml_tlatch_69.OUTP cml_tlatch_68.xmux.xn.S1 VSS sg13_lv_nmos ad=0.1082p pd=1.34u as=63.19999f ps=0.74u w=0.26u l=0.38u
X6995 cml_tlatch_24.xmux.xn.S1 cml_tlatch_24.INP MOT12_N VSS sg13_lv_nmos ad=63.19999f pd=0.74u as=0.1082p ps=1.34u w=0.26u l=0.38u
X6996 cml_tlatch_31.xmux.xp.S1 B0_2_N B0_2_P VSS sg13_lv_nmos ad=56.9f pd=0.74u as=56.9f ps=0.74u w=0.17u l=0.17u
X6997 cml_tlatch_22.xtail.S1 CKA1_N cml_tlatch_22.xmux.xp.S1 VSS sg13_lv_nmos ad=89.3f pd=0.85u as=89.3f ps=0.85u w=0.47u l=0.16u
X6998 cml_tlatch_45.xtail.S1 POLN VSS VSS sg13_lv_nmos ad=1.5637p pd=8.61u as=1.5637p ps=8.61u w=8.23u l=0.13u
X6999 cml_tlatch_2.xmux.xn.S1 cml_tlatch_7.OUTP cml_tlatch_2.OUTN VSS sg13_lv_nmos ad=0.1082p pd=1.34u as=63.19999f ps=0.74u w=0.26u l=0.38u
X7000 cml_tlatch_81.xmux.xp.S1 B2_8_P B2_8_N VSS sg13_lv_nmos ad=56.9f pd=0.74u as=56.9f ps=0.74u w=0.17u l=0.17u
X7001 cml_tlatch_25.xtail.S1 CKHA1_P cml_tlatch_25.xmux.xn.S1 VSS sg13_lv_nmos ad=89.3f pd=0.85u as=89.3f ps=0.85u w=0.47u l=0.16u
X7002 cml_tlatch_77.xmux.xn.S1 CKHB2_P cml_tlatch_77.xtail.S1 VSS sg13_lv_nmos ad=0.1598p pd=1.62u as=89.3f ps=0.85u w=0.47u l=0.16u
X7003 A1_2_P A1_2_N cml_tlatch_40.xmux.xp.S1 VSS sg13_lv_nmos ad=56.9f pd=0.74u as=56.9f ps=0.74u w=0.17u l=0.17u
X7004 cml_tlatch_71.xmux.xp.S1 cml_tlatch_71.OUTP cml_tlatch_71.OUTN VSS sg13_lv_nmos ad=56.9f pd=0.74u as=56.9f ps=0.74u w=0.17u l=0.17u
X7005 cml_tlatch_49.xmux.xp.S1 cml_tlatch_49.OUTP cml_tlatch_49.OUTN VSS sg13_lv_nmos ad=56.9f pd=0.74u as=56.9f ps=0.74u w=0.17u l=0.17u
X7006 cml_tlatch_62.xmux.xp.S1 MOT24_N MOT24_P VSS sg13_lv_nmos ad=56.9f pd=0.74u as=56.9f ps=0.74u w=0.17u l=0.17u
X7007 cml_tlatch_61.xmux.xp.S1 cml_tlatch_61.OUTN cml_tlatch_61.OUTP VSS sg13_lv_nmos ad=56.9f pd=0.74u as=56.9f ps=0.74u w=0.17u l=0.17u
X7008 cml_tlatch_23.OUTP cml_tlatch_23.OUTN cml_tlatch_23.xmux.xp.S1 VSS sg13_lv_nmos ad=56.9f pd=0.74u as=56.9f ps=0.74u w=0.17u l=0.17u
X7009 MOT1_N B0_8_P cml_tlatch_14.xmux.xn.S1 VSS sg13_lv_nmos ad=63.19999f pd=0.74u as=63.19999f ps=0.74u w=0.26u l=0.38u
X7010 cml_gate2_8.xamp.xn.S1 NS1_P cml_gate2_8.xrtail.R1 VSS sg13_lv_nmos ad=0.1007p pd=0.91u as=0.1007p ps=0.91u w=0.53u l=0.13u
X7011 MOT8_P MOT8_N cml_tlatch_42.xmux.xp.S1 VSS sg13_lv_nmos ad=56.9f pd=0.74u as=56.9f ps=0.74u w=0.17u l=0.17u
X7012 MOT29_P MOT29_N cml_tlatch_74.xmux.xp.S1 VSS sg13_lv_nmos ad=56.9f pd=0.74u as=56.9f ps=0.74u w=0.17u l=0.17u
X7013 VSS POLN cml_tlatch_15.xtail.S1 VSS sg13_lv_nmos ad=1.5637p pd=8.61u as=1.5637p ps=8.61u w=8.23u l=0.13u
X7014 cml_tlatch_13.xmux.xp.S1 stub_bi_17.BOTN stub_bi_17.BOTP VSS sg13_lv_nmos ad=56.9f pd=0.74u as=56.9f ps=0.74u w=0.17u l=0.17u
X7015 J4_P CLK_W_P cml_tlatch_92.xmux.xn.S1 VSS sg13_lv_nmos ad=63.19999f pd=0.74u as=0.1082p ps=1.34u w=0.26u l=0.38u
X7016 cml_gate2_9.xamp.xn.S1 J1_N ENA_P VSS sg13_lv_nmos ad=0.1007p pd=0.91u as=0.1007p ps=0.91u w=0.53u l=0.13u
X7017 cml_tlatch_46.xmux.xp.S1 stub_bi_38.BOTP stub_bi_38.BOTN VSS sg13_lv_nmos ad=56.9f pd=0.74u as=56.9f ps=0.74u w=0.17u l=0.17u
X7018 ENB_N J2_P cml_gate2_8.xamp.xn.S1 VSS sg13_lv_nmos ad=0.1007p pd=0.91u as=0.1007p ps=0.91u w=0.53u l=0.13u
X7019 MOT25_N MOT25_P cml_tlatch_72.xmux.xp.S1 VSS sg13_lv_nmos ad=56.9f pd=0.74u as=0.1019p ps=1.34u w=0.17u l=0.17u
X7020 cml_tlatch_92.xmux.xn.S1 CLK_W_N J4_N VSS sg13_lv_nmos ad=63.19999f pd=0.74u as=63.19999f ps=0.74u w=0.26u l=0.38u
X7021 A3_8_N A3_8_P cml_tlatch_68.xmux.xp.S1 VSS sg13_lv_nmos ad=56.9f pd=0.74u as=0.1019p ps=1.34u w=0.17u l=0.17u
X7022 cml_tlatch_89.xmux.xp.S1 cml_tlatch_44.INP cml_tlatch_44.INN VSS sg13_lv_nmos ad=56.9f pd=0.74u as=56.9f ps=0.74u w=0.17u l=0.17u
X7023 cml_tlatch_5.xmux.xp.S1 MOT13_N MOT13_P VSS sg13_lv_nmos ad=56.9f pd=0.74u as=56.9f ps=0.74u w=0.17u l=0.17u
X7024 cml_tlatch_80.xmux.xp.S1 MOT23_N MOT23_P VSS sg13_lv_nmos ad=56.9f pd=0.74u as=56.9f ps=0.74u w=0.17u l=0.17u
X7025 cml_tlatch_0.xmux.xp.S1 cml_tlatch_0.OUTP cml_tlatch_0.OUTN VSS sg13_lv_nmos ad=56.9f pd=0.74u as=56.9f ps=0.74u w=0.17u l=0.17u
X7026 cml_tlatch_58.xtail.S1 CKA3_N cml_tlatch_58.xmux.xp.S1 VSS sg13_lv_nmos ad=89.3f pd=0.85u as=89.3f ps=0.85u w=0.47u l=0.16u
X7027 cml_tlatch_58.xmux.xp.S1 cml_tlatch_58.OUTP cml_tlatch_58.OUTN VSS sg13_lv_nmos ad=56.9f pd=0.74u as=56.9f ps=0.74u w=0.17u l=0.17u
X7028 cml_tlatch_95.xmux.xp.S1 CKJ_N cml_tlatch_95.xtail.S1 VSS sg13_lv_nmos ad=89.3f pd=0.85u as=0.1598p ps=1.62u w=0.47u l=0.16u
X7029 stub_bi_55.BOTP stub_bi_38.BOTN cml_tlatch_90.xmux.xn.S1 VSS sg13_lv_nmos ad=63.19999f pd=0.74u as=63.19999f ps=0.74u w=0.26u l=0.38u
X7030 cml_tlatch_96.xmux.xp.S1 CKB1_P cml_tlatch_96.xtail.S1 VSS sg13_lv_nmos ad=89.3f pd=0.85u as=89.3f ps=0.85u w=0.47u l=0.16u
X7031 VSS hs_to_clk_0.sg13_lv_nmos_2HGZLP_0.G VSS VSS sg13_lv_nmos ad=2.071p pd=11.28u as=0 ps=0 w=10.9u l=1.38u
X7032 cml_tlatch_50.xmux.xp.S1 CKB3_P cml_tlatch_50.xtail.S1 VSS sg13_lv_nmos ad=89.3f pd=0.85u as=89.3f ps=0.85u w=0.47u l=0.16u
X7033 MOT24_P MOT24_N cml_tlatch_62.xmux.xp.S1 VSS sg13_lv_nmos ad=56.9f pd=0.74u as=56.9f ps=0.74u w=0.17u l=0.17u
X7034 B0_2_N B0_2_P cml_tlatch_31.xmux.xp.S1 VSS sg13_lv_nmos ad=56.9f pd=0.74u as=56.9f ps=0.74u w=0.17u l=0.17u
X7035 cml_tlatch_6.xtail.S1 CKHB1_N cml_tlatch_6.xmux.xp.S1 VSS sg13_lv_nmos ad=89.3f pd=0.85u as=0.1598p ps=1.62u w=0.47u l=0.16u
X7036 cml_tlatch_76.xmux.xn.S1 CKA2_P cml_tlatch_76.xtail.S1 VSS sg13_lv_nmos ad=89.3f pd=0.85u as=0.1598p ps=1.62u w=0.47u l=0.16u
X7037 cml_tlatch_56.OUTP cml_tlatch_56.OUTN cml_tlatch_56.xmux.xp.S1 VSS sg13_lv_nmos ad=56.9f pd=0.74u as=0.1019p ps=1.34u w=0.17u l=0.17u
X7038 cml_tlatch_55.xtail.S1 CKHA2_P cml_tlatch_55.xmux.xn.S1 VSS sg13_lv_nmos ad=89.3f pd=0.85u as=89.3f ps=0.85u w=0.47u l=0.16u
X7039 cml_tlatch_75.xmux.xp.S1 MOT31_P MOT31_N VSS sg13_lv_nmos ad=56.9f pd=0.74u as=56.9f ps=0.74u w=0.17u l=0.17u
X7040 cml_tlatch_99.xmux.xp.S1 cml_tlatch_99.OUTP cml_tlatch_99.OUTN VSS sg13_lv_nmos ad=56.9f pd=0.74u as=56.9f ps=0.74u w=0.17u l=0.17u
X7041 cml_tlatch_98.xtail.S1 POLN VSS VSS sg13_lv_nmos ad=1.5637p pd=8.61u as=2.7982p ps=17.14u w=8.23u l=0.13u
X7042 cml_tlatch_37.xmux.xp.S1 stub_bi_31.BOTN stub_bi_31.BOTP VSS sg13_lv_nmos ad=56.9f pd=0.74u as=56.9f ps=0.74u w=0.17u l=0.17u
X7043 A2_8_P A2_8_N cml_tlatch_85.xmux.xp.S1 VSS sg13_lv_nmos ad=56.9f pd=0.74u as=56.9f ps=0.74u w=0.17u l=0.17u
X7044 cml_tlatch_57.xmux.xp.S1 A3_2_N A3_2_P VSS sg13_lv_nmos ad=56.9f pd=0.74u as=56.9f ps=0.74u w=0.17u l=0.17u
X7045 cml_tlatch_20.xmux.xp.S1 cml_tlatch_20.OUTP cml_tlatch_20.OUTN VSS sg13_lv_nmos ad=56.9f pd=0.74u as=56.9f ps=0.74u w=0.17u l=0.17u
X7046 B3_2_P B3_2_N cml_tlatch_50.xmux.xp.S1 VSS sg13_lv_nmos ad=56.9f pd=0.74u as=56.9f ps=0.74u w=0.17u l=0.17u
X7047 cml_tlatch_18.xtail.S1 CKA0_P cml_tlatch_18.xmux.xn.S1 VSS sg13_lv_nmos ad=89.3f pd=0.85u as=89.3f ps=0.85u w=0.47u l=0.16u
X7048 stub_bi_31.BOTN VDD VSS rppd l=5.17u w=1u
X7049 cml_tlatch_29.xmux.xp.S1 MOT6_N MOT6_P VSS sg13_lv_nmos ad=56.9f pd=0.74u as=56.9f ps=0.74u w=0.17u l=0.17u
X7050 cml_tlatch_76.xmux.xn.S1 cml_tlatch_91.OUTN cml_tlatch_87.INP VSS sg13_lv_nmos ad=63.19999f pd=0.74u as=63.19999f ps=0.74u w=0.26u l=0.38u
X7051 GA2_P CKB2_N cml_gate2_5.xrtail.R1 VSS sg13_lv_nmos ad=0.1802p pd=1.74u as=0.1007p ps=0.91u w=0.53u l=0.13u
X7052 MOT7_N B0_2_P cml_tlatch_17.xmux.xn.S1 VSS sg13_lv_nmos ad=0.1082p pd=1.34u as=63.19999f ps=0.74u w=0.26u l=0.38u
X7053 cml_tlatch_28.xmux.xp.S1 MOT4_P MOT4_N VSS sg13_lv_nmos ad=0.1019p pd=1.34u as=56.9f ps=0.74u w=0.17u l=0.17u
X7054 cml_tlatch_83.xmux.xp.S1 stub_bi_63.BOTN stub_bi_63.BOTP VSS sg13_lv_nmos ad=56.9f pd=0.74u as=56.9f ps=0.74u w=0.17u l=0.17u
X7055 cml_tlatch_99.xtail.S1 CKA0_N cml_tlatch_99.xmux.xn.S1 VSS sg13_lv_nmos ad=89.3f pd=0.85u as=89.3f ps=0.85u w=0.47u l=0.16u
X7056 cml_tlatch_3.xmux.xp.S1 MOT9_N MOT9_P VSS sg13_lv_nmos ad=56.9f pd=0.74u as=56.9f ps=0.74u w=0.17u l=0.17u
X7057 cml_tlatch_43.INP cml_tlatch_43.INN cml_tlatch_21.xmux.xp.S1 VSS sg13_lv_nmos ad=56.9f pd=0.74u as=56.9f ps=0.74u w=0.17u l=0.17u
X7058 cml_tlatch_20.xtail.S1 POLN VSS VSS sg13_lv_nmos ad=1.5637p pd=8.61u as=2.7982p ps=17.14u w=8.23u l=0.13u
X7059 cml_tlatch_36.xmux.xp.S1 B1_2_N B1_2_P VSS sg13_lv_nmos ad=56.9f pd=0.74u as=56.9f ps=0.74u w=0.17u l=0.17u
X7060 VSS POLN cml_tlatch_10.xtail.S1 VSS sg13_lv_nmos ad=2.7982p pd=17.14u as=1.5637p ps=8.61u w=8.23u l=0.13u
X7061 VSS hs_to_clk_4.sg13_lv_nmos_2HGZLP_0.G VSS VSS sg13_lv_nmos ad=2.071p pd=11.28u as=0 ps=0 w=10.9u l=1.38u
X7062 cml_tlatch_8.xmux.xp.S1 cml_tlatch_8.OUTN cml_tlatch_8.OUTP VSS sg13_lv_nmos ad=56.9f pd=0.74u as=56.9f ps=0.74u w=0.17u l=0.17u
X7063 cml_tlatch_20.xmux.xn.S1 CKA1_P cml_tlatch_20.xtail.S1 VSS sg13_lv_nmos ad=89.3f pd=0.85u as=89.3f ps=0.85u w=0.47u l=0.16u
X7064 cml_tlatch_71.OUTP cml_tlatch_71.OUTN cml_tlatch_71.xmux.xp.S1 VSS sg13_lv_nmos ad=56.9f pd=0.74u as=56.9f ps=0.74u w=0.17u l=0.17u
X7065 GB3_N VDD VSS rppd l=7.42u w=1u
X7066 MOT18_N MOT18_P cml_tlatch_53.xmux.xp.S1 VSS sg13_lv_nmos ad=56.9f pd=0.74u as=56.9f ps=0.74u w=0.17u l=0.17u
X7067 cml_tlatch_7.xmux.xp.S1 cml_tlatch_7.OUTN cml_tlatch_7.OUTP VSS sg13_lv_nmos ad=56.9f pd=0.74u as=56.9f ps=0.74u w=0.17u l=0.17u
X7068 cml_tlatch_53.xmux.xn.S1 cml_tlatch_87.OUTP MOT18_N VSS sg13_lv_nmos ad=63.19999f pd=0.74u as=63.19999f ps=0.74u w=0.26u l=0.38u
X7069 cml_tlatch_15.xtail.S1 CKHB0_N cml_tlatch_15.xmux.xp.S1 VSS sg13_lv_nmos ad=89.3f pd=0.85u as=89.3f ps=0.85u w=0.47u l=0.16u
X7070 cml_tlatch_87.INN cml_tlatch_91.OUTP cml_tlatch_76.xmux.xn.S1 VSS sg13_lv_nmos ad=63.19999f pd=0.74u as=0.1082p ps=1.34u w=0.26u l=0.38u
X7071 cml_tlatch_52.xmux.xn.S1 CKHA2_P cml_tlatch_52.xtail.S1 VSS sg13_lv_nmos ad=89.3f pd=0.85u as=89.3f ps=0.85u w=0.47u l=0.16u
X7072 cml_tlatch_22.xmux.xp.S1 cml_tlatch_22.OUTN cml_tlatch_22.OUTP VSS sg13_lv_nmos ad=56.9f pd=0.74u as=56.9f ps=0.74u w=0.17u l=0.17u
X7073 cml_tlatch_35.xmux.xn.S1 B1_2_P stub_bi_29.BOTP VSS sg13_lv_nmos ad=63.19999f pd=0.74u as=63.19999f ps=0.74u w=0.26u l=0.38u
X7074 cml_tlatch_91.INN cml_tlatch_91.INP cml_tlatch_59.xmux.xp.S1 VSS sg13_lv_nmos ad=56.9f pd=0.74u as=56.9f ps=0.74u w=0.17u l=0.17u
X7075 cml_tlatch_59.xmux.xn.S1 CKA2_P cml_tlatch_59.xtail.S1 VSS sg13_lv_nmos ad=89.3f pd=0.85u as=89.3f ps=0.85u w=0.47u l=0.16u
X7076 stub_bi_17.BOTN stub_bi_17.BOTP cml_tlatch_13.xmux.xp.S1 VSS sg13_lv_nmos ad=56.9f pd=0.74u as=56.9f ps=0.74u w=0.17u l=0.17u
X7077 stub_bi_31.BOTN D1_N cml_tlatch_37.xmux.xn.S1 VSS sg13_lv_nmos ad=63.19999f pd=0.74u as=63.19999f ps=0.74u w=0.26u l=0.38u
X7078 MOT10_N MOT10_P cml_tlatch_43.xmux.xp.S1 VSS sg13_lv_nmos ad=56.9f pd=0.74u as=56.9f ps=0.74u w=0.17u l=0.17u
X7079 cml_tlatch_5.INN cml_tlatch_5.INP cml_tlatch_96.xmux.xp.S1 VSS sg13_lv_nmos ad=56.9f pd=0.74u as=56.9f ps=0.74u w=0.17u l=0.17u
X7080 cml_tlatch_33.xmux.xn.S1 CKA0_P cml_tlatch_33.xtail.S1 VSS sg13_lv_nmos ad=89.3f pd=0.85u as=89.3f ps=0.85u w=0.47u l=0.16u
X7081 cml_tlatch_9.xtail.S1 CKA0_P cml_tlatch_9.xmux.xp.S1 VSS sg13_lv_nmos ad=89.3f pd=0.85u as=89.3f ps=0.85u w=0.47u l=0.16u
X7082 VSS POLN cml_tlatch_49.xtail.S1 VSS sg13_lv_nmos ad=1.5637p pd=8.61u as=1.5637p ps=8.61u w=8.23u l=0.13u
X7083 cml_tlatch_67.OUTP VDD VSS rppd l=5.17u w=1u
X7084 cml_tlatch_75.xmux.xn.S1 B3_2_N MOT31_P VSS sg13_lv_nmos ad=63.19999f pd=0.74u as=63.19999f ps=0.74u w=0.26u l=0.38u
X7085 cml_tlatch_71.xtail.S1 CKA3_P cml_tlatch_71.xmux.xn.S1 VSS sg13_lv_nmos ad=89.3f pd=0.85u as=89.3f ps=0.85u w=0.47u l=0.16u
X7086 cml_tlatch_81.xmux.xn.S1 CKB2_N cml_tlatch_81.xtail.S1 VSS sg13_lv_nmos ad=89.3f pd=0.85u as=89.3f ps=0.85u w=0.47u l=0.16u
X7087 cml_gate2_0.xrtail.R1 CKA1_P cml_gate2_0.xamp.xn.S1 VSS sg13_lv_nmos ad=0.1007p pd=0.91u as=0.1007p ps=0.91u w=0.53u l=0.13u
X7088 cml_tlatch_92.xmux.xp.S1 CKJ_P cml_tlatch_92.xtail.S1 VSS sg13_lv_nmos ad=89.3f pd=0.85u as=0.1598p ps=1.62u w=0.47u l=0.16u
X7089 cml_tlatch_75.xmux.xn.S1 B3_2_N MOT31_P VSS sg13_lv_nmos ad=63.19999f pd=0.74u as=63.19999f ps=0.74u w=0.26u l=0.38u
X7090 cml_tlatch_61.xtail.S1 POLN VSS VSS sg13_lv_nmos ad=1.5637p pd=8.61u as=1.5637p ps=8.61u w=8.23u l=0.13u
X7091 cml_tlatch_23.OUTN cml_tlatch_23.OUTP cml_tlatch_23.xmux.xp.S1 VSS sg13_lv_nmos ad=56.9f pd=0.74u as=56.9f ps=0.74u w=0.17u l=0.17u
X7092 cml_tlatch_66.xmux.xp.S1 CKB3_P cml_tlatch_66.xtail.S1 VSS sg13_lv_nmos ad=89.3f pd=0.85u as=89.3f ps=0.85u w=0.47u l=0.16u
X7093 cml_tlatch_3.xtail.S1 CKHB1_N cml_tlatch_3.xmux.xp.S1 VSS sg13_lv_nmos ad=89.3f pd=0.85u as=0.1598p ps=1.62u w=0.47u l=0.16u
X7094 cml_tlatch_98.OUTN cml_tlatch_98.OUTP cml_tlatch_98.xmux.xp.S1 VSS sg13_lv_nmos ad=56.9f pd=0.74u as=56.9f ps=0.74u w=0.17u l=0.17u
X7095 cml_tlatch_0.xmux.xp.S1 cml_tlatch_0.OUTP cml_tlatch_0.OUTN VSS sg13_lv_nmos ad=0.1019p pd=1.34u as=56.9f ps=0.74u w=0.17u l=0.17u
X7096 cml_tlatch_59.xmux.xn.S1 A2_2_N cml_tlatch_91.INP VSS sg13_lv_nmos ad=63.19999f pd=0.74u as=63.19999f ps=0.74u w=0.26u l=0.38u
X7097 cml_tlatch_29.xtail.S1 POLN VSS VSS sg13_lv_nmos ad=1.5637p pd=8.61u as=1.5637p ps=8.61u w=8.23u l=0.13u
X7098 cml_tlatch_38.xmux.xp.S1 CKA0_N cml_tlatch_38.xtail.S1 VSS sg13_lv_nmos ad=0.1598p pd=1.62u as=89.3f ps=0.85u w=0.47u l=0.16u
X7099 cml_tlatch_18.xmux.xp.S1 CKA0_N cml_tlatch_18.xtail.S1 VSS sg13_lv_nmos ad=89.3f pd=0.85u as=89.3f ps=0.85u w=0.47u l=0.16u
X7100 MOT22_P MOT22_N cml_tlatch_55.xmux.xp.S1 VSS sg13_lv_nmos ad=56.9f pd=0.74u as=56.9f ps=0.74u w=0.17u l=0.17u
X7101 cml_tlatch_78.xtail.S1 CKHB2_N cml_tlatch_78.xmux.xp.S1 VSS sg13_lv_nmos ad=89.3f pd=0.85u as=89.3f ps=0.85u w=0.47u l=0.16u
X7102 cml_tlatch_16.xmux.xp.S1 CKHB0_N cml_tlatch_16.xtail.S1 VSS sg13_lv_nmos ad=0.1598p pd=1.62u as=89.3f ps=0.85u w=0.47u l=0.16u
X7103 cml_tlatch_51.OUTN cml_tlatch_51.OUTP cml_tlatch_51.xmux.xp.S1 VSS sg13_lv_nmos ad=56.9f pd=0.74u as=56.9f ps=0.74u w=0.17u l=0.17u
X7104 cml_tlatch_73.xtail.S1 POLN VSS VSS sg13_lv_nmos ad=1.5637p pd=8.61u as=2.7982p ps=17.14u w=8.23u l=0.13u
X7105 B1_8_N B1_8_P cml_tlatch_10.xmux.xp.S1 VSS sg13_lv_nmos ad=56.9f pd=0.74u as=56.9f ps=0.74u w=0.17u l=0.17u
X7106 cml_tlatch_92.xmux.xp.S1 J4_P J4_N VSS sg13_lv_nmos ad=56.9f pd=0.74u as=56.9f ps=0.74u w=0.17u l=0.17u
X7107 B0_8_P B0_8_N cml_tlatch_1.xmux.xp.S1 VSS sg13_lv_nmos ad=56.9f pd=0.74u as=56.9f ps=0.74u w=0.17u l=0.17u
X7108 cml_tlatch_59.xmux.xn.S1 A2_2_N cml_tlatch_91.INP VSS sg13_lv_nmos ad=63.19999f pd=0.74u as=63.19999f ps=0.74u w=0.26u l=0.38u
X7109 VSS hs_to_clk_8.sg13_lv_nmos_2HGZLP_0.G VSS VSS sg13_lv_nmos ad=2.071p pd=11.28u as=0 ps=0 w=10.9u l=1.38u
X7110 cml_tlatch_27.xmux.xp.S1 MOT2_N MOT2_P VSS sg13_lv_nmos ad=56.9f pd=0.74u as=56.9f ps=0.74u w=0.17u l=0.17u
X7111 GA0_N ENA0_P cml_gate2_3.xamp.xn.S1 VSS sg13_lv_nmos ad=0.1007p pd=0.91u as=0.1007p ps=0.91u w=0.53u l=0.13u
X7112 cml_tlatch_69.OUTN cml_tlatch_69.OUTP cml_tlatch_69.xmux.xp.S1 VSS sg13_lv_nmos ad=56.9f pd=0.74u as=56.9f ps=0.74u w=0.17u l=0.17u
X7113 MOT14_N MOT14_P cml_tlatch_25.xmux.xp.S1 VSS sg13_lv_nmos ad=56.9f pd=0.74u as=56.9f ps=0.74u w=0.17u l=0.17u
X7114 cml_tlatch_37.xmux.xp.S1 stub_bi_31.BOTN stub_bi_31.BOTP VSS sg13_lv_nmos ad=56.9f pd=0.74u as=56.9f ps=0.74u w=0.17u l=0.17u
X7115 cml_tlatch_63.INN cml_tlatch_63.INP cml_tlatch_70.xmux.xp.S1 VSS sg13_lv_nmos ad=56.9f pd=0.74u as=56.9f ps=0.74u w=0.17u l=0.17u
X7116 cml_tlatch_98.xmux.xn.S1 cml_tlatch_30.OUTP cml_tlatch_98.OUTN VSS sg13_lv_nmos ad=63.19999f pd=0.74u as=63.19999f ps=0.74u w=0.26u l=0.38u
X7117 cml_tlatch_12.xmux.xn.S1 CKB1_N cml_tlatch_12.xtail.S1 VSS sg13_lv_nmos ad=89.3f pd=0.85u as=89.3f ps=0.85u w=0.47u l=0.16u
X7118 cml_tlatch_88.xtail.S1 CKB3_P cml_tlatch_88.xmux.xp.S1 VSS sg13_lv_nmos ad=89.3f pd=0.85u as=89.3f ps=0.85u w=0.47u l=0.16u
X7119 cml_tlatch_66.xmux.xp.S1 cml_tlatch_73.INN cml_tlatch_73.INP VSS sg13_lv_nmos ad=56.9f pd=0.74u as=56.9f ps=0.74u w=0.17u l=0.17u
X7120 cml_tlatch_89.xmux.xp.S1 cml_tlatch_44.INN cml_tlatch_44.INP VSS sg13_lv_nmos ad=56.9f pd=0.74u as=56.9f ps=0.74u w=0.17u l=0.17u
X7121 cml_tlatch_91.INN A2_2_P cml_tlatch_59.xmux.xn.S1 VSS sg13_lv_nmos ad=63.19999f pd=0.74u as=63.19999f ps=0.74u w=0.26u l=0.38u
X7122 cml_tlatch_74.INP cml_tlatch_74.INN cml_tlatch_88.xmux.xp.S1 VSS sg13_lv_nmos ad=56.9f pd=0.74u as=56.9f ps=0.74u w=0.17u l=0.17u
X7123 cml_tlatch_69.xmux.xn.S1 cml_tlatch_63.INP cml_tlatch_69.OUTN VSS sg13_lv_nmos ad=63.19999f pd=0.74u as=63.19999f ps=0.74u w=0.26u l=0.38u
X7124 stub_bi_29.BOTN stub_bi_29.BOTP cml_tlatch_35.xmux.xp.S1 VSS sg13_lv_nmos ad=56.9f pd=0.74u as=56.9f ps=0.74u w=0.17u l=0.17u
X7125 cml_tlatch_98.xmux.xn.S1 cml_tlatch_30.OUTP cml_tlatch_98.OUTN VSS sg13_lv_nmos ad=63.19999f pd=0.74u as=63.19999f ps=0.74u w=0.26u l=0.38u
X7126 cml_tlatch_4.xmux.xp.S1 MOT11_P MOT11_N VSS sg13_lv_nmos ad=56.9f pd=0.74u as=56.9f ps=0.74u w=0.17u l=0.17u
X7127 stub_bi_15.BOTP stub_bi_15.BOTN cml_tlatch_11.xmux.xp.S1 VSS sg13_lv_nmos ad=56.9f pd=0.74u as=56.9f ps=0.74u w=0.17u l=0.17u
X7128 stub_bi_38.BOTP stub_bi_38.BOTN cml_tlatch_46.xmux.xp.S1 VSS sg13_lv_nmos ad=56.9f pd=0.74u as=56.9f ps=0.74u w=0.17u l=0.17u
X7129 A1_8_P A1_8_N cml_tlatch_19.xmux.xp.S1 VSS sg13_lv_nmos ad=56.9f pd=0.74u as=56.9f ps=0.74u w=0.17u l=0.17u
X7130 cml_tlatch_29.xmux.xp.S1 MOT6_N MOT6_P VSS sg13_lv_nmos ad=56.9f pd=0.74u as=56.9f ps=0.74u w=0.17u l=0.17u
X7131 cml_tlatch_94.xtail.S1 POLN VSS VSS sg13_lv_nmos ad=1.5637p pd=8.61u as=2.7982p ps=17.14u w=8.23u l=0.13u
X7132 cml_tlatch_95.xmux.xn.S1 J4_N J1_N VSS sg13_lv_nmos ad=63.19999f pd=0.74u as=63.19999f ps=0.74u w=0.26u l=0.38u
X7133 cml_tlatch_26.xmux.xp.S1 MOT0_P MOT0_N VSS sg13_lv_nmos ad=56.9f pd=0.74u as=56.9f ps=0.74u w=0.17u l=0.17u
X7134 cml_tlatch_9.xmux.xn.S1 cml_tlatch_18.OUTP A0_8_N VSS sg13_lv_nmos ad=63.19999f pd=0.74u as=63.19999f ps=0.74u w=0.26u l=0.38u
X7135 MOT30_N MOT30_P cml_tlatch_45.xmux.xp.S1 VSS sg13_lv_nmos ad=56.9f pd=0.74u as=56.9f ps=0.74u w=0.17u l=0.17u
X7136 MOT20_N cml_tlatch_91.OUTP cml_tlatch_54.xmux.xn.S1 VSS sg13_lv_nmos ad=0.1082p pd=1.34u as=63.19999f ps=0.74u w=0.26u l=0.38u
X7137 cml_tlatch_96.xtail.S1 CKB1_P cml_tlatch_96.xmux.xp.S1 VSS sg13_lv_nmos ad=89.3f pd=0.85u as=0.1598p ps=1.62u w=0.47u l=0.16u
X7138 cml_tlatch_4.xtail.S1 CKHB1_N cml_tlatch_4.xmux.xp.S1 VSS sg13_lv_nmos ad=89.3f pd=0.85u as=89.3f ps=0.85u w=0.47u l=0.16u
X7139 cml_tlatch_50.xtail.S1 CKB3_P cml_tlatch_50.xmux.xp.S1 VSS sg13_lv_nmos ad=89.3f pd=0.85u as=89.3f ps=0.85u w=0.47u l=0.16u
X7140 cml_tlatch_47.xmux.xn.S1 CKB2_N cml_tlatch_47.xtail.S1 VSS sg13_lv_nmos ad=89.3f pd=0.85u as=89.3f ps=0.85u w=0.47u l=0.16u
X7141 cml_tlatch_67.xmux.xp.S1 cml_tlatch_67.OUTN cml_tlatch_67.OUTP VSS sg13_lv_nmos ad=56.9f pd=0.74u as=56.9f ps=0.74u w=0.17u l=0.17u
X7142 cml_tlatch_87.INN cml_tlatch_87.INP cml_tlatch_76.xmux.xp.S1 VSS sg13_lv_nmos ad=56.9f pd=0.74u as=56.9f ps=0.74u w=0.17u l=0.17u
X7143 cml_tlatch_73.xmux.xp.S1 MOT27_P MOT27_N VSS sg13_lv_nmos ad=56.9f pd=0.74u as=56.9f ps=0.74u w=0.17u l=0.17u
X7144 cml_tlatch_69.xtail.S1 CKA3_P cml_tlatch_69.xmux.xn.S1 VSS sg13_lv_nmos ad=89.3f pd=0.85u as=89.3f ps=0.85u w=0.47u l=0.16u
X7145 MOT28_P cml_tlatch_44.INN cml_tlatch_44.xmux.xn.S1 VSS sg13_lv_nmos ad=63.19999f pd=0.74u as=63.19999f ps=0.74u w=0.26u l=0.38u
X7146 cml_tlatch_46.xtail.S1 POLN VSS VSS sg13_lv_nmos ad=1.5637p pd=8.61u as=1.5637p ps=8.61u w=8.23u l=0.13u
X7147 cml_tlatch_15.xtail.S1 CKHB0_P cml_tlatch_15.xmux.xn.S1 VSS sg13_lv_nmos ad=89.3f pd=0.85u as=89.3f ps=0.85u w=0.47u l=0.16u
X7148 stub_bi_17.BOTN stub_bi_17.BOTP cml_tlatch_13.xmux.xp.S1 VSS sg13_lv_nmos ad=56.9f pd=0.74u as=56.9f ps=0.74u w=0.17u l=0.17u
X7149 cml_tlatch_52.xmux.xp.S1 MOT16_P MOT16_N VSS sg13_lv_nmos ad=56.9f pd=0.74u as=56.9f ps=0.74u w=0.17u l=0.17u
X7150 VDD A2_2_N VSS rppd l=5.17u w=1u
X7151 VDD cml_tlatch_43.INP VSS rppd l=5.17u w=1u
X7152 cml_tlatch_82.xmux.xn.S1 stub_bi_63.BOTP stub_bi_62.BOTN VSS sg13_lv_nmos ad=63.19999f pd=0.74u as=63.19999f ps=0.74u w=0.26u l=0.38u
X7153 MOT10_N MOT10_P cml_tlatch_43.xmux.xp.S1 VSS sg13_lv_nmos ad=56.9f pd=0.74u as=56.9f ps=0.74u w=0.17u l=0.17u
X7154 MOT3_P MOT3_N cml_tlatch_15.xmux.xp.S1 VSS sg13_lv_nmos ad=56.9f pd=0.74u as=56.9f ps=0.74u w=0.17u l=0.17u
X7155 MOT4_P MOT4_N cml_tlatch_28.xmux.xp.S1 VSS sg13_lv_nmos ad=56.9f pd=0.74u as=56.9f ps=0.74u w=0.17u l=0.17u
X7156 cml_tlatch_75.xtail.S1 POLN VSS VSS sg13_lv_nmos ad=1.5637p pd=8.61u as=1.5637p ps=8.61u w=8.23u l=0.13u
X7157 cml_tlatch_24.INN cml_tlatch_97.INP cml_tlatch_97.xmux.xn.S1 VSS sg13_lv_nmos ad=0.1082p pd=1.34u as=63.19999f ps=0.74u w=0.26u l=0.38u
X7158 MOT18_P MOT18_N cml_tlatch_53.xmux.xp.S1 VSS sg13_lv_nmos ad=56.9f pd=0.74u as=0.1019p ps=1.34u w=0.17u l=0.17u
X7159 cml_tlatch_6.xtail.S1 CKHB1_P cml_tlatch_6.xmux.xn.S1 VSS sg13_lv_nmos ad=89.3f pd=0.85u as=89.3f ps=0.85u w=0.47u l=0.16u
X7160 cml_tlatch_85.xmux.xp.S1 A2_8_P A2_8_N VSS sg13_lv_nmos ad=56.9f pd=0.74u as=56.9f ps=0.74u w=0.17u l=0.17u
X7161 B3_8_N VDD VSS rppd l=5.17u w=1u
X7162 CKHB3_P GB3_N cml_drvb_6.xrtail.R2 VSS sg13_lv_nmos ad=0.2618p pd=2.22u as=0.1463p ps=1.15u w=0.77u l=0.21u
X7163 cml_tlatch_2.OUTN cml_tlatch_2.OUTP cml_tlatch_2.xmux.xp.S1 VSS sg13_lv_nmos ad=56.9f pd=0.74u as=56.9f ps=0.74u w=0.17u l=0.17u
X7164 cml_tlatch_23.OUTN cml_tlatch_23.OUTP cml_tlatch_23.xmux.xp.S1 VSS sg13_lv_nmos ad=56.9f pd=0.74u as=56.9f ps=0.74u w=0.17u l=0.17u
X7165 cml_tlatch_57.xmux.xn.S1 cml_tlatch_58.OUTN A3_2_P VSS sg13_lv_nmos ad=63.19999f pd=0.74u as=63.19999f ps=0.74u w=0.26u l=0.38u
X7166 cml_tlatch_52.xmux.xp.S1 MOT16_N MOT16_P VSS sg13_lv_nmos ad=56.9f pd=0.74u as=56.9f ps=0.74u w=0.17u l=0.17u
X7167 cml_tlatch_32.xmux.xp.S1 cml_tlatch_32.OUTN cml_tlatch_32.OUTP VSS sg13_lv_nmos ad=56.9f pd=0.74u as=56.9f ps=0.74u w=0.17u l=0.17u
X7168 MOT13_N MOT13_P cml_tlatch_5.xmux.xp.S1 VSS sg13_lv_nmos ad=56.9f pd=0.74u as=56.9f ps=0.74u w=0.17u l=0.17u
X7169 cml_tlatch_83.xmux.xn.S1 stub_bi_49.BOTN stub_bi_63.BOTP VSS sg13_lv_nmos ad=63.19999f pd=0.74u as=63.19999f ps=0.74u w=0.26u l=0.38u
X7170 cml_tlatch_5.INP cml_tlatch_5.INN cml_tlatch_96.xmux.xp.S1 VSS sg13_lv_nmos ad=56.9f pd=0.74u as=56.9f ps=0.74u w=0.17u l=0.17u
X7171 MOT1_N MOT1_P cml_tlatch_14.xmux.xp.S1 VSS sg13_lv_nmos ad=56.9f pd=0.74u as=56.9f ps=0.74u w=0.17u l=0.17u
X7172 cml_tlatch_94.xmux.xp.S1 J2_P J2_N VSS sg13_lv_nmos ad=56.9f pd=0.74u as=56.9f ps=0.74u w=0.17u l=0.17u
X7173 cml_tlatch_66.xmux.xp.S1 cml_tlatch_73.INP cml_tlatch_73.INN VSS sg13_lv_nmos ad=56.9f pd=0.74u as=56.9f ps=0.74u w=0.17u l=0.17u
X7174 cml_tlatch_69.xtail.S1 CKA3_N cml_tlatch_69.xmux.xp.S1 VSS sg13_lv_nmos ad=89.3f pd=0.85u as=89.3f ps=0.85u w=0.47u l=0.16u
X7175 cml_tlatch_87.OUTP cml_tlatch_87.OUTN cml_tlatch_87.xmux.xp.S1 VSS sg13_lv_nmos ad=56.9f pd=0.74u as=56.9f ps=0.74u w=0.17u l=0.17u
X7176 cml_tlatch_91.xmux.xn.S1 CKA2_N cml_tlatch_91.xtail.S1 VSS sg13_lv_nmos ad=89.3f pd=0.85u as=0.1598p ps=1.62u w=0.47u l=0.16u
X7177 cml_tlatch_66.xmux.xp.S1 cml_tlatch_73.INN cml_tlatch_73.INP VSS sg13_lv_nmos ad=56.9f pd=0.74u as=56.9f ps=0.74u w=0.17u l=0.17u
X7178 cml_tlatch_47.xmux.xp.S1 B2_2_P B2_2_N VSS sg13_lv_nmos ad=56.9f pd=0.74u as=56.9f ps=0.74u w=0.17u l=0.17u
X7179 cml_tlatch_7.xmux.xn.S1 CKB0_N cml_tlatch_7.xtail.S1 VSS sg13_lv_nmos ad=89.3f pd=0.85u as=89.3f ps=0.85u w=0.47u l=0.16u
X7180 cml_tlatch_34.xmux.xp.S1 A0_2_N A0_2_P VSS sg13_lv_nmos ad=56.9f pd=0.74u as=56.9f ps=0.74u w=0.17u l=0.17u
X7181 A1_2_N A1_2_P cml_tlatch_40.xmux.xp.S1 VSS sg13_lv_nmos ad=56.9f pd=0.74u as=56.9f ps=0.74u w=0.17u l=0.17u
X7182 B0_8_P B0_8_N cml_tlatch_1.xmux.xp.S1 VSS sg13_lv_nmos ad=56.9f pd=0.74u as=56.9f ps=0.74u w=0.17u l=0.17u
X7183 cml_tlatch_59.xmux.xp.S1 cml_tlatch_91.INN cml_tlatch_91.INP VSS sg13_lv_nmos ad=56.9f pd=0.74u as=56.9f ps=0.74u w=0.17u l=0.17u
X7184 cml_tlatch_48.xmux.xn.S1 CKB2_P cml_tlatch_48.xtail.S1 VSS sg13_lv_nmos ad=89.3f pd=0.85u as=89.3f ps=0.85u w=0.47u l=0.16u
X7185 MOT14_N MOT14_P cml_tlatch_25.xmux.xp.S1 VSS sg13_lv_nmos ad=56.9f pd=0.74u as=56.9f ps=0.74u w=0.17u l=0.17u
X7186 cml_tlatch_66.xmux.xp.S1 cml_tlatch_73.INP cml_tlatch_73.INN VSS sg13_lv_nmos ad=0.1019p pd=1.34u as=56.9f ps=0.74u w=0.17u l=0.17u
X7187 cml_tlatch_58.xmux.xn.S1 CKA3_P cml_tlatch_58.xtail.S1 VSS sg13_lv_nmos ad=89.3f pd=0.85u as=89.3f ps=0.85u w=0.47u l=0.16u
X7188 cml_tlatch_63.xmux.xn.S1 cml_tlatch_63.INN MOT26_P VSS sg13_lv_nmos ad=63.19999f pd=0.74u as=63.19999f ps=0.74u w=0.26u l=0.38u
X7189 A2_2_P A2_2_N cml_tlatch_60.xmux.xp.S1 VSS sg13_lv_nmos ad=56.9f pd=0.74u as=56.9f ps=0.74u w=0.17u l=0.17u
X7190 MOT29_N MOT29_P cml_tlatch_74.xmux.xp.S1 VSS sg13_lv_nmos ad=56.9f pd=0.74u as=56.9f ps=0.74u w=0.17u l=0.17u
X7191 MOT0_P MOT0_N cml_tlatch_26.xmux.xp.S1 VSS sg13_lv_nmos ad=56.9f pd=0.74u as=56.9f ps=0.74u w=0.17u l=0.17u
X7192 cml_tlatch_69.OUTP cml_tlatch_63.INN cml_tlatch_69.xmux.xn.S1 VSS sg13_lv_nmos ad=63.19999f pd=0.74u as=63.19999f ps=0.74u w=0.26u l=0.38u
X7193 cml_tlatch_81.xtail.S1 CKB2_N cml_tlatch_81.xmux.xn.S1 VSS sg13_lv_nmos ad=89.3f pd=0.85u as=0.1598p ps=1.62u w=0.47u l=0.16u
X7194 MOT18_P MOT18_N cml_tlatch_53.xmux.xp.S1 VSS sg13_lv_nmos ad=56.9f pd=0.74u as=56.9f ps=0.74u w=0.17u l=0.17u
X7195 cml_tlatch_80.xtail.S1 CKHB2_P cml_tlatch_80.xmux.xn.S1 VSS sg13_lv_nmos ad=89.3f pd=0.85u as=89.3f ps=0.85u w=0.47u l=0.16u
X7196 MOT0_P A0_8_N cml_tlatch_26.xmux.xn.S1 VSS sg13_lv_nmos ad=63.19999f pd=0.74u as=0.1082p ps=1.34u w=0.26u l=0.38u
X7197 cml_tlatch_4.xmux.xp.S1 MOT11_P MOT11_N VSS sg13_lv_nmos ad=0.1019p pd=1.34u as=56.9f ps=0.74u w=0.17u l=0.17u
X7198 cml_tlatch_4.INN cml_tlatch_4.INP cml_tlatch_12.xmux.xp.S1 VSS sg13_lv_nmos ad=56.9f pd=0.74u as=56.9f ps=0.74u w=0.17u l=0.17u
X7199 cml_tlatch_13.xtail.S1 CKB1_N cml_tlatch_13.xmux.xp.S1 VSS sg13_lv_nmos ad=0.1598p pd=1.62u as=89.3f ps=0.85u w=0.47u l=0.16u
X7200 cml_tlatch_99.xmux.xp.S1 cml_tlatch_99.OUTN cml_tlatch_99.OUTP VSS sg13_lv_nmos ad=56.9f pd=0.74u as=56.9f ps=0.74u w=0.17u l=0.17u
X7201 cml_tlatch_16.xmux.xp.S1 MOT5_N MOT5_P VSS sg13_lv_nmos ad=56.9f pd=0.74u as=56.9f ps=0.74u w=0.17u l=0.17u
X7202 cml_tlatch_26.xmux.xn.S1 A0_8_P MOT0_N VSS sg13_lv_nmos ad=63.19999f pd=0.74u as=63.19999f ps=0.74u w=0.26u l=0.38u
X7203 cml_tlatch_66.xtail.S1 CKB3_N cml_tlatch_66.xmux.xn.S1 VSS sg13_lv_nmos ad=89.3f pd=0.85u as=89.3f ps=0.85u w=0.47u l=0.16u
X7204 hs_to_clk_4.D2 POLN VSS VSS sg13_lv_nmos ad=3.4p pd=20.68u as=1.9p ps=10.38u w=10u l=0.13u
X7205 cml_tlatch_54.xmux.xp.S1 MOT20_N MOT20_P VSS sg13_lv_nmos ad=56.9f pd=0.74u as=56.9f ps=0.74u w=0.17u l=0.17u
X7206 MOT28_P MOT28_N cml_tlatch_44.xmux.xp.S1 VSS sg13_lv_nmos ad=56.9f pd=0.74u as=56.9f ps=0.74u w=0.17u l=0.17u
X7207 cml_tlatch_76.xmux.xp.S1 cml_tlatch_87.INN cml_tlatch_87.INP VSS sg13_lv_nmos ad=56.9f pd=0.74u as=56.9f ps=0.74u w=0.17u l=0.17u
X7208 cml_tlatch_67.OUTP cml_tlatch_74.INN cml_tlatch_67.xmux.xn.S1 VSS sg13_lv_nmos ad=63.19999f pd=0.74u as=63.19999f ps=0.74u w=0.26u l=0.38u
X7209 cml_tlatch_65.xmux.xp.S1 cml_tlatch_65.OUTN cml_tlatch_65.OUTP VSS sg13_lv_nmos ad=56.9f pd=0.74u as=56.9f ps=0.74u w=0.17u l=0.17u
X7210 cml_tlatch_78.xmux.xp.S1 CKHB2_N cml_tlatch_78.xtail.S1 VSS sg13_lv_nmos ad=89.3f pd=0.85u as=89.3f ps=0.85u w=0.47u l=0.16u
X7211 cml_tlatch_36.xmux.xn.S1 stub_bi_31.BOTP B1_2_P VSS sg13_lv_nmos ad=63.19999f pd=0.74u as=0.1082p ps=1.34u w=0.26u l=0.38u
X7212 B3_8_P B3_8_N cml_tlatch_64.xmux.xp.S1 VSS sg13_lv_nmos ad=56.9f pd=0.74u as=56.9f ps=0.74u w=0.17u l=0.17u
X7213 stub_bi_55.BOTP stub_bi_55.BOTN cml_tlatch_90.xmux.xp.S1 VSS sg13_lv_nmos ad=56.9f pd=0.74u as=56.9f ps=0.74u w=0.17u l=0.17u
X7214 cml_tlatch_97.xmux.xp.S1 cml_tlatch_24.INP cml_tlatch_24.INN VSS sg13_lv_nmos ad=56.9f pd=0.74u as=56.9f ps=0.74u w=0.17u l=0.17u
X7215 stub_bi_17.BOTP cml_tlatch_5.INP cml_tlatch_13.xmux.xn.S1 VSS sg13_lv_nmos ad=63.19999f pd=0.74u as=63.19999f ps=0.74u w=0.26u l=0.38u
X7216 cml_gate2_8.xrtail.R1 NS1_P cml_gate2_8.xamp.xn.S1 VSS sg13_lv_nmos ad=0.1007p pd=0.91u as=0.1802p ps=1.74u w=0.53u l=0.13u
X7217 cml_tlatch_64.xtail.S1 CKB3_N cml_tlatch_64.xmux.xn.S1 VSS sg13_lv_nmos ad=89.3f pd=0.85u as=89.3f ps=0.85u w=0.47u l=0.16u
X7218 cml_tlatch_17.xmux.xp.S1 MOT7_N MOT7_P VSS sg13_lv_nmos ad=56.9f pd=0.74u as=56.9f ps=0.74u w=0.17u l=0.17u
X7219 cml_tlatch_19.xmux.xn.S1 CKA1_N cml_tlatch_19.xtail.S1 VSS sg13_lv_nmos ad=0.1598p pd=1.62u as=89.3f ps=0.85u w=0.47u l=0.16u
X7220 GB2_P CKA2_N cml_gate2_7.xrtail.R1 VSS sg13_lv_nmos ad=0.1802p pd=1.74u as=0.1007p ps=0.91u w=0.53u l=0.13u
X7221 cml_tlatch_32.xmux.xp.S1 cml_tlatch_32.OUTP cml_tlatch_32.OUTN VSS sg13_lv_nmos ad=56.9f pd=0.74u as=56.9f ps=0.74u w=0.17u l=0.17u
X7222 cml_tlatch_24.xmux.xp.S1 MOT12_N MOT12_P VSS sg13_lv_nmos ad=56.9f pd=0.74u as=56.9f ps=0.74u w=0.17u l=0.17u
X7223 cml_tlatch_72.xtail.S1 POLN VSS VSS sg13_lv_nmos ad=1.5637p pd=8.61u as=1.5637p ps=8.61u w=8.23u l=0.13u
X7224 cml_tlatch_29.xmux.xn.S1 A0_2_P MOT6_N VSS sg13_lv_nmos ad=63.19999f pd=0.74u as=63.19999f ps=0.74u w=0.26u l=0.38u
X7225 cml_tlatch_98.OUTP cml_tlatch_30.OUTN cml_tlatch_98.xmux.xn.S1 VSS sg13_lv_nmos ad=63.19999f pd=0.74u as=63.19999f ps=0.74u w=0.26u l=0.38u
X7226 cml_tlatch_3.xtail.S1 CKHB1_P cml_tlatch_3.xmux.xn.S1 VSS sg13_lv_nmos ad=89.3f pd=0.85u as=89.3f ps=0.85u w=0.47u l=0.16u
X7227 cml_tlatch_42.xmux.xn.S1 A1_8_N MOT8_P VSS sg13_lv_nmos ad=0.1082p pd=1.34u as=63.19999f ps=0.74u w=0.26u l=0.38u
X7228 MOT4_N MOT4_P cml_tlatch_28.xmux.xp.S1 VSS sg13_lv_nmos ad=56.9f pd=0.74u as=56.9f ps=0.74u w=0.17u l=0.17u
X7229 cml_tlatch_12.xtail.S1 CKB1_N cml_tlatch_12.xmux.xn.S1 VSS sg13_lv_nmos ad=89.3f pd=0.85u as=0.1598p ps=1.62u w=0.47u l=0.16u
X7230 cml_tlatch_67.xmux.xn.S1 cml_tlatch_74.INP cml_tlatch_67.OUTN VSS sg13_lv_nmos ad=63.19999f pd=0.74u as=63.19999f ps=0.74u w=0.26u l=0.38u
X7231 stub_bi_63.BOTN stub_bi_63.BOTP cml_tlatch_83.xmux.xp.S1 VSS sg13_lv_nmos ad=56.9f pd=0.74u as=0.1019p ps=1.34u w=0.17u l=0.17u
X7232 B0_8_N B0_8_P cml_tlatch_1.xmux.xp.S1 VSS sg13_lv_nmos ad=56.9f pd=0.74u as=56.9f ps=0.74u w=0.17u l=0.17u
X7233 MOT24_N MOT24_P cml_tlatch_62.xmux.xp.S1 VSS sg13_lv_nmos ad=56.9f pd=0.74u as=56.9f ps=0.74u w=0.17u l=0.17u
X7234 cml_tlatch_73.xmux.xp.S1 CKHB3_N cml_tlatch_73.xtail.S1 VSS sg13_lv_nmos ad=89.3f pd=0.85u as=89.3f ps=0.85u w=0.47u l=0.16u
X7235 cml_tlatch_27.xtail.S1 CKHA0_P cml_tlatch_27.xmux.xn.S1 VSS sg13_lv_nmos ad=89.3f pd=0.85u as=89.3f ps=0.85u w=0.47u l=0.16u
X7236 cml_tlatch_29.xmux.xn.S1 A0_2_P MOT6_N VSS sg13_lv_nmos ad=63.19999f pd=0.74u as=63.19999f ps=0.74u w=0.26u l=0.38u
X7237 cml_tlatch_89.xtail.S1 CKA3_N cml_tlatch_89.xmux.xn.S1 VSS sg13_lv_nmos ad=89.3f pd=0.85u as=89.3f ps=0.85u w=0.47u l=0.16u
X7238 cml_tlatch_58.xmux.xn.S1 D3_P cml_tlatch_58.OUTN VSS sg13_lv_nmos ad=63.19999f pd=0.74u as=63.19999f ps=0.74u w=0.26u l=0.38u
X7239 cml_tlatch_98.xmux.xn.S1 CKB0_N cml_tlatch_98.xtail.S1 VSS sg13_lv_nmos ad=89.3f pd=0.85u as=89.3f ps=0.85u w=0.47u l=0.16u
X7240 VSS POLN cml_tlatch_54.xtail.S1 VSS sg13_lv_nmos ad=1.5637p pd=8.61u as=1.5637p ps=8.61u w=8.23u l=0.13u
X7241 B0_2_P B0_2_N cml_tlatch_31.xmux.xp.S1 VSS sg13_lv_nmos ad=56.9f pd=0.74u as=56.9f ps=0.74u w=0.17u l=0.17u
X7242 CLK_W_P J2_P cml_tlatch_93.xmux.xn.S1 VSS sg13_lv_nmos ad=63.19999f pd=0.74u as=0.1082p ps=1.34u w=0.26u l=0.38u
X7243 cml_tlatch_45.xmux.xn.S1 CKHA3_P cml_tlatch_45.xtail.S1 VSS sg13_lv_nmos ad=89.3f pd=0.85u as=89.3f ps=0.85u w=0.47u l=0.16u
X7244 cml_tlatch_85.xmux.xp.S1 A2_8_P A2_8_N VSS sg13_lv_nmos ad=56.9f pd=0.74u as=56.9f ps=0.74u w=0.17u l=0.17u
X7245 cml_tlatch_33.xmux.xp.S1 cml_tlatch_33.OUTN cml_tlatch_33.OUTP VSS sg13_lv_nmos ad=56.9f pd=0.74u as=56.9f ps=0.74u w=0.17u l=0.17u
X7246 B2_8_N B2_8_P cml_tlatch_81.xmux.xp.S1 VSS sg13_lv_nmos ad=56.9f pd=0.74u as=56.9f ps=0.74u w=0.17u l=0.17u
X7247 cml_tlatch_2.OUTN cml_tlatch_2.OUTP cml_tlatch_2.xmux.xp.S1 VSS sg13_lv_nmos ad=56.9f pd=0.74u as=56.9f ps=0.74u w=0.17u l=0.17u
X7248 cml_tlatch_10.xmux.xp.S1 B1_8_N B1_8_P VSS sg13_lv_nmos ad=0.1019p pd=1.34u as=56.9f ps=0.74u w=0.17u l=0.17u
X7249 cml_tlatch_40.xmux.xp.S1 A1_2_N A1_2_P VSS sg13_lv_nmos ad=56.9f pd=0.74u as=56.9f ps=0.74u w=0.17u l=0.17u
X7250 cml_tlatch_52.xmux.xp.S1 MOT16_N MOT16_P VSS sg13_lv_nmos ad=56.9f pd=0.74u as=56.9f ps=0.74u w=0.17u l=0.17u
X7251 CLK_W_N CLK_W_P cml_tlatch_93.xmux.xp.S1 VSS sg13_lv_nmos ad=56.9f pd=0.74u as=56.9f ps=0.74u w=0.17u l=0.17u
X7252 cml_tlatch_78.xmux.xp.S1 MOT19_N MOT19_P VSS sg13_lv_nmos ad=56.9f pd=0.74u as=56.9f ps=0.74u w=0.17u l=0.17u
X7253 cml_tlatch_93.xtail.S1 POLN VSS VSS sg13_lv_nmos ad=1.5637p pd=8.61u as=1.5637p ps=8.61u w=8.23u l=0.13u
X7254 cml_tlatch_25.xmux.xn.S1 A1_2_N MOT14_P VSS sg13_lv_nmos ad=63.19999f pd=0.74u as=63.19999f ps=0.74u w=0.26u l=0.38u
X7255 cml_tlatch_47.xtail.S1 CKB2_N cml_tlatch_47.xmux.xn.S1 VSS sg13_lv_nmos ad=89.3f pd=0.85u as=0.1598p ps=1.62u w=0.47u l=0.16u
X7256 cml_tlatch_48.xmux.xp.S1 stub_bi_43.BOTN stub_bi_43.BOTP VSS sg13_lv_nmos ad=56.9f pd=0.74u as=56.9f ps=0.74u w=0.17u l=0.17u
X7257 cml_tlatch_23.xmux.xp.S1 cml_tlatch_23.OUTN cml_tlatch_23.OUTP VSS sg13_lv_nmos ad=56.9f pd=0.74u as=56.9f ps=0.74u w=0.17u l=0.17u
X7258 cml_tlatch_21.xmux.xp.S1 CKA1_P cml_tlatch_21.xtail.S1 VSS sg13_lv_nmos ad=89.3f pd=0.85u as=0.1598p ps=1.62u w=0.47u l=0.16u
X7259 cml_tlatch_59.xmux.xp.S1 cml_tlatch_91.INN cml_tlatch_91.INP VSS sg13_lv_nmos ad=56.9f pd=0.74u as=56.9f ps=0.74u w=0.17u l=0.17u
X7260 cml_tlatch_16.xmux.xp.S1 CKHB0_N cml_tlatch_16.xtail.S1 VSS sg13_lv_nmos ad=89.3f pd=0.85u as=89.3f ps=0.85u w=0.47u l=0.16u
X7261 cml_tlatch_42.xmux.xp.S1 MOT8_N MOT8_P VSS sg13_lv_nmos ad=56.9f pd=0.74u as=56.9f ps=0.74u w=0.17u l=0.17u
X7262 cml_tlatch_80.xmux.xp.S1 MOT23_P MOT23_N VSS sg13_lv_nmos ad=56.9f pd=0.74u as=56.9f ps=0.74u w=0.17u l=0.17u
X7263 stub_bi_38.BOTN stub_bi_38.BOTP cml_tlatch_46.xmux.xp.S1 VSS sg13_lv_nmos ad=56.9f pd=0.74u as=56.9f ps=0.74u w=0.17u l=0.17u
X7264 cml_tlatch_34.xmux.xn.S1 CKA0_N cml_tlatch_34.xtail.S1 VSS sg13_lv_nmos ad=89.3f pd=0.85u as=89.3f ps=0.85u w=0.47u l=0.16u
X7265 cml_tlatch_67.xtail.S1 CKB3_P cml_tlatch_67.xmux.xn.S1 VSS sg13_lv_nmos ad=89.3f pd=0.85u as=89.3f ps=0.85u w=0.47u l=0.16u
X7266 MOT30_P A3_2_N cml_tlatch_45.xmux.xn.S1 VSS sg13_lv_nmos ad=63.19999f pd=0.74u as=63.19999f ps=0.74u w=0.26u l=0.38u
X7267 cml_tlatch_86.xmux.xp.S1 cml_tlatch_86.OUTP cml_tlatch_86.OUTN VSS sg13_lv_nmos ad=56.9f pd=0.74u as=56.9f ps=0.74u w=0.17u l=0.17u
X7268 cml_tlatch_77.xtail.S1 CKHB2_P cml_tlatch_77.xmux.xn.S1 VSS sg13_lv_nmos ad=89.3f pd=0.85u as=89.3f ps=0.85u w=0.47u l=0.16u
X7269 cml_tlatch_38.xmux.xn.S1 D0_N cml_tlatch_38.OUTP VSS sg13_lv_nmos ad=63.19999f pd=0.74u as=63.19999f ps=0.74u w=0.26u l=0.38u
X7270 cml_tlatch_73.xmux.xn.S1 cml_tlatch_73.INN MOT27_P VSS sg13_lv_nmos ad=0.1082p pd=1.34u as=63.19999f ps=0.74u w=0.26u l=0.38u
X7271 cml_tlatch_82.xmux.xn.S1 stub_bi_63.BOTN stub_bi_62.BOTP VSS sg13_lv_nmos ad=0.1082p pd=1.34u as=63.19999f ps=0.74u w=0.26u l=0.38u
X7272 cml_tlatch_43.INP cml_tlatch_22.OUTN cml_tlatch_21.xmux.xn.S1 VSS sg13_lv_nmos ad=63.19999f pd=0.74u as=63.19999f ps=0.74u w=0.26u l=0.38u
X7273 cml_tlatch_85.xtail.S1 CKA2_P cml_tlatch_85.xmux.xp.S1 VSS sg13_lv_nmos ad=89.3f pd=0.85u as=89.3f ps=0.85u w=0.47u l=0.16u
X7274 cml_tlatch_51.xmux.xp.S1 cml_tlatch_51.OUTN cml_tlatch_51.OUTP VSS sg13_lv_nmos ad=56.9f pd=0.74u as=56.9f ps=0.74u w=0.17u l=0.17u
X7275 cml_tlatch_49.OUTP B3_2_N cml_tlatch_49.xmux.xn.S1 VSS sg13_lv_nmos ad=63.19999f pd=0.74u as=63.19999f ps=0.74u w=0.26u l=0.38u
X7276 cml_tlatch_88.xtail.S1 POLN VSS VSS sg13_lv_nmos ad=1.5637p pd=8.61u as=1.5637p ps=8.61u w=8.23u l=0.13u
X7277 MOT13_P MOT13_N cml_tlatch_5.xmux.xp.S1 VSS sg13_lv_nmos ad=56.9f pd=0.74u as=56.9f ps=0.74u w=0.17u l=0.17u
X7278 cml_tlatch_76.xmux.xn.S1 cml_tlatch_91.OUTP cml_tlatch_87.INN VSS sg13_lv_nmos ad=63.19999f pd=0.74u as=63.19999f ps=0.74u w=0.26u l=0.38u
X7279 cml_tlatch_0.OUTN cml_tlatch_0.OUTP cml_tlatch_0.xmux.xp.S1 VSS sg13_lv_nmos ad=56.9f pd=0.74u as=56.9f ps=0.74u w=0.17u l=0.17u
X7280 CKB0_N CK_P hs_to_clk_1.D2 VSS sg13_lv_nmos ad=0.228p pd=1.58u as=0.228p ps=1.58u w=1.2u l=0.2u
X7281 MOT23_P MOT23_N cml_tlatch_80.xmux.xp.S1 VSS sg13_lv_nmos ad=56.9f pd=0.74u as=56.9f ps=0.74u w=0.17u l=0.17u
X7282 VDD MOT0_N VSS rppd l=5.17u w=1u
X7283 cml_tlatch_50.xtail.S1 CKB3_N cml_tlatch_50.xmux.xn.S1 VSS sg13_lv_nmos ad=89.3f pd=0.85u as=89.3f ps=0.85u w=0.47u l=0.16u
X7284 cml_tlatch_40.xmux.xn.S1 CKA1_N cml_tlatch_40.xtail.S1 VSS sg13_lv_nmos ad=0.1598p pd=1.62u as=89.3f ps=0.85u w=0.47u l=0.16u
X7285 cml_tlatch_22.xmux.xp.S1 cml_tlatch_22.OUTP cml_tlatch_22.OUTN VSS sg13_lv_nmos ad=56.9f pd=0.74u as=56.9f ps=0.74u w=0.17u l=0.17u
X7286 cml_tlatch_35.xmux.xp.S1 stub_bi_29.BOTN stub_bi_29.BOTP VSS sg13_lv_nmos ad=56.9f pd=0.74u as=56.9f ps=0.74u w=0.17u l=0.17u
X7287 cml_tlatch_58.OUTN cml_tlatch_58.OUTP cml_tlatch_58.xmux.xp.S1 VSS sg13_lv_nmos ad=56.9f pd=0.74u as=0.1019p ps=1.34u w=0.17u l=0.17u
X7288 cml_tlatch_97.xmux.xp.S1 cml_tlatch_24.INP cml_tlatch_24.INN VSS sg13_lv_nmos ad=56.9f pd=0.74u as=56.9f ps=0.74u w=0.17u l=0.17u
X7289 CKA3_P CK_P hs_to_clk_6.D2 VSS sg13_lv_nmos ad=0.408p pd=3.08u as=0.228p ps=1.58u w=1.2u l=0.2u
X7290 cml_tlatch_49.xmux.xn.S1 B3_2_P cml_tlatch_49.OUTN VSS sg13_lv_nmos ad=63.19999f pd=0.74u as=0.1082p ps=1.34u w=0.26u l=0.38u
X7291 VSS POLN cml_tlatch_0.xtail.S1 VSS sg13_lv_nmos ad=1.5637p pd=8.61u as=1.5637p ps=8.61u w=8.23u l=0.13u
X7292 GB0_N ENB1_P cml_gate2_1.xamp.xn.S1 VSS sg13_lv_nmos ad=0.1007p pd=0.91u as=0.1007p ps=0.91u w=0.53u l=0.13u
X7293 cml_tlatch_62.xtail.S1 CKHA3_P cml_tlatch_62.xmux.xn.S1 VSS sg13_lv_nmos ad=89.3f pd=0.85u as=89.3f ps=0.85u w=0.47u l=0.16u
X7294 cml_tlatch_46.xtail.S1 CKB2_P cml_tlatch_46.xmux.xn.S1 VSS sg13_lv_nmos ad=89.3f pd=0.85u as=89.3f ps=0.85u w=0.47u l=0.16u
X7295 cml_tlatch_81.xtail.S1 CKB2_P cml_tlatch_81.xmux.xp.S1 VSS sg13_lv_nmos ad=89.3f pd=0.85u as=89.3f ps=0.85u w=0.47u l=0.16u
X7296 cml_tlatch_99.OUTN cml_tlatch_99.OUTP cml_tlatch_99.xmux.xp.S1 VSS sg13_lv_nmos ad=56.9f pd=0.74u as=56.9f ps=0.74u w=0.17u l=0.17u
X7297 cml_tlatch_68.xtail.S1 CKA3_P cml_tlatch_68.xmux.xp.S1 VSS sg13_lv_nmos ad=89.3f pd=0.85u as=89.3f ps=0.85u w=0.47u l=0.16u
X7298 MOT9_N MOT9_P cml_tlatch_3.xmux.xp.S1 VSS sg13_lv_nmos ad=56.9f pd=0.74u as=56.9f ps=0.74u w=0.17u l=0.17u
X7299 VDD cml_tlatch_97.INN VSS rppd l=5.17u w=1u
X7300 GA1_P VDD VSS rppd l=7.42u w=1u
X7301 stub_bi_49.BOTN stub_bi_49.BOTP cml_tlatch_84.xmux.xp.S1 VSS sg13_lv_nmos ad=56.9f pd=0.74u as=56.9f ps=0.74u w=0.17u l=0.17u
X7302 cml_tlatch_78.xmux.xn.S1 CKHB2_P cml_tlatch_78.xtail.S1 VSS sg13_lv_nmos ad=0.1598p pd=1.62u as=89.3f ps=0.85u w=0.47u l=0.16u
X7303 MOT13_N cml_tlatch_5.INP cml_tlatch_5.xmux.xn.S1 VSS sg13_lv_nmos ad=63.19999f pd=0.74u as=63.19999f ps=0.74u w=0.26u l=0.38u
X7304 cml_tlatch_1.xtail.S1 CKB0_P cml_tlatch_1.xmux.xp.S1 VSS sg13_lv_nmos ad=0.1598p pd=1.62u as=89.3f ps=0.85u w=0.47u l=0.16u
X7305 cml_gate2_2.xamp.xn.S1 ENA0_N GA1_P VSS sg13_lv_nmos ad=0.1007p pd=0.91u as=0.1007p ps=0.91u w=0.53u l=0.13u
X7306 cml_tlatch_97.xmux.xp.S1 cml_tlatch_24.INP cml_tlatch_24.INN VSS sg13_lv_nmos ad=56.9f pd=0.74u as=56.9f ps=0.74u w=0.17u l=0.17u
X7307 A2_8_P cml_tlatch_86.OUTN cml_tlatch_85.xmux.xn.S1 VSS sg13_lv_nmos ad=63.19999f pd=0.74u as=63.19999f ps=0.74u w=0.26u l=0.38u
X7308 A3_2_P A3_2_N cml_tlatch_57.xmux.xp.S1 VSS sg13_lv_nmos ad=56.9f pd=0.74u as=56.9f ps=0.74u w=0.17u l=0.17u
X7309 CKB0_P CK_N hs_to_clk_1.D2 VSS sg13_lv_nmos ad=0.228p pd=1.58u as=0.228p ps=1.58u w=1.2u l=0.2u
X7310 cml_tlatch_17.xmux.xp.S1 MOT7_N MOT7_P VSS sg13_lv_nmos ad=56.9f pd=0.74u as=56.9f ps=0.74u w=0.17u l=0.17u
X7311 cml_tlatch_73.xmux.xp.S1 MOT27_N MOT27_P VSS sg13_lv_nmos ad=56.9f pd=0.74u as=56.9f ps=0.74u w=0.17u l=0.17u
X7312 MOT6_P MOT6_N cml_tlatch_29.xmux.xp.S1 VSS sg13_lv_nmos ad=56.9f pd=0.74u as=0.1019p ps=1.34u w=0.17u l=0.17u
X7313 MOT3_N cml_tlatch_7.OUTP cml_tlatch_15.xmux.xn.S1 VSS sg13_lv_nmos ad=63.19999f pd=0.74u as=63.19999f ps=0.74u w=0.26u l=0.38u
X7314 cml_tlatch_40.xtail.S1 CKA1_P cml_tlatch_40.xmux.xp.S1 VSS sg13_lv_nmos ad=89.3f pd=0.85u as=89.3f ps=0.85u w=0.47u l=0.16u
X7315 stub_bi_63.BOTP stub_bi_63.BOTN cml_tlatch_83.xmux.xp.S1 VSS sg13_lv_nmos ad=56.9f pd=0.74u as=56.9f ps=0.74u w=0.17u l=0.17u
X7316 NS1_P J4_P cml_drvb_8.xrtail.R2 VSS sg13_lv_nmos ad=0.2618p pd=2.22u as=0.1463p ps=1.15u w=0.77u l=0.21u
X7317 cml_tlatch_40.xmux.xp.S1 A1_2_N A1_2_P VSS sg13_lv_nmos ad=56.9f pd=0.74u as=56.9f ps=0.74u w=0.17u l=0.17u
X7318 cml_tlatch_73.INP cml_tlatch_67.OUTN cml_tlatch_66.xmux.xn.S1 VSS sg13_lv_nmos ad=63.19999f pd=0.74u as=63.19999f ps=0.74u w=0.26u l=0.38u
X7319 B1_2_P B1_2_N cml_tlatch_36.xmux.xp.S1 VSS sg13_lv_nmos ad=56.9f pd=0.74u as=56.9f ps=0.74u w=0.17u l=0.17u
X7320 cml_tlatch_69.xtail.S1 CKA3_P cml_tlatch_69.xmux.xn.S1 VSS sg13_lv_nmos ad=89.3f pd=0.85u as=89.3f ps=0.85u w=0.47u l=0.16u
X7321 cml_tlatch_8.OUTP cml_tlatch_8.OUTN cml_tlatch_8.xmux.xp.S1 VSS sg13_lv_nmos ad=56.9f pd=0.74u as=56.9f ps=0.74u w=0.17u l=0.17u
X7322 cml_tlatch_27.xtail.S1 CKHA0_N cml_tlatch_27.xmux.xp.S1 VSS sg13_lv_nmos ad=89.3f pd=0.85u as=89.3f ps=0.85u w=0.47u l=0.16u
X7323 cml_gate2_9.xrtail.R1 NM1_P cml_gate2_9.xamp.xn.S1 VSS sg13_lv_nmos ad=0.1007p pd=0.91u as=0.1007p ps=0.91u w=0.53u l=0.13u
X7324 cml_tlatch_87.xtail.S1 CKA2_P cml_tlatch_87.xmux.xp.S1 VSS sg13_lv_nmos ad=89.3f pd=0.85u as=89.3f ps=0.85u w=0.47u l=0.16u
X7325 cml_tlatch_18.xmux.xp.S1 cml_tlatch_18.OUTN cml_tlatch_18.OUTP VSS sg13_lv_nmos ad=56.9f pd=0.74u as=56.9f ps=0.74u w=0.17u l=0.17u
X7326 cml_tlatch_71.xmux.xp.S1 cml_tlatch_71.OUTN cml_tlatch_71.OUTP VSS sg13_lv_nmos ad=56.9f pd=0.74u as=56.9f ps=0.74u w=0.17u l=0.17u
X7327 MOT25_P B3_8_N cml_tlatch_72.xmux.xn.S1 VSS sg13_lv_nmos ad=63.19999f pd=0.74u as=63.19999f ps=0.74u w=0.26u l=0.38u
X7328 GB3_P ENB0_N cml_gate2_6.xamp.xn.S1 VSS sg13_lv_nmos ad=0.1007p pd=0.91u as=0.1007p ps=0.91u w=0.53u l=0.13u
X7329 VSS POLN cml_tlatch_37.xtail.S1 VSS sg13_lv_nmos ad=2.7982p pd=17.14u as=1.5637p ps=8.61u w=8.23u l=0.13u
X7330 cml_tlatch_50.xmux.xp.S1 B3_2_P B3_2_N VSS sg13_lv_nmos ad=56.9f pd=0.74u as=56.9f ps=0.74u w=0.17u l=0.17u
X7331 cml_tlatch_53.xmux.xp.S1 MOT18_P MOT18_N VSS sg13_lv_nmos ad=56.9f pd=0.74u as=56.9f ps=0.74u w=0.17u l=0.17u
X7332 cml_tlatch_31.xmux.xp.S1 B0_2_P B0_2_N VSS sg13_lv_nmos ad=56.9f pd=0.74u as=56.9f ps=0.74u w=0.17u l=0.17u
X7333 cml_tlatch_36.xtail.S1 CKB1_P cml_tlatch_36.xmux.xp.S1 VSS sg13_lv_nmos ad=89.3f pd=0.85u as=89.3f ps=0.85u w=0.47u l=0.16u
X7334 cml_tlatch_65.xtail.S1 CKB3_P cml_tlatch_65.xmux.xn.S1 VSS sg13_lv_nmos ad=0.1598p pd=1.62u as=89.3f ps=0.85u w=0.47u l=0.16u
X7335 cml_tlatch_49.OUTN cml_tlatch_49.OUTP cml_tlatch_49.xmux.xp.S1 VSS sg13_lv_nmos ad=56.9f pd=0.74u as=56.9f ps=0.74u w=0.17u l=0.17u
X7336 cml_tlatch_23.xmux.xp.S1 CKA0_P cml_tlatch_23.xtail.S1 VSS sg13_lv_nmos ad=0.1598p pd=1.62u as=89.3f ps=0.85u w=0.47u l=0.16u
X7337 cml_tlatch_43.xmux.xp.S1 MOT10_P MOT10_N VSS sg13_lv_nmos ad=56.9f pd=0.74u as=56.9f ps=0.74u w=0.17u l=0.17u
X7338 cml_tlatch_42.xtail.S1 CKHA1_N cml_tlatch_42.xmux.xp.S1 VSS sg13_lv_nmos ad=89.3f pd=0.85u as=89.3f ps=0.85u w=0.47u l=0.16u
X7339 cml_tlatch_68.xmux.xn.S1 cml_tlatch_69.OUTP A3_8_N VSS sg13_lv_nmos ad=63.19999f pd=0.74u as=63.19999f ps=0.74u w=0.26u l=0.38u
X7340 VSS POLN cml_tlatch_90.xtail.S1 VSS sg13_lv_nmos ad=2.7982p pd=17.14u as=1.5637p ps=8.61u w=8.23u l=0.13u
X7341 cml_tlatch_9.xtail.S1 CKA0_N cml_tlatch_9.xmux.xn.S1 VSS sg13_lv_nmos ad=89.3f pd=0.85u as=89.3f ps=0.85u w=0.47u l=0.16u
X7342 cml_tlatch_30.OUTN B0_2_P cml_tlatch_30.xmux.xn.S1 VSS sg13_lv_nmos ad=63.19999f pd=0.74u as=63.19999f ps=0.74u w=0.26u l=0.38u
X7343 cml_tlatch_87.OUTP cml_tlatch_87.INN cml_tlatch_87.xmux.xn.S1 VSS sg13_lv_nmos ad=0.1082p pd=1.34u as=63.19999f ps=0.74u w=0.26u l=0.38u
X7344 cml_tlatch_24.INP cml_tlatch_24.INN cml_tlatch_97.xmux.xp.S1 VSS sg13_lv_nmos ad=56.9f pd=0.74u as=56.9f ps=0.74u w=0.17u l=0.17u
X7345 cml_tlatch_98.xmux.xp.S1 cml_tlatch_98.OUTP cml_tlatch_98.OUTN VSS sg13_lv_nmos ad=56.9f pd=0.74u as=56.9f ps=0.74u w=0.17u l=0.17u
X7346 cml_tlatch_48.xmux.xn.S1 CKB2_P cml_tlatch_48.xtail.S1 VSS sg13_lv_nmos ad=89.3f pd=0.85u as=89.3f ps=0.85u w=0.47u l=0.16u
X7347 cml_tlatch_0.OUTN cml_tlatch_0.OUTP cml_tlatch_0.xmux.xp.S1 VSS sg13_lv_nmos ad=56.9f pd=0.74u as=56.9f ps=0.74u w=0.17u l=0.17u
X7348 VSS hs_to_clk_5.sg13_lv_nmos_2HGZLP_0.G VSS VSS sg13_lv_nmos ad=2.071p pd=11.28u as=0 ps=0 w=10.9u l=1.38u
X7349 cml_tlatch_71.xmux.xp.S1 cml_tlatch_71.OUTN cml_tlatch_71.OUTP VSS sg13_lv_nmos ad=56.9f pd=0.74u as=56.9f ps=0.74u w=0.17u l=0.17u
X7350 J4_N J4_P cml_tlatch_92.xmux.xp.S1 VSS sg13_lv_nmos ad=56.9f pd=0.74u as=56.9f ps=0.74u w=0.17u l=0.17u
X7351 cml_tlatch_38.xmux.xn.S1 CKA0_P cml_tlatch_38.xtail.S1 VSS sg13_lv_nmos ad=89.3f pd=0.85u as=89.3f ps=0.85u w=0.47u l=0.16u
X7352 cml_tlatch_21.xmux.xn.S1 cml_tlatch_22.OUTP cml_tlatch_43.INN VSS sg13_lv_nmos ad=63.19999f pd=0.74u as=63.19999f ps=0.74u w=0.26u l=0.38u
X7353 cml_tlatch_38.xmux.xp.S1 cml_tlatch_38.OUTN cml_tlatch_38.OUTP VSS sg13_lv_nmos ad=56.9f pd=0.74u as=56.9f ps=0.74u w=0.17u l=0.17u
X7354 cml_tlatch_60.xmux.xp.S1 CKA2_P cml_tlatch_60.xtail.S1 VSS sg13_lv_nmos ad=89.3f pd=0.85u as=89.3f ps=0.85u w=0.47u l=0.16u
X7355 cml_tlatch_26.xmux.xn.S1 CKHA0_P cml_tlatch_26.xtail.S1 VSS sg13_lv_nmos ad=89.3f pd=0.85u as=89.3f ps=0.85u w=0.47u l=0.16u
X7356 cml_tlatch_13.xtail.S1 CKB1_N cml_tlatch_13.xmux.xp.S1 VSS sg13_lv_nmos ad=89.3f pd=0.85u as=89.3f ps=0.85u w=0.47u l=0.16u
X7357 ENA1_N ENA_P cml_drv_1.xrtail.R1 VSS sg13_lv_nmos ad=56.2f pd=0.74u as=56.2f ps=0.74u w=0.16u l=0.19u
X7358 B3_2_N cml_tlatch_51.OUTP cml_tlatch_50.xmux.xn.S1 VSS sg13_lv_nmos ad=63.19999f pd=0.74u as=63.19999f ps=0.74u w=0.26u l=0.38u
X7359 CKHA3_P VDD VSS rppd l=13.09u w=1u
X7360 stub_bi_62.BOTN stub_bi_62.BOTP cml_tlatch_82.xmux.xp.S1 VSS sg13_lv_nmos ad=56.9f pd=0.74u as=56.9f ps=0.74u w=0.17u l=0.17u
X7361 stub_bi_31.BOTP stub_bi_31.BOTN cml_tlatch_37.xmux.xp.S1 VSS sg13_lv_nmos ad=56.9f pd=0.74u as=56.9f ps=0.74u w=0.17u l=0.17u
X7362 MOT20_N MOT20_P cml_tlatch_54.xmux.xp.S1 VSS sg13_lv_nmos ad=56.9f pd=0.74u as=56.9f ps=0.74u w=0.17u l=0.17u
X7363 cml_tlatch_70.xmux.xp.S1 cml_tlatch_63.INN cml_tlatch_63.INP VSS sg13_lv_nmos ad=56.9f pd=0.74u as=56.9f ps=0.74u w=0.17u l=0.17u
X7364 cml_tlatch_70.xmux.xp.S1 cml_tlatch_63.INP cml_tlatch_63.INN VSS sg13_lv_nmos ad=56.9f pd=0.74u as=56.9f ps=0.74u w=0.17u l=0.17u
X7365 A3_2_P cml_tlatch_58.OUTN cml_tlatch_57.xmux.xn.S1 VSS sg13_lv_nmos ad=0.1082p pd=1.34u as=63.19999f ps=0.74u w=0.26u l=0.38u
X7366 cml_tlatch_44.INP cml_tlatch_44.INN cml_tlatch_89.xmux.xp.S1 VSS sg13_lv_nmos ad=56.9f pd=0.74u as=56.9f ps=0.74u w=0.17u l=0.17u
X7367 cml_tlatch_98.OUTP cml_tlatch_30.OUTN cml_tlatch_98.xmux.xn.S1 VSS sg13_lv_nmos ad=63.19999f pd=0.74u as=63.19999f ps=0.74u w=0.26u l=0.38u
X7368 cml_tlatch_90.xmux.xn.S1 stub_bi_38.BOTN stub_bi_55.BOTP VSS sg13_lv_nmos ad=63.19999f pd=0.74u as=63.19999f ps=0.74u w=0.26u l=0.38u
X7369 cml_tlatch_38.xtail.S1 CKA0_N cml_tlatch_38.xmux.xp.S1 VSS sg13_lv_nmos ad=89.3f pd=0.85u as=89.3f ps=0.85u w=0.47u l=0.16u
X7370 cml_tlatch_16.xtail.S1 CKHB0_N cml_tlatch_16.xmux.xp.S1 VSS sg13_lv_nmos ad=89.3f pd=0.85u as=89.3f ps=0.85u w=0.47u l=0.16u
X7371 cml_tlatch_53.xmux.xn.S1 CKHA2_P cml_tlatch_53.xtail.S1 VSS sg13_lv_nmos ad=89.3f pd=0.85u as=89.3f ps=0.85u w=0.47u l=0.16u
X7372 cml_tlatch_67.xmux.xn.S1 CKB3_P cml_tlatch_67.xtail.S1 VSS sg13_lv_nmos ad=89.3f pd=0.85u as=89.3f ps=0.85u w=0.47u l=0.16u
X7373 cml_tlatch_20.OUTN cml_tlatch_20.OUTP cml_tlatch_20.xmux.xp.S1 VSS sg13_lv_nmos ad=56.9f pd=0.74u as=56.9f ps=0.74u w=0.17u l=0.17u
X7374 cml_tlatch_58.xmux.xn.S1 D3_N cml_tlatch_58.OUTP VSS sg13_lv_nmos ad=63.19999f pd=0.74u as=63.19999f ps=0.74u w=0.26u l=0.38u
X7375 cml_tlatch_46.xmux.xp.S1 stub_bi_38.BOTN stub_bi_38.BOTP VSS sg13_lv_nmos ad=56.9f pd=0.74u as=56.9f ps=0.74u w=0.17u l=0.17u
X7376 cml_tlatch_99.xtail.S1 CKA0_P cml_tlatch_99.xmux.xp.S1 VSS sg13_lv_nmos ad=89.3f pd=0.85u as=89.3f ps=0.85u w=0.47u l=0.16u
X7377 MOT11_N MOT11_P cml_tlatch_4.xmux.xp.S1 VSS sg13_lv_nmos ad=56.9f pd=0.74u as=56.9f ps=0.74u w=0.17u l=0.17u
X7378 MOT12_N MOT12_P cml_tlatch_24.xmux.xp.S1 VSS sg13_lv_nmos ad=56.9f pd=0.74u as=56.9f ps=0.74u w=0.17u l=0.17u
X7379 cml_tlatch_43.INN cml_tlatch_43.INP cml_tlatch_21.xmux.xp.S1 VSS sg13_lv_nmos ad=56.9f pd=0.74u as=56.9f ps=0.74u w=0.17u l=0.17u
X7380 VSS POLN cml_tlatch_32.xtail.S1 VSS sg13_lv_nmos ad=1.5637p pd=8.61u as=1.5637p ps=8.61u w=8.23u l=0.13u
X7381 cml_tlatch_12.xmux.xp.S1 cml_tlatch_4.INN cml_tlatch_4.INP VSS sg13_lv_nmos ad=56.9f pd=0.74u as=56.9f ps=0.74u w=0.17u l=0.17u
X7382 MOT6_P MOT6_N cml_tlatch_29.xmux.xp.S1 VSS sg13_lv_nmos ad=56.9f pd=0.74u as=56.9f ps=0.74u w=0.17u l=0.17u
X7383 A0_8_P cml_tlatch_18.OUTN cml_tlatch_9.xmux.xn.S1 VSS sg13_lv_nmos ad=0.1082p pd=1.34u as=63.19999f ps=0.74u w=0.26u l=0.38u
X7384 MOT0_N MOT0_P cml_tlatch_26.xmux.xp.S1 VSS sg13_lv_nmos ad=56.9f pd=0.74u as=56.9f ps=0.74u w=0.17u l=0.17u
X7385 cml_tlatch_68.xmux.xp.S1 A3_8_P A3_8_N VSS sg13_lv_nmos ad=56.9f pd=0.74u as=56.9f ps=0.74u w=0.17u l=0.17u
X7386 cml_tlatch_48.xmux.xn.S1 D2_P stub_bi_43.BOTP VSS sg13_lv_nmos ad=0.1082p pd=1.34u as=63.19999f ps=0.74u w=0.26u l=0.38u
X7387 cml_gate2_5.xamp.xn.S1 ENA1_P GA2_N VSS sg13_lv_nmos ad=0.1007p pd=0.91u as=0.1007p ps=0.91u w=0.53u l=0.13u
X7388 cml_tlatch_30.xmux.xp.S1 cml_tlatch_30.OUTP cml_tlatch_30.OUTN VSS sg13_lv_nmos ad=56.9f pd=0.74u as=56.9f ps=0.74u w=0.17u l=0.17u
X7389 cml_tlatch_19.xtail.S1 CKA1_N cml_tlatch_19.xmux.xn.S1 VSS sg13_lv_nmos ad=89.3f pd=0.85u as=89.3f ps=0.85u w=0.47u l=0.16u
X7390 A0_8_P cml_tlatch_18.OUTN cml_tlatch_9.xmux.xn.S1 VSS sg13_lv_nmos ad=63.19999f pd=0.74u as=63.19999f ps=0.74u w=0.26u l=0.38u
X7391 cml_tlatch_73.xmux.xp.S1 CKHB3_N cml_tlatch_73.xtail.S1 VSS sg13_lv_nmos ad=89.3f pd=0.85u as=89.3f ps=0.85u w=0.47u l=0.16u
X7392 cml_tlatch_8.OUTP cml_tlatch_8.OUTN cml_tlatch_8.xmux.xp.S1 VSS sg13_lv_nmos ad=56.9f pd=0.74u as=56.9f ps=0.74u w=0.17u l=0.17u
X7393 cml_tlatch_43.INN cml_tlatch_43.INP cml_tlatch_21.xmux.xp.S1 VSS sg13_lv_nmos ad=56.9f pd=0.74u as=56.9f ps=0.74u w=0.17u l=0.17u
X7394 cml_tlatch_17.xmux.xn.S1 B0_2_P MOT7_N VSS sg13_lv_nmos ad=63.19999f pd=0.74u as=63.19999f ps=0.74u w=0.26u l=0.38u
X7395 cml_tlatch_97.xmux.xp.S1 cml_tlatch_24.INN cml_tlatch_24.INP VSS sg13_lv_nmos ad=0.1019p pd=1.34u as=56.9f ps=0.74u w=0.17u l=0.17u
X7396 cml_tlatch_94.xmux.xp.S1 J2_N J2_P VSS sg13_lv_nmos ad=56.9f pd=0.74u as=56.9f ps=0.74u w=0.17u l=0.17u
X7397 MOT26_N MOT26_P cml_tlatch_63.xmux.xp.S1 VSS sg13_lv_nmos ad=56.9f pd=0.74u as=56.9f ps=0.74u w=0.17u l=0.17u
X7398 cml_tlatch_46.xmux.xn.S1 CKB2_P cml_tlatch_46.xtail.S1 VSS sg13_lv_nmos ad=89.3f pd=0.85u as=89.3f ps=0.85u w=0.47u l=0.16u
X7399 cml_tlatch_76.xmux.xp.S1 cml_tlatch_87.INP cml_tlatch_87.INN VSS sg13_lv_nmos ad=56.9f pd=0.74u as=56.9f ps=0.74u w=0.17u l=0.17u
X7400 cml_tlatch_56.xmux.xp.S1 cml_tlatch_56.OUTN cml_tlatch_56.OUTP VSS sg13_lv_nmos ad=56.9f pd=0.74u as=56.9f ps=0.74u w=0.17u l=0.17u
X7401 MOT27_N MOT27_P cml_tlatch_73.xmux.xp.S1 VSS sg13_lv_nmos ad=56.9f pd=0.74u as=56.9f ps=0.74u w=0.17u l=0.17u
X7402 cml_tlatch_87.INP cml_tlatch_91.OUTN cml_tlatch_76.xmux.xn.S1 VSS sg13_lv_nmos ad=63.19999f pd=0.74u as=0.1082p ps=1.34u w=0.26u l=0.38u
X7403 cml_tlatch_71.xtail.S1 CKA3_N cml_tlatch_71.xmux.xp.S1 VSS sg13_lv_nmos ad=89.3f pd=0.85u as=89.3f ps=0.85u w=0.47u l=0.16u
X7404 cml_tlatch_56.xmux.xn.S1 CKA3_P cml_tlatch_56.xtail.S1 VSS sg13_lv_nmos ad=89.3f pd=0.85u as=0.1598p ps=1.62u w=0.47u l=0.16u
X7405 cml_tlatch_17.xmux.xn.S1 B0_2_P MOT7_N VSS sg13_lv_nmos ad=63.19999f pd=0.74u as=63.19999f ps=0.74u w=0.26u l=0.38u
X7406 cml_tlatch_35.xmux.xn.S1 B1_2_N stub_bi_29.BOTN VSS sg13_lv_nmos ad=63.19999f pd=0.74u as=63.19999f ps=0.74u w=0.26u l=0.38u
X7407 cml_tlatch_79.xtail.S1 CKHB2_N cml_tlatch_79.xmux.xp.S1 VSS sg13_lv_nmos ad=89.3f pd=0.85u as=89.3f ps=0.85u w=0.47u l=0.16u
X7408 cml_tlatch_93.xmux.xp.S1 CLK_W_N CLK_W_P VSS sg13_lv_nmos ad=56.9f pd=0.74u as=56.9f ps=0.74u w=0.17u l=0.17u
X7409 cml_tlatch_13.xmux.xp.S1 stub_bi_17.BOTP stub_bi_17.BOTN VSS sg13_lv_nmos ad=56.9f pd=0.74u as=56.9f ps=0.74u w=0.17u l=0.17u
X7410 cml_tlatch_43.xmux.xp.S1 MOT10_P MOT10_N VSS sg13_lv_nmos ad=56.9f pd=0.74u as=56.9f ps=0.74u w=0.17u l=0.17u
X7411 cml_tlatch_88.xtail.S1 CKB3_N cml_tlatch_88.xmux.xn.S1 VSS sg13_lv_nmos ad=89.3f pd=0.85u as=89.3f ps=0.85u w=0.47u l=0.16u
X7412 GB2_P ENB0_N cml_gate2_7.xamp.xn.S1 VSS sg13_lv_nmos ad=0.1007p pd=0.91u as=0.1007p ps=0.91u w=0.53u l=0.13u
X7413 cml_tlatch_28.xmux.xp.S1 MOT4_N MOT4_P VSS sg13_lv_nmos ad=56.9f pd=0.74u as=56.9f ps=0.74u w=0.17u l=0.17u
X7414 cml_tlatch_75.xmux.xn.S1 CKHB3_P cml_tlatch_75.xtail.S1 VSS sg13_lv_nmos ad=89.3f pd=0.85u as=89.3f ps=0.85u w=0.47u l=0.16u
X7415 cml_tlatch_91.xmux.xp.S1 CKA2_P cml_tlatch_91.xtail.S1 VSS sg13_lv_nmos ad=89.3f pd=0.85u as=89.3f ps=0.85u w=0.47u l=0.16u
X7416 GA0_P CKB0_N cml_gate2_3.xrtail.R1 VSS sg13_lv_nmos ad=0.1007p pd=0.91u as=0.1007p ps=0.91u w=0.53u l=0.13u
X7417 cml_tlatch_46.xmux.xp.S1 stub_bi_38.BOTN stub_bi_38.BOTP VSS sg13_lv_nmos ad=56.9f pd=0.74u as=56.9f ps=0.74u w=0.17u l=0.17u
X7418 stub_bi_43.BOTN stub_bi_43.BOTP cml_tlatch_48.xmux.xp.S1 VSS sg13_lv_nmos ad=56.9f pd=0.74u as=56.9f ps=0.74u w=0.17u l=0.17u
X7419 cml_tlatch_23.xmux.xp.S1 cml_tlatch_23.OUTP cml_tlatch_23.OUTN VSS sg13_lv_nmos ad=56.9f pd=0.74u as=56.9f ps=0.74u w=0.17u l=0.17u
X7420 cml_tlatch_32.OUTP cml_tlatch_32.OUTN cml_tlatch_32.xmux.xp.S1 VSS sg13_lv_nmos ad=56.9f pd=0.74u as=56.9f ps=0.74u w=0.17u l=0.17u
X7421 cml_tlatch_6.xmux.xn.S1 B1_2_N MOT15_P VSS sg13_lv_nmos ad=63.19999f pd=0.74u as=63.19999f ps=0.74u w=0.26u l=0.38u
X7422 cml_tlatch_25.xmux.xn.S1 CKHA1_P cml_tlatch_25.xtail.S1 VSS sg13_lv_nmos ad=89.3f pd=0.85u as=89.3f ps=0.85u w=0.47u l=0.16u
X7423 cml_tlatch_5.xmux.xp.S1 MOT13_P MOT13_N VSS sg13_lv_nmos ad=56.9f pd=0.74u as=56.9f ps=0.74u w=0.17u l=0.17u
X7424 cml_tlatch_37.xmux.xn.S1 D1_N stub_bi_31.BOTN VSS sg13_lv_nmos ad=63.19999f pd=0.74u as=0.1082p ps=1.34u w=0.26u l=0.38u
X7425 cml_tlatch_61.xmux.xp.S1 cml_tlatch_61.OUTP cml_tlatch_61.OUTN VSS sg13_lv_nmos ad=56.9f pd=0.74u as=56.9f ps=0.74u w=0.17u l=0.17u
X7426 cml_tlatch_51.OUTN VDD VSS rppd l=5.17u w=1u
X7427 cml_tlatch_2.xmux.xp.S1 cml_tlatch_2.OUTN cml_tlatch_2.OUTP VSS sg13_lv_nmos ad=56.9f pd=0.74u as=56.9f ps=0.74u w=0.17u l=0.17u
X7428 cml_tlatch_95.xtail.S1 POLN VSS VSS sg13_lv_nmos ad=1.5637p pd=8.61u as=2.7982p ps=17.14u w=8.23u l=0.13u
X7429 cml_gate2_2.xamp.xn.S1 ENA0_P GA1_N VSS sg13_lv_nmos ad=0.1007p pd=0.91u as=0.1802p ps=1.74u w=0.53u l=0.13u
X7430 J2_P J2_N cml_tlatch_94.xmux.xp.S1 VSS sg13_lv_nmos ad=56.9f pd=0.74u as=0.1019p ps=1.34u w=0.17u l=0.17u
X7431 ENB_N J2_P cml_gate2_8.xamp.xn.S1 VSS sg13_lv_nmos ad=0.1007p pd=0.91u as=0.1007p ps=0.91u w=0.53u l=0.13u
X7432 MOT31_P B3_2_N cml_tlatch_75.xmux.xn.S1 VSS sg13_lv_nmos ad=63.19999f pd=0.74u as=63.19999f ps=0.74u w=0.26u l=0.38u
X7433 B2_2_N B2_2_P cml_tlatch_47.xmux.xp.S1 VSS sg13_lv_nmos ad=56.9f pd=0.74u as=56.9f ps=0.74u w=0.17u l=0.17u
X7434 A0_2_P A0_2_N cml_tlatch_34.xmux.xp.S1 VSS sg13_lv_nmos ad=56.9f pd=0.74u as=56.9f ps=0.74u w=0.17u l=0.17u
X7435 cml_tlatch_1.xmux.xp.S1 B0_8_N B0_8_P VSS sg13_lv_nmos ad=56.9f pd=0.74u as=56.9f ps=0.74u w=0.17u l=0.17u
X7436 cml_tlatch_40.xtail.S1 CKA1_N cml_tlatch_40.xmux.xn.S1 VSS sg13_lv_nmos ad=89.3f pd=0.85u as=89.3f ps=0.85u w=0.47u l=0.16u
X7437 cml_tlatch_65.xmux.xp.S1 cml_tlatch_65.OUTP cml_tlatch_65.OUTN VSS sg13_lv_nmos ad=56.9f pd=0.74u as=56.9f ps=0.74u w=0.17u l=0.17u
X7438 cml_tlatch_30.OUTP cml_tlatch_30.OUTN cml_tlatch_30.xmux.xp.S1 VSS sg13_lv_nmos ad=56.9f pd=0.74u as=56.9f ps=0.74u w=0.17u l=0.17u
X7439 cml_tlatch_5.xtail.S1 CKHB1_N cml_tlatch_5.xmux.xp.S1 VSS sg13_lv_nmos ad=89.3f pd=0.85u as=89.3f ps=0.85u w=0.47u l=0.16u
X7440 cml_tlatch_62.xmux.xn.S1 A3_8_N MOT24_P VSS sg13_lv_nmos ad=63.19999f pd=0.74u as=0.1082p ps=1.34u w=0.26u l=0.38u
X7441 cml_tlatch_70.xmux.xp.S1 cml_tlatch_63.INP cml_tlatch_63.INN VSS sg13_lv_nmos ad=56.9f pd=0.74u as=56.9f ps=0.74u w=0.17u l=0.17u
X7442 cml_tlatch_73.INN cml_tlatch_73.INP cml_tlatch_66.xmux.xp.S1 VSS sg13_lv_nmos ad=56.9f pd=0.74u as=56.9f ps=0.74u w=0.17u l=0.17u
X7443 MOT24_N A3_8_P cml_tlatch_62.xmux.xn.S1 VSS sg13_lv_nmos ad=63.19999f pd=0.74u as=63.19999f ps=0.74u w=0.26u l=0.38u
X7444 cml_tlatch_91.INP A2_2_N cml_tlatch_59.xmux.xn.S1 VSS sg13_lv_nmos ad=63.19999f pd=0.74u as=63.19999f ps=0.74u w=0.26u l=0.38u
X7445 cml_tlatch_73.INP cml_tlatch_73.INN cml_tlatch_66.xmux.xp.S1 VSS sg13_lv_nmos ad=56.9f pd=0.74u as=56.9f ps=0.74u w=0.17u l=0.17u
X7446 cml_tlatch_74.xmux.xp.S1 MOT29_P MOT29_N VSS sg13_lv_nmos ad=56.9f pd=0.74u as=56.9f ps=0.74u w=0.17u l=0.17u
X7447 cml_tlatch_60.xmux.xp.S1 A2_2_N A2_2_P VSS sg13_lv_nmos ad=56.9f pd=0.74u as=56.9f ps=0.74u w=0.17u l=0.17u
X7448 cml_tlatch_26.xmux.xp.S1 MOT0_N MOT0_P VSS sg13_lv_nmos ad=56.9f pd=0.74u as=56.9f ps=0.74u w=0.17u l=0.17u
X7449 cml_gate2_4.xamp.xn.S1 CKB3_P cml_gate2_4.xrtail.R1 VSS sg13_lv_nmos ad=0.1007p pd=0.91u as=0.1007p ps=0.91u w=0.53u l=0.13u
X7450 cml_tlatch_16.xtail.S1 CKHB0_P cml_tlatch_16.xmux.xn.S1 VSS sg13_lv_nmos ad=89.3f pd=0.85u as=89.3f ps=0.85u w=0.47u l=0.16u
X7451 cml_tlatch_20.xmux.xn.S1 cml_tlatch_43.INP cml_tlatch_20.OUTN VSS sg13_lv_nmos ad=63.19999f pd=0.74u as=63.19999f ps=0.74u w=0.26u l=0.38u
X7452 cml_tlatch_79.xmux.xn.S1 stub_bi_55.BOTN MOT21_N VSS sg13_lv_nmos ad=63.19999f pd=0.74u as=63.19999f ps=0.74u w=0.26u l=0.38u
X7453 cml_tlatch_98.xtail.S1 POLN VSS VSS sg13_lv_nmos ad=1.5637p pd=8.61u as=1.5637p ps=8.61u w=8.23u l=0.13u
X7454 cml_tlatch_64.xmux.xn.S1 cml_tlatch_65.OUTN B3_8_P VSS sg13_lv_nmos ad=0.1082p pd=1.34u as=63.19999f ps=0.74u w=0.26u l=0.38u
X7455 MOT11_N MOT11_P cml_tlatch_4.xmux.xp.S1 VSS sg13_lv_nmos ad=56.9f pd=0.74u as=56.9f ps=0.74u w=0.17u l=0.17u
X7456 MOT12_N MOT12_P cml_tlatch_24.xmux.xp.S1 VSS sg13_lv_nmos ad=56.9f pd=0.74u as=56.9f ps=0.74u w=0.17u l=0.17u
X7457 cml_tlatch_12.xmux.xp.S1 cml_tlatch_4.INP cml_tlatch_4.INN VSS sg13_lv_nmos ad=56.9f pd=0.74u as=56.9f ps=0.74u w=0.17u l=0.17u
X7458 cml_tlatch_12.xmux.xp.S1 cml_tlatch_4.INN cml_tlatch_4.INP VSS sg13_lv_nmos ad=56.9f pd=0.74u as=56.9f ps=0.74u w=0.17u l=0.17u
X7459 MOT5_P MOT5_N cml_tlatch_16.xmux.xp.S1 VSS sg13_lv_nmos ad=56.9f pd=0.74u as=56.9f ps=0.74u w=0.17u l=0.17u
X7460 cml_tlatch_64.xmux.xn.S1 cml_tlatch_65.OUTN B3_8_P VSS sg13_lv_nmos ad=63.19999f pd=0.74u as=63.19999f ps=0.74u w=0.26u l=0.38u
X7461 VDD CKHA2_N VSS rppd l=13.09u w=1u
X7462 cml_tlatch_48.xtail.S1 CKB2_P cml_tlatch_48.xmux.xn.S1 VSS sg13_lv_nmos ad=89.3f pd=0.85u as=0.1598p ps=1.62u w=0.47u l=0.16u
X7463 MOT20_P MOT20_N cml_tlatch_54.xmux.xp.S1 VSS sg13_lv_nmos ad=56.9f pd=0.74u as=0.1019p ps=1.34u w=0.17u l=0.17u
X7464 MOT30_N A3_2_P cml_tlatch_45.xmux.xn.S1 VSS sg13_lv_nmos ad=63.19999f pd=0.74u as=63.19999f ps=0.74u w=0.26u l=0.38u
X7465 cml_tlatch_98.OUTN cml_tlatch_30.OUTP cml_tlatch_98.xmux.xn.S1 VSS sg13_lv_nmos ad=63.19999f pd=0.74u as=63.19999f ps=0.74u w=0.26u l=0.38u
X7466 cml_tlatch_19.xmux.xn.S1 cml_tlatch_20.OUTN A1_8_P VSS sg13_lv_nmos ad=63.19999f pd=0.74u as=63.19999f ps=0.74u w=0.26u l=0.38u
X7467 cml_tlatch_87.INP cml_tlatch_87.INN cml_tlatch_76.xmux.xp.S1 VSS sg13_lv_nmos ad=56.9f pd=0.74u as=56.9f ps=0.74u w=0.17u l=0.17u
X7468 cml_tlatch_27.xtail.S1 CKHA0_N cml_tlatch_27.xmux.xp.S1 VSS sg13_lv_nmos ad=89.3f pd=0.85u as=89.3f ps=0.85u w=0.47u l=0.16u
X7469 cml_tlatch_91.OUTN cml_tlatch_91.OUTP cml_tlatch_91.xmux.xp.S1 VSS sg13_lv_nmos ad=56.9f pd=0.74u as=56.9f ps=0.74u w=0.17u l=0.17u
X7470 cml_tlatch_90.xmux.xp.S1 stub_bi_55.BOTN stub_bi_55.BOTP VSS sg13_lv_nmos ad=56.9f pd=0.74u as=56.9f ps=0.74u w=0.17u l=0.17u
X7471 cml_tlatch_74.INP cml_tlatch_49.OUTN cml_tlatch_88.xmux.xn.S1 VSS sg13_lv_nmos ad=63.19999f pd=0.74u as=63.19999f ps=0.74u w=0.26u l=0.38u
X7472 cml_tlatch_8.xmux.xp.S1 CKB0_N cml_tlatch_8.xtail.S1 VSS sg13_lv_nmos ad=89.3f pd=0.85u as=89.3f ps=0.85u w=0.47u l=0.16u
X7473 MOT7_P MOT7_N cml_tlatch_17.xmux.xp.S1 VSS sg13_lv_nmos ad=56.9f pd=0.74u as=0.1019p ps=1.34u w=0.17u l=0.17u
X7474 cml_tlatch_13.xmux.xp.S1 CKB1_N cml_tlatch_13.xtail.S1 VSS sg13_lv_nmos ad=89.3f pd=0.85u as=89.3f ps=0.85u w=0.47u l=0.16u
X7475 cml_tlatch_72.xmux.xn.S1 CKHB3_P cml_tlatch_72.xtail.S1 VSS sg13_lv_nmos ad=89.3f pd=0.85u as=89.3f ps=0.85u w=0.47u l=0.16u
X7476 cml_tlatch_8.xmux.xn.S1 CKB0_P cml_tlatch_8.xtail.S1 VSS sg13_lv_nmos ad=89.3f pd=0.85u as=89.3f ps=0.85u w=0.47u l=0.16u
X7477 cml_tlatch_32.OUTN cml_tlatch_32.OUTP cml_tlatch_32.xmux.xp.S1 VSS sg13_lv_nmos ad=56.9f pd=0.74u as=56.9f ps=0.74u w=0.17u l=0.17u
X7478 A0_8_N cml_tlatch_18.OUTP cml_tlatch_9.xmux.xn.S1 VSS sg13_lv_nmos ad=63.19999f pd=0.74u as=63.19999f ps=0.74u w=0.26u l=0.38u
X7479 cml_drv_3.xrtail.R1 ENA_N ENA0_P VSS sg13_lv_nmos ad=56.2f pd=0.74u as=56.2f ps=0.74u w=0.16u l=0.19u
X7480 cml_tlatch_51.xtail.S1 CKB3_P cml_tlatch_51.xmux.xn.S1 VSS sg13_lv_nmos ad=89.3f pd=0.85u as=89.3f ps=0.85u w=0.47u l=0.16u
X7481 cml_tlatch_46.xmux.xp.S1 CKB2_N cml_tlatch_46.xtail.S1 VSS sg13_lv_nmos ad=89.3f pd=0.85u as=89.3f ps=0.85u w=0.47u l=0.16u
X7482 cml_tlatch_30.OUTN B0_2_P cml_tlatch_30.xmux.xn.S1 VSS sg13_lv_nmos ad=63.19999f pd=0.74u as=63.19999f ps=0.74u w=0.26u l=0.38u
X7483 cml_tlatch_42.xtail.S1 POLN VSS VSS sg13_lv_nmos ad=1.5637p pd=8.61u as=1.5637p ps=8.61u w=8.23u l=0.13u
X7484 cml_tlatch_41.xmux.xn.S1 CKA1_P cml_tlatch_41.xtail.S1 VSS sg13_lv_nmos ad=0.1598p pd=1.62u as=89.3f ps=0.85u w=0.47u l=0.16u
X7485 cml_tlatch_56.xmux.xp.S1 CKA3_N cml_tlatch_56.xtail.S1 VSS sg13_lv_nmos ad=89.3f pd=0.85u as=89.3f ps=0.85u w=0.47u l=0.16u
X7486 cml_tlatch_77.xmux.xp.S1 MOT17_P MOT17_N VSS sg13_lv_nmos ad=56.9f pd=0.74u as=56.9f ps=0.74u w=0.17u l=0.17u
X7487 cml_gate2_8.xamp.xn.S1 J2_N ENB_P VSS sg13_lv_nmos ad=0.1007p pd=0.91u as=0.1007p ps=0.91u w=0.53u l=0.13u
X7488 cml_tlatch_44.xmux.xn.S1 cml_tlatch_44.INN MOT28_P VSS sg13_lv_nmos ad=63.19999f pd=0.74u as=63.19999f ps=0.74u w=0.26u l=0.38u
X7489 cml_tlatch_31.xmux.xp.S1 B0_2_N B0_2_P VSS sg13_lv_nmos ad=56.9f pd=0.74u as=56.9f ps=0.74u w=0.17u l=0.17u
X7490 A2_8_N A2_8_P cml_tlatch_85.xmux.xp.S1 VSS sg13_lv_nmos ad=56.9f pd=0.74u as=56.9f ps=0.74u w=0.17u l=0.17u
X7491 cml_tlatch_81.xmux.xp.S1 B2_8_P B2_8_N VSS sg13_lv_nmos ad=56.9f pd=0.74u as=56.9f ps=0.74u w=0.17u l=0.17u
X7492 B1_8_P B1_8_N cml_tlatch_10.xmux.xp.S1 VSS sg13_lv_nmos ad=56.9f pd=0.74u as=56.9f ps=0.74u w=0.17u l=0.17u
X7493 cml_tlatch_47.xmux.xp.S1 B2_2_N B2_2_P VSS sg13_lv_nmos ad=56.9f pd=0.74u as=56.9f ps=0.74u w=0.17u l=0.17u
X7494 NS1_N VDD VSS rppd l=13.09u w=1u
X7495 MOT19_P MOT19_N cml_tlatch_78.xmux.xp.S1 VSS sg13_lv_nmos ad=56.9f pd=0.74u as=56.9f ps=0.74u w=0.17u l=0.17u
X7496 MOT20_P MOT20_N cml_tlatch_54.xmux.xp.S1 VSS sg13_lv_nmos ad=56.9f pd=0.74u as=56.9f ps=0.74u w=0.17u l=0.17u
X7497 cml_tlatch_5.xmux.xp.S1 MOT13_P MOT13_N VSS sg13_lv_nmos ad=0.1019p pd=1.34u as=56.9f ps=0.74u w=0.17u l=0.17u
X7498 cml_tlatch_52.xtail.S1 CKHA2_P cml_tlatch_52.xmux.xn.S1 VSS sg13_lv_nmos ad=89.3f pd=0.85u as=89.3f ps=0.85u w=0.47u l=0.16u
X7499 MOT2_P cml_tlatch_23.OUTN cml_tlatch_27.xmux.xn.S1 VSS sg13_lv_nmos ad=63.19999f pd=0.74u as=0.1082p ps=1.34u w=0.26u l=0.38u
X7500 cml_tlatch_87.xmux.xn.S1 CKA2_N cml_tlatch_87.xtail.S1 VSS sg13_lv_nmos ad=89.3f pd=0.85u as=89.3f ps=0.85u w=0.47u l=0.16u
X7501 cml_tlatch_63.xmux.xp.S1 MOT26_N MOT26_P VSS sg13_lv_nmos ad=56.9f pd=0.74u as=56.9f ps=0.74u w=0.17u l=0.17u
X7502 cml_tlatch_61.xmux.xp.S1 cml_tlatch_61.OUTP cml_tlatch_61.OUTN VSS sg13_lv_nmos ad=56.9f pd=0.74u as=56.9f ps=0.74u w=0.17u l=0.17u
X7503 stub_bi_43.BOTP stub_bi_43.BOTN cml_tlatch_48.xmux.xp.S1 VSS sg13_lv_nmos ad=56.9f pd=0.74u as=56.9f ps=0.74u w=0.17u l=0.17u
X7504 J2_N J2_P cml_tlatch_94.xmux.xp.S1 VSS sg13_lv_nmos ad=56.9f pd=0.74u as=56.9f ps=0.74u w=0.17u l=0.17u
X7505 cml_tlatch_23.OUTP cml_tlatch_23.OUTN cml_tlatch_23.xmux.xp.S1 VSS sg13_lv_nmos ad=56.9f pd=0.74u as=56.9f ps=0.74u w=0.17u l=0.17u
X7506 cml_tlatch_27.xmux.xn.S1 cml_tlatch_23.OUTP MOT2_N VSS sg13_lv_nmos ad=63.19999f pd=0.74u as=63.19999f ps=0.74u w=0.26u l=0.38u
X7507 cml_tlatch_66.xmux.xn.S1 cml_tlatch_67.OUTN cml_tlatch_73.INP VSS sg13_lv_nmos ad=63.19999f pd=0.74u as=63.19999f ps=0.74u w=0.26u l=0.38u
X7508 cml_tlatch_33.xtail.S1 CKA0_P cml_tlatch_33.xmux.xn.S1 VSS sg13_lv_nmos ad=89.3f pd=0.85u as=89.3f ps=0.85u w=0.47u l=0.16u
X7509 cml_tlatch_91.INP cml_tlatch_91.INN cml_tlatch_59.xmux.xp.S1 VSS sg13_lv_nmos ad=56.9f pd=0.74u as=56.9f ps=0.74u w=0.17u l=0.17u
X7510 MOT23_N MOT23_P cml_tlatch_80.xmux.xp.S1 VSS sg13_lv_nmos ad=56.9f pd=0.74u as=56.9f ps=0.74u w=0.17u l=0.17u
X7511 cml_tlatch_46.xmux.xp.S1 stub_bi_38.BOTP stub_bi_38.BOTN VSS sg13_lv_nmos ad=56.9f pd=0.74u as=56.9f ps=0.74u w=0.17u l=0.17u
X7512 cml_tlatch_0.OUTP cml_tlatch_99.OUTN cml_tlatch_0.xmux.xn.S1 VSS sg13_lv_nmos ad=63.19999f pd=0.74u as=63.19999f ps=0.74u w=0.26u l=0.38u
X7513 cml_tlatch_79.xmux.xp.S1 CKHB2_N cml_tlatch_79.xtail.S1 VSS sg13_lv_nmos ad=89.3f pd=0.85u as=89.3f ps=0.85u w=0.47u l=0.16u
X7514 cml_tlatch_86.OUTN cml_tlatch_86.OUTP cml_tlatch_86.xmux.xp.S1 VSS sg13_lv_nmos ad=56.9f pd=0.74u as=56.9f ps=0.74u w=0.17u l=0.17u
X7515 cml_tlatch_56.OUTN cml_tlatch_56.OUTP cml_tlatch_56.xmux.xp.S1 VSS sg13_lv_nmos ad=56.9f pd=0.74u as=56.9f ps=0.74u w=0.17u l=0.17u
X7516 GB3_P VDD VSS rppd l=7.42u w=1u
X7517 cml_tlatch_1.xmux.xn.S1 CKB0_N cml_tlatch_1.xtail.S1 VSS sg13_lv_nmos ad=89.3f pd=0.85u as=89.3f ps=0.85u w=0.47u l=0.16u
X7518 B3_8_P B3_8_N cml_tlatch_64.xmux.xp.S1 VSS sg13_lv_nmos ad=56.9f pd=0.74u as=56.9f ps=0.74u w=0.17u l=0.17u
X7519 MOT16_N MOT16_P cml_tlatch_52.xmux.xp.S1 VSS sg13_lv_nmos ad=56.9f pd=0.74u as=56.9f ps=0.74u w=0.17u l=0.17u
X7520 cml_tlatch_88.xmux.xn.S1 CKB3_N cml_tlatch_88.xtail.S1 VSS sg13_lv_nmos ad=89.3f pd=0.85u as=89.3f ps=0.85u w=0.47u l=0.16u
X7521 cml_tlatch_45.xmux.xp.S1 MOT30_N MOT30_P VSS sg13_lv_nmos ad=0.1019p pd=1.34u as=56.9f ps=0.74u w=0.17u l=0.17u
X7522 cml_tlatch_62.xmux.xp.S1 MOT24_P MOT24_N VSS sg13_lv_nmos ad=56.9f pd=0.74u as=56.9f ps=0.74u w=0.17u l=0.17u
X7523 stub_bi_63.BOTP stub_bi_49.BOTN cml_tlatch_83.xmux.xn.S1 VSS sg13_lv_nmos ad=63.19999f pd=0.74u as=63.19999f ps=0.74u w=0.26u l=0.38u
X7524 cml_tlatch_73.xtail.S1 POLN VSS VSS sg13_lv_nmos ad=1.5637p pd=8.61u as=1.5637p ps=8.61u w=8.23u l=0.13u
X7525 cml_tlatch_4.xtail.S1 CKHB1_P cml_tlatch_4.xmux.xn.S1 VSS sg13_lv_nmos ad=89.3f pd=0.85u as=89.3f ps=0.85u w=0.47u l=0.16u
X7526 cml_tlatch_39.xmux.xp.S1 cml_tlatch_97.INP cml_tlatch_97.INN VSS sg13_lv_nmos ad=56.9f pd=0.74u as=56.9f ps=0.74u w=0.17u l=0.17u
X7527 cml_tlatch_26.xmux.xp.S1 MOT0_N MOT0_P VSS sg13_lv_nmos ad=0.1019p pd=1.34u as=56.9f ps=0.74u w=0.17u l=0.17u
X7528 cml_tlatch_43.xmux.xn.S1 cml_tlatch_43.INN MOT10_P VSS sg13_lv_nmos ad=0.1082p pd=1.34u as=63.19999f ps=0.74u w=0.26u l=0.38u
X7529 stub_bi_29.BOTP stub_bi_29.BOTN cml_tlatch_35.xmux.xp.S1 VSS sg13_lv_nmos ad=56.9f pd=0.74u as=56.9f ps=0.74u w=0.17u l=0.17u
X7530 cml_tlatch_61.xtail.S1 CKA2_N cml_tlatch_61.xmux.xp.S1 VSS sg13_lv_nmos ad=89.3f pd=0.85u as=89.3f ps=0.85u w=0.47u l=0.16u
X7531 cml_tlatch_74.xmux.xp.S1 CKHB3_N cml_tlatch_74.xtail.S1 VSS sg13_lv_nmos ad=89.3f pd=0.85u as=89.3f ps=0.85u w=0.47u l=0.16u
X7532 cml_tlatch_18.xtail.S1 CKA0_N cml_tlatch_18.xmux.xp.S1 VSS sg13_lv_nmos ad=89.3f pd=0.85u as=89.3f ps=0.85u w=0.47u l=0.16u
X7533 cml_tlatch_28.xtail.S1 CKHA0_P cml_tlatch_28.xmux.xn.S1 VSS sg13_lv_nmos ad=89.3f pd=0.85u as=89.3f ps=0.85u w=0.47u l=0.16u
X7534 cml_tlatch_38.xmux.xn.S1 D0_P cml_tlatch_38.OUTN VSS sg13_lv_nmos ad=63.19999f pd=0.74u as=63.19999f ps=0.74u w=0.26u l=0.38u
X7535 hs_to_clk_4.D2 CK_N CKB2_P VSS sg13_lv_nmos ad=0.228p pd=1.58u as=0.408p ps=3.08u w=1.2u l=0.2u
X7536 cml_tlatch_32.xtail.S1 CKB0_P cml_tlatch_32.xmux.xn.S1 VSS sg13_lv_nmos ad=89.3f pd=0.85u as=89.3f ps=0.85u w=0.47u l=0.16u
X7537 cml_tlatch_99.xmux.xp.S1 cml_tlatch_99.OUTP cml_tlatch_99.OUTN VSS sg13_lv_nmos ad=56.9f pd=0.74u as=56.9f ps=0.74u w=0.17u l=0.17u
X7538 cml_tlatch_22.xmux.xn.S1 CKA1_P cml_tlatch_22.xtail.S1 VSS sg13_lv_nmos ad=89.3f pd=0.85u as=89.3f ps=0.85u w=0.47u l=0.16u
X7539 cml_gate2_9.xrtail.R1 NM1_N ENA_P VSS sg13_lv_nmos ad=0.1007p pd=0.91u as=0.1007p ps=0.91u w=0.53u l=0.13u
X7540 cml_tlatch_87.INP cml_tlatch_87.INN cml_tlatch_76.xmux.xp.S1 VSS sg13_lv_nmos ad=56.9f pd=0.74u as=56.9f ps=0.74u w=0.17u l=0.17u
X7541 cml_tlatch_84.xmux.xp.S1 stub_bi_49.BOTP stub_bi_49.BOTN VSS sg13_lv_nmos ad=56.9f pd=0.74u as=56.9f ps=0.74u w=0.17u l=0.17u
X7542 cml_tlatch_48.xtail.S1 CKB2_N cml_tlatch_48.xmux.xp.S1 VSS sg13_lv_nmos ad=89.3f pd=0.85u as=89.3f ps=0.85u w=0.47u l=0.16u
X7543 cml_tlatch_64.xmux.xp.S1 B3_8_N B3_8_P VSS sg13_lv_nmos ad=56.9f pd=0.74u as=56.9f ps=0.74u w=0.17u l=0.17u
X7544 cml_tlatch_79.xmux.xp.S1 MOT21_N MOT21_P VSS sg13_lv_nmos ad=56.9f pd=0.74u as=56.9f ps=0.74u w=0.17u l=0.17u
X7545 cml_tlatch_90.xmux.xp.S1 stub_bi_55.BOTN stub_bi_55.BOTP VSS sg13_lv_nmos ad=56.9f pd=0.74u as=56.9f ps=0.74u w=0.17u l=0.17u
X7546 stub_bi_17.BOTN cml_tlatch_5.INN cml_tlatch_13.xmux.xn.S1 VSS sg13_lv_nmos ad=63.19999f pd=0.74u as=63.19999f ps=0.74u w=0.26u l=0.38u
X7547 cml_tlatch_94.xtail.S1 POLN VSS VSS sg13_lv_nmos ad=1.5637p pd=8.61u as=1.5637p ps=8.61u w=8.23u l=0.13u
X7548 A2_2_N cml_tlatch_61.OUTP cml_tlatch_60.xmux.xn.S1 VSS sg13_lv_nmos ad=63.19999f pd=0.74u as=63.19999f ps=0.74u w=0.26u l=0.38u
X7549 cml_tlatch_22.xtail.S1 POLN VSS VSS sg13_lv_nmos ad=1.5637p pd=8.61u as=2.7982p ps=17.14u w=8.23u l=0.13u
X7550 cml_tlatch_58.xtail.S1 CKA3_N cml_tlatch_58.xmux.xp.S1 VSS sg13_lv_nmos ad=89.3f pd=0.85u as=89.3f ps=0.85u w=0.47u l=0.16u
X7551 MOT7_P MOT7_N cml_tlatch_17.xmux.xp.S1 VSS sg13_lv_nmos ad=56.9f pd=0.74u as=56.9f ps=0.74u w=0.17u l=0.17u
X7552 MOT27_P MOT27_N cml_tlatch_73.xmux.xp.S1 VSS sg13_lv_nmos ad=56.9f pd=0.74u as=56.9f ps=0.74u w=0.17u l=0.17u
X7553 cml_tlatch_32.OUTN cml_tlatch_32.OUTP cml_tlatch_32.xmux.xp.S1 VSS sg13_lv_nmos ad=56.9f pd=0.74u as=56.9f ps=0.74u w=0.17u l=0.17u
X7554 cml_gate2_7.xamp.xn.S1 ENB0_P GB2_N VSS sg13_lv_nmos ad=0.1007p pd=0.91u as=0.1007p ps=0.91u w=0.53u l=0.13u
X7555 cml_tlatch_13.xmux.xn.S1 CKB1_P cml_tlatch_13.xtail.S1 VSS sg13_lv_nmos ad=89.3f pd=0.85u as=89.3f ps=0.85u w=0.47u l=0.16u
X7556 cml_tlatch_67.xmux.xn.S1 cml_tlatch_74.INN cml_tlatch_67.OUTP VSS sg13_lv_nmos ad=63.19999f pd=0.74u as=63.19999f ps=0.74u w=0.26u l=0.38u
X7557 cml_tlatch_33.xtail.S1 CKA0_N cml_tlatch_33.xmux.xp.S1 VSS sg13_lv_nmos ad=89.3f pd=0.85u as=89.3f ps=0.85u w=0.47u l=0.16u
X7558 VSS POLN cml_tlatch_26.xtail.S1 VSS sg13_lv_nmos ad=2.7982p pd=17.14u as=1.5637p ps=8.61u w=8.23u l=0.13u
X7559 cml_tlatch_4.xmux.xp.S1 MOT11_N MOT11_P VSS sg13_lv_nmos ad=56.9f pd=0.74u as=56.9f ps=0.74u w=0.17u l=0.17u
X7560 cml_tlatch_13.xmux.xn.S1 cml_tlatch_5.INP stub_bi_17.BOTP VSS sg13_lv_nmos ad=63.19999f pd=0.74u as=63.19999f ps=0.74u w=0.26u l=0.38u
X7561 cml_tlatch_78.xtail.S1 CKHB2_P cml_tlatch_78.xmux.xn.S1 VSS sg13_lv_nmos ad=89.3f pd=0.85u as=89.3f ps=0.85u w=0.47u l=0.16u
X7562 B2_2_N VDD VSS rppd l=5.17u w=1u
X7563 cml_tlatch_91.OUTP cml_tlatch_91.OUTN cml_tlatch_91.xmux.xp.S1 VSS sg13_lv_nmos ad=56.9f pd=0.74u as=56.9f ps=0.74u w=0.17u l=0.17u
X7564 stub_bi_62.BOTP stub_bi_62.BOTN cml_tlatch_82.xmux.xp.S1 VSS sg13_lv_nmos ad=56.9f pd=0.74u as=56.9f ps=0.74u w=0.17u l=0.17u
X7565 cml_tlatch_1.xmux.xp.S1 CKB0_P cml_tlatch_1.xtail.S1 VSS sg13_lv_nmos ad=89.3f pd=0.85u as=89.3f ps=0.85u w=0.47u l=0.16u
X7566 cml_tlatch_0.xmux.xn.S1 CKA0_P cml_tlatch_0.xtail.S1 VSS sg13_lv_nmos ad=89.3f pd=0.85u as=0.1598p ps=1.62u w=0.47u l=0.16u
X7567 cml_tlatch_18.OUTP cml_tlatch_18.OUTN cml_tlatch_18.xmux.xp.S1 VSS sg13_lv_nmos ad=56.9f pd=0.74u as=56.9f ps=0.74u w=0.17u l=0.17u
X7568 cml_tlatch_41.xmux.xn.S1 D1_P cml_tlatch_41.OUTN VSS sg13_lv_nmos ad=63.19999f pd=0.74u as=63.19999f ps=0.74u w=0.26u l=0.38u
X7569 cml_tlatch_77.xmux.xp.S1 MOT17_P MOT17_N VSS sg13_lv_nmos ad=0.1019p pd=1.34u as=56.9f ps=0.74u w=0.17u l=0.17u
X7570 cml_tlatch_13.xmux.xn.S1 cml_tlatch_5.INP stub_bi_17.BOTP VSS sg13_lv_nmos ad=63.19999f pd=0.74u as=63.19999f ps=0.74u w=0.26u l=0.38u
X7571 MOT25_N MOT25_P cml_tlatch_72.xmux.xp.S1 VSS sg13_lv_nmos ad=56.9f pd=0.74u as=56.9f ps=0.74u w=0.17u l=0.17u
X7572 cml_tlatch_98.xmux.xn.S1 cml_tlatch_30.OUTN cml_tlatch_98.OUTP VSS sg13_lv_nmos ad=63.19999f pd=0.74u as=63.19999f ps=0.74u w=0.26u l=0.38u
X7573 MOT8_P A1_8_N cml_tlatch_42.xmux.xn.S1 VSS sg13_lv_nmos ad=63.19999f pd=0.74u as=63.19999f ps=0.74u w=0.26u l=0.38u
X7574 VSS POLN cml_tlatch_92.xtail.S1 VSS sg13_lv_nmos ad=1.5637p pd=8.61u as=1.5637p ps=8.61u w=8.23u l=0.13u
X7575 cml_tlatch_57.xmux.xp.S1 A3_2_P A3_2_N VSS sg13_lv_nmos ad=56.9f pd=0.74u as=56.9f ps=0.74u w=0.17u l=0.17u
X7576 cml_tlatch_4.xmux.xp.S1 CKHB1_N cml_tlatch_4.xtail.S1 VSS sg13_lv_nmos ad=89.3f pd=0.85u as=89.3f ps=0.85u w=0.47u l=0.16u
X7577 B3_2_N B3_2_P cml_tlatch_50.xmux.xp.S1 VSS sg13_lv_nmos ad=56.9f pd=0.74u as=56.9f ps=0.74u w=0.17u l=0.17u
X7578 VDD MOT2_N VSS rppd l=5.17u w=1u
X7579 cml_tlatch_33.xmux.xp.S1 cml_tlatch_33.OUTP cml_tlatch_33.OUTN VSS sg13_lv_nmos ad=56.9f pd=0.74u as=56.9f ps=0.74u w=0.17u l=0.17u
X7580 cml_tlatch_91.xmux.xp.S1 CKA2_P cml_tlatch_91.xtail.S1 VSS sg13_lv_nmos ad=89.3f pd=0.85u as=89.3f ps=0.85u w=0.47u l=0.16u
X7581 MOT6_N A0_2_P cml_tlatch_29.xmux.xn.S1 VSS sg13_lv_nmos ad=63.19999f pd=0.74u as=63.19999f ps=0.74u w=0.26u l=0.38u
X7582 MOT8_P A1_8_N cml_tlatch_42.xmux.xn.S1 VSS sg13_lv_nmos ad=63.19999f pd=0.74u as=63.19999f ps=0.74u w=0.26u l=0.38u
X7583 A1_2_P A1_2_N cml_tlatch_40.xmux.xp.S1 VSS sg13_lv_nmos ad=56.9f pd=0.74u as=56.9f ps=0.74u w=0.17u l=0.17u
X7584 cml_tlatch_58.OUTP D3_N cml_tlatch_58.xmux.xn.S1 VSS sg13_lv_nmos ad=0.1082p pd=1.34u as=63.19999f ps=0.74u w=0.26u l=0.38u
X7585 cml_tlatch_19.xtail.S1 CKA1_P cml_tlatch_19.xmux.xp.S1 VSS sg13_lv_nmos ad=89.3f pd=0.85u as=89.3f ps=0.85u w=0.47u l=0.16u
X7586 cml_tlatch_3.xmux.xp.S1 MOT9_P MOT9_N VSS sg13_lv_nmos ad=56.9f pd=0.74u as=56.9f ps=0.74u w=0.17u l=0.17u
X7587 cml_tlatch_27.xmux.xp.S1 CKHA0_N cml_tlatch_27.xtail.S1 VSS sg13_lv_nmos ad=89.3f pd=0.85u as=0.1598p ps=1.62u w=0.47u l=0.16u
X7588 cml_tlatch_39.xmux.xn.S1 CKA1_P cml_tlatch_39.xtail.S1 VSS sg13_lv_nmos ad=89.3f pd=0.85u as=89.3f ps=0.85u w=0.47u l=0.16u
X7589 cml_tlatch_63.xtail.S1 CKHA3_P cml_tlatch_63.xmux.xn.S1 VSS sg13_lv_nmos ad=89.3f pd=0.85u as=89.3f ps=0.85u w=0.47u l=0.16u
X7590 cml_tlatch_19.xmux.xp.S1 A1_8_P A1_8_N VSS sg13_lv_nmos ad=56.9f pd=0.74u as=56.9f ps=0.74u w=0.17u l=0.17u
X7591 VDD J4_P VSS rppd l=5.17u w=1u
X7592 GB0_P CKA0_N cml_gate2_1.xrtail.R1 VSS sg13_lv_nmos ad=0.1007p pd=0.91u as=0.1007p ps=0.91u w=0.53u l=0.13u
X7593 cml_tlatch_31.xmux.xp.S1 CKB0_P cml_tlatch_31.xtail.S1 VSS sg13_lv_nmos ad=89.3f pd=0.85u as=89.3f ps=0.85u w=0.47u l=0.16u
X7594 cml_tlatch_75.xmux.xp.S1 MOT31_P MOT31_N VSS sg13_lv_nmos ad=56.9f pd=0.74u as=56.9f ps=0.74u w=0.17u l=0.17u
X7595 cml_tlatch_6.xmux.xn.S1 CKHB1_P cml_tlatch_6.xtail.S1 VSS sg13_lv_nmos ad=89.3f pd=0.85u as=89.3f ps=0.85u w=0.47u l=0.16u
X7596 cml_tlatch_79.xmux.xn.S1 CKHB2_P cml_tlatch_79.xtail.S1 VSS sg13_lv_nmos ad=0.1598p pd=1.62u as=89.3f ps=0.85u w=0.47u l=0.16u
X7597 cml_tlatch_87.OUTN cml_tlatch_87.OUTP cml_tlatch_87.xmux.xp.S1 VSS sg13_lv_nmos ad=56.9f pd=0.74u as=56.9f ps=0.74u w=0.17u l=0.17u
X7598 MOT14_P A1_2_N cml_tlatch_25.xmux.xn.S1 VSS sg13_lv_nmos ad=63.19999f pd=0.74u as=63.19999f ps=0.74u w=0.26u l=0.38u
X7599 cml_tlatch_49.xmux.xp.S1 cml_tlatch_49.OUTP cml_tlatch_49.OUTN VSS sg13_lv_nmos ad=56.9f pd=0.74u as=56.9f ps=0.74u w=0.17u l=0.17u
X7600 cml_gate2_4.xrtail.R1 CKB3_N GA3_P VSS sg13_lv_nmos ad=0.1007p pd=0.91u as=0.1802p ps=1.74u w=0.53u l=0.13u
X7601 cml_tlatch_65.xmux.xn.S1 CKB3_P cml_tlatch_65.xtail.S1 VSS sg13_lv_nmos ad=89.3f pd=0.85u as=89.3f ps=0.85u w=0.47u l=0.16u
X7602 cml_tlatch_83.xmux.xp.S1 stub_bi_63.BOTP stub_bi_63.BOTN VSS sg13_lv_nmos ad=56.9f pd=0.74u as=56.9f ps=0.74u w=0.17u l=0.17u
X7603 cml_tlatch_27.xmux.xp.S1 MOT2_P MOT2_N VSS sg13_lv_nmos ad=56.9f pd=0.74u as=56.9f ps=0.74u w=0.17u l=0.17u
X7604 cml_tlatch_83.xmux.xp.S1 CKB2_P cml_tlatch_83.xtail.S1 VSS sg13_lv_nmos ad=89.3f pd=0.85u as=89.3f ps=0.85u w=0.47u l=0.16u
X7605 cml_gate2_0.xamp.xn.S1 ENB1_P GB1_N VSS sg13_lv_nmos ad=0.1007p pd=0.91u as=0.1802p ps=1.74u w=0.53u l=0.13u
X7606 cml_tlatch_76.xmux.xn.S1 cml_tlatch_91.OUTN cml_tlatch_87.INP VSS sg13_lv_nmos ad=63.19999f pd=0.74u as=63.19999f ps=0.74u w=0.26u l=0.38u
X7607 cml_tlatch_74.xmux.xp.S1 MOT29_N MOT29_P VSS sg13_lv_nmos ad=56.9f pd=0.74u as=56.9f ps=0.74u w=0.17u l=0.17u
X7608 cml_tlatch_39.xmux.xp.S1 cml_tlatch_97.INN cml_tlatch_97.INP VSS sg13_lv_nmos ad=56.9f pd=0.74u as=56.9f ps=0.74u w=0.17u l=0.17u
X7609 cml_tlatch_23.xtail.S1 CKA0_P cml_tlatch_23.xmux.xp.S1 VSS sg13_lv_nmos ad=89.3f pd=0.85u as=89.3f ps=0.85u w=0.47u l=0.16u
X7610 cml_tlatch_0.xmux.xp.S1 cml_tlatch_0.OUTP cml_tlatch_0.OUTN VSS sg13_lv_nmos ad=56.9f pd=0.74u as=56.9f ps=0.74u w=0.17u l=0.17u
X7611 MOT15_N MOT15_P cml_tlatch_6.xmux.xp.S1 VSS sg13_lv_nmos ad=56.9f pd=0.74u as=56.9f ps=0.74u w=0.17u l=0.17u
X7612 stub_bi_29.BOTP stub_bi_29.BOTN cml_tlatch_35.xmux.xp.S1 VSS sg13_lv_nmos ad=56.9f pd=0.74u as=56.9f ps=0.74u w=0.17u l=0.17u
X7613 VSS POLN cml_tlatch_7.xtail.S1 VSS sg13_lv_nmos ad=1.5637p pd=8.61u as=1.5637p ps=8.61u w=8.23u l=0.13u
X7614 cml_tlatch_49.xmux.xn.S1 B3_2_N cml_tlatch_49.OUTP VSS sg13_lv_nmos ad=63.19999f pd=0.74u as=0.1082p ps=1.34u w=0.26u l=0.38u
X7615 cml_tlatch_44.INN cml_tlatch_44.INP cml_tlatch_89.xmux.xp.S1 VSS sg13_lv_nmos ad=56.9f pd=0.74u as=56.9f ps=0.74u w=0.17u l=0.17u
X7616 cml_tlatch_28.xtail.S1 CKHA0_N cml_tlatch_28.xmux.xp.S1 VSS sg13_lv_nmos ad=89.3f pd=0.85u as=89.3f ps=0.85u w=0.47u l=0.16u
X7617 cml_tlatch_53.xmux.xp.S1 CKHA2_N cml_tlatch_53.xtail.S1 VSS sg13_lv_nmos ad=89.3f pd=0.85u as=89.3f ps=0.85u w=0.47u l=0.16u
X7618 cml_tlatch_38.OUTP cml_tlatch_38.OUTN cml_tlatch_38.xmux.xp.S1 VSS sg13_lv_nmos ad=56.9f pd=0.74u as=56.9f ps=0.74u w=0.17u l=0.17u
X7619 CKA1_N CK_N hs_to_clk_3.D2 VSS sg13_lv_nmos ad=0.228p pd=1.58u as=0.408p ps=3.08u w=1.2u l=0.2u
X7620 MOT27_P MOT27_N cml_tlatch_73.xmux.xp.S1 VSS sg13_lv_nmos ad=56.9f pd=0.74u as=0.1019p ps=1.34u w=0.17u l=0.17u
X7621 VSS POLN cml_tlatch_38.xtail.S1 VSS sg13_lv_nmos ad=1.5637p pd=8.61u as=1.5637p ps=8.61u w=8.23u l=0.13u
X7622 MOT27_P cml_tlatch_73.INN cml_tlatch_73.xmux.xn.S1 VSS sg13_lv_nmos ad=63.19999f pd=0.74u as=63.19999f ps=0.74u w=0.26u l=0.38u
X7623 stub_bi_62.BOTP stub_bi_63.BOTN cml_tlatch_82.xmux.xn.S1 VSS sg13_lv_nmos ad=63.19999f pd=0.74u as=63.19999f ps=0.74u w=0.26u l=0.38u
X7624 cml_tlatch_99.xmux.xp.S1 cml_tlatch_99.OUTP cml_tlatch_99.OUTN VSS sg13_lv_nmos ad=56.9f pd=0.74u as=56.9f ps=0.74u w=0.17u l=0.17u
X7625 cml_tlatch_82.xmux.xp.S1 stub_bi_62.BOTP stub_bi_62.BOTN VSS sg13_lv_nmos ad=56.9f pd=0.74u as=56.9f ps=0.74u w=0.17u l=0.17u
X7626 cml_tlatch_54.xmux.xp.S1 MOT20_P MOT20_N VSS sg13_lv_nmos ad=56.9f pd=0.74u as=56.9f ps=0.74u w=0.17u l=0.17u
X7627 cml_tlatch_63.INP cml_tlatch_63.INN cml_tlatch_70.xmux.xp.S1 VSS sg13_lv_nmos ad=56.9f pd=0.74u as=0.1019p ps=1.34u w=0.17u l=0.17u
X7628 cml_gate2_6.xamp.xn.S1 CKA3_P cml_gate2_6.xrtail.R1 VSS sg13_lv_nmos ad=0.1007p pd=0.91u as=0.1007p ps=0.91u w=0.53u l=0.13u
X7629 cml_tlatch_55.xmux.xp.S1 CKHA2_N cml_tlatch_55.xtail.S1 VSS sg13_lv_nmos ad=89.3f pd=0.85u as=0.1598p ps=1.62u w=0.47u l=0.16u
X7630 cml_gate2_7.xamp.xn.S1 ENB0_N GB2_P VSS sg13_lv_nmos ad=0.1007p pd=0.91u as=0.1802p ps=1.74u w=0.53u l=0.13u
X7631 cml_tlatch_9.xmux.xp.S1 A0_8_N A0_8_P VSS sg13_lv_nmos ad=56.9f pd=0.74u as=56.9f ps=0.74u w=0.17u l=0.17u
X7632 MOT31_N MOT31_P cml_tlatch_75.xmux.xp.S1 VSS sg13_lv_nmos ad=56.9f pd=0.74u as=56.9f ps=0.74u w=0.17u l=0.17u
X7633 B1_2_N B1_2_P cml_tlatch_36.xmux.xp.S1 VSS sg13_lv_nmos ad=56.9f pd=0.74u as=56.9f ps=0.74u w=0.17u l=0.17u
X7634 cml_tlatch_24.xmux.xp.S1 MOT12_P MOT12_N VSS sg13_lv_nmos ad=56.9f pd=0.74u as=56.9f ps=0.74u w=0.17u l=0.17u
X7635 VDD CKHB2_N VSS rppd l=13.09u w=1u
X7636 cml_tlatch_81.xmux.xn.S1 stub_bi_62.BOTN B2_8_N VSS sg13_lv_nmos ad=63.19999f pd=0.74u as=63.19999f ps=0.74u w=0.26u l=0.38u
X7637 cml_tlatch_29.xmux.xp.S1 MOT6_N MOT6_P VSS sg13_lv_nmos ad=56.9f pd=0.74u as=56.9f ps=0.74u w=0.17u l=0.17u
X7638 A3_8_N A3_8_P cml_tlatch_68.xmux.xp.S1 VSS sg13_lv_nmos ad=56.9f pd=0.74u as=56.9f ps=0.74u w=0.17u l=0.17u
X7639 cml_tlatch_68.xmux.xn.S1 CKA3_N cml_tlatch_68.xtail.S1 VSS sg13_lv_nmos ad=89.3f pd=0.85u as=89.3f ps=0.85u w=0.47u l=0.16u
X7640 cml_tlatch_8.xmux.xn.S1 CKB0_P cml_tlatch_8.xtail.S1 VSS sg13_lv_nmos ad=89.3f pd=0.85u as=89.3f ps=0.85u w=0.47u l=0.16u
X7641 MOT31_N B3_2_P cml_tlatch_75.xmux.xn.S1 VSS sg13_lv_nmos ad=63.19999f pd=0.74u as=63.19999f ps=0.74u w=0.26u l=0.38u
X7642 cml_tlatch_85.xmux.xp.S1 A2_8_N A2_8_P VSS sg13_lv_nmos ad=0.1019p pd=1.34u as=56.9f ps=0.74u w=0.17u l=0.17u
X7643 cml_tlatch_30.OUTN cml_tlatch_30.OUTP cml_tlatch_30.xmux.xp.S1 VSS sg13_lv_nmos ad=56.9f pd=0.74u as=56.9f ps=0.74u w=0.17u l=0.17u
X7644 cml_tlatch_45.xmux.xp.S1 CKHA3_N cml_tlatch_45.xtail.S1 VSS sg13_lv_nmos ad=89.3f pd=0.85u as=89.3f ps=0.85u w=0.47u l=0.16u
X7645 cml_tlatch_50.xmux.xp.S1 B3_2_N B3_2_P VSS sg13_lv_nmos ad=56.9f pd=0.74u as=56.9f ps=0.74u w=0.17u l=0.17u
X7646 cml_tlatch_85.xmux.xn.S1 cml_tlatch_86.OUTN A2_8_P VSS sg13_lv_nmos ad=63.19999f pd=0.74u as=63.19999f ps=0.74u w=0.26u l=0.38u
X7647 cml_tlatch_56.xmux.xn.S1 A3_2_P cml_tlatch_56.OUTN VSS sg13_lv_nmos ad=63.19999f pd=0.74u as=63.19999f ps=0.74u w=0.26u l=0.38u
X7648 cml_tlatch_46.xmux.xp.S1 CKB2_N cml_tlatch_46.xtail.S1 VSS sg13_lv_nmos ad=89.3f pd=0.85u as=89.3f ps=0.85u w=0.47u l=0.16u
X7649 MOT4_N cml_tlatch_99.OUTP cml_tlatch_28.xmux.xn.S1 VSS sg13_lv_nmos ad=63.19999f pd=0.74u as=63.19999f ps=0.74u w=0.26u l=0.38u
X7650 cml_tlatch_58.xmux.xp.S1 cml_tlatch_58.OUTP cml_tlatch_58.OUTN VSS sg13_lv_nmos ad=56.9f pd=0.74u as=56.9f ps=0.74u w=0.17u l=0.17u
X7651 cml_tlatch_18.OUTP cml_tlatch_18.OUTN cml_tlatch_18.xmux.xp.S1 VSS sg13_lv_nmos ad=56.9f pd=0.74u as=56.9f ps=0.74u w=0.17u l=0.17u
X7652 MOT9_P MOT9_N cml_tlatch_3.xmux.xp.S1 VSS sg13_lv_nmos ad=56.9f pd=0.74u as=56.9f ps=0.74u w=0.17u l=0.17u
X7653 cml_tlatch_41.xtail.S1 CKA1_P cml_tlatch_41.xmux.xn.S1 VSS sg13_lv_nmos ad=89.3f pd=0.85u as=89.3f ps=0.85u w=0.47u l=0.16u
X7654 cml_tlatch_21.xmux.xp.S1 cml_tlatch_43.INP cml_tlatch_43.INN VSS sg13_lv_nmos ad=56.9f pd=0.74u as=56.9f ps=0.74u w=0.17u l=0.17u
X7655 cml_tlatch_24.INP cml_tlatch_24.INN cml_tlatch_97.xmux.xp.S1 VSS sg13_lv_nmos ad=56.9f pd=0.74u as=56.9f ps=0.74u w=0.17u l=0.17u
X7656 cml_drv_3.xrtail.R1 ENA_P ENA0_N VSS sg13_lv_nmos ad=56.2f pd=0.74u as=56.2f ps=0.74u w=0.16u l=0.19u
X7657 cml_tlatch_47.xtail.S1 CKB2_P cml_tlatch_47.xmux.xp.S1 VSS sg13_lv_nmos ad=89.3f pd=0.85u as=89.3f ps=0.85u w=0.47u l=0.16u
X7658 B0_2_N B0_2_P cml_tlatch_31.xmux.xp.S1 VSS sg13_lv_nmos ad=56.9f pd=0.74u as=56.9f ps=0.74u w=0.17u l=0.17u
X7659 cml_tlatch_64.xmux.xn.S1 CKB3_N cml_tlatch_64.xtail.S1 VSS sg13_lv_nmos ad=89.3f pd=0.85u as=89.3f ps=0.85u w=0.47u l=0.16u
X7660 cml_tlatch_56.OUTP cml_tlatch_56.OUTN cml_tlatch_56.xmux.xp.S1 VSS sg13_lv_nmos ad=56.9f pd=0.74u as=56.9f ps=0.74u w=0.17u l=0.17u
X7661 CLK_W_P CLK_W_N cml_tlatch_93.xmux.xp.S1 VSS sg13_lv_nmos ad=56.9f pd=0.74u as=56.9f ps=0.74u w=0.17u l=0.17u
X7662 cml_tlatch_3.xmux.xn.S1 CKHB1_P cml_tlatch_3.xtail.S1 VSS sg13_lv_nmos ad=89.3f pd=0.85u as=89.3f ps=0.85u w=0.47u l=0.16u
X7663 VSS POLN cml_tlatch_28.xtail.S1 VSS sg13_lv_nmos ad=2.7982p pd=17.14u as=1.5637p ps=8.61u w=8.23u l=0.13u
X7664 cml_tlatch_7.OUTP cml_tlatch_7.OUTN cml_tlatch_7.xmux.xp.S1 VSS sg13_lv_nmos ad=56.9f pd=0.74u as=56.9f ps=0.74u w=0.17u l=0.17u
X7665 cml_tlatch_91.OUTP cml_tlatch_91.INN cml_tlatch_91.xmux.xn.S1 VSS sg13_lv_nmos ad=63.19999f pd=0.74u as=63.19999f ps=0.74u w=0.26u l=0.38u
X7666 MOT10_N MOT10_P cml_tlatch_43.xmux.xp.S1 VSS sg13_lv_nmos ad=56.9f pd=0.74u as=56.9f ps=0.74u w=0.17u l=0.17u
X7667 VSS POLN cml_tlatch_54.xtail.S1 VSS sg13_lv_nmos ad=2.7982p pd=17.14u as=1.5637p ps=8.61u w=8.23u l=0.13u
X7668 cml_tlatch_27.xmux.xn.S1 CKHA0_P cml_tlatch_27.xtail.S1 VSS sg13_lv_nmos ad=89.3f pd=0.85u as=89.3f ps=0.85u w=0.47u l=0.16u
X7669 cml_tlatch_87.xmux.xn.S1 CKA2_N cml_tlatch_87.xtail.S1 VSS sg13_lv_nmos ad=89.3f pd=0.85u as=89.3f ps=0.85u w=0.47u l=0.16u
X7670 cml_tlatch_59.xmux.xp.S1 cml_tlatch_91.INP cml_tlatch_91.INN VSS sg13_lv_nmos ad=56.9f pd=0.74u as=56.9f ps=0.74u w=0.17u l=0.17u
X7671 cml_tlatch_67.xmux.xp.S1 cml_tlatch_67.OUTP cml_tlatch_67.OUTN VSS sg13_lv_nmos ad=56.9f pd=0.74u as=56.9f ps=0.74u w=0.17u l=0.17u
X7672 MOT30_P VDD VSS rppd l=5.17u w=1u
X7673 MOT25_P MOT25_N cml_tlatch_72.xmux.xp.S1 VSS sg13_lv_nmos ad=56.9f pd=0.74u as=56.9f ps=0.74u w=0.17u l=0.17u
X7674 cml_tlatch_48.xmux.xp.S1 stub_bi_43.BOTP stub_bi_43.BOTN VSS sg13_lv_nmos ad=56.9f pd=0.74u as=56.9f ps=0.74u w=0.17u l=0.17u
X7675 cml_tlatch_88.xmux.xp.S1 cml_tlatch_74.INP cml_tlatch_74.INN VSS sg13_lv_nmos ad=56.9f pd=0.74u as=56.9f ps=0.74u w=0.17u l=0.17u
X7676 cml_tlatch_56.xtail.S1 CKA3_P cml_tlatch_56.xmux.xn.S1 VSS sg13_lv_nmos ad=89.3f pd=0.85u as=89.3f ps=0.85u w=0.47u l=0.16u
X7677 cml_tlatch_54.xmux.xn.S1 CKHA2_P cml_tlatch_54.xtail.S1 VSS sg13_lv_nmos ad=89.3f pd=0.85u as=89.3f ps=0.85u w=0.47u l=0.16u
X7678 cml_tlatch_32.xmux.xp.S1 cml_tlatch_32.OUTN cml_tlatch_32.OUTP VSS sg13_lv_nmos ad=56.9f pd=0.74u as=56.9f ps=0.74u w=0.17u l=0.17u
X7679 J4_P J4_N cml_tlatch_92.xmux.xp.S1 VSS sg13_lv_nmos ad=56.9f pd=0.74u as=56.9f ps=0.74u w=0.17u l=0.17u
X7680 VDD ENA_N VSS rppd l=7.42u w=1u
X7681 CKHA0_P GA0_N cml_drvb_3.xrtail.R2 VSS sg13_lv_nmos ad=0.2618p pd=2.22u as=0.1463p ps=1.15u w=0.77u l=0.21u
X7682 MOT13_N MOT13_P cml_tlatch_5.xmux.xp.S1 VSS sg13_lv_nmos ad=56.9f pd=0.74u as=56.9f ps=0.74u w=0.17u l=0.17u
X7683 A3_8_N cml_tlatch_69.OUTP cml_tlatch_68.xmux.xn.S1 VSS sg13_lv_nmos ad=63.19999f pd=0.74u as=63.19999f ps=0.74u w=0.26u l=0.38u
X7684 cml_tlatch_71.OUTP cml_tlatch_71.OUTN cml_tlatch_71.xmux.xp.S1 VSS sg13_lv_nmos ad=56.9f pd=0.74u as=56.9f ps=0.74u w=0.17u l=0.17u
X7685 cml_tlatch_30.xmux.xn.S1 B0_2_P cml_tlatch_30.OUTN VSS sg13_lv_nmos ad=63.19999f pd=0.74u as=63.19999f ps=0.74u w=0.26u l=0.38u
X7686 cml_tlatch_34.xmux.xp.S1 A0_2_N A0_2_P VSS sg13_lv_nmos ad=56.9f pd=0.74u as=56.9f ps=0.74u w=0.17u l=0.17u
X7687 cml_tlatch_97.xmux.xn.S1 CKA1_N cml_tlatch_97.xtail.S1 VSS sg13_lv_nmos ad=89.3f pd=0.85u as=89.3f ps=0.85u w=0.47u l=0.16u
X7688 cml_tlatch_86.xtail.S1 CKA2_N cml_tlatch_86.xmux.xp.S1 VSS sg13_lv_nmos ad=89.3f pd=0.85u as=89.3f ps=0.85u w=0.47u l=0.16u
X7689 cml_tlatch_87.xmux.xn.S1 cml_tlatch_87.INN cml_tlatch_87.OUTP VSS sg13_lv_nmos ad=63.19999f pd=0.74u as=63.19999f ps=0.74u w=0.26u l=0.38u
X7690 VSS hs_to_clk_5.sg13_lv_nmos_2HGZLP_0.G VSS VSS sg13_lv_nmos ad=2.071p pd=11.28u as=0 ps=0 w=10.9u l=1.38u
X7691 cml_tlatch_57.xmux.xn.S1 CKA3_N cml_tlatch_57.xtail.S1 VSS sg13_lv_nmos ad=89.3f pd=0.85u as=89.3f ps=0.85u w=0.47u l=0.16u
X7692 cml_gate2_5.xrtail.R1 CKB2_N GA2_P VSS sg13_lv_nmos ad=0.1007p pd=0.91u as=0.1007p ps=0.91u w=0.53u l=0.13u
X7693 cml_tlatch_88.xmux.xp.S1 cml_tlatch_74.INP cml_tlatch_74.INN VSS sg13_lv_nmos ad=0.1019p pd=1.34u as=56.9f ps=0.74u w=0.17u l=0.17u
X7694 cml_tlatch_74.xmux.xp.S1 CKHB3_N cml_tlatch_74.xtail.S1 VSS sg13_lv_nmos ad=89.3f pd=0.85u as=89.3f ps=0.85u w=0.47u l=0.16u
X7695 cml_tlatch_30.xmux.xp.S1 cml_tlatch_30.OUTN cml_tlatch_30.OUTP VSS sg13_lv_nmos ad=56.9f pd=0.74u as=56.9f ps=0.74u w=0.17u l=0.17u
X7696 cml_tlatch_75.xmux.xp.S1 MOT31_N MOT31_P VSS sg13_lv_nmos ad=0.1019p pd=1.34u as=56.9f ps=0.74u w=0.17u l=0.17u
X7697 cml_tlatch_34.xtail.S1 CKA0_N cml_tlatch_34.xmux.xn.S1 VSS sg13_lv_nmos ad=89.3f pd=0.85u as=89.3f ps=0.85u w=0.47u l=0.16u
X7698 VSS hs_to_clk_2.sg13_lv_nmos_2HGZLP_0.G VSS VSS sg13_lv_nmos ad=2.071p pd=11.28u as=0 ps=0 w=10.9u l=1.38u
X7699 cml_tlatch_2.xmux.xn.S1 CKB0_P cml_tlatch_2.xtail.S1 VSS sg13_lv_nmos ad=89.3f pd=0.85u as=89.3f ps=0.85u w=0.47u l=0.16u
X7700 cml_tlatch_87.xmux.xn.S1 cml_tlatch_87.INN cml_tlatch_87.OUTP VSS sg13_lv_nmos ad=63.19999f pd=0.74u as=63.19999f ps=0.74u w=0.26u l=0.38u
X7701 cml_tlatch_32.xtail.S1 CKB0_P cml_tlatch_32.xmux.xn.S1 VSS sg13_lv_nmos ad=89.3f pd=0.85u as=89.3f ps=0.85u w=0.47u l=0.16u
X7702 cml_tlatch_20.OUTP cml_tlatch_20.OUTN cml_tlatch_20.xmux.xp.S1 VSS sg13_lv_nmos ad=56.9f pd=0.74u as=0.1019p ps=1.34u w=0.17u l=0.17u
X7703 cml_tlatch_95.xmux.xp.S1 J1_N J1_P VSS sg13_lv_nmos ad=56.9f pd=0.74u as=56.9f ps=0.74u w=0.17u l=0.17u
X7704 cml_tlatch_63.INN cml_tlatch_63.INP cml_tlatch_70.xmux.xp.S1 VSS sg13_lv_nmos ad=56.9f pd=0.74u as=56.9f ps=0.74u w=0.17u l=0.17u
X7705 MOT28_N MOT28_P cml_tlatch_44.xmux.xp.S1 VSS sg13_lv_nmos ad=56.9f pd=0.74u as=56.9f ps=0.74u w=0.17u l=0.17u
X7706 cml_tlatch_5.INN cml_tlatch_5.INP cml_tlatch_96.xmux.xp.S1 VSS sg13_lv_nmos ad=56.9f pd=0.74u as=56.9f ps=0.74u w=0.17u l=0.17u
X7707 MOT29_N MOT29_P cml_tlatch_74.xmux.xp.S1 VSS sg13_lv_nmos ad=56.9f pd=0.74u as=56.9f ps=0.74u w=0.17u l=0.17u
X7708 A2_2_P A2_2_N cml_tlatch_60.xmux.xp.S1 VSS sg13_lv_nmos ad=56.9f pd=0.74u as=56.9f ps=0.74u w=0.17u l=0.17u
X7709 cml_tlatch_50.xmux.xp.S1 B3_2_N B3_2_P VSS sg13_lv_nmos ad=56.9f pd=0.74u as=56.9f ps=0.74u w=0.17u l=0.17u
X7710 MOT0_P MOT0_N cml_tlatch_26.xmux.xp.S1 VSS sg13_lv_nmos ad=56.9f pd=0.74u as=56.9f ps=0.74u w=0.17u l=0.17u
X7711 cml_tlatch_82.xtail.S1 CKB2_N cml_tlatch_82.xmux.xp.S1 VSS sg13_lv_nmos ad=89.3f pd=0.85u as=89.3f ps=0.85u w=0.47u l=0.16u
X7712 VSS POLN cml_tlatch_0.xtail.S1 VSS sg13_lv_nmos ad=2.7982p pd=17.14u as=1.5637p ps=8.61u w=8.23u l=0.13u
X7713 cml_tlatch_43.INN cml_tlatch_22.OUTP cml_tlatch_21.xmux.xn.S1 VSS sg13_lv_nmos ad=63.19999f pd=0.74u as=63.19999f ps=0.74u w=0.26u l=0.38u
X7714 cml_tlatch_96.xmux.xn.S1 CKB1_N cml_tlatch_96.xtail.S1 VSS sg13_lv_nmos ad=89.3f pd=0.85u as=89.3f ps=0.85u w=0.47u l=0.16u
X7715 cml_tlatch_50.xmux.xn.S1 CKB3_N cml_tlatch_50.xtail.S1 VSS sg13_lv_nmos ad=89.3f pd=0.85u as=89.3f ps=0.85u w=0.47u l=0.16u
X7716 cml_tlatch_69.xtail.S1 CKA3_N cml_tlatch_69.xmux.xp.S1 VSS sg13_lv_nmos ad=89.3f pd=0.85u as=89.3f ps=0.85u w=0.47u l=0.16u
X7717 cml_tlatch_24.xmux.xp.S1 MOT12_P MOT12_N VSS sg13_lv_nmos ad=56.9f pd=0.74u as=56.9f ps=0.74u w=0.17u l=0.17u
X7718 cml_tlatch_21.xmux.xp.S1 cml_tlatch_43.INP cml_tlatch_43.INN VSS sg13_lv_nmos ad=56.9f pd=0.74u as=56.9f ps=0.74u w=0.17u l=0.17u
X7719 cml_tlatch_10.xtail.S1 CKB1_N cml_tlatch_10.xmux.xn.S1 VSS sg13_lv_nmos ad=89.3f pd=0.85u as=89.3f ps=0.85u w=0.47u l=0.16u
X7720 CKB1_N CK_P hs_to_clk_2.D2 VSS sg13_lv_nmos ad=0.228p pd=1.58u as=0.228p ps=1.58u w=1.2u l=0.2u
X7721 cml_tlatch_9.xmux.xp.S1 A0_8_P A0_8_N VSS sg13_lv_nmos ad=56.9f pd=0.74u as=56.9f ps=0.74u w=0.17u l=0.17u
X7722 cml_tlatch_4.INN cml_tlatch_4.INP cml_tlatch_12.xmux.xp.S1 VSS sg13_lv_nmos ad=56.9f pd=0.74u as=56.9f ps=0.74u w=0.17u l=0.17u
X7723 cml_tlatch_4.INP cml_tlatch_4.INN cml_tlatch_12.xmux.xp.S1 VSS sg13_lv_nmos ad=56.9f pd=0.74u as=56.9f ps=0.74u w=0.17u l=0.17u
X7724 cml_tlatch_64.xtail.S1 POLN VSS VSS sg13_lv_nmos ad=1.5637p pd=8.61u as=1.5637p ps=8.61u w=8.23u l=0.13u
X7725 cml_tlatch_86.OUTP cml_tlatch_87.OUTN cml_tlatch_86.xmux.xn.S1 VSS sg13_lv_nmos ad=63.19999f pd=0.74u as=63.19999f ps=0.74u w=0.26u l=0.38u
X7726 MOT9_P B1_8_N cml_tlatch_3.xmux.xn.S1 VSS sg13_lv_nmos ad=63.19999f pd=0.74u as=63.19999f ps=0.74u w=0.26u l=0.38u
X7727 cml_tlatch_11.xmux.xp.S1 stub_bi_15.BOTN stub_bi_15.BOTP VSS sg13_lv_nmos ad=56.9f pd=0.74u as=56.9f ps=0.74u w=0.17u l=0.17u
X7728 cml_tlatch_57.xmux.xn.S1 cml_tlatch_58.OUTN A3_2_P VSS sg13_lv_nmos ad=63.19999f pd=0.74u as=63.19999f ps=0.74u w=0.26u l=0.38u
X7729 CLK_W_N J2_N cml_tlatch_93.xmux.xn.S1 VSS sg13_lv_nmos ad=63.19999f pd=0.74u as=63.19999f ps=0.74u w=0.26u l=0.38u
X7730 cml_tlatch_67.OUTP cml_tlatch_67.OUTN cml_tlatch_67.xmux.xp.S1 VSS sg13_lv_nmos ad=56.9f pd=0.74u as=0.1019p ps=1.34u w=0.17u l=0.17u
X7731 GA1_P CKB1_N cml_gate2_2.xrtail.R1 VSS sg13_lv_nmos ad=0.1007p pd=0.91u as=0.1007p ps=0.91u w=0.53u l=0.13u
X7732 MOT22_N MOT22_P cml_tlatch_55.xmux.xp.S1 VSS sg13_lv_nmos ad=56.9f pd=0.74u as=56.9f ps=0.74u w=0.17u l=0.17u
X7733 cml_tlatch_53.xtail.S1 CKHA2_N cml_tlatch_53.xmux.xp.S1 VSS sg13_lv_nmos ad=89.3f pd=0.85u as=89.3f ps=0.85u w=0.47u l=0.16u
X7734 cml_tlatch_67.xtail.S1 CKB3_N cml_tlatch_67.xmux.xp.S1 VSS sg13_lv_nmos ad=89.3f pd=0.85u as=0.1598p ps=1.62u w=0.47u l=0.16u
X7735 cml_tlatch_30.xtail.S1 CKB0_P cml_tlatch_30.xmux.xn.S1 VSS sg13_lv_nmos ad=0.1598p pd=1.62u as=89.3f ps=0.85u w=0.47u l=0.16u
X7736 ENA_N J1_P cml_gate2_9.xamp.xn.S1 VSS sg13_lv_nmos ad=0.1007p pd=0.91u as=0.1007p ps=0.91u w=0.53u l=0.13u
X7737 MOT29_N VDD VSS rppd l=5.17u w=1u
X7738 J1_P J1_N cml_tlatch_95.xmux.xp.S1 VSS sg13_lv_nmos ad=56.9f pd=0.74u as=0.1019p ps=1.34u w=0.17u l=0.17u
X7739 J1_N J1_P cml_tlatch_95.xmux.xp.S1 VSS sg13_lv_nmos ad=56.9f pd=0.74u as=56.9f ps=0.74u w=0.17u l=0.17u
X7740 cml_tlatch_9.xmux.xn.S1 cml_tlatch_18.OUTN A0_8_P VSS sg13_lv_nmos ad=63.19999f pd=0.74u as=63.19999f ps=0.74u w=0.26u l=0.38u
X7741 stub_bi_43.BOTP D2_P cml_tlatch_48.xmux.xn.S1 VSS sg13_lv_nmos ad=63.19999f pd=0.74u as=63.19999f ps=0.74u w=0.26u l=0.38u
X7742 cml_tlatch_27.xmux.xp.S1 MOT2_N MOT2_P VSS sg13_lv_nmos ad=56.9f pd=0.74u as=56.9f ps=0.74u w=0.17u l=0.17u
X7743 cml_gate2_2.xrtail.R1 CKB1_N GA1_P VSS sg13_lv_nmos ad=0.1007p pd=0.91u as=0.1007p ps=0.91u w=0.53u l=0.13u
X7744 cml_tlatch_21.xmux.xp.S1 CKA1_P cml_tlatch_21.xtail.S1 VSS sg13_lv_nmos ad=89.3f pd=0.85u as=89.3f ps=0.85u w=0.47u l=0.16u
X7745 VSS hs_to_clk_8.sg13_lv_nmos_2HGZLP_0.G VSS VSS sg13_lv_nmos ad=2.071p pd=11.28u as=0 ps=0 w=10.9u l=1.38u
X7746 cml_tlatch_42.xmux.xn.S1 CKHA1_P cml_tlatch_42.xtail.S1 VSS sg13_lv_nmos ad=89.3f pd=0.85u as=89.3f ps=0.85u w=0.47u l=0.16u
X7747 cml_gate2_3.xamp.xn.S1 ENA0_N GA0_P VSS sg13_lv_nmos ad=0.1007p pd=0.91u as=0.1802p ps=1.74u w=0.53u l=0.13u
X7748 MOT15_P VDD VSS rppd l=5.17u w=1u
X7749 cml_tlatch_74.INP cml_tlatch_74.INN cml_tlatch_88.xmux.xp.S1 VSS sg13_lv_nmos ad=56.9f pd=0.74u as=56.9f ps=0.74u w=0.17u l=0.17u
X7750 cml_tlatch_70.xtail.S1 POLN VSS VSS sg13_lv_nmos ad=1.5637p pd=8.61u as=1.5637p ps=8.61u w=8.23u l=0.13u
X7751 cml_tlatch_63.xtail.S1 CKHA3_N cml_tlatch_63.xmux.xp.S1 VSS sg13_lv_nmos ad=89.3f pd=0.85u as=89.3f ps=0.85u w=0.47u l=0.16u
X7752 cml_tlatch_87.xmux.xp.S1 CKA2_P cml_tlatch_87.xtail.S1 VSS sg13_lv_nmos ad=0.1598p pd=1.62u as=89.3f ps=0.85u w=0.47u l=0.16u
X7753 VSS POLN cml_tlatch_24.xtail.S1 VSS sg13_lv_nmos ad=1.5637p pd=8.61u as=1.5637p ps=8.61u w=8.23u l=0.13u
X7754 cml_tlatch_63.xmux.xn.S1 cml_tlatch_63.INN MOT26_P VSS sg13_lv_nmos ad=63.19999f pd=0.74u as=0.1082p ps=1.34u w=0.26u l=0.38u
X7755 MOT17_N MOT17_P cml_tlatch_77.xmux.xp.S1 VSS sg13_lv_nmos ad=56.9f pd=0.74u as=56.9f ps=0.74u w=0.17u l=0.17u
X7756 MOT7_N B0_2_P cml_tlatch_17.xmux.xn.S1 VSS sg13_lv_nmos ad=63.19999f pd=0.74u as=63.19999f ps=0.74u w=0.26u l=0.38u
X7757 stub_bi_38.BOTP stub_bi_38.BOTN cml_tlatch_46.xmux.xp.S1 VSS sg13_lv_nmos ad=56.9f pd=0.74u as=56.9f ps=0.74u w=0.17u l=0.17u
X7758 cml_tlatch_2.xtail.S1 CKB0_N cml_tlatch_2.xmux.xp.S1 VSS sg13_lv_nmos ad=0.1598p pd=1.62u as=89.3f ps=0.85u w=0.47u l=0.16u
X7759 B3_8_N B3_8_P cml_tlatch_64.xmux.xp.S1 VSS sg13_lv_nmos ad=56.9f pd=0.74u as=56.9f ps=0.74u w=0.17u l=0.17u
X7760 MOT26_N cml_tlatch_63.INP cml_tlatch_63.xmux.xn.S1 VSS sg13_lv_nmos ad=63.19999f pd=0.74u as=63.19999f ps=0.74u w=0.26u l=0.38u
X7761 cml_tlatch_8.xtail.S1 CKB0_P cml_tlatch_8.xmux.xn.S1 VSS sg13_lv_nmos ad=89.3f pd=0.85u as=0.1598p ps=1.62u w=0.47u l=0.16u
X7762 A1_8_P A1_8_N cml_tlatch_19.xmux.xp.S1 VSS sg13_lv_nmos ad=56.9f pd=0.74u as=56.9f ps=0.74u w=0.17u l=0.17u
X7763 cml_tlatch_41.OUTP cml_tlatch_41.OUTN cml_tlatch_41.xmux.xp.S1 VSS sg13_lv_nmos ad=56.9f pd=0.74u as=0.1019p ps=1.34u w=0.17u l=0.17u
X7764 cml_tlatch_10.xmux.xp.S1 B1_8_N B1_8_P VSS sg13_lv_nmos ad=56.9f pd=0.74u as=56.9f ps=0.74u w=0.17u l=0.17u
X7765 cml_tlatch_76.xtail.S1 CKA2_N cml_tlatch_76.xmux.xp.S1 VSS sg13_lv_nmos ad=89.3f pd=0.85u as=89.3f ps=0.85u w=0.47u l=0.16u
X7766 cml_tlatch_20.OUTN cml_tlatch_43.INP cml_tlatch_20.xmux.xn.S1 VSS sg13_lv_nmos ad=0.1082p pd=1.34u as=63.19999f ps=0.74u w=0.26u l=0.38u
X7767 B2_2_P B2_2_N cml_tlatch_47.xmux.xp.S1 VSS sg13_lv_nmos ad=56.9f pd=0.74u as=0.1019p ps=1.34u w=0.17u l=0.17u
X7768 cml_tlatch_46.xtail.S1 CKB2_N cml_tlatch_46.xmux.xp.S1 VSS sg13_lv_nmos ad=89.3f pd=0.85u as=0.1598p ps=1.62u w=0.47u l=0.16u
X7769 MOT13_N MOT13_P cml_tlatch_5.xmux.xp.S1 VSS sg13_lv_nmos ad=56.9f pd=0.74u as=56.9f ps=0.74u w=0.17u l=0.17u
X7770 cml_tlatch_24.INN cml_tlatch_97.INP cml_tlatch_97.xmux.xn.S1 VSS sg13_lv_nmos ad=63.19999f pd=0.74u as=0.1082p ps=1.34u w=0.26u l=0.38u
X7771 cml_tlatch_69.OUTP cml_tlatch_69.OUTN cml_tlatch_69.xmux.xp.S1 VSS sg13_lv_nmos ad=56.9f pd=0.74u as=56.9f ps=0.74u w=0.17u l=0.17u
X7772 cml_tlatch_53.xmux.xp.S1 MOT18_N MOT18_P VSS sg13_lv_nmos ad=56.9f pd=0.74u as=56.9f ps=0.74u w=0.17u l=0.17u
X7773 cml_tlatch_61.OUTN cml_tlatch_61.OUTP cml_tlatch_61.xmux.xp.S1 VSS sg13_lv_nmos ad=56.9f pd=0.74u as=56.9f ps=0.74u w=0.17u l=0.17u
X7774 cml_tlatch_48.xmux.xp.S1 stub_bi_43.BOTN stub_bi_43.BOTP VSS sg13_lv_nmos ad=56.9f pd=0.74u as=56.9f ps=0.74u w=0.17u l=0.17u
X7775 cml_tlatch_27.xtail.S1 POLN VSS VSS sg13_lv_nmos ad=1.5637p pd=8.61u as=2.7982p ps=17.14u w=8.23u l=0.13u
X7776 cml_tlatch_20.xmux.xn.S1 CKA1_P cml_tlatch_20.xtail.S1 VSS sg13_lv_nmos ad=89.3f pd=0.85u as=0.1598p ps=1.62u w=0.47u l=0.16u
X7777 cml_tlatch_36.xtail.S1 CKB1_N cml_tlatch_36.xmux.xn.S1 VSS sg13_lv_nmos ad=89.3f pd=0.85u as=89.3f ps=0.85u w=0.47u l=0.16u
X7778 cml_tlatch_34.xmux.xp.S1 A0_2_N A0_2_P VSS sg13_lv_nmos ad=56.9f pd=0.74u as=56.9f ps=0.74u w=0.17u l=0.17u
X7779 MOT5_P cml_tlatch_98.OUTN cml_tlatch_16.xmux.xn.S1 VSS sg13_lv_nmos ad=63.19999f pd=0.74u as=63.19999f ps=0.74u w=0.26u l=0.38u
X7780 cml_tlatch_49.OUTP cml_tlatch_49.OUTN cml_tlatch_49.xmux.xp.S1 VSS sg13_lv_nmos ad=56.9f pd=0.74u as=56.9f ps=0.74u w=0.17u l=0.17u
X7781 cml_tlatch_80.xmux.xp.S1 MOT23_P MOT23_N VSS sg13_lv_nmos ad=56.9f pd=0.74u as=56.9f ps=0.74u w=0.17u l=0.17u
X7782 cml_tlatch_23.xmux.xn.S1 cml_tlatch_0.OUTP cml_tlatch_23.OUTN VSS sg13_lv_nmos ad=63.19999f pd=0.74u as=63.19999f ps=0.74u w=0.26u l=0.38u
X7783 MOT15_P B1_2_N cml_tlatch_6.xmux.xn.S1 VSS sg13_lv_nmos ad=63.19999f pd=0.74u as=63.19999f ps=0.74u w=0.26u l=0.38u
X7784 B1_2_N stub_bi_31.BOTN cml_tlatch_36.xmux.xn.S1 VSS sg13_lv_nmos ad=63.19999f pd=0.74u as=63.19999f ps=0.74u w=0.26u l=0.38u
X7785 cml_tlatch_98.xmux.xp.S1 cml_tlatch_98.OUTP cml_tlatch_98.OUTN VSS sg13_lv_nmos ad=0.1019p pd=1.34u as=56.9f ps=0.74u w=0.17u l=0.17u
X7786 cml_tlatch_96.xmux.xp.S1 cml_tlatch_5.INN cml_tlatch_5.INP VSS sg13_lv_nmos ad=0.1019p pd=1.34u as=56.9f ps=0.74u w=0.17u l=0.17u
X7787 cml_gate2_6.xrtail.R1 CKA3_N GB3_P VSS sg13_lv_nmos ad=0.1007p pd=0.91u as=0.1802p ps=1.74u w=0.53u l=0.13u
X7788 cml_tlatch_65.OUTN cml_tlatch_65.OUTP cml_tlatch_65.xmux.xp.S1 VSS sg13_lv_nmos ad=56.9f pd=0.74u as=56.9f ps=0.74u w=0.17u l=0.17u
X7789 cml_tlatch_56.xmux.xp.S1 cml_tlatch_56.OUTP cml_tlatch_56.OUTN VSS sg13_lv_nmos ad=56.9f pd=0.74u as=56.9f ps=0.74u w=0.17u l=0.17u
X7790 cml_tlatch_14.xmux.xp.S1 MOT1_P MOT1_N VSS sg13_lv_nmos ad=56.9f pd=0.74u as=56.9f ps=0.74u w=0.17u l=0.17u
X7791 cml_tlatch_28.xtail.S1 CKHA0_N cml_tlatch_28.xmux.xp.S1 VSS sg13_lv_nmos ad=89.3f pd=0.85u as=89.3f ps=0.85u w=0.47u l=0.16u
X7792 cml_tlatch_93.xtail.S1 CKJ_P cml_tlatch_93.xmux.xn.S1 VSS sg13_lv_nmos ad=89.3f pd=0.85u as=89.3f ps=0.85u w=0.47u l=0.16u
X7793 cml_tlatch_87.xmux.xp.S1 cml_tlatch_87.OUTN cml_tlatch_87.OUTP VSS sg13_lv_nmos ad=56.9f pd=0.74u as=56.9f ps=0.74u w=0.17u l=0.17u
X7794 cml_tlatch_55.xmux.xp.S1 MOT22_N MOT22_P VSS sg13_lv_nmos ad=56.9f pd=0.74u as=56.9f ps=0.74u w=0.17u l=0.17u
X7795 VDD NM1_N VSS rppd l=13.09u w=1u
X7796 cml_tlatch_49.xtail.S1 CKB3_N cml_tlatch_49.xmux.xp.S1 VSS sg13_lv_nmos ad=89.3f pd=0.85u as=89.3f ps=0.85u w=0.47u l=0.16u
X7797 MOT30_P MOT30_N cml_tlatch_45.xmux.xp.S1 VSS sg13_lv_nmos ad=56.9f pd=0.74u as=56.9f ps=0.74u w=0.17u l=0.17u
X7798 cml_tlatch_52.xmux.xp.S1 MOT16_P MOT16_N VSS sg13_lv_nmos ad=56.9f pd=0.74u as=56.9f ps=0.74u w=0.17u l=0.17u
X7799 VDD hs_to_clk_3.sg13_lv_nmos_2HGZLP_0.G VSS rppd l=0.68u w=1u
X7800 cml_tlatch_39.xmux.xp.S1 CKA1_N cml_tlatch_39.xtail.S1 VSS sg13_lv_nmos ad=0.1598p pd=1.62u as=89.3f ps=0.85u w=0.47u l=0.16u
X7801 cml_tlatch_73.xmux.xn.S1 CKHB3_P cml_tlatch_73.xtail.S1 VSS sg13_lv_nmos ad=89.3f pd=0.85u as=89.3f ps=0.85u w=0.47u l=0.16u
X7802 VSS POLN cml_tlatch_81.xtail.S1 VSS sg13_lv_nmos ad=2.7982p pd=17.14u as=1.5637p ps=8.61u w=8.23u l=0.13u
X7803 MOT3_P MOT3_N cml_tlatch_15.xmux.xp.S1 VSS sg13_lv_nmos ad=56.9f pd=0.74u as=56.9f ps=0.74u w=0.17u l=0.17u
X7804 VDD MOT0_P VSS rppd l=5.17u w=1u
X7805 cml_tlatch_25.xmux.xp.S1 MOT14_P MOT14_N VSS sg13_lv_nmos ad=56.9f pd=0.74u as=56.9f ps=0.74u w=0.17u l=0.17u
X7806 cml_tlatch_90.xtail.S1 CKB2_P cml_tlatch_90.xmux.xp.S1 VSS sg13_lv_nmos ad=89.3f pd=0.85u as=89.3f ps=0.85u w=0.47u l=0.16u
X7807 cml_tlatch_43.xtail.S1 POLN VSS VSS sg13_lv_nmos ad=1.5637p pd=8.61u as=1.5637p ps=8.61u w=8.23u l=0.13u
X7808 cml_tlatch_71.OUTN cml_tlatch_44.INP cml_tlatch_71.xmux.xn.S1 VSS sg13_lv_nmos ad=63.19999f pd=0.74u as=63.19999f ps=0.74u w=0.26u l=0.38u
X7809 cml_tlatch_95.xmux.xn.S1 CKJ_P cml_tlatch_95.xtail.S1 VSS sg13_lv_nmos ad=89.3f pd=0.85u as=89.3f ps=0.85u w=0.47u l=0.16u
X7810 cml_tlatch_71.xtail.S1 CKA3_P cml_tlatch_71.xmux.xn.S1 VSS sg13_lv_nmos ad=89.3f pd=0.85u as=89.3f ps=0.85u w=0.47u l=0.16u
X7811 cml_tlatch_62.xmux.xn.S1 A3_8_P MOT24_N VSS sg13_lv_nmos ad=63.19999f pd=0.74u as=63.19999f ps=0.74u w=0.26u l=0.38u
X7812 cml_tlatch_46.xmux.xn.S1 B2_2_P stub_bi_38.BOTP VSS sg13_lv_nmos ad=0.1082p pd=1.34u as=63.19999f ps=0.74u w=0.26u l=0.38u
X7813 VSS POLN cml_tlatch_8.xtail.S1 VSS sg13_lv_nmos ad=1.5637p pd=8.61u as=1.5637p ps=8.61u w=8.23u l=0.13u
X7814 MOT7_N MOT7_P cml_tlatch_17.xmux.xp.S1 VSS sg13_lv_nmos ad=56.9f pd=0.74u as=56.9f ps=0.74u w=0.17u l=0.17u
X7815 cml_tlatch_80.xmux.xp.S1 CKHB2_N cml_tlatch_80.xtail.S1 VSS sg13_lv_nmos ad=89.3f pd=0.85u as=0.1598p ps=1.62u w=0.47u l=0.16u
X7816 cml_tlatch_10.xtail.S1 CKB1_P cml_tlatch_10.xmux.xp.S1 VSS sg13_lv_nmos ad=0.1598p pd=1.62u as=89.3f ps=0.85u w=0.47u l=0.16u
X7817 ENA_P NM1_N cml_gate2_9.xrtail.R1 VSS sg13_lv_nmos ad=0.1007p pd=0.91u as=0.1007p ps=0.91u w=0.53u l=0.13u
X7818 MOT21_N stub_bi_55.BOTN cml_tlatch_79.xmux.xn.S1 VSS sg13_lv_nmos ad=63.19999f pd=0.74u as=63.19999f ps=0.74u w=0.26u l=0.38u
X7819 ENA1_P ENA_N cml_drv_1.xrtail.R1 VSS sg13_lv_nmos ad=56.2f pd=0.74u as=56.2f ps=0.74u w=0.16u l=0.19u
X7820 cml_tlatch_76.xmux.xp.S1 cml_tlatch_87.INN cml_tlatch_87.INP VSS sg13_lv_nmos ad=56.9f pd=0.74u as=56.9f ps=0.74u w=0.17u l=0.17u
X7821 VSS POLN cml_tlatch_32.xtail.S1 VSS sg13_lv_nmos ad=2.7982p pd=17.14u as=1.5637p ps=8.61u w=8.23u l=0.13u
X7822 VSS hs_to_clk_0.sg13_lv_nmos_2HGZLP_0.G VSS VSS sg13_lv_nmos ad=2.071p pd=11.28u as=0 ps=0 w=10.9u l=1.38u
X7823 cml_tlatch_99.OUTP cml_tlatch_99.OUTN cml_tlatch_99.xmux.xp.S1 VSS sg13_lv_nmos ad=56.9f pd=0.74u as=56.9f ps=0.74u w=0.17u l=0.17u
X7824 A1_2_N A1_2_P cml_tlatch_40.xmux.xp.S1 VSS sg13_lv_nmos ad=56.9f pd=0.74u as=56.9f ps=0.74u w=0.17u l=0.17u
X7825 MOT21_P MOT21_N cml_tlatch_79.xmux.xp.S1 VSS sg13_lv_nmos ad=56.9f pd=0.74u as=56.9f ps=0.74u w=0.17u l=0.17u
X7826 stub_bi_55.BOTP stub_bi_55.BOTN cml_tlatch_90.xmux.xp.S1 VSS sg13_lv_nmos ad=56.9f pd=0.74u as=56.9f ps=0.74u w=0.17u l=0.17u
X7827 B3_8_P cml_tlatch_65.OUTN cml_tlatch_64.xmux.xn.S1 VSS sg13_lv_nmos ad=63.19999f pd=0.74u as=63.19999f ps=0.74u w=0.26u l=0.38u
X7828 cml_tlatch_17.xmux.xp.S1 MOT7_N MOT7_P VSS sg13_lv_nmos ad=56.9f pd=0.74u as=56.9f ps=0.74u w=0.17u l=0.17u
X7829 MOT4_P cml_tlatch_99.OUTN cml_tlatch_28.xmux.xn.S1 VSS sg13_lv_nmos ad=63.19999f pd=0.74u as=0.1082p ps=1.34u w=0.26u l=0.38u
X7830 cml_tlatch_53.xtail.S1 CKHA2_P cml_tlatch_53.xmux.xn.S1 VSS sg13_lv_nmos ad=89.3f pd=0.85u as=89.3f ps=0.85u w=0.47u l=0.16u
X7831 cml_tlatch_44.xmux.xp.S1 MOT28_N MOT28_P VSS sg13_lv_nmos ad=56.9f pd=0.74u as=56.9f ps=0.74u w=0.17u l=0.17u
X7832 cml_tlatch_56.xmux.xp.S1 cml_tlatch_56.OUTP cml_tlatch_56.OUTN VSS sg13_lv_nmos ad=56.9f pd=0.74u as=56.9f ps=0.74u w=0.17u l=0.17u
X7833 cml_tlatch_45.xmux.xn.S1 A3_2_P MOT30_N VSS sg13_lv_nmos ad=63.19999f pd=0.74u as=63.19999f ps=0.74u w=0.26u l=0.38u
X7834 cml_tlatch_58.OUTP cml_tlatch_58.OUTN cml_tlatch_58.xmux.xp.S1 VSS sg13_lv_nmos ad=56.9f pd=0.74u as=56.9f ps=0.74u w=0.17u l=0.17u
X7835 cml_tlatch_75.xmux.xp.S1 CKHB3_N cml_tlatch_75.xtail.S1 VSS sg13_lv_nmos ad=89.3f pd=0.85u as=89.3f ps=0.85u w=0.47u l=0.16u
X7836 cml_tlatch_45.xmux.xn.S1 A3_2_P MOT30_N VSS sg13_lv_nmos ad=63.19999f pd=0.74u as=63.19999f ps=0.74u w=0.26u l=0.38u
X7837 stub_bi_49.BOTP stub_bi_49.BOTN cml_tlatch_84.xmux.xp.S1 VSS sg13_lv_nmos ad=56.9f pd=0.74u as=56.9f ps=0.74u w=0.17u l=0.17u
X7838 cml_tlatch_86.xtail.S1 CKA2_P cml_tlatch_86.xmux.xn.S1 VSS sg13_lv_nmos ad=89.3f pd=0.85u as=89.3f ps=0.85u w=0.47u l=0.16u
X7839 MOT17_N MOT17_P cml_tlatch_77.xmux.xp.S1 VSS sg13_lv_nmos ad=56.9f pd=0.74u as=56.9f ps=0.74u w=0.17u l=0.17u
X7840 cml_tlatch_82.xmux.xp.S1 stub_bi_62.BOTN stub_bi_62.BOTP VSS sg13_lv_nmos ad=56.9f pd=0.74u as=56.9f ps=0.74u w=0.17u l=0.17u
X7841 cml_tlatch_12.xtail.S1 POLN VSS VSS sg13_lv_nmos ad=1.5637p pd=8.61u as=2.7982p ps=17.14u w=8.23u l=0.13u
X7842 cml_tlatch_1.xmux.xp.S1 B0_8_P B0_8_N VSS sg13_lv_nmos ad=56.9f pd=0.74u as=56.9f ps=0.74u w=0.17u l=0.17u
X7843 A3_2_N A3_2_P cml_tlatch_57.xmux.xp.S1 VSS sg13_lv_nmos ad=56.9f pd=0.74u as=56.9f ps=0.74u w=0.17u l=0.17u
X7844 cml_tlatch_72.xmux.xp.S1 MOT25_P MOT25_N VSS sg13_lv_nmos ad=56.9f pd=0.74u as=56.9f ps=0.74u w=0.17u l=0.17u
X7845 cml_tlatch_33.OUTN cml_tlatch_33.OUTP cml_tlatch_33.xmux.xp.S1 VSS sg13_lv_nmos ad=56.9f pd=0.74u as=56.9f ps=0.74u w=0.17u l=0.17u
X7846 cml_tlatch_9.xmux.xn.S1 cml_tlatch_18.OUTP A0_8_N VSS sg13_lv_nmos ad=63.19999f pd=0.74u as=63.19999f ps=0.74u w=0.26u l=0.38u
X7847 cml_tlatch_5.xtail.S1 CKHB1_P cml_tlatch_5.xmux.xn.S1 VSS sg13_lv_nmos ad=89.3f pd=0.85u as=89.3f ps=0.85u w=0.47u l=0.16u
X7848 cml_tlatch_24.xmux.xn.S1 cml_tlatch_24.INN MOT12_P VSS sg13_lv_nmos ad=0.1082p pd=1.34u as=63.19999f ps=0.74u w=0.26u l=0.38u
X7849 cml_tlatch_10.xmux.xp.S1 B1_8_N B1_8_P VSS sg13_lv_nmos ad=56.9f pd=0.74u as=56.9f ps=0.74u w=0.17u l=0.17u
X7850 cml_tlatch_18.OUTP cml_tlatch_23.OUTN cml_tlatch_18.xmux.xn.S1 VSS sg13_lv_nmos ad=0.1082p pd=1.34u as=63.19999f ps=0.74u w=0.26u l=0.38u
X7851 cml_tlatch_56.xtail.S1 CKA3_P cml_tlatch_56.xmux.xn.S1 VSS sg13_lv_nmos ad=89.3f pd=0.85u as=89.3f ps=0.85u w=0.47u l=0.16u
X7852 MOT26_P MOT26_N cml_tlatch_63.xmux.xp.S1 VSS sg13_lv_nmos ad=56.9f pd=0.74u as=56.9f ps=0.74u w=0.17u l=0.17u
X7853 cml_tlatch_18.OUTP cml_tlatch_23.OUTN cml_tlatch_18.xmux.xn.S1 VSS sg13_lv_nmos ad=63.19999f pd=0.74u as=63.19999f ps=0.74u w=0.26u l=0.38u
X7854 cml_tlatch_32.OUTP D0_N cml_tlatch_32.xmux.xn.S1 VSS sg13_lv_nmos ad=63.19999f pd=0.74u as=63.19999f ps=0.74u w=0.26u l=0.38u
X7855 A0_2_N A0_2_P cml_tlatch_34.xmux.xp.S1 VSS sg13_lv_nmos ad=56.9f pd=0.74u as=56.9f ps=0.74u w=0.17u l=0.17u
X7856 cml_tlatch_41.xtail.S1 CKA1_N cml_tlatch_41.xmux.xp.S1 VSS sg13_lv_nmos ad=89.3f pd=0.85u as=89.3f ps=0.85u w=0.47u l=0.16u
X7857 MOT16_P MOT16_N cml_tlatch_52.xmux.xp.S1 VSS sg13_lv_nmos ad=56.9f pd=0.74u as=56.9f ps=0.74u w=0.17u l=0.17u
X7858 cml_tlatch_80.xmux.xp.S1 MOT23_P MOT23_N VSS sg13_lv_nmos ad=56.9f pd=0.74u as=56.9f ps=0.74u w=0.17u l=0.17u
X7859 cml_tlatch_94.xtail.S1 CKJ_P cml_tlatch_94.xmux.xp.S1 VSS sg13_lv_nmos ad=89.3f pd=0.85u as=89.3f ps=0.85u w=0.47u l=0.16u
X7860 cml_tlatch_41.xmux.xp.S1 cml_tlatch_41.OUTP cml_tlatch_41.OUTN VSS sg13_lv_nmos ad=56.9f pd=0.74u as=56.9f ps=0.74u w=0.17u l=0.17u
X7861 cml_tlatch_5.INP VDD VSS rppd l=5.17u w=1u
X7862 cml_tlatch_49.xtail.S1 CKB3_P cml_tlatch_49.xmux.xn.S1 VSS sg13_lv_nmos ad=0.1598p pd=1.62u as=89.3f ps=0.85u w=0.47u l=0.16u
X7863 cml_tlatch_87.xmux.xp.S1 cml_tlatch_87.OUTN cml_tlatch_87.OUTP VSS sg13_lv_nmos ad=56.9f pd=0.74u as=56.9f ps=0.74u w=0.17u l=0.17u
X7864 cml_tlatch_87.xmux.xp.S1 cml_tlatch_87.OUTP cml_tlatch_87.OUTN VSS sg13_lv_nmos ad=56.9f pd=0.74u as=56.9f ps=0.74u w=0.17u l=0.17u
X7865 stub_bi_63.BOTN stub_bi_63.BOTP cml_tlatch_83.xmux.xp.S1 VSS sg13_lv_nmos ad=56.9f pd=0.74u as=56.9f ps=0.74u w=0.17u l=0.17u
X7866 MOT2_N MOT2_P cml_tlatch_27.xmux.xp.S1 VSS sg13_lv_nmos ad=56.9f pd=0.74u as=56.9f ps=0.74u w=0.17u l=0.17u
X7867 cml_tlatch_40.xmux.xp.S1 A1_2_P A1_2_N VSS sg13_lv_nmos ad=0.1019p pd=1.34u as=56.9f ps=0.74u w=0.17u l=0.17u
X7868 cml_tlatch_95.xtail.S1 POLN VSS VSS sg13_lv_nmos ad=1.5637p pd=8.61u as=1.5637p ps=8.61u w=8.23u l=0.13u
X7869 MOT8_P MOT8_N cml_tlatch_42.xmux.xp.S1 VSS sg13_lv_nmos ad=56.9f pd=0.74u as=56.9f ps=0.74u w=0.17u l=0.17u
X7870 MOT29_P MOT29_N cml_tlatch_74.xmux.xp.S1 VSS sg13_lv_nmos ad=56.9f pd=0.74u as=56.9f ps=0.74u w=0.17u l=0.17u
X7871 cml_tlatch_99.xmux.xn.S1 CKA0_N cml_tlatch_99.xtail.S1 VSS sg13_lv_nmos ad=89.3f pd=0.85u as=89.3f ps=0.85u w=0.47u l=0.16u
X7872 cml_tlatch_6.xmux.xp.S1 MOT15_P MOT15_N VSS sg13_lv_nmos ad=56.9f pd=0.74u as=56.9f ps=0.74u w=0.17u l=0.17u
X7873 cml_tlatch_77.xmux.xp.S1 CKHB2_N cml_tlatch_77.xtail.S1 VSS sg13_lv_nmos ad=89.3f pd=0.85u as=0.1598p ps=1.62u w=0.47u l=0.16u
X7874 cml_tlatch_73.INP cml_tlatch_67.OUTN cml_tlatch_66.xmux.xn.S1 VSS sg13_lv_nmos ad=63.19999f pd=0.74u as=63.19999f ps=0.74u w=0.26u l=0.38u
X7875 cml_tlatch_82.xmux.xp.S1 stub_bi_62.BOTN stub_bi_62.BOTP VSS sg13_lv_nmos ad=56.9f pd=0.74u as=56.9f ps=0.74u w=0.17u l=0.17u
X7876 cml_tlatch_35.xmux.xp.S1 stub_bi_29.BOTN stub_bi_29.BOTP VSS sg13_lv_nmos ad=56.9f pd=0.74u as=56.9f ps=0.74u w=0.17u l=0.17u
X7877 cml_gate2_7.xrtail.R1 CKA2_N GB2_P VSS sg13_lv_nmos ad=0.1007p pd=0.91u as=0.1007p ps=0.91u w=0.53u l=0.13u
X7878 cml_tlatch_89.xmux.xp.S1 cml_tlatch_44.INP cml_tlatch_44.INN VSS sg13_lv_nmos ad=56.9f pd=0.74u as=56.9f ps=0.74u w=0.17u l=0.17u
X7879 cml_tlatch_5.xmux.xp.S1 MOT13_N MOT13_P VSS sg13_lv_nmos ad=56.9f pd=0.74u as=56.9f ps=0.74u w=0.17u l=0.17u
X7880 cml_tlatch_72.xmux.xn.S1 B3_8_P MOT25_N VSS sg13_lv_nmos ad=0.1082p pd=1.34u as=63.19999f ps=0.74u w=0.26u l=0.38u
X7881 cml_tlatch_79.xtail.S1 CKHB2_P cml_tlatch_79.xmux.xn.S1 VSS sg13_lv_nmos ad=89.3f pd=0.85u as=89.3f ps=0.85u w=0.47u l=0.16u
X7882 cml_tlatch_38.xmux.xp.S1 cml_tlatch_38.OUTN cml_tlatch_38.OUTP VSS sg13_lv_nmos ad=56.9f pd=0.74u as=56.9f ps=0.74u w=0.17u l=0.17u
X7883 cml_tlatch_41.OUTN D1_P cml_tlatch_41.xmux.xn.S1 VSS sg13_lv_nmos ad=0.1082p pd=1.34u as=63.19999f ps=0.74u w=0.26u l=0.38u
X7884 cml_tlatch_83.xmux.xn.S1 stub_bi_49.BOTN stub_bi_63.BOTP VSS sg13_lv_nmos ad=63.19999f pd=0.74u as=0.1082p ps=1.34u w=0.26u l=0.38u
X7885 cml_gate2_4.xamp.xn.S1 ENA1_P GA3_N VSS sg13_lv_nmos ad=0.1007p pd=0.91u as=0.1007p ps=0.91u w=0.53u l=0.13u
X7886 stub_bi_62.BOTN stub_bi_62.BOTP cml_tlatch_82.xmux.xp.S1 VSS sg13_lv_nmos ad=56.9f pd=0.74u as=56.9f ps=0.74u w=0.17u l=0.17u
X7887 cml_tlatch_5.xmux.xp.S1 CKHB1_N cml_tlatch_5.xtail.S1 VSS sg13_lv_nmos ad=89.3f pd=0.85u as=89.3f ps=0.85u w=0.47u l=0.16u
X7888 MOT10_P cml_tlatch_43.INN cml_tlatch_43.xmux.xn.S1 VSS sg13_lv_nmos ad=63.19999f pd=0.74u as=63.19999f ps=0.74u w=0.26u l=0.38u
X7889 CKJ_N CK_N hs_to_clk_8.D2 VSS sg13_lv_nmos ad=0.228p pd=1.58u as=0.408p ps=3.08u w=1.2u l=0.2u
X7890 cml_tlatch_65.xmux.xn.S1 cml_tlatch_73.INN cml_tlatch_65.OUTP VSS sg13_lv_nmos ad=0.1082p pd=1.34u as=63.19999f ps=0.74u w=0.26u l=0.38u
X7891 cml_tlatch_72.xmux.xp.S1 CKHB3_N cml_tlatch_72.xtail.S1 VSS sg13_lv_nmos ad=89.3f pd=0.85u as=89.3f ps=0.85u w=0.47u l=0.16u
X7892 cml_tlatch_24.INN cml_tlatch_24.INP cml_tlatch_97.xmux.xp.S1 VSS sg13_lv_nmos ad=56.9f pd=0.74u as=56.9f ps=0.74u w=0.17u l=0.17u
X7893 cml_tlatch_83.xtail.S1 CKB2_N cml_tlatch_83.xmux.xn.S1 VSS sg13_lv_nmos ad=89.3f pd=0.85u as=89.3f ps=0.85u w=0.47u l=0.16u
X7894 cml_tlatch_5.INP stub_bi_29.BOTP cml_tlatch_96.xmux.xn.S1 VSS sg13_lv_nmos ad=63.19999f pd=0.74u as=63.19999f ps=0.74u w=0.26u l=0.38u
X7895 cml_tlatch_77.xmux.xn.S1 B2_8_N MOT17_P VSS sg13_lv_nmos ad=63.19999f pd=0.74u as=63.19999f ps=0.74u w=0.26u l=0.38u
X7896 MOT10_P cml_tlatch_43.INN cml_tlatch_43.xmux.xn.S1 VSS sg13_lv_nmos ad=63.19999f pd=0.74u as=63.19999f ps=0.74u w=0.26u l=0.38u
X7897 cml_tlatch_65.xmux.xn.S1 cml_tlatch_73.INN cml_tlatch_65.OUTP VSS sg13_lv_nmos ad=63.19999f pd=0.74u as=63.19999f ps=0.74u w=0.26u l=0.38u
X7898 cml_tlatch_38.OUTN D0_P cml_tlatch_38.xmux.xn.S1 VSS sg13_lv_nmos ad=63.19999f pd=0.74u as=63.19999f ps=0.74u w=0.26u l=0.38u
X7899 cml_tlatch_28.xmux.xp.S1 CKHA0_N cml_tlatch_28.xtail.S1 VSS sg13_lv_nmos ad=89.3f pd=0.85u as=0.1598p ps=1.62u w=0.47u l=0.16u
X7900 cml_tlatch_20.xmux.xn.S1 cml_tlatch_43.INN cml_tlatch_20.OUTP VSS sg13_lv_nmos ad=63.19999f pd=0.74u as=63.19999f ps=0.74u w=0.26u l=0.38u
X7901 cml_tlatch_29.xmux.xn.S1 CKHA0_P cml_tlatch_29.xtail.S1 VSS sg13_lv_nmos ad=0.1598p pd=1.62u as=89.3f ps=0.85u w=0.47u l=0.16u
X7902 cml_tlatch_44.xtail.S1 CKHA3_P cml_tlatch_44.xmux.xn.S1 VSS sg13_lv_nmos ad=89.3f pd=0.85u as=89.3f ps=0.85u w=0.47u l=0.16u
X7903 cml_tlatch_22.OUTP cml_tlatch_22.OUTN cml_tlatch_22.xmux.xp.S1 VSS sg13_lv_nmos ad=56.9f pd=0.74u as=56.9f ps=0.74u w=0.17u l=0.17u
X7904 cml_tlatch_68.xmux.xp.S1 A3_8_P A3_8_N VSS sg13_lv_nmos ad=56.9f pd=0.74u as=56.9f ps=0.74u w=0.17u l=0.17u
X7905 A2_8_P A2_8_N cml_tlatch_85.xmux.xp.S1 VSS sg13_lv_nmos ad=56.9f pd=0.74u as=56.9f ps=0.74u w=0.17u l=0.17u
X7906 cml_tlatch_30.xmux.xp.S1 cml_tlatch_30.OUTP cml_tlatch_30.OUTN VSS sg13_lv_nmos ad=56.9f pd=0.74u as=56.9f ps=0.74u w=0.17u l=0.17u
X7907 cml_tlatch_24.INN cml_tlatch_24.INP cml_tlatch_97.xmux.xp.S1 VSS sg13_lv_nmos ad=56.9f pd=0.74u as=56.9f ps=0.74u w=0.17u l=0.17u
X7908 cml_tlatch_57.xmux.xp.S1 A3_2_N A3_2_P VSS sg13_lv_nmos ad=56.9f pd=0.74u as=56.9f ps=0.74u w=0.17u l=0.17u
X7909 cml_tlatch_13.xmux.xn.S1 cml_tlatch_5.INN stub_bi_17.BOTN VSS sg13_lv_nmos ad=63.19999f pd=0.74u as=63.19999f ps=0.74u w=0.26u l=0.38u
X7910 MOT11_P MOT11_N cml_tlatch_4.xmux.xp.S1 VSS sg13_lv_nmos ad=56.9f pd=0.74u as=56.9f ps=0.74u w=0.17u l=0.17u
X7911 GB1_P CKA1_N cml_gate2_0.xrtail.R1 VSS sg13_lv_nmos ad=0.1007p pd=0.91u as=0.1007p ps=0.91u w=0.53u l=0.13u
X7912 GB0_P ENB1_N cml_gate2_1.xamp.xn.S1 VSS sg13_lv_nmos ad=0.1007p pd=0.91u as=0.1007p ps=0.91u w=0.53u l=0.13u
X7913 cml_tlatch_58.OUTN cml_tlatch_58.OUTP cml_tlatch_58.xmux.xp.S1 VSS sg13_lv_nmos ad=56.9f pd=0.74u as=56.9f ps=0.74u w=0.17u l=0.17u
X7914 cml_tlatch_58.xmux.xn.S1 CKA3_P cml_tlatch_58.xtail.S1 VSS sg13_lv_nmos ad=89.3f pd=0.85u as=89.3f ps=0.85u w=0.47u l=0.16u
X7915 cml_tlatch_90.xmux.xp.S1 CKB2_P cml_tlatch_90.xtail.S1 VSS sg13_lv_nmos ad=89.3f pd=0.85u as=89.3f ps=0.85u w=0.47u l=0.16u
X7916 cml_tlatch_28.xmux.xp.S1 MOT4_P MOT4_N VSS sg13_lv_nmos ad=56.9f pd=0.74u as=56.9f ps=0.74u w=0.17u l=0.17u
X7917 cml_tlatch_13.xmux.xn.S1 cml_tlatch_5.INN stub_bi_17.BOTN VSS sg13_lv_nmos ad=63.19999f pd=0.74u as=63.19999f ps=0.74u w=0.26u l=0.38u
X7918 cml_tlatch_3.xmux.xp.S1 MOT9_N MOT9_P VSS sg13_lv_nmos ad=56.9f pd=0.74u as=56.9f ps=0.74u w=0.17u l=0.17u
X7919 cml_tlatch_95.xtail.S1 CKJ_P cml_tlatch_95.xmux.xn.S1 VSS sg13_lv_nmos ad=89.3f pd=0.85u as=89.3f ps=0.85u w=0.47u l=0.16u
X7920 cml_tlatch_63.xtail.S1 CKHA3_N cml_tlatch_63.xmux.xp.S1 VSS sg13_lv_nmos ad=89.3f pd=0.85u as=89.3f ps=0.85u w=0.47u l=0.16u
X7921 cml_tlatch_83.xmux.xp.S1 stub_bi_63.BOTN stub_bi_63.BOTP VSS sg13_lv_nmos ad=56.9f pd=0.74u as=56.9f ps=0.74u w=0.17u l=0.17u
X7922 cml_tlatch_89.xmux.xp.S1 CKA3_P cml_tlatch_89.xtail.S1 VSS sg13_lv_nmos ad=89.3f pd=0.85u as=0.1598p ps=1.62u w=0.47u l=0.16u
X7923 cml_tlatch_36.xmux.xp.S1 B1_2_N B1_2_P VSS sg13_lv_nmos ad=56.9f pd=0.74u as=56.9f ps=0.74u w=0.17u l=0.17u
X7924 cml_tlatch_31.xmux.xp.S1 B0_2_P B0_2_N VSS sg13_lv_nmos ad=56.9f pd=0.74u as=56.9f ps=0.74u w=0.17u l=0.17u
X7925 cml_gate2_0.xrtail.R1 CKA1_N GB1_P VSS sg13_lv_nmos ad=0.1007p pd=0.91u as=0.1007p ps=0.91u w=0.53u l=0.13u
X7926 cml_tlatch_56.xmux.xp.S1 cml_tlatch_56.OUTN cml_tlatch_56.OUTP VSS sg13_lv_nmos ad=56.9f pd=0.74u as=56.9f ps=0.74u w=0.17u l=0.17u
X7927 J4_N CLK_W_N cml_tlatch_92.xmux.xn.S1 VSS sg13_lv_nmos ad=63.19999f pd=0.74u as=0.1082p ps=1.34u w=0.26u l=0.38u
X7928 cml_tlatch_31.xtail.S1 CKB0_N cml_tlatch_31.xmux.xn.S1 VSS sg13_lv_nmos ad=0.1598p pd=1.62u as=89.3f ps=0.85u w=0.47u l=0.16u
X7929 cml_tlatch_76.xtail.S1 CKA2_N cml_tlatch_76.xmux.xp.S1 VSS sg13_lv_nmos ad=89.3f pd=0.85u as=89.3f ps=0.85u w=0.47u l=0.16u
X7930 cml_tlatch_7.xmux.xp.S1 cml_tlatch_7.OUTN cml_tlatch_7.OUTP VSS sg13_lv_nmos ad=56.9f pd=0.74u as=56.9f ps=0.74u w=0.17u l=0.17u
X7931 cml_tlatch_31.xmux.xp.S1 B0_2_N B0_2_P VSS sg13_lv_nmos ad=0.1019p pd=1.34u as=56.9f ps=0.74u w=0.17u l=0.17u
X7932 stub_bi_17.BOTP cml_tlatch_5.INP cml_tlatch_13.xmux.xn.S1 VSS sg13_lv_nmos ad=63.19999f pd=0.74u as=63.19999f ps=0.74u w=0.26u l=0.38u
X7933 cml_tlatch_51.xmux.xn.S1 CKB3_P cml_tlatch_51.xtail.S1 VSS sg13_lv_nmos ad=89.3f pd=0.85u as=89.3f ps=0.85u w=0.47u l=0.16u
X7934 MOT29_P MOT29_N cml_tlatch_74.xmux.xp.S1 VSS sg13_lv_nmos ad=56.9f pd=0.74u as=0.1019p ps=1.34u w=0.17u l=0.17u
X7935 cml_tlatch_54.xmux.xp.S1 CKHA2_N cml_tlatch_54.xtail.S1 VSS sg13_lv_nmos ad=89.3f pd=0.85u as=89.3f ps=0.85u w=0.47u l=0.16u
X7936 A0_8_P A0_8_N cml_tlatch_9.xmux.xp.S1 VSS sg13_lv_nmos ad=56.9f pd=0.74u as=56.9f ps=0.74u w=0.17u l=0.17u
X7937 A1_8_N A1_8_P cml_tlatch_19.xmux.xp.S1 VSS sg13_lv_nmos ad=56.9f pd=0.74u as=56.9f ps=0.74u w=0.17u l=0.17u
X7938 cml_gate2_8.xamp.xn.S1 J2_N ENB_P VSS sg13_lv_nmos ad=0.1007p pd=0.91u as=0.1007p ps=0.91u w=0.53u l=0.13u
X7939 cml_tlatch_93.xmux.xn.S1 J2_N CLK_W_N VSS sg13_lv_nmos ad=63.19999f pd=0.74u as=63.19999f ps=0.74u w=0.26u l=0.38u
X7940 VSS POLN cml_tlatch_57.xtail.S1 VSS sg13_lv_nmos ad=1.5637p pd=8.61u as=1.5637p ps=8.61u w=8.23u l=0.13u
X7941 cml_tlatch_42.xmux.xn.S1 A1_8_N MOT8_P VSS sg13_lv_nmos ad=63.19999f pd=0.74u as=63.19999f ps=0.74u w=0.26u l=0.38u
X7942 cml_tlatch_91.INN cml_tlatch_91.INP cml_tlatch_59.xmux.xp.S1 VSS sg13_lv_nmos ad=56.9f pd=0.74u as=56.9f ps=0.74u w=0.17u l=0.17u
X7943 cml_tlatch_72.xmux.xp.S1 MOT25_N MOT25_P VSS sg13_lv_nmos ad=56.9f pd=0.74u as=56.9f ps=0.74u w=0.17u l=0.17u
X7944 stub_bi_43.BOTN stub_bi_43.BOTP cml_tlatch_48.xmux.xp.S1 VSS sg13_lv_nmos ad=56.9f pd=0.74u as=56.9f ps=0.74u w=0.17u l=0.17u
X7945 cml_tlatch_58.xmux.xn.S1 D3_N cml_tlatch_58.OUTP VSS sg13_lv_nmos ad=63.19999f pd=0.74u as=63.19999f ps=0.74u w=0.26u l=0.38u
X7946 cml_tlatch_84.xtail.S1 CKB2_N cml_tlatch_84.xmux.xp.S1 VSS sg13_lv_nmos ad=0.1598p pd=1.62u as=89.3f ps=0.85u w=0.47u l=0.16u
X7947 VSS POLN cml_tlatch_69.xtail.S1 VSS sg13_lv_nmos ad=2.7982p pd=17.14u as=1.5637p ps=8.61u w=8.23u l=0.13u
X7948 MOT8_P MOT8_N cml_tlatch_42.xmux.xp.S1 VSS sg13_lv_nmos ad=56.9f pd=0.74u as=56.9f ps=0.74u w=0.17u l=0.17u
X7949 cml_tlatch_93.xtail.S1 CKJ_P cml_tlatch_93.xmux.xn.S1 VSS sg13_lv_nmos ad=89.3f pd=0.85u as=89.3f ps=0.85u w=0.47u l=0.16u
X7950 cml_tlatch_97.INP cml_tlatch_97.INN cml_tlatch_39.xmux.xp.S1 VSS sg13_lv_nmos ad=56.9f pd=0.74u as=56.9f ps=0.74u w=0.17u l=0.17u
X7951 cml_tlatch_25.xtail.S1 CKHA1_N cml_tlatch_25.xmux.xp.S1 VSS sg13_lv_nmos ad=89.3f pd=0.85u as=89.3f ps=0.85u w=0.47u l=0.16u
X7952 cml_gate2_1.xrtail.R1 VSS VSS rppd l=4.86u w=1u
X7953 VSS hs_to_clk_5.sg13_lv_nmos_2HGZLP_0.G VSS VSS sg13_lv_nmos ad=2.071p pd=11.28u as=0 ps=0 w=10.9u l=1.38u
X7954 cml_tlatch_89.xtail.S1 CKA3_N cml_tlatch_89.xmux.xn.S1 VSS sg13_lv_nmos ad=89.3f pd=0.85u as=89.3f ps=0.85u w=0.47u l=0.16u
X7955 cml_tlatch_71.xmux.xp.S1 cml_tlatch_71.OUTN cml_tlatch_71.OUTP VSS sg13_lv_nmos ad=56.9f pd=0.74u as=56.9f ps=0.74u w=0.17u l=0.17u
X7956 cml_tlatch_39.xtail.S1 CKA1_N cml_tlatch_39.xmux.xp.S1 VSS sg13_lv_nmos ad=89.3f pd=0.85u as=89.3f ps=0.85u w=0.47u l=0.16u
X7957 cml_tlatch_89.xmux.xp.S1 cml_tlatch_44.INP cml_tlatch_44.INN VSS sg13_lv_nmos ad=56.9f pd=0.74u as=56.9f ps=0.74u w=0.17u l=0.17u
X7958 cml_tlatch_53.xmux.xp.S1 MOT18_P MOT18_N VSS sg13_lv_nmos ad=56.9f pd=0.74u as=56.9f ps=0.74u w=0.17u l=0.17u
X7959 cml_tlatch_82.xtail.S1 POLN VSS VSS sg13_lv_nmos ad=1.5637p pd=8.61u as=2.7982p ps=17.14u w=8.23u l=0.13u
X7960 cml_tlatch_98.OUTN cml_tlatch_98.OUTP cml_tlatch_98.xmux.xp.S1 VSS sg13_lv_nmos ad=56.9f pd=0.74u as=56.9f ps=0.74u w=0.17u l=0.17u
X7961 cml_tlatch_74.INN cml_tlatch_74.INP cml_tlatch_88.xmux.xp.S1 VSS sg13_lv_nmos ad=56.9f pd=0.74u as=56.9f ps=0.74u w=0.17u l=0.17u
X7962 cml_tlatch_80.xmux.xp.S1 MOT23_N MOT23_P VSS sg13_lv_nmos ad=56.9f pd=0.74u as=56.9f ps=0.74u w=0.17u l=0.17u
X7963 cml_tlatch_38.xmux.xp.S1 cml_tlatch_38.OUTN cml_tlatch_38.OUTP VSS sg13_lv_nmos ad=56.9f pd=0.74u as=56.9f ps=0.74u w=0.17u l=0.17u
X7964 MOT31_P MOT31_N cml_tlatch_75.xmux.xp.S1 VSS sg13_lv_nmos ad=56.9f pd=0.74u as=56.9f ps=0.74u w=0.17u l=0.17u
X7965 cml_tlatch_30.OUTP cml_tlatch_30.OUTN cml_tlatch_30.xmux.xp.S1 VSS sg13_lv_nmos ad=56.9f pd=0.74u as=56.9f ps=0.74u w=0.17u l=0.17u
X7966 cml_tlatch_25.xmux.xn.S1 A1_2_N MOT14_P VSS sg13_lv_nmos ad=63.19999f pd=0.74u as=0.1082p ps=1.34u w=0.26u l=0.38u
X7967 GA3_P ENA1_N cml_gate2_4.xamp.xn.S1 VSS sg13_lv_nmos ad=0.1007p pd=0.91u as=0.1007p ps=0.91u w=0.53u l=0.13u
X7968 cml_tlatch_96.xmux.xp.S1 cml_tlatch_5.INP cml_tlatch_5.INN VSS sg13_lv_nmos ad=56.9f pd=0.74u as=56.9f ps=0.74u w=0.17u l=0.17u
X7969 cml_tlatch_10.xtail.S1 CKB1_P cml_tlatch_10.xmux.xp.S1 VSS sg13_lv_nmos ad=89.3f pd=0.85u as=89.3f ps=0.85u w=0.47u l=0.16u
X7970 cml_tlatch_26.xtail.S1 CKHA0_N cml_tlatch_26.xmux.xp.S1 VSS sg13_lv_nmos ad=89.3f pd=0.85u as=89.3f ps=0.85u w=0.47u l=0.16u
X7971 cml_tlatch_94.xmux.xp.S1 CKJ_P cml_tlatch_94.xtail.S1 VSS sg13_lv_nmos ad=89.3f pd=0.85u as=89.3f ps=0.85u w=0.47u l=0.16u
X7972 cml_tlatch_4.xmux.xn.S1 CKHB1_P cml_tlatch_4.xtail.S1 VSS sg13_lv_nmos ad=89.3f pd=0.85u as=89.3f ps=0.85u w=0.47u l=0.16u
X7973 cml_tlatch_69.OUTN cml_tlatch_69.OUTP cml_tlatch_69.xmux.xp.S1 VSS sg13_lv_nmos ad=56.9f pd=0.74u as=56.9f ps=0.74u w=0.17u l=0.17u
X7974 cml_tlatch_82.xmux.xn.S1 stub_bi_63.BOTN stub_bi_62.BOTP VSS sg13_lv_nmos ad=63.19999f pd=0.74u as=63.19999f ps=0.74u w=0.26u l=0.38u
X7975 MOT12_N MOT12_P cml_tlatch_24.xmux.xp.S1 VSS sg13_lv_nmos ad=56.9f pd=0.74u as=56.9f ps=0.74u w=0.17u l=0.17u
X7976 A0_8_N A0_8_P cml_tlatch_9.xmux.xp.S1 VSS sg13_lv_nmos ad=56.9f pd=0.74u as=56.9f ps=0.74u w=0.17u l=0.17u
X7977 cml_tlatch_28.xmux.xn.S1 CKHA0_P cml_tlatch_28.xtail.S1 VSS sg13_lv_nmos ad=89.3f pd=0.85u as=89.3f ps=0.85u w=0.47u l=0.16u
X7978 cml_tlatch_81.xmux.xp.S1 B2_8_N B2_8_P VSS sg13_lv_nmos ad=0.1019p pd=1.34u as=56.9f ps=0.74u w=0.17u l=0.17u
X7979 cml_tlatch_20.xmux.xp.S1 cml_tlatch_20.OUTP cml_tlatch_20.OUTN VSS sg13_lv_nmos ad=56.9f pd=0.74u as=56.9f ps=0.74u w=0.17u l=0.17u
X7980 cml_tlatch_37.xtail.S1 CKB1_P cml_tlatch_37.xmux.xn.S1 VSS sg13_lv_nmos ad=89.3f pd=0.85u as=89.3f ps=0.85u w=0.47u l=0.16u
X7981 B3_2_P B3_2_N cml_tlatch_50.xmux.xp.S1 VSS sg13_lv_nmos ad=56.9f pd=0.74u as=56.9f ps=0.74u w=0.17u l=0.17u
X7982 cml_tlatch_56.xmux.xn.S1 A3_2_N cml_tlatch_56.OUTP VSS sg13_lv_nmos ad=63.19999f pd=0.74u as=63.19999f ps=0.74u w=0.26u l=0.38u
X7983 stub_bi_15.BOTP stub_bi_15.BOTN cml_tlatch_11.xmux.xp.S1 VSS sg13_lv_nmos ad=56.9f pd=0.74u as=56.9f ps=0.74u w=0.17u l=0.17u
X7984 cml_tlatch_51.xtail.S1 POLN VSS VSS sg13_lv_nmos ad=1.5637p pd=8.61u as=1.5637p ps=8.61u w=8.23u l=0.13u
X7985 cml_tlatch_26.xmux.xp.S1 MOT0_P MOT0_N VSS sg13_lv_nmos ad=56.9f pd=0.74u as=56.9f ps=0.74u w=0.17u l=0.17u
X7986 cml_tlatch_39.xmux.xn.S1 A1_2_P cml_tlatch_97.INN VSS sg13_lv_nmos ad=63.19999f pd=0.74u as=63.19999f ps=0.74u w=0.26u l=0.38u
X7987 cml_tlatch_3.xmux.xp.S1 MOT9_N MOT9_P VSS sg13_lv_nmos ad=0.1019p pd=1.34u as=56.9f ps=0.74u w=0.17u l=0.17u
X7988 cml_tlatch_43.INN cml_tlatch_43.INP cml_tlatch_21.xmux.xp.S1 VSS sg13_lv_nmos ad=56.9f pd=0.74u as=56.9f ps=0.74u w=0.17u l=0.17u
X7989 cml_tlatch_75.xmux.xn.S1 B3_2_P MOT31_N VSS sg13_lv_nmos ad=63.19999f pd=0.74u as=63.19999f ps=0.74u w=0.26u l=0.38u
X7990 cml_tlatch_36.xmux.xp.S1 B1_2_N B1_2_P VSS sg13_lv_nmos ad=56.9f pd=0.74u as=56.9f ps=0.74u w=0.17u l=0.17u
X7991 cml_tlatch_75.xmux.xn.S1 B3_2_P MOT31_N VSS sg13_lv_nmos ad=63.19999f pd=0.74u as=63.19999f ps=0.74u w=0.26u l=0.38u
X7992 MOT2_P MOT2_N cml_tlatch_27.xmux.xp.S1 VSS sg13_lv_nmos ad=56.9f pd=0.74u as=56.9f ps=0.74u w=0.17u l=0.17u
X7993 cml_tlatch_62.xtail.S1 CKHA3_P cml_tlatch_62.xmux.xn.S1 VSS sg13_lv_nmos ad=89.3f pd=0.85u as=89.3f ps=0.85u w=0.47u l=0.16u
X7994 MOT19_N MOT19_P cml_tlatch_78.xmux.xp.S1 VSS sg13_lv_nmos ad=56.9f pd=0.74u as=56.9f ps=0.74u w=0.17u l=0.17u
X7995 cml_tlatch_83.xmux.xn.S1 CKB2_N cml_tlatch_83.xtail.S1 VSS sg13_lv_nmos ad=89.3f pd=0.85u as=89.3f ps=0.85u w=0.47u l=0.16u
X7996 cml_tlatch_70.xmux.xp.S1 cml_tlatch_63.INN cml_tlatch_63.INP VSS sg13_lv_nmos ad=56.9f pd=0.74u as=56.9f ps=0.74u w=0.17u l=0.17u
X7997 cml_tlatch_7.xmux.xp.S1 cml_tlatch_7.OUTN cml_tlatch_7.OUTP VSS sg13_lv_nmos ad=56.9f pd=0.74u as=56.9f ps=0.74u w=0.17u l=0.17u
X7998 J2_P J2_N cml_tlatch_94.xmux.xp.S1 VSS sg13_lv_nmos ad=56.9f pd=0.74u as=56.9f ps=0.74u w=0.17u l=0.17u
X7999 A2_8_P cml_tlatch_86.OUTN cml_tlatch_85.xmux.xn.S1 VSS sg13_lv_nmos ad=63.19999f pd=0.74u as=0.1082p ps=1.34u w=0.26u l=0.38u
X8000 cml_tlatch_70.xmux.xn.S1 CKA3_N cml_tlatch_70.xtail.S1 VSS sg13_lv_nmos ad=89.3f pd=0.85u as=0.1598p ps=1.62u w=0.47u l=0.16u
X8001 cml_tlatch_68.xtail.S1 CKA3_P cml_tlatch_68.xmux.xp.S1 VSS sg13_lv_nmos ad=89.3f pd=0.85u as=89.3f ps=0.85u w=0.47u l=0.16u
X8002 cml_tlatch_63.xmux.xp.S1 MOT26_P MOT26_N VSS sg13_lv_nmos ad=56.9f pd=0.74u as=56.9f ps=0.74u w=0.17u l=0.17u
X8003 cml_tlatch_12.xmux.xn.S1 stub_bi_17.BOTP cml_tlatch_4.INP VSS sg13_lv_nmos ad=63.19999f pd=0.74u as=63.19999f ps=0.74u w=0.26u l=0.38u
X8004 cml_tlatch_20.xtail.S1 CKA1_N cml_tlatch_20.xmux.xp.S1 VSS sg13_lv_nmos ad=89.3f pd=0.85u as=89.3f ps=0.85u w=0.47u l=0.16u
X8005 cml_tlatch_91.INN cml_tlatch_91.INP cml_tlatch_59.xmux.xp.S1 VSS sg13_lv_nmos ad=56.9f pd=0.74u as=56.9f ps=0.74u w=0.17u l=0.17u
X8006 cml_tlatch_30.xmux.xn.S1 CKB0_P cml_tlatch_30.xtail.S1 VSS sg13_lv_nmos ad=89.3f pd=0.85u as=89.3f ps=0.85u w=0.47u l=0.16u
X8007 GB1_P ENB1_N cml_gate2_0.xamp.xn.S1 VSS sg13_lv_nmos ad=0.1007p pd=0.91u as=0.1007p ps=0.91u w=0.53u l=0.13u
X8008 cml_tlatch_46.xmux.xp.S1 stub_bi_38.BOTN stub_bi_38.BOTP VSS sg13_lv_nmos ad=56.9f pd=0.74u as=56.9f ps=0.74u w=0.17u l=0.17u
X8009 cml_tlatch_1.xtail.S1 CKB0_P cml_tlatch_1.xmux.xp.S1 VSS sg13_lv_nmos ad=89.3f pd=0.85u as=89.3f ps=0.85u w=0.47u l=0.16u
X8010 stub_bi_17.BOTN stub_bi_17.BOTP cml_tlatch_13.xmux.xp.S1 VSS sg13_lv_nmos ad=56.9f pd=0.74u as=56.9f ps=0.74u w=0.17u l=0.17u
X8011 cml_tlatch_33.xmux.xn.S1 A0_2_N cml_tlatch_33.OUTP VSS sg13_lv_nmos ad=63.19999f pd=0.74u as=63.19999f ps=0.74u w=0.26u l=0.38u
X8012 VSS POLN cml_tlatch_11.xtail.S1 VSS sg13_lv_nmos ad=1.5637p pd=8.61u as=1.5637p ps=8.61u w=8.23u l=0.13u
X8013 cml_tlatch_69.xmux.xp.S1 cml_tlatch_69.OUTN cml_tlatch_69.OUTP VSS sg13_lv_nmos ad=56.9f pd=0.74u as=56.9f ps=0.74u w=0.17u l=0.17u
X8014 cml_tlatch_51.OUTN cml_tlatch_51.OUTP cml_tlatch_51.xmux.xp.S1 VSS sg13_lv_nmos ad=56.9f pd=0.74u as=56.9f ps=0.74u w=0.17u l=0.17u
X8015 VSS POLN cml_tlatch_87.xtail.S1 VSS sg13_lv_nmos ad=1.5637p pd=8.61u as=1.5637p ps=8.61u w=8.23u l=0.13u
X8016 cml_tlatch_23.OUTN cml_tlatch_23.OUTP cml_tlatch_23.xmux.xp.S1 VSS sg13_lv_nmos ad=56.9f pd=0.74u as=56.9f ps=0.74u w=0.17u l=0.17u
X8017 cml_tlatch_87.xtail.S1 CKA2_P cml_tlatch_87.xmux.xp.S1 VSS sg13_lv_nmos ad=89.3f pd=0.85u as=89.3f ps=0.85u w=0.47u l=0.16u
X8018 cml_tlatch_47.xmux.xn.S1 stub_bi_43.BOTP B2_2_P VSS sg13_lv_nmos ad=63.19999f pd=0.74u as=63.19999f ps=0.74u w=0.26u l=0.38u
X8019 cml_tlatch_32.xmux.xp.S1 CKB0_N cml_tlatch_32.xtail.S1 VSS sg13_lv_nmos ad=89.3f pd=0.85u as=89.3f ps=0.85u w=0.47u l=0.16u
X8020 MOT11_P cml_tlatch_4.INN cml_tlatch_4.xmux.xn.S1 VSS sg13_lv_nmos ad=63.19999f pd=0.74u as=63.19999f ps=0.74u w=0.26u l=0.38u
X8021 VSS hs_to_clk_3.sg13_lv_nmos_2HGZLP_0.G VSS VSS sg13_lv_nmos ad=2.071p pd=11.28u as=0 ps=0 w=10.9u l=1.38u
X8022 A2_2_N A2_2_P cml_tlatch_60.xmux.xp.S1 VSS sg13_lv_nmos ad=56.9f pd=0.74u as=56.9f ps=0.74u w=0.17u l=0.17u
X8023 cml_tlatch_98.OUTN cml_tlatch_98.OUTP cml_tlatch_98.xmux.xp.S1 VSS sg13_lv_nmos ad=56.9f pd=0.74u as=56.9f ps=0.74u w=0.17u l=0.17u
X8024 cml_tlatch_2.xmux.xp.S1 CKB0_N cml_tlatch_2.xtail.S1 VSS sg13_lv_nmos ad=89.3f pd=0.85u as=89.3f ps=0.85u w=0.47u l=0.16u
X8025 J2_P J1_N cml_tlatch_94.xmux.xn.S1 VSS sg13_lv_nmos ad=63.19999f pd=0.74u as=63.19999f ps=0.74u w=0.26u l=0.38u
X8026 cml_tlatch_5.INP cml_tlatch_5.INN cml_tlatch_96.xmux.xp.S1 VSS sg13_lv_nmos ad=56.9f pd=0.74u as=56.9f ps=0.74u w=0.17u l=0.17u
X8027 cml_tlatch_30.OUTP cml_tlatch_30.OUTN cml_tlatch_30.xmux.xp.S1 VSS sg13_lv_nmos ad=56.9f pd=0.74u as=56.9f ps=0.74u w=0.17u l=0.17u
X8028 MOT1_N MOT1_P cml_tlatch_14.xmux.xp.S1 VSS sg13_lv_nmos ad=56.9f pd=0.74u as=56.9f ps=0.74u w=0.17u l=0.17u
X8029 MOT22_P MOT22_N cml_tlatch_55.xmux.xp.S1 VSS sg13_lv_nmos ad=56.9f pd=0.74u as=56.9f ps=0.74u w=0.17u l=0.17u
X8030 cml_tlatch_54.xtail.S1 CKHA2_N cml_tlatch_54.xmux.xp.S1 VSS sg13_lv_nmos ad=89.3f pd=0.85u as=89.3f ps=0.85u w=0.47u l=0.16u
X8031 cml_tlatch_45.xmux.xp.S1 MOT30_N MOT30_P VSS sg13_lv_nmos ad=56.9f pd=0.74u as=56.9f ps=0.74u w=0.17u l=0.17u
X8032 MOT16_N MOT16_P cml_tlatch_52.xmux.xp.S1 VSS sg13_lv_nmos ad=56.9f pd=0.74u as=56.9f ps=0.74u w=0.17u l=0.17u
X8033 VSS hs_to_clk_2.sg13_lv_nmos_2HGZLP_0.G VSS VSS sg13_lv_nmos ad=2.071p pd=11.28u as=0 ps=0 w=10.9u l=1.38u
X8034 cml_tlatch_83.xtail.S1 CKB2_P cml_tlatch_83.xmux.xp.S1 VSS sg13_lv_nmos ad=89.3f pd=0.85u as=89.3f ps=0.85u w=0.47u l=0.16u
X8035 VSS POLN cml_tlatch_7.xtail.S1 VSS sg13_lv_nmos ad=2.7982p pd=17.14u as=1.5637p ps=8.61u w=8.23u l=0.13u
X8036 cml_tlatch_28.xmux.xp.S1 MOT4_N MOT4_P VSS sg13_lv_nmos ad=56.9f pd=0.74u as=56.9f ps=0.74u w=0.17u l=0.17u
X8037 VSS POLN cml_tlatch_38.xtail.S1 VSS sg13_lv_nmos ad=2.7982p pd=17.14u as=1.5637p ps=8.61u w=8.23u l=0.13u
X8038 cml_drv_2.xrtail.R1 ENB_N ENB0_P VSS sg13_lv_nmos ad=56.2f pd=0.74u as=56.2f ps=0.74u w=0.16u l=0.19u
X8039 MOT14_N MOT14_P cml_tlatch_25.xmux.xp.S1 VSS sg13_lv_nmos ad=56.9f pd=0.74u as=56.9f ps=0.74u w=0.17u l=0.17u
X8040 cml_tlatch_43.xmux.xn.S1 CKHA1_P cml_tlatch_43.xtail.S1 VSS sg13_lv_nmos ad=89.3f pd=0.85u as=89.3f ps=0.85u w=0.47u l=0.16u
X8041 cml_tlatch_87.OUTP cml_tlatch_87.INN cml_tlatch_87.xmux.xn.S1 VSS sg13_lv_nmos ad=63.19999f pd=0.74u as=63.19999f ps=0.74u w=0.26u l=0.38u
X8042 cml_tlatch_65.xmux.xp.S1 cml_tlatch_65.OUTP cml_tlatch_65.OUTN VSS sg13_lv_nmos ad=56.9f pd=0.74u as=56.9f ps=0.74u w=0.17u l=0.17u
X8043 cml_gate2_6.xamp.xn.S1 ENB0_P GB3_N VSS sg13_lv_nmos ad=0.1007p pd=0.91u as=0.1007p ps=0.91u w=0.53u l=0.13u
X8044 A0_8_N A0_8_P cml_tlatch_9.xmux.xp.S1 VSS sg13_lv_nmos ad=56.9f pd=0.74u as=56.9f ps=0.74u w=0.17u l=0.17u
X8045 cml_tlatch_66.xmux.xp.S1 cml_tlatch_73.INP cml_tlatch_73.INN VSS sg13_lv_nmos ad=56.9f pd=0.74u as=56.9f ps=0.74u w=0.17u l=0.17u
X8046 cml_tlatch_93.xmux.xn.S1 CKJ_P cml_tlatch_93.xtail.S1 VSS sg13_lv_nmos ad=89.3f pd=0.85u as=0.1598p ps=1.62u w=0.47u l=0.16u
X8047 cml_tlatch_74.INP cml_tlatch_74.INN cml_tlatch_88.xmux.xp.S1 VSS sg13_lv_nmos ad=56.9f pd=0.74u as=56.9f ps=0.74u w=0.17u l=0.17u
X8048 cml_tlatch_44.xtail.S1 CKHA3_N cml_tlatch_44.xmux.xp.S1 VSS sg13_lv_nmos ad=89.3f pd=0.85u as=89.3f ps=0.85u w=0.47u l=0.16u
X8049 VSS POLN cml_tlatch_48.xtail.S1 VSS sg13_lv_nmos ad=2.7982p pd=17.14u as=1.5637p ps=8.61u w=8.23u l=0.13u
X8050 cml_tlatch_44.xmux.xn.S1 cml_tlatch_44.INN MOT28_P VSS sg13_lv_nmos ad=63.19999f pd=0.74u as=0.1082p ps=1.34u w=0.26u l=0.38u
X8051 cml_tlatch_29.xmux.xn.S1 CKHA0_P cml_tlatch_29.xtail.S1 VSS sg13_lv_nmos ad=89.3f pd=0.85u as=89.3f ps=0.85u w=0.47u l=0.16u
X8052 cml_tlatch_17.xmux.xp.S1 MOT7_P MOT7_N VSS sg13_lv_nmos ad=56.9f pd=0.74u as=56.9f ps=0.74u w=0.17u l=0.17u
X8053 cml_tlatch_4.xmux.xp.S1 MOT11_P MOT11_N VSS sg13_lv_nmos ad=56.9f pd=0.74u as=56.9f ps=0.74u w=0.17u l=0.17u
X8054 stub_bi_15.BOTP stub_bi_15.BOTN cml_tlatch_11.xmux.xp.S1 VSS sg13_lv_nmos ad=56.9f pd=0.74u as=56.9f ps=0.74u w=0.17u l=0.17u
X8055 cml_tlatch_2.xmux.xp.S1 cml_tlatch_2.OUTN cml_tlatch_2.OUTP VSS sg13_lv_nmos ad=56.9f pd=0.74u as=56.9f ps=0.74u w=0.17u l=0.17u
X8056 J2_P J2_N cml_tlatch_94.xmux.xp.S1 VSS sg13_lv_nmos ad=56.9f pd=0.74u as=56.9f ps=0.74u w=0.17u l=0.17u
X8057 cml_tlatch_26.xmux.xp.S1 MOT0_P MOT0_N VSS sg13_lv_nmos ad=56.9f pd=0.74u as=56.9f ps=0.74u w=0.17u l=0.17u
X8058 cml_tlatch_17.xmux.xn.S1 CKHB0_P cml_tlatch_17.xtail.S1 VSS sg13_lv_nmos ad=0.1598p pd=1.62u as=89.3f ps=0.85u w=0.47u l=0.16u
X8059 cml_tlatch_37.xtail.S1 CKB1_N cml_tlatch_37.xmux.xp.S1 VSS sg13_lv_nmos ad=0.1598p pd=1.62u as=89.3f ps=0.85u w=0.47u l=0.16u
X8060 cml_tlatch_54.xmux.xp.S1 MOT20_N MOT20_P VSS sg13_lv_nmos ad=56.9f pd=0.74u as=56.9f ps=0.74u w=0.17u l=0.17u
X8061 cml_tlatch_86.xmux.xn.S1 cml_tlatch_87.OUTN cml_tlatch_86.OUTP VSS sg13_lv_nmos ad=63.19999f pd=0.74u as=63.19999f ps=0.74u w=0.26u l=0.38u
X8062 cml_tlatch_93.xmux.xp.S1 CLK_W_P CLK_W_N VSS sg13_lv_nmos ad=56.9f pd=0.74u as=56.9f ps=0.74u w=0.17u l=0.17u
X8063 cml_tlatch_58.xmux.xp.S1 cml_tlatch_58.OUTN cml_tlatch_58.OUTP VSS sg13_lv_nmos ad=56.9f pd=0.74u as=56.9f ps=0.74u w=0.17u l=0.17u
X8064 A3_2_P cml_tlatch_58.OUTN cml_tlatch_57.xmux.xn.S1 VSS sg13_lv_nmos ad=63.19999f pd=0.74u as=63.19999f ps=0.74u w=0.26u l=0.38u
X8065 cml_tlatch_60.xmux.xp.S1 CKA2_P cml_tlatch_60.xtail.S1 VSS sg13_lv_nmos ad=89.3f pd=0.85u as=89.3f ps=0.85u w=0.47u l=0.16u
X8066 cml_tlatch_26.xmux.xp.S1 CKHA0_N cml_tlatch_26.xtail.S1 VSS sg13_lv_nmos ad=89.3f pd=0.85u as=89.3f ps=0.85u w=0.47u l=0.16u
X8067 cml_tlatch_10.xmux.xp.S1 CKB1_P cml_tlatch_10.xtail.S1 VSS sg13_lv_nmos ad=89.3f pd=0.85u as=89.3f ps=0.85u w=0.47u l=0.16u
X8068 cml_tlatch_57.xmux.xn.S1 cml_tlatch_58.OUTP A3_2_N VSS sg13_lv_nmos ad=63.19999f pd=0.74u as=63.19999f ps=0.74u w=0.26u l=0.38u
X8069 cml_tlatch_88.xmux.xp.S1 cml_tlatch_74.INN cml_tlatch_74.INP VSS sg13_lv_nmos ad=56.9f pd=0.74u as=56.9f ps=0.74u w=0.17u l=0.17u
X8070 cml_tlatch_45.xtail.S1 CKHA3_N cml_tlatch_45.xmux.xp.S1 VSS sg13_lv_nmos ad=0.1598p pd=1.62u as=89.3f ps=0.85u w=0.47u l=0.16u
X8071 cml_tlatch_94.xtail.S1 CKJ_N cml_tlatch_94.xmux.xn.S1 VSS sg13_lv_nmos ad=89.3f pd=0.85u as=89.3f ps=0.85u w=0.47u l=0.16u
X8072 cml_tlatch_84.xmux.xp.S1 stub_bi_49.BOTN stub_bi_49.BOTP VSS sg13_lv_nmos ad=56.9f pd=0.74u as=56.9f ps=0.74u w=0.17u l=0.17u
X8073 cml_tlatch_77.xmux.xp.S1 MOT17_P MOT17_N VSS sg13_lv_nmos ad=56.9f pd=0.74u as=56.9f ps=0.74u w=0.17u l=0.17u
X8074 A0_2_N cml_tlatch_38.OUTP cml_tlatch_34.xmux.xn.S1 VSS sg13_lv_nmos ad=0.1082p pd=1.34u as=63.19999f ps=0.74u w=0.26u l=0.38u
X8075 cml_tlatch_48.xmux.xn.S1 D2_P stub_bi_43.BOTP VSS sg13_lv_nmos ad=63.19999f pd=0.74u as=63.19999f ps=0.74u w=0.26u l=0.38u
X8076 cml_tlatch_74.xmux.xn.S1 CKHB3_P cml_tlatch_74.xtail.S1 VSS sg13_lv_nmos ad=89.3f pd=0.85u as=89.3f ps=0.85u w=0.47u l=0.16u
X8077 A0_2_N cml_tlatch_38.OUTP cml_tlatch_34.xmux.xn.S1 VSS sg13_lv_nmos ad=63.19999f pd=0.74u as=63.19999f ps=0.74u w=0.26u l=0.38u
X8078 cml_tlatch_33.xmux.xp.S1 cml_tlatch_33.OUTP cml_tlatch_33.OUTN VSS sg13_lv_nmos ad=56.9f pd=0.74u as=56.9f ps=0.74u w=0.17u l=0.17u
X8079 VDD MOT2_P VSS rppd l=5.17u w=1u
X8080 cml_tlatch_47.xmux.xp.S1 CKB2_P cml_tlatch_47.xtail.S1 VSS sg13_lv_nmos ad=89.3f pd=0.85u as=89.3f ps=0.85u w=0.47u l=0.16u
X8081 MOT5_P MOT5_N cml_tlatch_16.xmux.xp.S1 VSS sg13_lv_nmos ad=56.9f pd=0.74u as=56.9f ps=0.74u w=0.17u l=0.17u
X8082 cml_tlatch_21.xtail.S1 POLN VSS VSS sg13_lv_nmos ad=1.5637p pd=8.61u as=1.5637p ps=8.61u w=8.23u l=0.13u
X8083 cml_tlatch_97.xmux.xp.S1 CKA1_P cml_tlatch_97.xtail.S1 VSS sg13_lv_nmos ad=89.3f pd=0.85u as=89.3f ps=0.85u w=0.47u l=0.16u
X8084 cml_tlatch_57.xmux.xp.S1 CKA3_P cml_tlatch_57.xtail.S1 VSS sg13_lv_nmos ad=89.3f pd=0.85u as=89.3f ps=0.85u w=0.47u l=0.16u
X8085 cml_gate2_5.xamp.xn.S1 CKB2_P cml_gate2_5.xrtail.R1 VSS sg13_lv_nmos ad=0.1802p pd=1.74u as=0.1007p ps=0.91u w=0.53u l=0.13u
X8086 stub_bi_49.BOTP stub_bi_55.BOTN cml_tlatch_84.xmux.xn.S1 VSS sg13_lv_nmos ad=63.19999f pd=0.74u as=63.19999f ps=0.74u w=0.26u l=0.38u
X8087 cml_tlatch_45.xmux.xp.S1 MOT30_P MOT30_N VSS sg13_lv_nmos ad=56.9f pd=0.74u as=56.9f ps=0.74u w=0.17u l=0.17u
X8088 B0_2_P B0_2_N cml_tlatch_31.xmux.xp.S1 VSS sg13_lv_nmos ad=56.9f pd=0.74u as=56.9f ps=0.74u w=0.17u l=0.17u
X8089 cml_tlatch_2.OUTN cml_tlatch_2.OUTP cml_tlatch_2.xmux.xp.S1 VSS sg13_lv_nmos ad=56.9f pd=0.74u as=56.9f ps=0.74u w=0.17u l=0.17u
X8090 VSS hs_to_clk_8.sg13_lv_nmos_2HGZLP_0.G VSS VSS sg13_lv_nmos ad=2.071p pd=11.28u as=0 ps=0 w=10.9u l=1.38u
X8091 B2_8_N B2_8_P cml_tlatch_81.xmux.xp.S1 VSS sg13_lv_nmos ad=56.9f pd=0.74u as=56.9f ps=0.74u w=0.17u l=0.17u
X8092 cml_tlatch_63.xmux.xn.S1 cml_tlatch_63.INP MOT26_N VSS sg13_lv_nmos ad=63.19999f pd=0.74u as=63.19999f ps=0.74u w=0.26u l=0.38u
X8093 cml_tlatch_91.OUTN cml_tlatch_91.OUTP cml_tlatch_91.xmux.xp.S1 VSS sg13_lv_nmos ad=56.9f pd=0.74u as=56.9f ps=0.74u w=0.17u l=0.17u
X8094 cml_tlatch_25.xtail.S1 CKHA1_N cml_tlatch_25.xmux.xp.S1 VSS sg13_lv_nmos ad=89.3f pd=0.85u as=89.3f ps=0.85u w=0.47u l=0.16u
X8095 VDD cml_tlatch_99.OUTP VSS rppd l=5.17u w=1u
X8096 cml_tlatch_34.xmux.xp.S1 A0_2_P A0_2_N VSS sg13_lv_nmos ad=56.9f pd=0.74u as=56.9f ps=0.74u w=0.17u l=0.17u
X8097 cml_tlatch_0.xmux.xp.S1 CKA0_N cml_tlatch_0.xtail.S1 VSS sg13_lv_nmos ad=89.3f pd=0.85u as=89.3f ps=0.85u w=0.47u l=0.16u
X8098 CLK_W_N CLK_W_P cml_tlatch_93.xmux.xp.S1 VSS sg13_lv_nmos ad=56.9f pd=0.74u as=0.1019p ps=1.34u w=0.17u l=0.17u
X8099 cml_tlatch_52.xmux.xp.S1 MOT16_N MOT16_P VSS sg13_lv_nmos ad=56.9f pd=0.74u as=56.9f ps=0.74u w=0.17u l=0.17u
X8100 cml_tlatch_78.xmux.xp.S1 MOT19_N MOT19_P VSS sg13_lv_nmos ad=56.9f pd=0.74u as=56.9f ps=0.74u w=0.17u l=0.17u
X8101 cml_tlatch_32.xmux.xp.S1 cml_tlatch_32.OUTN cml_tlatch_32.OUTP VSS sg13_lv_nmos ad=0.1019p pd=1.34u as=56.9f ps=0.74u w=0.17u l=0.17u
X8102 MOT22_P A2_2_N cml_tlatch_55.xmux.xn.S1 VSS sg13_lv_nmos ad=0.1082p pd=1.34u as=63.19999f ps=0.74u w=0.26u l=0.38u
X8103 MOT1_N MOT1_P cml_tlatch_14.xmux.xp.S1 VSS sg13_lv_nmos ad=56.9f pd=0.74u as=56.9f ps=0.74u w=0.17u l=0.17u
X8104 MOT0_N A0_8_P cml_tlatch_26.xmux.xn.S1 VSS sg13_lv_nmos ad=63.19999f pd=0.74u as=0.1082p ps=1.34u w=0.26u l=0.38u
X8105 cml_tlatch_66.xmux.xp.S1 cml_tlatch_73.INP cml_tlatch_73.INN VSS sg13_lv_nmos ad=56.9f pd=0.74u as=56.9f ps=0.74u w=0.17u l=0.17u
X8106 cml_tlatch_87.OUTN cml_tlatch_87.OUTP cml_tlatch_87.xmux.xp.S1 VSS sg13_lv_nmos ad=56.9f pd=0.74u as=56.9f ps=0.74u w=0.17u l=0.17u
X8107 cml_tlatch_87.OUTP cml_tlatch_87.OUTN cml_tlatch_87.xmux.xp.S1 VSS sg13_lv_nmos ad=56.9f pd=0.74u as=56.9f ps=0.74u w=0.17u l=0.17u
X8108 cml_tlatch_6.xtail.S1 CKHB1_N cml_tlatch_6.xmux.xp.S1 VSS sg13_lv_nmos ad=89.3f pd=0.85u as=89.3f ps=0.85u w=0.47u l=0.16u
X8109 A1_2_N A1_2_P cml_tlatch_40.xmux.xp.S1 VSS sg13_lv_nmos ad=56.9f pd=0.74u as=56.9f ps=0.74u w=0.17u l=0.17u
X8110 cml_tlatch_83.xmux.xp.S1 stub_bi_63.BOTP stub_bi_63.BOTN VSS sg13_lv_nmos ad=56.9f pd=0.74u as=56.9f ps=0.74u w=0.17u l=0.17u
X8111 cml_tlatch_54.xtail.S1 CKHA2_P cml_tlatch_54.xmux.xn.S1 VSS sg13_lv_nmos ad=89.3f pd=0.85u as=89.3f ps=0.85u w=0.47u l=0.16u
X8112 cml_tlatch_42.xmux.xp.S1 MOT8_N MOT8_P VSS sg13_lv_nmos ad=56.9f pd=0.74u as=56.9f ps=0.74u w=0.17u l=0.17u
X8113 cml_tlatch_82.xmux.xn.S1 CKB2_P cml_tlatch_82.xtail.S1 VSS sg13_lv_nmos ad=89.3f pd=0.85u as=89.3f ps=0.85u w=0.47u l=0.16u
X8114 stub_bi_38.BOTN stub_bi_38.BOTP cml_tlatch_46.xmux.xp.S1 VSS sg13_lv_nmos ad=56.9f pd=0.74u as=56.9f ps=0.74u w=0.17u l=0.17u
X8115 cml_tlatch_23.OUTN cml_tlatch_0.OUTP cml_tlatch_23.xmux.xn.S1 VSS sg13_lv_nmos ad=63.19999f pd=0.74u as=63.19999f ps=0.74u w=0.26u l=0.38u
X8116 cml_tlatch_86.xmux.xp.S1 cml_tlatch_86.OUTP cml_tlatch_86.OUTN VSS sg13_lv_nmos ad=56.9f pd=0.74u as=56.9f ps=0.74u w=0.17u l=0.17u
X8117 cml_tlatch_16.xmux.xn.S1 cml_tlatch_98.OUTN MOT5_P VSS sg13_lv_nmos ad=63.19999f pd=0.74u as=63.19999f ps=0.74u w=0.26u l=0.38u
X8118 cml_tlatch_36.xmux.xn.S1 stub_bi_31.BOTN B1_2_N VSS sg13_lv_nmos ad=63.19999f pd=0.74u as=0.1082p ps=1.34u w=0.26u l=0.38u
X8119 cml_tlatch_6.xmux.xn.S1 B1_2_N MOT15_P VSS sg13_lv_nmos ad=63.19999f pd=0.74u as=0.1082p ps=1.34u w=0.26u l=0.38u
X8120 cml_tlatch_71.OUTP cml_tlatch_44.INN cml_tlatch_71.xmux.xn.S1 VSS sg13_lv_nmos ad=63.19999f pd=0.74u as=63.19999f ps=0.74u w=0.26u l=0.38u
X8121 cml_tlatch_14.xmux.xn.S1 CKHB0_P cml_tlatch_14.xtail.S1 VSS sg13_lv_nmos ad=0.1598p pd=1.62u as=89.3f ps=0.85u w=0.47u l=0.16u
X8122 cml_tlatch_46.xmux.xn.S1 B2_2_N stub_bi_38.BOTN VSS sg13_lv_nmos ad=0.1082p pd=1.34u as=63.19999f ps=0.74u w=0.26u l=0.38u
X8123 cml_tlatch_49.xmux.xn.S1 CKB3_P cml_tlatch_49.xtail.S1 VSS sg13_lv_nmos ad=89.3f pd=0.85u as=89.3f ps=0.85u w=0.47u l=0.16u
X8124 cml_tlatch_47.xmux.xp.S1 B2_2_N B2_2_P VSS sg13_lv_nmos ad=56.9f pd=0.74u as=56.9f ps=0.74u w=0.17u l=0.17u
X8125 cml_tlatch_17.xmux.xp.S1 MOT7_P MOT7_N VSS sg13_lv_nmos ad=0.1019p pd=1.34u as=56.9f ps=0.74u w=0.17u l=0.17u
X8126 cml_tlatch_99.xmux.xn.S1 cml_tlatch_33.OUTP cml_tlatch_99.OUTN VSS sg13_lv_nmos ad=63.19999f pd=0.74u as=63.19999f ps=0.74u w=0.26u l=0.38u
X8127 cml_tlatch_42.xmux.xn.S1 A1_8_P MOT8_N VSS sg13_lv_nmos ad=0.1082p pd=1.34u as=63.19999f ps=0.74u w=0.26u l=0.38u
X8128 MOT18_P MOT18_N cml_tlatch_53.xmux.xp.S1 VSS sg13_lv_nmos ad=56.9f pd=0.74u as=56.9f ps=0.74u w=0.17u l=0.17u
X8129 cml_tlatch_63.xmux.xp.S1 MOT26_N MOT26_P VSS sg13_lv_nmos ad=56.9f pd=0.74u as=56.9f ps=0.74u w=0.17u l=0.17u
X8130 cml_tlatch_0.OUTN cml_tlatch_99.OUTP cml_tlatch_0.xmux.xn.S1 VSS sg13_lv_nmos ad=0.1082p pd=1.34u as=63.19999f ps=0.74u w=0.26u l=0.38u
X8131 VDD ENA_P VSS rppd l=7.42u w=1u
X8132 ENB_P J2_N cml_gate2_8.xamp.xn.S1 VSS sg13_lv_nmos ad=0.1007p pd=0.91u as=0.1007p ps=0.91u w=0.53u l=0.13u
X8133 cml_tlatch_0.OUTN cml_tlatch_99.OUTP cml_tlatch_0.xmux.xn.S1 VSS sg13_lv_nmos ad=63.19999f pd=0.74u as=63.19999f ps=0.74u w=0.26u l=0.38u
X8134 MOT9_N MOT9_P cml_tlatch_3.xmux.xp.S1 VSS sg13_lv_nmos ad=56.9f pd=0.74u as=0.1019p ps=1.34u w=0.17u l=0.17u
X8135 MOT28_P MOT28_N cml_tlatch_44.xmux.xp.S1 VSS sg13_lv_nmos ad=56.9f pd=0.74u as=56.9f ps=0.74u w=0.17u l=0.17u
X8136 cml_tlatch_56.OUTN cml_tlatch_56.OUTP cml_tlatch_56.xmux.xp.S1 VSS sg13_lv_nmos ad=56.9f pd=0.74u as=56.9f ps=0.74u w=0.17u l=0.17u
X8137 cml_tlatch_22.xmux.xp.S1 cml_tlatch_22.OUTN cml_tlatch_22.OUTP VSS sg13_lv_nmos ad=56.9f pd=0.74u as=56.9f ps=0.74u w=0.17u l=0.17u
X8138 B1_8_P stub_bi_15.BOTP cml_tlatch_10.xmux.xn.S1 VSS sg13_lv_nmos ad=63.19999f pd=0.74u as=63.19999f ps=0.74u w=0.26u l=0.38u
X8139 VSS POLN cml_tlatch_62.xtail.S1 VSS sg13_lv_nmos ad=1.5637p pd=8.61u as=1.5637p ps=8.61u w=8.23u l=0.13u
X8140 cml_tlatch_79.xmux.xn.S1 stub_bi_55.BOTN MOT21_N VSS sg13_lv_nmos ad=63.19999f pd=0.74u as=63.19999f ps=0.74u w=0.26u l=0.38u
X8141 stub_bi_38.BOTP B2_2_P cml_tlatch_46.xmux.xn.S1 VSS sg13_lv_nmos ad=63.19999f pd=0.74u as=63.19999f ps=0.74u w=0.26u l=0.38u
X8142 stub_bi_49.BOTN stub_bi_49.BOTP cml_tlatch_84.xmux.xp.S1 VSS sg13_lv_nmos ad=56.9f pd=0.74u as=56.9f ps=0.74u w=0.17u l=0.17u
X8143 cml_tlatch_9.xmux.xn.S1 CKA0_N cml_tlatch_9.xtail.S1 VSS sg13_lv_nmos ad=89.3f pd=0.85u as=89.3f ps=0.85u w=0.47u l=0.16u
X8144 cml_tlatch_10.xmux.xn.S1 CKB1_N cml_tlatch_10.xtail.S1 VSS sg13_lv_nmos ad=89.3f pd=0.85u as=89.3f ps=0.85u w=0.47u l=0.16u
X8145 cml_tlatch_85.xmux.xp.S1 A2_8_N A2_8_P VSS sg13_lv_nmos ad=56.9f pd=0.74u as=56.9f ps=0.74u w=0.17u l=0.17u
X8146 B3_8_P B3_8_N cml_tlatch_64.xmux.xp.S1 VSS sg13_lv_nmos ad=56.9f pd=0.74u as=56.9f ps=0.74u w=0.17u l=0.17u
X8147 cml_tlatch_97.xmux.xp.S1 cml_tlatch_24.INP cml_tlatch_24.INN VSS sg13_lv_nmos ad=56.9f pd=0.74u as=56.9f ps=0.74u w=0.17u l=0.17u
X8148 A3_2_P A3_2_N cml_tlatch_57.xmux.xp.S1 VSS sg13_lv_nmos ad=56.9f pd=0.74u as=0.1019p ps=1.34u w=0.17u l=0.17u
X8149 cml_tlatch_95.xtail.S1 CKJ_N cml_tlatch_95.xmux.xp.S1 VSS sg13_lv_nmos ad=89.3f pd=0.85u as=89.3f ps=0.85u w=0.47u l=0.16u
X8150 cml_drv_0.xrtail.R1 ENB_N ENB1_P VSS sg13_lv_nmos ad=56.2f pd=0.74u as=56.2f ps=0.74u w=0.16u l=0.19u
X8151 cml_tlatch_85.xmux.xn.S1 CKA2_N cml_tlatch_85.xtail.S1 VSS sg13_lv_nmos ad=89.3f pd=0.85u as=89.3f ps=0.85u w=0.47u l=0.16u
X8152 MOT16_P A2_8_N cml_tlatch_52.xmux.xn.S1 VSS sg13_lv_nmos ad=63.19999f pd=0.74u as=0.1082p ps=1.34u w=0.26u l=0.38u
X8153 cml_tlatch_64.xmux.xn.S1 cml_tlatch_65.OUTN B3_8_P VSS sg13_lv_nmos ad=63.19999f pd=0.74u as=63.19999f ps=0.74u w=0.26u l=0.38u
X8154 cml_tlatch_25.xmux.xn.S1 A1_2_P MOT14_N VSS sg13_lv_nmos ad=63.19999f pd=0.74u as=63.19999f ps=0.74u w=0.26u l=0.38u
X8155 stub_bi_17.BOTP VDD VSS rppd l=5.17u w=1u
X8156 cml_tlatch_58.xmux.xp.S1 cml_tlatch_58.OUTP cml_tlatch_58.OUTN VSS sg13_lv_nmos ad=56.9f pd=0.74u as=56.9f ps=0.74u w=0.17u l=0.17u
X8157 cml_tlatch_22.OUTN cml_tlatch_22.OUTP cml_tlatch_22.xmux.xp.S1 VSS sg13_lv_nmos ad=56.9f pd=0.74u as=0.1019p ps=1.34u w=0.17u l=0.17u
X8158 MOT4_N MOT4_P cml_tlatch_28.xmux.xp.S1 VSS sg13_lv_nmos ad=56.9f pd=0.74u as=56.9f ps=0.74u w=0.17u l=0.17u
X8159 stub_bi_63.BOTP stub_bi_63.BOTN cml_tlatch_83.xmux.xp.S1 VSS sg13_lv_nmos ad=56.9f pd=0.74u as=0.1019p ps=1.34u w=0.17u l=0.17u
X8160 MOT9_P MOT9_N cml_tlatch_3.xmux.xp.S1 VSS sg13_lv_nmos ad=56.9f pd=0.74u as=56.9f ps=0.74u w=0.17u l=0.17u
X8161 cml_gate2_2.xrtail.R1 CKB1_N GA1_P VSS sg13_lv_nmos ad=0.1007p pd=0.91u as=0.1007p ps=0.91u w=0.53u l=0.13u
X8162 cml_tlatch_33.xmux.xp.S1 cml_tlatch_33.OUTP cml_tlatch_33.OUTN VSS sg13_lv_nmos ad=56.9f pd=0.74u as=56.9f ps=0.74u w=0.17u l=0.17u
X8163 cml_tlatch_29.xtail.S1 CKHA0_P cml_tlatch_29.xmux.xn.S1 VSS sg13_lv_nmos ad=89.3f pd=0.85u as=89.3f ps=0.85u w=0.47u l=0.16u
X8164 cml_tlatch_91.xmux.xp.S1 cml_tlatch_91.OUTN cml_tlatch_91.OUTP VSS sg13_lv_nmos ad=0.1019p pd=1.34u as=56.9f ps=0.74u w=0.17u l=0.17u
X8165 cml_tlatch_38.xtail.S1 CKA0_P cml_tlatch_38.xmux.xn.S1 VSS sg13_lv_nmos ad=89.3f pd=0.85u as=89.3f ps=0.85u w=0.47u l=0.16u
X8166 MOT30_N A3_2_P cml_tlatch_45.xmux.xn.S1 VSS sg13_lv_nmos ad=63.19999f pd=0.74u as=63.19999f ps=0.74u w=0.26u l=0.38u
X8167 VDD cml_tlatch_91.OUTN VSS rppd l=5.17u w=1u
X8168 cml_tlatch_73.xmux.xn.S1 cml_tlatch_73.INP MOT27_N VSS sg13_lv_nmos ad=0.1082p pd=1.34u as=63.19999f ps=0.74u w=0.26u l=0.38u
X8169 B0_2_P B0_2_N cml_tlatch_31.xmux.xp.S1 VSS sg13_lv_nmos ad=56.9f pd=0.74u as=56.9f ps=0.74u w=0.17u l=0.17u
X8170 cml_tlatch_3.xtail.S1 CKHB1_N cml_tlatch_3.xmux.xp.S1 VSS sg13_lv_nmos ad=89.3f pd=0.85u as=89.3f ps=0.85u w=0.47u l=0.16u
X8171 B2_8_N B2_8_P cml_tlatch_81.xmux.xp.S1 VSS sg13_lv_nmos ad=56.9f pd=0.74u as=56.9f ps=0.74u w=0.17u l=0.17u
X8172 cml_tlatch_19.xmux.xp.S1 A1_8_P A1_8_N VSS sg13_lv_nmos ad=56.9f pd=0.74u as=56.9f ps=0.74u w=0.17u l=0.17u
X8173 MOT12_P cml_tlatch_24.INN cml_tlatch_24.xmux.xn.S1 VSS sg13_lv_nmos ad=63.19999f pd=0.74u as=63.19999f ps=0.74u w=0.26u l=0.38u
X8174 cml_tlatch_21.xmux.xn.S1 CKA1_N cml_tlatch_21.xtail.S1 VSS sg13_lv_nmos ad=89.3f pd=0.85u as=89.3f ps=0.85u w=0.47u l=0.16u
X8175 cml_tlatch_49.OUTN cml_tlatch_49.OUTP cml_tlatch_49.xmux.xp.S1 VSS sg13_lv_nmos ad=56.9f pd=0.74u as=0.1019p ps=1.34u w=0.17u l=0.17u
X8176 cml_tlatch_78.xmux.xp.S1 MOT19_N MOT19_P VSS sg13_lv_nmos ad=0.1019p pd=1.34u as=56.9f ps=0.74u w=0.17u l=0.17u
X8177 cml_tlatch_89.xtail.S1 CKA3_P cml_tlatch_89.xmux.xp.S1 VSS sg13_lv_nmos ad=89.3f pd=0.85u as=89.3f ps=0.85u w=0.47u l=0.16u
X8178 MOT24_P MOT24_N cml_tlatch_62.xmux.xp.S1 VSS sg13_lv_nmos ad=56.9f pd=0.74u as=56.9f ps=0.74u w=0.17u l=0.17u
X8179 MOT27_P MOT27_N cml_tlatch_73.xmux.xp.S1 VSS sg13_lv_nmos ad=56.9f pd=0.74u as=56.9f ps=0.74u w=0.17u l=0.17u
X8180 MOT25_P MOT25_N cml_tlatch_72.xmux.xp.S1 VSS sg13_lv_nmos ad=56.9f pd=0.74u as=56.9f ps=0.74u w=0.17u l=0.17u
X8181 cml_tlatch_89.xmux.xn.S1 cml_tlatch_56.OUTN cml_tlatch_44.INP VSS sg13_lv_nmos ad=63.19999f pd=0.74u as=63.19999f ps=0.74u w=0.26u l=0.38u
X8182 cml_tlatch_78.xmux.xn.S1 stub_bi_63.BOTP MOT19_P VSS sg13_lv_nmos ad=63.19999f pd=0.74u as=63.19999f ps=0.74u w=0.26u l=0.38u
X8183 cml_tlatch_41.OUTN cml_tlatch_41.OUTP cml_tlatch_41.xmux.xp.S1 VSS sg13_lv_nmos ad=56.9f pd=0.74u as=56.9f ps=0.74u w=0.17u l=0.17u
X8184 cml_tlatch_31.xmux.xn.S1 CKB0_N cml_tlatch_31.xtail.S1 VSS sg13_lv_nmos ad=89.3f pd=0.85u as=89.3f ps=0.85u w=0.47u l=0.16u
X8185 MOT12_P cml_tlatch_24.INN cml_tlatch_24.xmux.xn.S1 VSS sg13_lv_nmos ad=63.19999f pd=0.74u as=63.19999f ps=0.74u w=0.26u l=0.38u
X8186 cml_tlatch_18.xmux.xn.S1 cml_tlatch_23.OUTN cml_tlatch_18.OUTP VSS sg13_lv_nmos ad=63.19999f pd=0.74u as=63.19999f ps=0.74u w=0.26u l=0.38u
X8187 cml_tlatch_32.xmux.xn.S1 D0_N cml_tlatch_32.OUTP VSS sg13_lv_nmos ad=63.19999f pd=0.74u as=63.19999f ps=0.74u w=0.26u l=0.38u
X8188 cml_tlatch_4.xmux.xp.S1 MOT11_N MOT11_P VSS sg13_lv_nmos ad=56.9f pd=0.74u as=56.9f ps=0.74u w=0.17u l=0.17u
X8189 cml_tlatch_42.xmux.xp.S1 MOT8_N MOT8_P VSS sg13_lv_nmos ad=56.9f pd=0.74u as=56.9f ps=0.74u w=0.17u l=0.17u
X8190 stub_bi_38.BOTN stub_bi_38.BOTP cml_tlatch_46.xmux.xp.S1 VSS sg13_lv_nmos ad=56.9f pd=0.74u as=56.9f ps=0.74u w=0.17u l=0.17u
X8191 cml_tlatch_98.xmux.xp.S1 CKB0_P cml_tlatch_98.xtail.S1 VSS sg13_lv_nmos ad=89.3f pd=0.85u as=89.3f ps=0.85u w=0.47u l=0.16u
X8192 cml_tlatch_34.xmux.xn.S1 cml_tlatch_38.OUTN A0_2_P VSS sg13_lv_nmos ad=63.19999f pd=0.74u as=63.19999f ps=0.74u w=0.26u l=0.38u
X8193 cml_tlatch_39.xmux.xp.S1 cml_tlatch_97.INN cml_tlatch_97.INP VSS sg13_lv_nmos ad=56.9f pd=0.74u as=56.9f ps=0.74u w=0.17u l=0.17u
X8194 cml_tlatch_55.xtail.S1 CKHA2_P cml_tlatch_55.xmux.xn.S1 VSS sg13_lv_nmos ad=89.3f pd=0.85u as=89.3f ps=0.85u w=0.47u l=0.16u
X8195 cml_tlatch_56.xmux.xp.S1 CKA3_N cml_tlatch_56.xtail.S1 VSS sg13_lv_nmos ad=89.3f pd=0.85u as=89.3f ps=0.85u w=0.47u l=0.16u
X8196 stub_bi_62.BOTP stub_bi_62.BOTN cml_tlatch_82.xmux.xp.S1 VSS sg13_lv_nmos ad=56.9f pd=0.74u as=56.9f ps=0.74u w=0.17u l=0.17u
X8197 cml_tlatch_32.xmux.xn.S1 D0_N cml_tlatch_32.OUTP VSS sg13_lv_nmos ad=63.19999f pd=0.74u as=63.19999f ps=0.74u w=0.26u l=0.38u
X8198 cml_tlatch_85.xmux.xn.S1 cml_tlatch_86.OUTN A2_8_P VSS sg13_lv_nmos ad=63.19999f pd=0.74u as=63.19999f ps=0.74u w=0.26u l=0.38u
X8199 CKHB2_P GB2_N cml_drvb_7.xrtail.R2 VSS sg13_lv_nmos ad=0.2618p pd=2.22u as=0.1463p ps=1.15u w=0.77u l=0.21u
X8200 cml_tlatch_21.xmux.xp.S1 cml_tlatch_43.INN cml_tlatch_43.INP VSS sg13_lv_nmos ad=56.9f pd=0.74u as=56.9f ps=0.74u w=0.17u l=0.17u
X8201 MOT18_N MOT18_P cml_tlatch_53.xmux.xp.S1 VSS sg13_lv_nmos ad=56.9f pd=0.74u as=56.9f ps=0.74u w=0.17u l=0.17u
X8202 cml_tlatch_36.xmux.xn.S1 CKB1_N cml_tlatch_36.xtail.S1 VSS sg13_lv_nmos ad=89.3f pd=0.85u as=89.3f ps=0.85u w=0.47u l=0.16u
X8203 cml_tlatch_60.xtail.S1 POLN VSS VSS sg13_lv_nmos ad=1.5637p pd=8.61u as=2.7982p ps=17.14u w=8.23u l=0.13u
X8204 B3_2_N B3_2_P cml_tlatch_50.xmux.xp.S1 VSS sg13_lv_nmos ad=56.9f pd=0.74u as=56.9f ps=0.74u w=0.17u l=0.17u
X8205 cml_tlatch_44.INN cml_tlatch_44.INP cml_tlatch_89.xmux.xp.S1 VSS sg13_lv_nmos ad=56.9f pd=0.74u as=56.9f ps=0.74u w=0.17u l=0.17u
X8206 MOT13_P MOT13_N cml_tlatch_5.xmux.xp.S1 VSS sg13_lv_nmos ad=56.9f pd=0.74u as=56.9f ps=0.74u w=0.17u l=0.17u
X8207 A2_8_N cml_tlatch_86.OUTP cml_tlatch_85.xmux.xn.S1 VSS sg13_lv_nmos ad=63.19999f pd=0.74u as=63.19999f ps=0.74u w=0.26u l=0.38u
X8208 cml_tlatch_0.OUTN cml_tlatch_0.OUTP cml_tlatch_0.xmux.xp.S1 VSS sg13_lv_nmos ad=56.9f pd=0.74u as=56.9f ps=0.74u w=0.17u l=0.17u
X8209 MOT23_P MOT23_N cml_tlatch_80.xmux.xp.S1 VSS sg13_lv_nmos ad=56.9f pd=0.74u as=56.9f ps=0.74u w=0.17u l=0.17u
X8210 cml_tlatch_60.xmux.xn.S1 CKA2_N cml_tlatch_60.xtail.S1 VSS sg13_lv_nmos ad=89.3f pd=0.85u as=89.3f ps=0.85u w=0.47u l=0.16u
X8211 cml_tlatch_56.xtail.S1 POLN VSS VSS sg13_lv_nmos ad=1.5637p pd=8.61u as=2.7982p ps=17.14u w=8.23u l=0.13u
X8212 cml_tlatch_75.xmux.xp.S1 MOT31_N MOT31_P VSS sg13_lv_nmos ad=56.9f pd=0.74u as=56.9f ps=0.74u w=0.17u l=0.17u
X8213 cml_tlatch_22.xmux.xp.S1 cml_tlatch_22.OUTN cml_tlatch_22.OUTP VSS sg13_lv_nmos ad=56.9f pd=0.74u as=56.9f ps=0.74u w=0.17u l=0.17u
X8214 cml_tlatch_86.xtail.S1 POLN VSS VSS sg13_lv_nmos ad=1.5637p pd=8.61u as=1.5637p ps=8.61u w=8.23u l=0.13u
X8215 cml_tlatch_66.xmux.xn.S1 cml_tlatch_67.OUTN cml_tlatch_73.INP VSS sg13_lv_nmos ad=63.19999f pd=0.74u as=0.1082p ps=1.34u w=0.26u l=0.38u
X8216 cml_tlatch_44.xtail.S1 CKHA3_N cml_tlatch_44.xmux.xp.S1 VSS sg13_lv_nmos ad=89.3f pd=0.85u as=89.3f ps=0.85u w=0.47u l=0.16u
X8217 cml_tlatch_97.xmux.xp.S1 cml_tlatch_24.INP cml_tlatch_24.INN VSS sg13_lv_nmos ad=56.9f pd=0.74u as=56.9f ps=0.74u w=0.17u l=0.17u
X8218 cml_tlatch_5.INN cml_tlatch_5.INP cml_tlatch_96.xmux.xp.S1 VSS sg13_lv_nmos ad=56.9f pd=0.74u as=56.9f ps=0.74u w=0.17u l=0.17u
X8219 cml_tlatch_49.xmux.xp.S1 CKB3_N cml_tlatch_49.xtail.S1 VSS sg13_lv_nmos ad=89.3f pd=0.85u as=89.3f ps=0.85u w=0.47u l=0.16u
X8220 cml_tlatch_52.xtail.S1 CKHA2_N cml_tlatch_52.xmux.xp.S1 VSS sg13_lv_nmos ad=89.3f pd=0.85u as=89.3f ps=0.85u w=0.47u l=0.16u
X8221 cml_tlatch_92.xtail.S1 CKJ_P cml_tlatch_92.xmux.xp.S1 VSS sg13_lv_nmos ad=89.3f pd=0.85u as=89.3f ps=0.85u w=0.47u l=0.16u
X8222 cml_drv_1.xrtail.R1 ENA_N ENA1_P VSS sg13_lv_nmos ad=56.2f pd=0.74u as=56.2f ps=0.74u w=0.16u l=0.19u
X8223 cml_tlatch_71.OUTN cml_tlatch_71.OUTP cml_tlatch_71.xmux.xp.S1 VSS sg13_lv_nmos ad=56.9f pd=0.74u as=56.9f ps=0.74u w=0.17u l=0.17u
X8224 cml_tlatch_11.xtail.S1 CKB1_N cml_tlatch_11.xmux.xp.S1 VSS sg13_lv_nmos ad=0.1598p pd=1.62u as=89.3f ps=0.85u w=0.47u l=0.16u
X8225 cml_tlatch_69.xmux.xp.S1 cml_tlatch_69.OUTP cml_tlatch_69.OUTN VSS sg13_lv_nmos ad=56.9f pd=0.74u as=56.9f ps=0.74u w=0.17u l=0.17u
X8226 VSS POLN cml_tlatch_8.xtail.S1 VSS sg13_lv_nmos ad=2.7982p pd=17.14u as=1.5637p ps=8.61u w=8.23u l=0.13u
X8227 MOT25_N B3_8_P cml_tlatch_72.xmux.xn.S1 VSS sg13_lv_nmos ad=63.19999f pd=0.74u as=63.19999f ps=0.74u w=0.26u l=0.38u
X8228 cml_tlatch_17.xmux.xn.S1 CKHB0_P cml_tlatch_17.xtail.S1 VSS sg13_lv_nmos ad=89.3f pd=0.85u as=89.3f ps=0.85u w=0.47u l=0.16u
X8229 cml_tlatch_37.xtail.S1 CKB1_N cml_tlatch_37.xmux.xp.S1 VSS sg13_lv_nmos ad=89.3f pd=0.85u as=89.3f ps=0.85u w=0.47u l=0.16u
X8230 cml_drvb_3.xrtail.R2 GA0_P CKHA0_N VSS sg13_lv_nmos ad=0.1463p pd=1.15u as=0.2618p ps=2.22u w=0.77u l=0.21u
X8231 cml_tlatch_22.xmux.xp.S1 cml_tlatch_22.OUTN cml_tlatch_22.OUTP VSS sg13_lv_nmos ad=56.9f pd=0.74u as=56.9f ps=0.74u w=0.17u l=0.17u
X8232 CKB0_P hs_to_clk_1.sg13_lv_nmos_2HGZLP_0.G VSS rppd l=4.25u w=1u
X8233 MOT17_P B2_8_N cml_tlatch_77.xmux.xn.S1 VSS sg13_lv_nmos ad=63.19999f pd=0.74u as=63.19999f ps=0.74u w=0.26u l=0.38u
X8234 cml_tlatch_85.xmux.xp.S1 A2_8_N A2_8_P VSS sg13_lv_nmos ad=56.9f pd=0.74u as=56.9f ps=0.74u w=0.17u l=0.17u
X8235 cml_tlatch_94.xmux.xn.S1 J1_N J2_P VSS sg13_lv_nmos ad=63.19999f pd=0.74u as=63.19999f ps=0.74u w=0.26u l=0.38u
X8236 cml_tlatch_43.xmux.xn.S1 cml_tlatch_43.INN MOT10_P VSS sg13_lv_nmos ad=63.19999f pd=0.74u as=63.19999f ps=0.74u w=0.26u l=0.38u
X8237 cml_tlatch_36.xmux.xp.S1 B1_2_P B1_2_N VSS sg13_lv_nmos ad=0.1019p pd=1.34u as=56.9f ps=0.74u w=0.17u l=0.17u
X8238 cml_tlatch_65.OUTP cml_tlatch_73.INN cml_tlatch_65.xmux.xn.S1 VSS sg13_lv_nmos ad=63.19999f pd=0.74u as=63.19999f ps=0.74u w=0.26u l=0.38u
X8239 CKHA3_P GA3_N cml_drvb_4.xrtail.R2 VSS sg13_lv_nmos ad=0.2618p pd=2.22u as=0.1463p ps=1.15u w=0.77u l=0.21u
X8240 ENA_P J1_N cml_gate2_9.xamp.xn.S1 VSS sg13_lv_nmos ad=0.1007p pd=0.91u as=0.1007p ps=0.91u w=0.53u l=0.13u
X8241 cml_tlatch_25.xtail.S1 CKHA1_P cml_tlatch_25.xmux.xn.S1 VSS sg13_lv_nmos ad=89.3f pd=0.85u as=89.3f ps=0.85u w=0.47u l=0.16u
X8242 cml_tlatch_96.xmux.xn.S1 stub_bi_29.BOTP cml_tlatch_5.INP VSS sg13_lv_nmos ad=63.19999f pd=0.74u as=0.1082p ps=1.34u w=0.26u l=0.38u
X8243 cml_tlatch_48.xmux.xn.S1 D2_N stub_bi_43.BOTN VSS sg13_lv_nmos ad=63.19999f pd=0.74u as=63.19999f ps=0.74u w=0.26u l=0.38u
X8244 cml_tlatch_38.xmux.xn.S1 D0_P cml_tlatch_38.OUTN VSS sg13_lv_nmos ad=63.19999f pd=0.74u as=63.19999f ps=0.74u w=0.26u l=0.38u
X8245 MOT6_P MOT6_N cml_tlatch_29.xmux.xp.S1 VSS sg13_lv_nmos ad=56.9f pd=0.74u as=56.9f ps=0.74u w=0.17u l=0.17u
X8246 MOT0_N MOT0_P cml_tlatch_26.xmux.xp.S1 VSS sg13_lv_nmos ad=56.9f pd=0.74u as=0.1019p ps=1.34u w=0.17u l=0.17u
X8247 cml_tlatch_92.xmux.xp.S1 J4_P J4_N VSS sg13_lv_nmos ad=56.9f pd=0.74u as=56.9f ps=0.74u w=0.17u l=0.17u
X8248 MOT9_P MOT9_N cml_tlatch_3.xmux.xp.S1 VSS sg13_lv_nmos ad=56.9f pd=0.74u as=56.9f ps=0.74u w=0.17u l=0.17u
X8249 cml_tlatch_94.xtail.S1 CKJ_N cml_tlatch_94.xmux.xn.S1 VSS sg13_lv_nmos ad=89.3f pd=0.85u as=89.3f ps=0.85u w=0.47u l=0.16u
X8250 B1_2_P B1_2_N cml_tlatch_36.xmux.xp.S1 VSS sg13_lv_nmos ad=56.9f pd=0.74u as=56.9f ps=0.74u w=0.17u l=0.17u
X8251 cml_tlatch_8.OUTP cml_tlatch_8.OUTN cml_tlatch_8.xmux.xp.S1 VSS sg13_lv_nmos ad=56.9f pd=0.74u as=56.9f ps=0.74u w=0.17u l=0.17u
X8252 cml_tlatch_18.xmux.xp.S1 cml_tlatch_18.OUTN cml_tlatch_18.OUTP VSS sg13_lv_nmos ad=56.9f pd=0.74u as=56.9f ps=0.74u w=0.17u l=0.17u
X8253 cml_tlatch_54.xmux.xp.S1 MOT20_P MOT20_N VSS sg13_lv_nmos ad=56.9f pd=0.74u as=56.9f ps=0.74u w=0.17u l=0.17u
X8254 VSS POLN cml_tlatch_34.xtail.S1 VSS sg13_lv_nmos ad=1.5637p pd=8.61u as=1.5637p ps=8.61u w=8.23u l=0.13u
X8255 cml_tlatch_20.xmux.xn.S1 CKA1_P cml_tlatch_20.xtail.S1 VSS sg13_lv_nmos ad=89.3f pd=0.85u as=89.3f ps=0.85u w=0.47u l=0.16u
X8256 cml_tlatch_63.INP cml_tlatch_63.INN cml_tlatch_70.xmux.xp.S1 VSS sg13_lv_nmos ad=56.9f pd=0.74u as=56.9f ps=0.74u w=0.17u l=0.17u
X8257 cml_tlatch_75.xtail.S1 CKHB3_N cml_tlatch_75.xmux.xp.S1 VSS sg13_lv_nmos ad=0.1598p pd=1.62u as=89.3f ps=0.85u w=0.47u l=0.16u
X8258 cml_tlatch_7.OUTP cml_tlatch_7.OUTN cml_tlatch_7.xmux.xp.S1 VSS sg13_lv_nmos ad=56.9f pd=0.74u as=56.9f ps=0.74u w=0.17u l=0.17u
X8259 stub_bi_17.BOTN cml_tlatch_5.INN cml_tlatch_13.xmux.xn.S1 VSS sg13_lv_nmos ad=63.19999f pd=0.74u as=63.19999f ps=0.74u w=0.26u l=0.38u
X8260 MOT26_N MOT26_P cml_tlatch_63.xmux.xp.S1 VSS sg13_lv_nmos ad=56.9f pd=0.74u as=56.9f ps=0.74u w=0.17u l=0.17u
X8261 cml_tlatch_9.xmux.xp.S1 A0_8_N A0_8_P VSS sg13_lv_nmos ad=56.9f pd=0.74u as=56.9f ps=0.74u w=0.17u l=0.17u
X8262 cml_tlatch_7.xmux.xp.S1 CKB0_P cml_tlatch_7.xtail.S1 VSS sg13_lv_nmos ad=89.3f pd=0.85u as=89.3f ps=0.85u w=0.47u l=0.16u
X8263 cml_tlatch_86.xmux.xn.S1 CKA2_P cml_tlatch_86.xtail.S1 VSS sg13_lv_nmos ad=0.1598p pd=1.62u as=89.3f ps=0.85u w=0.47u l=0.16u
X8264 cml_tlatch_69.xmux.xp.S1 cml_tlatch_69.OUTP cml_tlatch_69.OUTN VSS sg13_lv_nmos ad=56.9f pd=0.74u as=56.9f ps=0.74u w=0.17u l=0.17u
X8265 cml_tlatch_7.xmux.xn.S1 CKB0_N cml_tlatch_7.xtail.S1 VSS sg13_lv_nmos ad=89.3f pd=0.85u as=89.3f ps=0.85u w=0.47u l=0.16u
X8266 cml_tlatch_59.xmux.xp.S1 cml_tlatch_91.INP cml_tlatch_91.INN VSS sg13_lv_nmos ad=56.9f pd=0.74u as=56.9f ps=0.74u w=0.17u l=0.17u
X8267 cml_tlatch_58.xtail.S1 CKA3_N cml_tlatch_58.xmux.xp.S1 VSS sg13_lv_nmos ad=89.3f pd=0.85u as=89.3f ps=0.85u w=0.47u l=0.16u
X8268 cml_tlatch_43.xmux.xp.S1 MOT10_P MOT10_N VSS sg13_lv_nmos ad=56.9f pd=0.74u as=56.9f ps=0.74u w=0.17u l=0.17u
X8269 cml_gate2_7.xamp.xn.S1 CKA2_P cml_gate2_7.xrtail.R1 VSS sg13_lv_nmos ad=0.1802p pd=1.74u as=0.1007p ps=0.91u w=0.53u l=0.13u
X8270 cml_tlatch_95.xmux.xp.S1 CKJ_N cml_tlatch_95.xtail.S1 VSS sg13_lv_nmos ad=89.3f pd=0.85u as=89.3f ps=0.85u w=0.47u l=0.16u
X8271 cml_tlatch_5.xmux.xn.S1 CKHB1_P cml_tlatch_5.xtail.S1 VSS sg13_lv_nmos ad=89.3f pd=0.85u as=89.3f ps=0.85u w=0.47u l=0.16u
X8272 VSS POLN cml_tlatch_40.xtail.S1 VSS sg13_lv_nmos ad=1.5637p pd=8.61u as=1.5637p ps=8.61u w=8.23u l=0.13u
X8273 cml_tlatch_69.OUTP cml_tlatch_69.OUTN cml_tlatch_69.xmux.xp.S1 VSS sg13_lv_nmos ad=56.9f pd=0.74u as=56.9f ps=0.74u w=0.17u l=0.17u
X8274 cml_tlatch_6.xtail.S1 CKHB1_N cml_tlatch_6.xmux.xp.S1 VSS sg13_lv_nmos ad=89.3f pd=0.85u as=89.3f ps=0.85u w=0.47u l=0.16u
X8275 cml_tlatch_35.xtail.S1 CKB1_N cml_tlatch_35.xmux.xp.S1 VSS sg13_lv_nmos ad=89.3f pd=0.85u as=89.3f ps=0.85u w=0.47u l=0.16u
X8276 cml_tlatch_70.xtail.S1 CKA3_N cml_tlatch_70.xmux.xn.S1 VSS sg13_lv_nmos ad=89.3f pd=0.85u as=89.3f ps=0.85u w=0.47u l=0.16u
X8277 VSS POLN hs_to_clk_8.D2 VSS sg13_lv_nmos ad=1.9p pd=10.38u as=3.4p ps=20.68u w=10u l=0.13u
X8278 VSS hs_to_clk_3.sg13_lv_nmos_2HGZLP_0.G VSS VSS sg13_lv_nmos ad=2.071p pd=11.28u as=0 ps=0 w=10.9u l=1.38u
X8279 A3_2_N cml_tlatch_58.OUTP cml_tlatch_57.xmux.xn.S1 VSS sg13_lv_nmos ad=0.1082p pd=1.34u as=63.19999f ps=0.74u w=0.26u l=0.38u
X8280 MOT23_P B2_2_N cml_tlatch_80.xmux.xn.S1 VSS sg13_lv_nmos ad=0.1082p pd=1.34u as=63.19999f ps=0.74u w=0.26u l=0.38u
X8281 CLK_W_N J2_N cml_tlatch_93.xmux.xn.S1 VSS sg13_lv_nmos ad=63.19999f pd=0.74u as=63.19999f ps=0.74u w=0.26u l=0.38u
X8282 cml_tlatch_32.OUTP cml_tlatch_32.OUTN cml_tlatch_32.xmux.xp.S1 VSS sg13_lv_nmos ad=56.9f pd=0.74u as=56.9f ps=0.74u w=0.17u l=0.17u
X8283 VSS hs_to_clk_5.sg13_lv_nmos_2HGZLP_0.G VSS VSS sg13_lv_nmos ad=2.071p pd=11.28u as=0 ps=0 w=10.9u l=1.38u
X8284 cml_tlatch_58.OUTP D3_N cml_tlatch_58.xmux.xn.S1 VSS sg13_lv_nmos ad=63.19999f pd=0.74u as=63.19999f ps=0.74u w=0.26u l=0.38u
X8285 cml_tlatch_24.INP cml_tlatch_24.INN cml_tlatch_97.xmux.xp.S1 VSS sg13_lv_nmos ad=56.9f pd=0.74u as=56.9f ps=0.74u w=0.17u l=0.17u
X8286 cml_tlatch_98.xmux.xp.S1 cml_tlatch_98.OUTP cml_tlatch_98.OUTN VSS sg13_lv_nmos ad=56.9f pd=0.74u as=56.9f ps=0.74u w=0.17u l=0.17u
X8287 cml_tlatch_96.xmux.xp.S1 cml_tlatch_5.INN cml_tlatch_5.INP VSS sg13_lv_nmos ad=56.9f pd=0.74u as=56.9f ps=0.74u w=0.17u l=0.17u
X8288 cml_tlatch_97.INN A1_2_P cml_tlatch_39.xmux.xn.S1 VSS sg13_lv_nmos ad=0.1082p pd=1.34u as=63.19999f ps=0.74u w=0.26u l=0.38u
X8289 cml_tlatch_14.xmux.xp.S1 MOT1_P MOT1_N VSS sg13_lv_nmos ad=56.9f pd=0.74u as=56.9f ps=0.74u w=0.17u l=0.17u
X8290 VSS hs_to_clk_2.sg13_lv_nmos_2HGZLP_0.G VSS VSS sg13_lv_nmos ad=2.071p pd=11.28u as=0 ps=0 w=10.9u l=1.38u
X8291 cml_tlatch_14.xmux.xn.S1 CKHB0_P cml_tlatch_14.xtail.S1 VSS sg13_lv_nmos ad=89.3f pd=0.85u as=89.3f ps=0.85u w=0.47u l=0.16u
X8292 ENB_P NS1_N cml_gate2_8.xrtail.R1 VSS sg13_lv_nmos ad=0.1007p pd=0.91u as=0.1007p ps=0.91u w=0.53u l=0.13u
X8293 cml_gate2_9.xamp.xn.S1 J1_P ENA_N VSS sg13_lv_nmos ad=0.1007p pd=0.91u as=0.1802p ps=1.74u w=0.53u l=0.13u
X8294 cml_tlatch_39.xmux.xn.S1 CKA1_P cml_tlatch_39.xtail.S1 VSS sg13_lv_nmos ad=89.3f pd=0.85u as=0.1598p ps=1.62u w=0.47u l=0.16u
X8295 cml_tlatch_84.xmux.xn.S1 stub_bi_55.BOTN stub_bi_49.BOTP VSS sg13_lv_nmos ad=63.19999f pd=0.74u as=63.19999f ps=0.74u w=0.26u l=0.38u
X8296 cml_tlatch_99.xtail.S1 CKA0_N cml_tlatch_99.xmux.xn.S1 VSS sg13_lv_nmos ad=89.3f pd=0.85u as=89.3f ps=0.85u w=0.47u l=0.16u
X8297 MOT4_P MOT4_N cml_tlatch_28.xmux.xp.S1 VSS sg13_lv_nmos ad=56.9f pd=0.74u as=56.9f ps=0.74u w=0.17u l=0.17u
X8298 cml_tlatch_63.xtail.S1 CKHA3_P cml_tlatch_63.xmux.xn.S1 VSS sg13_lv_nmos ad=89.3f pd=0.85u as=89.3f ps=0.85u w=0.47u l=0.16u
X8299 MOT21_N MOT21_P cml_tlatch_79.xmux.xp.S1 VSS sg13_lv_nmos ad=56.9f pd=0.74u as=56.9f ps=0.74u w=0.17u l=0.17u
X8300 cml_tlatch_23.OUTP cml_tlatch_0.OUTN cml_tlatch_23.xmux.xn.S1 VSS sg13_lv_nmos ad=63.19999f pd=0.74u as=63.19999f ps=0.74u w=0.26u l=0.38u
X8301 cml_tlatch_20.xmux.xp.S1 cml_tlatch_20.OUTN cml_tlatch_20.OUTP VSS sg13_lv_nmos ad=56.9f pd=0.74u as=56.9f ps=0.74u w=0.17u l=0.17u
X8302 J1_P J1_N cml_tlatch_95.xmux.xp.S1 VSS sg13_lv_nmos ad=56.9f pd=0.74u as=56.9f ps=0.74u w=0.17u l=0.17u
X8303 cml_tlatch_70.xmux.xp.S1 cml_tlatch_63.INP cml_tlatch_63.INN VSS sg13_lv_nmos ad=56.9f pd=0.74u as=56.9f ps=0.74u w=0.17u l=0.17u
X8304 cml_gate2_4.xamp.xn.S1 ENA1_P GA3_N VSS sg13_lv_nmos ad=0.1007p pd=0.91u as=0.1007p ps=0.91u w=0.53u l=0.13u
X8305 cml_tlatch_44.xmux.xp.S1 MOT28_P MOT28_N VSS sg13_lv_nmos ad=56.9f pd=0.74u as=56.9f ps=0.74u w=0.17u l=0.17u
X8306 cml_tlatch_60.xmux.xp.S1 A2_2_N A2_2_P VSS sg13_lv_nmos ad=56.9f pd=0.74u as=56.9f ps=0.74u w=0.17u l=0.17u
X8307 MOT7_N MOT7_P cml_tlatch_17.xmux.xp.S1 VSS sg13_lv_nmos ad=56.9f pd=0.74u as=56.9f ps=0.74u w=0.17u l=0.17u
X8308 cml_tlatch_76.xtail.S1 CKA2_P cml_tlatch_76.xmux.xn.S1 VSS sg13_lv_nmos ad=89.3f pd=0.85u as=89.3f ps=0.85u w=0.47u l=0.16u
X8309 cml_tlatch_55.xmux.xn.S1 CKHA2_P cml_tlatch_55.xtail.S1 VSS sg13_lv_nmos ad=89.3f pd=0.85u as=89.3f ps=0.85u w=0.47u l=0.16u
X8310 cml_tlatch_2.OUTP cml_tlatch_2.OUTN cml_tlatch_2.xmux.xp.S1 VSS sg13_lv_nmos ad=56.9f pd=0.74u as=56.9f ps=0.74u w=0.17u l=0.17u
X8311 MOT11_N MOT11_P cml_tlatch_4.xmux.xp.S1 VSS sg13_lv_nmos ad=56.9f pd=0.74u as=56.9f ps=0.74u w=0.17u l=0.17u
X8312 cml_tlatch_11.xmux.xp.S1 stub_bi_15.BOTN stub_bi_15.BOTP VSS sg13_lv_nmos ad=56.9f pd=0.74u as=56.9f ps=0.74u w=0.17u l=0.17u
X8313 cml_tlatch_12.xmux.xp.S1 cml_tlatch_4.INP cml_tlatch_4.INN VSS sg13_lv_nmos ad=56.9f pd=0.74u as=56.9f ps=0.74u w=0.17u l=0.17u
X8314 cml_tlatch_94.xmux.xp.S1 J2_N J2_P VSS sg13_lv_nmos ad=56.9f pd=0.74u as=56.9f ps=0.74u w=0.17u l=0.17u
X8315 cml_tlatch_72.xtail.S1 CKHB3_N cml_tlatch_72.xmux.xp.S1 VSS sg13_lv_nmos ad=0.1598p pd=1.62u as=89.3f ps=0.85u w=0.47u l=0.16u
X8316 B0_8_P cml_tlatch_2.OUTN cml_tlatch_1.xmux.xn.S1 VSS sg13_lv_nmos ad=63.19999f pd=0.74u as=63.19999f ps=0.74u w=0.26u l=0.38u
X8317 cml_tlatch_15.xtail.S1 CKHB0_N cml_tlatch_15.xmux.xp.S1 VSS sg13_lv_nmos ad=89.3f pd=0.85u as=89.3f ps=0.85u w=0.47u l=0.16u
X8318 cml_tlatch_39.xmux.xn.S1 A1_2_N cml_tlatch_97.INP VSS sg13_lv_nmos ad=63.19999f pd=0.74u as=63.19999f ps=0.74u w=0.26u l=0.38u
X8319 MOT26_N MOT26_P cml_tlatch_63.xmux.xp.S1 VSS sg13_lv_nmos ad=56.9f pd=0.74u as=0.1019p ps=1.34u w=0.17u l=0.17u
X8320 MOT0_N MOT0_P cml_tlatch_26.xmux.xp.S1 VSS sg13_lv_nmos ad=56.9f pd=0.74u as=56.9f ps=0.74u w=0.17u l=0.17u
X8321 B3_8_N B3_8_P cml_tlatch_64.xmux.xp.S1 VSS sg13_lv_nmos ad=56.9f pd=0.74u as=56.9f ps=0.74u w=0.17u l=0.17u
X8322 cml_tlatch_30.xmux.xp.S1 cml_tlatch_30.OUTP cml_tlatch_30.OUTN VSS sg13_lv_nmos ad=0.1019p pd=1.34u as=56.9f ps=0.74u w=0.17u l=0.17u
X8323 cml_tlatch_64.xtail.S1 CKB3_P cml_tlatch_64.xmux.xp.S1 VSS sg13_lv_nmos ad=89.3f pd=0.85u as=0.1598p ps=1.62u w=0.47u l=0.16u
X8324 cml_tlatch_84.xtail.S1 CKB2_P cml_tlatch_84.xmux.xn.S1 VSS sg13_lv_nmos ad=89.3f pd=0.85u as=89.3f ps=0.85u w=0.47u l=0.16u
X8325 cml_tlatch_18.xmux.xn.S1 CKA0_P cml_tlatch_18.xtail.S1 VSS sg13_lv_nmos ad=89.3f pd=0.85u as=89.3f ps=0.85u w=0.47u l=0.16u
X8326 cml_tlatch_58.OUTP cml_tlatch_58.OUTN cml_tlatch_58.xmux.xp.S1 VSS sg13_lv_nmos ad=56.9f pd=0.74u as=56.9f ps=0.74u w=0.17u l=0.17u
X8327 cml_tlatch_45.xmux.xn.S1 CKHA3_P cml_tlatch_45.xtail.S1 VSS sg13_lv_nmos ad=89.3f pd=0.85u as=89.3f ps=0.85u w=0.47u l=0.16u
X8328 cml_tlatch_55.xmux.xp.S1 MOT22_P MOT22_N VSS sg13_lv_nmos ad=56.9f pd=0.74u as=56.9f ps=0.74u w=0.17u l=0.17u
X8329 GB0_P ENB1_N cml_gate2_1.xamp.xn.S1 VSS sg13_lv_nmos ad=0.1007p pd=0.91u as=0.1007p ps=0.91u w=0.53u l=0.13u
X8330 cml_tlatch_10.xmux.xp.S1 B1_8_P B1_8_N VSS sg13_lv_nmos ad=56.9f pd=0.74u as=56.9f ps=0.74u w=0.17u l=0.17u
X8331 cml_tlatch_71.xtail.S1 CKA3_P cml_tlatch_71.xmux.xn.S1 VSS sg13_lv_nmos ad=89.3f pd=0.85u as=89.3f ps=0.85u w=0.47u l=0.16u
X8332 cml_tlatch_92.xmux.xp.S1 CKJ_P cml_tlatch_92.xtail.S1 VSS sg13_lv_nmos ad=89.3f pd=0.85u as=89.3f ps=0.85u w=0.47u l=0.16u
X8333 cml_tlatch_94.xmux.xp.S1 J2_P J2_N VSS sg13_lv_nmos ad=56.9f pd=0.74u as=56.9f ps=0.74u w=0.17u l=0.17u
X8334 cml_tlatch_81.xmux.xn.S1 CKB2_N cml_tlatch_81.xtail.S1 VSS sg13_lv_nmos ad=89.3f pd=0.85u as=89.3f ps=0.85u w=0.47u l=0.16u
X8335 cml_tlatch_6.xmux.xn.S1 B1_2_P MOT15_N VSS sg13_lv_nmos ad=63.19999f pd=0.74u as=63.19999f ps=0.74u w=0.26u l=0.38u
X8336 cml_tlatch_94.xmux.xp.S1 J2_N J2_P VSS sg13_lv_nmos ad=0.1019p pd=1.34u as=56.9f ps=0.74u w=0.17u l=0.17u
X8337 stub_bi_49.BOTP stub_bi_49.BOTN cml_tlatch_84.xmux.xp.S1 VSS sg13_lv_nmos ad=56.9f pd=0.74u as=56.9f ps=0.74u w=0.17u l=0.17u
X8338 cml_tlatch_49.OUTP cml_tlatch_49.OUTN cml_tlatch_49.xmux.xp.S1 VSS sg13_lv_nmos ad=56.9f pd=0.74u as=56.9f ps=0.74u w=0.17u l=0.17u
X8339 cml_tlatch_3.xtail.S1 CKHB1_N cml_tlatch_3.xmux.xp.S1 VSS sg13_lv_nmos ad=89.3f pd=0.85u as=89.3f ps=0.85u w=0.47u l=0.16u
X8340 cml_gate2_0.xrtail.R1 CKA1_N GB1_P VSS sg13_lv_nmos ad=0.1007p pd=0.91u as=0.1007p ps=0.91u w=0.53u l=0.13u
X8341 cml_tlatch_17.xtail.S1 CKHB0_P cml_tlatch_17.xmux.xn.S1 VSS sg13_lv_nmos ad=89.3f pd=0.85u as=89.3f ps=0.85u w=0.47u l=0.16u
X8342 cml_tlatch_37.xmux.xp.S1 CKB1_N cml_tlatch_37.xtail.S1 VSS sg13_lv_nmos ad=89.3f pd=0.85u as=89.3f ps=0.85u w=0.47u l=0.16u
X8343 MOT31_N B3_2_P cml_tlatch_75.xmux.xn.S1 VSS sg13_lv_nmos ad=63.19999f pd=0.74u as=63.19999f ps=0.74u w=0.26u l=0.38u
X8344 VSS POLN cml_tlatch_17.xtail.S1 VSS sg13_lv_nmos ad=1.5637p pd=8.61u as=1.5637p ps=8.61u w=8.23u l=0.13u
X8345 cml_tlatch_89.xtail.S1 CKA3_P cml_tlatch_89.xmux.xp.S1 VSS sg13_lv_nmos ad=89.3f pd=0.85u as=89.3f ps=0.85u w=0.47u l=0.16u
X8346 cml_tlatch_35.xmux.xp.S1 stub_bi_29.BOTP stub_bi_29.BOTN VSS sg13_lv_nmos ad=56.9f pd=0.74u as=56.9f ps=0.74u w=0.17u l=0.17u
X8347 cml_tlatch_24.xmux.xn.S1 CKHA1_P cml_tlatch_24.xtail.S1 VSS sg13_lv_nmos ad=89.3f pd=0.85u as=89.3f ps=0.85u w=0.47u l=0.16u
X8348 cml_tlatch_62.xmux.xn.S1 A3_8_P MOT24_N VSS sg13_lv_nmos ad=63.19999f pd=0.74u as=0.1082p ps=1.34u w=0.26u l=0.38u
X8349 cml_tlatch_97.INN cml_tlatch_97.INP cml_tlatch_39.xmux.xp.S1 VSS sg13_lv_nmos ad=56.9f pd=0.74u as=56.9f ps=0.74u w=0.17u l=0.17u
X8350 cml_tlatch_41.xmux.xp.S1 cml_tlatch_41.OUTN cml_tlatch_41.OUTP VSS sg13_lv_nmos ad=56.9f pd=0.74u as=56.9f ps=0.74u w=0.17u l=0.17u
X8351 cml_tlatch_85.xtail.S1 CKA2_P cml_tlatch_85.xmux.xp.S1 VSS sg13_lv_nmos ad=89.3f pd=0.85u as=89.3f ps=0.85u w=0.47u l=0.16u
X8352 cml_tlatch_59.xtail.S1 CKA2_P cml_tlatch_59.xmux.xn.S1 VSS sg13_lv_nmos ad=89.3f pd=0.85u as=89.3f ps=0.85u w=0.47u l=0.16u
X8353 cml_tlatch_45.xmux.xp.S1 CKHA3_N cml_tlatch_45.xtail.S1 VSS sg13_lv_nmos ad=89.3f pd=0.85u as=89.3f ps=0.85u w=0.47u l=0.16u
X8354 cml_tlatch_23.xmux.xn.S1 CKA0_N cml_tlatch_23.xtail.S1 VSS sg13_lv_nmos ad=89.3f pd=0.85u as=0.1598p ps=1.62u w=0.47u l=0.16u
X8355 cml_tlatch_94.xmux.xn.S1 CKJ_N cml_tlatch_94.xtail.S1 VSS sg13_lv_nmos ad=89.3f pd=0.85u as=0.1598p ps=1.62u w=0.47u l=0.16u
X8356 cml_tlatch_91.xmux.xp.S1 cml_tlatch_91.OUTP cml_tlatch_91.OUTN VSS sg13_lv_nmos ad=56.9f pd=0.74u as=56.9f ps=0.74u w=0.17u l=0.17u
X8357 cml_tlatch_20.OUTN cml_tlatch_43.INP cml_tlatch_20.xmux.xn.S1 VSS sg13_lv_nmos ad=63.19999f pd=0.74u as=0.1082p ps=1.34u w=0.26u l=0.38u
X8358 cml_tlatch_32.OUTP cml_tlatch_32.OUTN cml_tlatch_32.xmux.xp.S1 VSS sg13_lv_nmos ad=56.9f pd=0.74u as=56.9f ps=0.74u w=0.17u l=0.17u
X8359 cml_tlatch_33.OUTP A0_2_N cml_tlatch_33.xmux.xn.S1 VSS sg13_lv_nmos ad=63.19999f pd=0.74u as=63.19999f ps=0.74u w=0.26u l=0.38u
X8360 A0_2_N A0_2_P cml_tlatch_34.xmux.xp.S1 VSS sg13_lv_nmos ad=56.9f pd=0.74u as=56.9f ps=0.74u w=0.17u l=0.17u
X8361 MOT19_P MOT19_N cml_tlatch_78.xmux.xp.S1 VSS sg13_lv_nmos ad=56.9f pd=0.74u as=56.9f ps=0.74u w=0.17u l=0.17u
X8362 cml_tlatch_5.xmux.xp.S1 MOT13_P MOT13_N VSS sg13_lv_nmos ad=56.9f pd=0.74u as=56.9f ps=0.74u w=0.17u l=0.17u
X8363 cml_tlatch_88.xtail.S1 CKB3_P cml_tlatch_88.xmux.xp.S1 VSS sg13_lv_nmos ad=0.1598p pd=1.62u as=89.3f ps=0.85u w=0.47u l=0.16u
X8364 cml_tlatch_96.xmux.xp.S1 cml_tlatch_5.INN cml_tlatch_5.INP VSS sg13_lv_nmos ad=56.9f pd=0.74u as=56.9f ps=0.74u w=0.17u l=0.17u
X8365 J1_P J1_N cml_tlatch_95.xmux.xp.S1 VSS sg13_lv_nmos ad=56.9f pd=0.74u as=56.9f ps=0.74u w=0.17u l=0.17u
X8366 J1_N J1_P cml_tlatch_95.xmux.xp.S1 VSS sg13_lv_nmos ad=56.9f pd=0.74u as=56.9f ps=0.74u w=0.17u l=0.17u
X8367 cml_tlatch_64.xmux.xn.S1 cml_tlatch_65.OUTP B3_8_N VSS sg13_lv_nmos ad=0.1082p pd=1.34u as=63.19999f ps=0.74u w=0.26u l=0.38u
X8368 cml_tlatch_73.xmux.xp.S1 MOT27_P MOT27_N VSS sg13_lv_nmos ad=56.9f pd=0.74u as=56.9f ps=0.74u w=0.17u l=0.17u
X8369 stub_bi_43.BOTP stub_bi_43.BOTN cml_tlatch_48.xmux.xp.S1 VSS sg13_lv_nmos ad=56.9f pd=0.74u as=56.9f ps=0.74u w=0.17u l=0.17u
X8370 J2_N J2_P cml_tlatch_94.xmux.xp.S1 VSS sg13_lv_nmos ad=56.9f pd=0.74u as=0.1019p ps=1.34u w=0.17u l=0.17u
X8371 cml_tlatch_14.xmux.xp.S1 MOT1_P MOT1_N VSS sg13_lv_nmos ad=56.9f pd=0.74u as=56.9f ps=0.74u w=0.17u l=0.17u
X8372 cml_tlatch_73.INP cml_tlatch_73.INN cml_tlatch_66.xmux.xp.S1 VSS sg13_lv_nmos ad=56.9f pd=0.74u as=56.9f ps=0.74u w=0.17u l=0.17u
X8373 cml_tlatch_80.xtail.S1 CKHB2_P cml_tlatch_80.xmux.xn.S1 VSS sg13_lv_nmos ad=89.3f pd=0.85u as=89.3f ps=0.85u w=0.47u l=0.16u
X8374 cml_tlatch_64.xmux.xn.S1 cml_tlatch_65.OUTP B3_8_N VSS sg13_lv_nmos ad=63.19999f pd=0.74u as=63.19999f ps=0.74u w=0.26u l=0.38u
X8375 cml_tlatch_66.xtail.S1 CKB3_P cml_tlatch_66.xmux.xp.S1 VSS sg13_lv_nmos ad=89.3f pd=0.85u as=89.3f ps=0.85u w=0.47u l=0.16u
X8376 cml_tlatch_68.xmux.xp.S1 A3_8_N A3_8_P VSS sg13_lv_nmos ad=0.1019p pd=1.34u as=56.9f ps=0.74u w=0.17u l=0.17u
X8377 cml_tlatch_19.xmux.xn.S1 cml_tlatch_20.OUTP A1_8_N VSS sg13_lv_nmos ad=63.19999f pd=0.74u as=63.19999f ps=0.74u w=0.26u l=0.38u
X8378 cml_tlatch_86.OUTN cml_tlatch_86.OUTP cml_tlatch_86.xmux.xp.S1 VSS sg13_lv_nmos ad=56.9f pd=0.74u as=56.9f ps=0.74u w=0.17u l=0.17u
X8379 cml_tlatch_30.xmux.xp.S1 CKB0_N cml_tlatch_30.xtail.S1 VSS sg13_lv_nmos ad=89.3f pd=0.85u as=89.3f ps=0.85u w=0.47u l=0.16u
X8380 cml_tlatch_22.xtail.S1 CKA1_N cml_tlatch_22.xmux.xp.S1 VSS sg13_lv_nmos ad=89.3f pd=0.85u as=89.3f ps=0.85u w=0.47u l=0.16u
X8381 cml_tlatch_74.INN cml_tlatch_49.OUTP cml_tlatch_88.xmux.xn.S1 VSS sg13_lv_nmos ad=63.19999f pd=0.74u as=63.19999f ps=0.74u w=0.26u l=0.38u
X8382 cml_tlatch_73.INN cml_tlatch_73.INP cml_tlatch_66.xmux.xp.S1 VSS sg13_lv_nmos ad=56.9f pd=0.74u as=56.9f ps=0.74u w=0.17u l=0.17u
X8383 cml_tlatch_11.xtail.S1 CKB1_N cml_tlatch_11.xmux.xp.S1 VSS sg13_lv_nmos ad=89.3f pd=0.85u as=89.3f ps=0.85u w=0.47u l=0.16u
X8384 cml_tlatch_60.xmux.xp.S1 A2_2_N A2_2_P VSS sg13_lv_nmos ad=56.9f pd=0.74u as=56.9f ps=0.74u w=0.17u l=0.17u
X8385 VSS hs_to_clk_0.sg13_lv_nmos_2HGZLP_0.G VSS VSS sg13_lv_nmos ad=2.071p pd=11.28u as=0 ps=0 w=10.9u l=1.38u
X8386 cml_tlatch_47.xmux.xn.S1 CKB2_N cml_tlatch_47.xtail.S1 VSS sg13_lv_nmos ad=89.3f pd=0.85u as=89.3f ps=0.85u w=0.47u l=0.16u
X8387 B2_2_P B2_2_N cml_tlatch_47.xmux.xp.S1 VSS sg13_lv_nmos ad=56.9f pd=0.74u as=56.9f ps=0.74u w=0.17u l=0.17u
X8388 VDD cml_tlatch_0.OUTN VSS rppd l=5.17u w=1u
X8389 cml_tlatch_15.xmux.xp.S1 MOT3_N MOT3_P VSS sg13_lv_nmos ad=56.9f pd=0.74u as=56.9f ps=0.74u w=0.17u l=0.17u
X8390 cml_tlatch_26.xmux.xp.S1 MOT0_N MOT0_P VSS sg13_lv_nmos ad=56.9f pd=0.74u as=56.9f ps=0.74u w=0.17u l=0.17u
X8391 GA3_P ENA1_N cml_gate2_4.xamp.xn.S1 VSS sg13_lv_nmos ad=0.1007p pd=0.91u as=0.1007p ps=0.91u w=0.53u l=0.13u
X8392 cml_tlatch_12.xmux.xn.S1 stub_bi_17.BOTN cml_tlatch_4.INN VSS sg13_lv_nmos ad=0.1082p pd=1.34u as=63.19999f ps=0.74u w=0.26u l=0.38u
X8393 cml_tlatch_44.INP cml_tlatch_56.OUTN cml_tlatch_89.xmux.xn.S1 VSS sg13_lv_nmos ad=0.1082p pd=1.34u as=63.19999f ps=0.74u w=0.26u l=0.38u
X8394 cml_tlatch_53.xmux.xp.S1 MOT18_N MOT18_P VSS sg13_lv_nmos ad=56.9f pd=0.74u as=56.9f ps=0.74u w=0.17u l=0.17u
X8395 cml_tlatch_2.xmux.xp.S1 cml_tlatch_2.OUTP cml_tlatch_2.OUTN VSS sg13_lv_nmos ad=56.9f pd=0.74u as=56.9f ps=0.74u w=0.17u l=0.17u
X8396 cml_tlatch_12.xmux.xp.S1 cml_tlatch_4.INP cml_tlatch_4.INN VSS sg13_lv_nmos ad=56.9f pd=0.74u as=56.9f ps=0.74u w=0.17u l=0.17u
X8397 J4_P CLK_W_P cml_tlatch_92.xmux.xn.S1 VSS sg13_lv_nmos ad=63.19999f pd=0.74u as=63.19999f ps=0.74u w=0.26u l=0.38u
X8398 cml_tlatch_62.xtail.S1 CKHA3_N cml_tlatch_62.xmux.xp.S1 VSS sg13_lv_nmos ad=89.3f pd=0.85u as=89.3f ps=0.85u w=0.47u l=0.16u
X8399 cml_drvb_1.xrtail.R2 GB0_P CKHB0_N VSS sg13_lv_nmos ad=0.1463p pd=1.15u as=0.2618p ps=2.22u w=0.77u l=0.21u
X8400 cml_tlatch_43.xtail.S1 CKHA1_N cml_tlatch_43.xmux.xp.S1 VSS sg13_lv_nmos ad=89.3f pd=0.85u as=0.1598p ps=1.62u w=0.47u l=0.16u
X8401 cml_tlatch_14.xtail.S1 CKHB0_P cml_tlatch_14.xmux.xn.S1 VSS sg13_lv_nmos ad=89.3f pd=0.85u as=89.3f ps=0.85u w=0.47u l=0.16u
X8402 cml_tlatch_87.INP cml_tlatch_87.INN cml_tlatch_76.xmux.xp.S1 VSS sg13_lv_nmos ad=56.9f pd=0.74u as=56.9f ps=0.74u w=0.17u l=0.17u
X8403 cml_tlatch_56.xmux.xp.S1 cml_tlatch_56.OUTP cml_tlatch_56.OUTN VSS sg13_lv_nmos ad=56.9f pd=0.74u as=56.9f ps=0.74u w=0.17u l=0.17u
X8404 cml_tlatch_84.xmux.xp.S1 stub_bi_49.BOTP stub_bi_49.BOTN VSS sg13_lv_nmos ad=56.9f pd=0.74u as=56.9f ps=0.74u w=0.17u l=0.17u
X8405 cml_tlatch_32.OUTP VDD VSS rppd l=5.17u w=1u
X8406 cml_tlatch_64.xmux.xp.S1 B3_8_N B3_8_P VSS sg13_lv_nmos ad=56.9f pd=0.74u as=56.9f ps=0.74u w=0.17u l=0.17u
X8407 cml_tlatch_6.xtail.S1 CKHB1_P cml_tlatch_6.xmux.xn.S1 VSS sg13_lv_nmos ad=89.3f pd=0.85u as=89.3f ps=0.85u w=0.47u l=0.16u
X8408 cml_tlatch_79.xmux.xp.S1 MOT21_N MOT21_P VSS sg13_lv_nmos ad=56.9f pd=0.74u as=56.9f ps=0.74u w=0.17u l=0.17u
X8409 cml_tlatch_90.xmux.xp.S1 stub_bi_55.BOTN stub_bi_55.BOTP VSS sg13_lv_nmos ad=56.9f pd=0.74u as=56.9f ps=0.74u w=0.17u l=0.17u
X8410 MOT7_P MOT7_N cml_tlatch_17.xmux.xp.S1 VSS sg13_lv_nmos ad=56.9f pd=0.74u as=56.9f ps=0.74u w=0.17u l=0.17u
X8411 cml_tlatch_44.xtail.S1 POLN VSS VSS sg13_lv_nmos ad=1.5637p pd=8.61u as=2.7982p ps=17.14u w=8.23u l=0.13u
X8412 B0_8_N cml_tlatch_2.OUTP cml_tlatch_1.xmux.xn.S1 VSS sg13_lv_nmos ad=63.19999f pd=0.74u as=63.19999f ps=0.74u w=0.26u l=0.38u
X8413 cml_tlatch_32.OUTN cml_tlatch_32.OUTP cml_tlatch_32.xmux.xp.S1 VSS sg13_lv_nmos ad=56.9f pd=0.74u as=56.9f ps=0.74u w=0.17u l=0.17u
X8414 MOT2_N cml_tlatch_23.OUTP cml_tlatch_27.xmux.xn.S1 VSS sg13_lv_nmos ad=63.19999f pd=0.74u as=0.1082p ps=1.34u w=0.26u l=0.38u
X8415 cml_tlatch_37.xmux.xn.S1 CKB1_P cml_tlatch_37.xtail.S1 VSS sg13_lv_nmos ad=89.3f pd=0.85u as=89.3f ps=0.85u w=0.47u l=0.16u
X8416 cml_tlatch_61.xmux.xn.S1 CKA2_P cml_tlatch_61.xtail.S1 VSS sg13_lv_nmos ad=89.3f pd=0.85u as=89.3f ps=0.85u w=0.47u l=0.16u
X8417 cml_tlatch_86.OUTP cml_tlatch_87.OUTN cml_tlatch_86.xmux.xn.S1 VSS sg13_lv_nmos ad=63.19999f pd=0.74u as=0.1082p ps=1.34u w=0.26u l=0.38u
X8418 cml_tlatch_50.xmux.xp.S1 CKB3_P cml_tlatch_50.xtail.S1 VSS sg13_lv_nmos ad=89.3f pd=0.85u as=89.3f ps=0.85u w=0.47u l=0.16u
X8419 cml_tlatch_69.xtail.S1 CKA3_N cml_tlatch_69.xmux.xp.S1 VSS sg13_lv_nmos ad=89.3f pd=0.85u as=89.3f ps=0.85u w=0.47u l=0.16u
X8420 cml_tlatch_7.xmux.xn.S1 CKB0_N cml_tlatch_7.xtail.S1 VSS sg13_lv_nmos ad=89.3f pd=0.85u as=89.3f ps=0.85u w=0.47u l=0.16u
X8421 cml_tlatch_91.OUTP cml_tlatch_91.OUTN cml_tlatch_91.xmux.xp.S1 VSS sg13_lv_nmos ad=56.9f pd=0.74u as=56.9f ps=0.74u w=0.17u l=0.17u
X8422 stub_bi_49.BOTN stub_bi_55.BOTP cml_tlatch_84.xmux.xn.S1 VSS sg13_lv_nmos ad=63.19999f pd=0.74u as=63.19999f ps=0.74u w=0.26u l=0.38u
X8423 MOT25_N MOT25_P cml_tlatch_72.xmux.xp.S1 VSS sg13_lv_nmos ad=56.9f pd=0.74u as=56.9f ps=0.74u w=0.17u l=0.17u
X8424 cml_tlatch_31.xmux.xp.S1 B0_2_N B0_2_P VSS sg13_lv_nmos ad=56.9f pd=0.74u as=56.9f ps=0.74u w=0.17u l=0.17u
X8425 cml_tlatch_22.xtail.S1 CKA1_N cml_tlatch_22.xmux.xp.S1 VSS sg13_lv_nmos ad=89.3f pd=0.85u as=89.3f ps=0.85u w=0.47u l=0.16u
X8426 cml_tlatch_77.xtail.S1 CKHB2_P cml_tlatch_77.xmux.xn.S1 VSS sg13_lv_nmos ad=89.3f pd=0.85u as=89.3f ps=0.85u w=0.47u l=0.16u
X8427 cml_tlatch_15.xmux.xn.S1 CKHB0_P cml_tlatch_15.xtail.S1 VSS sg13_lv_nmos ad=0.1598p pd=1.62u as=89.3f ps=0.85u w=0.47u l=0.16u
X8428 cml_tlatch_81.xmux.xp.S1 B2_8_P B2_8_N VSS sg13_lv_nmos ad=56.9f pd=0.74u as=56.9f ps=0.74u w=0.17u l=0.17u
X8429 cml_tlatch_70.xtail.S1 CKA3_N cml_tlatch_70.xmux.xn.S1 VSS sg13_lv_nmos ad=89.3f pd=0.85u as=89.3f ps=0.85u w=0.47u l=0.16u
X8430 cml_tlatch_99.OUTP cml_tlatch_99.OUTN cml_tlatch_99.xmux.xp.S1 VSS sg13_lv_nmos ad=56.9f pd=0.74u as=56.9f ps=0.74u w=0.17u l=0.17u
X8431 cml_tlatch_34.xmux.xn.S1 cml_tlatch_38.OUTP A0_2_N VSS sg13_lv_nmos ad=63.19999f pd=0.74u as=63.19999f ps=0.74u w=0.26u l=0.38u
X8432 VSS POLN cml_tlatch_71.xtail.S1 VSS sg13_lv_nmos ad=2.7982p pd=17.14u as=1.5637p ps=8.61u w=8.23u l=0.13u
X8433 MOT19_P MOT19_N cml_tlatch_78.xmux.xp.S1 VSS sg13_lv_nmos ad=56.9f pd=0.74u as=56.9f ps=0.74u w=0.17u l=0.17u
X8434 cml_tlatch_43.xmux.xn.S1 cml_tlatch_43.INP MOT10_N VSS sg13_lv_nmos ad=0.1082p pd=1.34u as=63.19999f ps=0.74u w=0.26u l=0.38u
X8435 cml_tlatch_73.xmux.xp.S1 MOT27_N MOT27_P VSS sg13_lv_nmos ad=56.9f pd=0.74u as=56.9f ps=0.74u w=0.17u l=0.17u
X8436 MOT20_P MOT20_N cml_tlatch_54.xmux.xp.S1 VSS sg13_lv_nmos ad=56.9f pd=0.74u as=56.9f ps=0.74u w=0.17u l=0.17u
X8437 VDD A0_8_N VSS rppd l=5.17u w=1u
X8438 cml_tlatch_44.xmux.xp.S1 MOT28_N MOT28_P VSS sg13_lv_nmos ad=56.9f pd=0.74u as=56.9f ps=0.74u w=0.17u l=0.17u
X8439 cml_tlatch_30.xtail.S1 CKB0_P cml_tlatch_30.xmux.xn.S1 VSS sg13_lv_nmos ad=89.3f pd=0.85u as=89.3f ps=0.85u w=0.47u l=0.16u
X8440 stub_bi_43.BOTP stub_bi_43.BOTN cml_tlatch_48.xmux.xp.S1 VSS sg13_lv_nmos ad=56.9f pd=0.74u as=56.9f ps=0.74u w=0.17u l=0.17u
X8441 cml_tlatch_41.xmux.xp.S1 cml_tlatch_41.OUTP cml_tlatch_41.OUTN VSS sg13_lv_nmos ad=56.9f pd=0.74u as=56.9f ps=0.74u w=0.17u l=0.17u
X8442 VSS POLN cml_tlatch_11.xtail.S1 VSS sg13_lv_nmos ad=2.7982p pd=17.14u as=1.5637p ps=8.61u w=8.23u l=0.13u
X8443 cml_tlatch_81.xtail.S1 CKB2_N cml_tlatch_81.xmux.xn.S1 VSS sg13_lv_nmos ad=89.3f pd=0.85u as=89.3f ps=0.85u w=0.47u l=0.16u
X8444 cml_tlatch_92.xtail.S1 CKJ_N cml_tlatch_92.xmux.xn.S1 VSS sg13_lv_nmos ad=89.3f pd=0.85u as=89.3f ps=0.85u w=0.47u l=0.16u
X8445 cml_gate2_8.xamp.xn.S1 NS1_P cml_gate2_8.xrtail.R1 VSS sg13_lv_nmos ad=0.1007p pd=0.91u as=0.1007p ps=0.91u w=0.53u l=0.13u
X8446 cml_tlatch_84.xtail.S1 POLN VSS VSS sg13_lv_nmos ad=1.5637p pd=8.61u as=2.7982p ps=17.14u w=8.23u l=0.13u
X8447 MOT8_P MOT8_N cml_tlatch_42.xmux.xp.S1 VSS sg13_lv_nmos ad=56.9f pd=0.74u as=56.9f ps=0.74u w=0.17u l=0.17u
X8448 MOT23_N MOT23_P cml_tlatch_80.xmux.xp.S1 VSS sg13_lv_nmos ad=56.9f pd=0.74u as=56.9f ps=0.74u w=0.17u l=0.17u
X8449 cml_tlatch_46.xmux.xp.S1 stub_bi_38.BOTP stub_bi_38.BOTN VSS sg13_lv_nmos ad=56.9f pd=0.74u as=56.9f ps=0.74u w=0.17u l=0.17u
X8450 cml_tlatch_93.xmux.xp.S1 CKJ_N cml_tlatch_93.xtail.S1 VSS sg13_lv_nmos ad=89.3f pd=0.85u as=89.3f ps=0.85u w=0.47u l=0.16u
X8451 cml_tlatch_66.xtail.S1 CKB3_N cml_tlatch_66.xmux.xn.S1 VSS sg13_lv_nmos ad=0.1598p pd=1.62u as=89.3f ps=0.85u w=0.47u l=0.16u
X8452 cml_tlatch_86.OUTN cml_tlatch_86.OUTP cml_tlatch_86.xmux.xp.S1 VSS sg13_lv_nmos ad=56.9f pd=0.74u as=56.9f ps=0.74u w=0.17u l=0.17u
X8453 VSS POLN cml_tlatch_63.xtail.S1 VSS sg13_lv_nmos ad=1.5637p pd=8.61u as=1.5637p ps=8.61u w=8.23u l=0.13u
X8454 cml_tlatch_82.xmux.xp.S1 stub_bi_62.BOTN stub_bi_62.BOTP VSS sg13_lv_nmos ad=56.9f pd=0.74u as=56.9f ps=0.74u w=0.17u l=0.17u
X8455 cml_tlatch_1.xmux.xp.S1 B0_8_P B0_8_N VSS sg13_lv_nmos ad=56.9f pd=0.74u as=56.9f ps=0.74u w=0.17u l=0.17u
X8456 cml_drv_1.xrtail.R1 ENA_N ENA1_P VSS sg13_lv_nmos ad=56.2f pd=0.74u as=56.2f ps=0.74u w=0.16u l=0.19u
X8457 cml_tlatch_91.xtail.S1 CKA2_N cml_tlatch_91.xmux.xn.S1 VSS sg13_lv_nmos ad=89.3f pd=0.85u as=89.3f ps=0.85u w=0.47u l=0.16u
X8458 MOT18_P cml_tlatch_87.OUTN cml_tlatch_53.xmux.xn.S1 VSS sg13_lv_nmos ad=63.19999f pd=0.74u as=0.1082p ps=1.34u w=0.26u l=0.38u
X8459 cml_tlatch_78.xmux.xp.S1 CKHB2_N cml_tlatch_78.xtail.S1 VSS sg13_lv_nmos ad=89.3f pd=0.85u as=89.3f ps=0.85u w=0.47u l=0.16u
X8460 cml_tlatch_62.xmux.xp.S1 MOT24_P MOT24_N VSS sg13_lv_nmos ad=0.1019p pd=1.34u as=56.9f ps=0.74u w=0.17u l=0.17u
X8461 MOT15_N MOT15_P cml_tlatch_6.xmux.xp.S1 VSS sg13_lv_nmos ad=56.9f pd=0.74u as=56.9f ps=0.74u w=0.17u l=0.17u
X8462 VDD J2_P VSS rppd l=5.17u w=1u
X8463 cml_tlatch_2.xtail.S1 CKB0_N cml_tlatch_2.xmux.xp.S1 VSS sg13_lv_nmos ad=89.3f pd=0.85u as=89.3f ps=0.85u w=0.47u l=0.16u
X8464 cml_gate2_3.xamp.xn.S1 CKB0_P cml_gate2_3.xrtail.R1 VSS sg13_lv_nmos ad=0.1007p pd=0.91u as=0.1007p ps=0.91u w=0.53u l=0.13u
X8465 stub_bi_29.BOTP stub_bi_29.BOTN cml_tlatch_35.xmux.xp.S1 VSS sg13_lv_nmos ad=56.9f pd=0.74u as=56.9f ps=0.74u w=0.17u l=0.17u
X8466 cml_tlatch_23.xmux.xn.S1 cml_tlatch_0.OUTP cml_tlatch_23.OUTN VSS sg13_lv_nmos ad=63.19999f pd=0.74u as=63.19999f ps=0.74u w=0.26u l=0.38u
X8467 cml_tlatch_3.xtail.S1 CKHB1_P cml_tlatch_3.xmux.xn.S1 VSS sg13_lv_nmos ad=89.3f pd=0.85u as=89.3f ps=0.85u w=0.47u l=0.16u
X8468 cml_tlatch_41.OUTN D1_P cml_tlatch_41.xmux.xn.S1 VSS sg13_lv_nmos ad=63.19999f pd=0.74u as=0.1082p ps=1.34u w=0.26u l=0.38u
X8469 cml_gate2_6.xamp.xn.S1 ENB0_P GB3_N VSS sg13_lv_nmos ad=0.1007p pd=0.91u as=0.1007p ps=0.91u w=0.53u l=0.13u
X8470 cml_tlatch_90.xtail.S1 CKB2_N cml_tlatch_90.xmux.xn.S1 VSS sg13_lv_nmos ad=89.3f pd=0.85u as=89.3f ps=0.85u w=0.47u l=0.16u
X8471 cml_tlatch_99.xmux.xp.S1 cml_tlatch_99.OUTP cml_tlatch_99.OUTN VSS sg13_lv_nmos ad=56.9f pd=0.74u as=56.9f ps=0.74u w=0.17u l=0.17u
X8472 cml_tlatch_71.xmux.xp.S1 cml_tlatch_71.OUTP cml_tlatch_71.OUTN VSS sg13_lv_nmos ad=56.9f pd=0.74u as=56.9f ps=0.74u w=0.17u l=0.17u
X8473 GA2_P ENA1_N cml_gate2_5.xamp.xn.S1 VSS sg13_lv_nmos ad=0.1007p pd=0.91u as=0.1007p ps=0.91u w=0.53u l=0.13u
X8474 cml_tlatch_89.xtail.S1 CKA3_N cml_tlatch_89.xmux.xn.S1 VSS sg13_lv_nmos ad=89.3f pd=0.85u as=89.3f ps=0.85u w=0.47u l=0.16u
X8475 MOT8_N A1_8_P cml_tlatch_42.xmux.xn.S1 VSS sg13_lv_nmos ad=63.19999f pd=0.74u as=63.19999f ps=0.74u w=0.26u l=0.38u
X8476 cml_tlatch_80.xmux.xn.S1 CKHB2_P cml_tlatch_80.xtail.S1 VSS sg13_lv_nmos ad=89.3f pd=0.85u as=89.3f ps=0.85u w=0.47u l=0.16u
X8477 stub_bi_38.BOTN B2_2_N cml_tlatch_46.xmux.xn.S1 VSS sg13_lv_nmos ad=63.19999f pd=0.74u as=63.19999f ps=0.74u w=0.26u l=0.38u
X8478 cml_tlatch_84.xmux.xp.S1 stub_bi_49.BOTP stub_bi_49.BOTN VSS sg13_lv_nmos ad=56.9f pd=0.74u as=56.9f ps=0.74u w=0.17u l=0.17u
X8479 MOT2_N MOT2_P cml_tlatch_27.xmux.xp.S1 VSS sg13_lv_nmos ad=56.9f pd=0.74u as=56.9f ps=0.74u w=0.17u l=0.17u
X8480 cml_tlatch_22.xmux.xn.S1 cml_tlatch_24.INP cml_tlatch_22.OUTN VSS sg13_lv_nmos ad=63.19999f pd=0.74u as=63.19999f ps=0.74u w=0.26u l=0.38u
X8481 cml_tlatch_79.xmux.xp.S1 MOT21_N MOT21_P VSS sg13_lv_nmos ad=0.1019p pd=1.34u as=56.9f ps=0.74u w=0.17u l=0.17u
X8482 cml_tlatch_24.INN cml_tlatch_24.INP cml_tlatch_97.xmux.xp.S1 VSS sg13_lv_nmos ad=56.9f pd=0.74u as=56.9f ps=0.74u w=0.17u l=0.17u
X8483 MOT8_N A1_8_P cml_tlatch_42.xmux.xn.S1 VSS sg13_lv_nmos ad=63.19999f pd=0.74u as=63.19999f ps=0.74u w=0.26u l=0.38u
X8484 B1_2_N B1_2_P cml_tlatch_36.xmux.xp.S1 VSS sg13_lv_nmos ad=56.9f pd=0.74u as=56.9f ps=0.74u w=0.17u l=0.17u
X8485 cml_tlatch_45.xmux.xn.S1 CKHA3_P cml_tlatch_45.xtail.S1 VSS sg13_lv_nmos ad=89.3f pd=0.85u as=89.3f ps=0.85u w=0.47u l=0.16u
X8486 MOT29_P MOT29_N cml_tlatch_74.xmux.xp.S1 VSS sg13_lv_nmos ad=56.9f pd=0.74u as=56.9f ps=0.74u w=0.17u l=0.17u
X8487 ENA1_P VDD VSS rppd l=8.13u w=1u
X8488 cml_tlatch_0.xmux.xn.S1 cml_tlatch_99.OUTP cml_tlatch_0.OUTN VSS sg13_lv_nmos ad=63.19999f pd=0.74u as=63.19999f ps=0.74u w=0.26u l=0.38u
X8489 A3_8_N A3_8_P cml_tlatch_68.xmux.xp.S1 VSS sg13_lv_nmos ad=56.9f pd=0.74u as=56.9f ps=0.74u w=0.17u l=0.17u
X8490 cml_tlatch_11.xmux.xp.S1 CKB1_N cml_tlatch_11.xtail.S1 VSS sg13_lv_nmos ad=89.3f pd=0.85u as=89.3f ps=0.85u w=0.47u l=0.16u
X8491 cml_tlatch_10.xmux.xn.S1 stub_bi_15.BOTP B1_8_P VSS sg13_lv_nmos ad=63.19999f pd=0.74u as=63.19999f ps=0.74u w=0.26u l=0.38u
X8492 cml_tlatch_46.xmux.xn.S1 B2_2_P stub_bi_38.BOTP VSS sg13_lv_nmos ad=63.19999f pd=0.74u as=63.19999f ps=0.74u w=0.26u l=0.38u
X8493 cml_tlatch_30.OUTN cml_tlatch_30.OUTP cml_tlatch_30.xmux.xp.S1 VSS sg13_lv_nmos ad=56.9f pd=0.74u as=56.9f ps=0.74u w=0.17u l=0.17u
X8494 cml_tlatch_47.xtail.S1 CKB2_N cml_tlatch_47.xmux.xn.S1 VSS sg13_lv_nmos ad=89.3f pd=0.85u as=89.3f ps=0.85u w=0.47u l=0.16u
X8495 cml_tlatch_5.xmux.xp.S1 MOT13_N MOT13_P VSS sg13_lv_nmos ad=56.9f pd=0.74u as=56.9f ps=0.74u w=0.17u l=0.17u
X8496 cml_tlatch_75.xmux.xn.S1 CKHB3_P cml_tlatch_75.xtail.S1 VSS sg13_lv_nmos ad=89.3f pd=0.85u as=89.3f ps=0.85u w=0.47u l=0.16u
X8497 cml_tlatch_5.xmux.xn.S1 cml_tlatch_5.INN MOT13_P VSS sg13_lv_nmos ad=63.19999f pd=0.74u as=63.19999f ps=0.74u w=0.26u l=0.38u
X8498 cml_tlatch_10.xmux.xn.S1 stub_bi_15.BOTP B1_8_P VSS sg13_lv_nmos ad=63.19999f pd=0.74u as=63.19999f ps=0.74u w=0.26u l=0.38u
X8499 cml_tlatch_90.xmux.xp.S1 stub_bi_55.BOTP stub_bi_55.BOTN VSS sg13_lv_nmos ad=0.1019p pd=1.34u as=56.9f ps=0.74u w=0.17u l=0.17u
X8500 cml_tlatch_18.OUTP cml_tlatch_18.OUTN cml_tlatch_18.xmux.xp.S1 VSS sg13_lv_nmos ad=56.9f pd=0.74u as=56.9f ps=0.74u w=0.17u l=0.17u
X8501 MOT20_N MOT20_P cml_tlatch_54.xmux.xp.S1 VSS sg13_lv_nmos ad=56.9f pd=0.74u as=56.9f ps=0.74u w=0.17u l=0.17u
X8502 MOT14_N A1_2_P cml_tlatch_25.xmux.xn.S1 VSS sg13_lv_nmos ad=63.19999f pd=0.74u as=63.19999f ps=0.74u w=0.26u l=0.38u
X8503 cml_tlatch_70.xmux.xp.S1 cml_tlatch_63.INN cml_tlatch_63.INP VSS sg13_lv_nmos ad=56.9f pd=0.74u as=56.9f ps=0.74u w=0.17u l=0.17u
X8504 B3_2_N B3_2_P cml_tlatch_50.xmux.xp.S1 VSS sg13_lv_nmos ad=56.9f pd=0.74u as=56.9f ps=0.74u w=0.17u l=0.17u
X8505 B0_2_N B0_2_P cml_tlatch_31.xmux.xp.S1 VSS sg13_lv_nmos ad=56.9f pd=0.74u as=56.9f ps=0.74u w=0.17u l=0.17u
X8506 A0_8_P A0_8_N cml_tlatch_9.xmux.xp.S1 VSS sg13_lv_nmos ad=56.9f pd=0.74u as=56.9f ps=0.74u w=0.17u l=0.17u
X8507 cml_tlatch_56.OUTP cml_tlatch_56.OUTN cml_tlatch_56.xmux.xp.S1 VSS sg13_lv_nmos ad=56.9f pd=0.74u as=56.9f ps=0.74u w=0.17u l=0.17u
X8508 cml_tlatch_98.xtail.S1 CKB0_N cml_tlatch_98.xmux.xn.S1 VSS sg13_lv_nmos ad=0.1598p pd=1.62u as=89.3f ps=0.85u w=0.47u l=0.16u
X8509 cml_tlatch_85.xtail.S1 CKA2_P cml_tlatch_85.xmux.xp.S1 VSS sg13_lv_nmos ad=89.3f pd=0.85u as=89.3f ps=0.85u w=0.47u l=0.16u
X8510 cml_tlatch_44.xmux.xn.S1 cml_tlatch_44.INP MOT28_N VSS sg13_lv_nmos ad=0.1082p pd=1.34u as=63.19999f ps=0.74u w=0.26u l=0.38u
X8511 cml_tlatch_3.xmux.xp.S1 MOT9_P MOT9_N VSS sg13_lv_nmos ad=56.9f pd=0.74u as=56.9f ps=0.74u w=0.17u l=0.17u
X8512 VSS POLN cml_tlatch_13.xtail.S1 VSS sg13_lv_nmos ad=1.5637p pd=8.61u as=1.5637p ps=8.61u w=8.23u l=0.13u
X8513 GA3_N ENA1_P cml_gate2_4.xamp.xn.S1 VSS sg13_lv_nmos ad=0.1007p pd=0.91u as=0.1007p ps=0.91u w=0.53u l=0.13u
X8514 VSS hs_to_clk_0.sg13_lv_nmos_2HGZLP_0.G VSS VSS sg13_lv_nmos ad=3.706p pd=22.48u as=0 ps=0 w=10.9u l=1.38u
X8515 cml_tlatch_71.xmux.xp.S1 CKA3_N cml_tlatch_71.xtail.S1 VSS sg13_lv_nmos ad=0.1598p pd=1.62u as=89.3f ps=0.85u w=0.47u l=0.16u
X8516 cml_tlatch_57.xmux.xp.S1 A3_2_N A3_2_P VSS sg13_lv_nmos ad=56.9f pd=0.74u as=56.9f ps=0.74u w=0.17u l=0.17u
X8517 cml_tlatch_75.xmux.xp.S1 CKHB3_N cml_tlatch_75.xtail.S1 VSS sg13_lv_nmos ad=89.3f pd=0.85u as=89.3f ps=0.85u w=0.47u l=0.16u
X8518 MOT27_N cml_tlatch_73.INP cml_tlatch_73.xmux.xn.S1 VSS sg13_lv_nmos ad=63.19999f pd=0.74u as=63.19999f ps=0.74u w=0.26u l=0.38u
X8519 cml_tlatch_81.xtail.S1 CKB2_P cml_tlatch_81.xmux.xp.S1 VSS sg13_lv_nmos ad=0.1598p pd=1.62u as=89.3f ps=0.85u w=0.47u l=0.16u
X8520 VSS hs_to_clk_5.sg13_lv_nmos_2HGZLP_0.G VSS VSS sg13_lv_nmos ad=2.071p pd=11.28u as=0 ps=0 w=10.9u l=1.38u
X8521 MOT19_P stub_bi_63.BOTP cml_tlatch_78.xmux.xn.S1 VSS sg13_lv_nmos ad=63.19999f pd=0.74u as=63.19999f ps=0.74u w=0.26u l=0.38u
X8522 VDD cml_tlatch_87.INP VSS rppd l=5.17u w=1u
X8523 cml_tlatch_86.xtail.S1 CKA2_P cml_tlatch_86.xmux.xn.S1 VSS sg13_lv_nmos ad=89.3f pd=0.85u as=89.3f ps=0.85u w=0.47u l=0.16u
X8524 cml_tlatch_83.xmux.xp.S1 stub_bi_63.BOTN stub_bi_63.BOTP VSS sg13_lv_nmos ad=56.9f pd=0.74u as=56.9f ps=0.74u w=0.17u l=0.17u
X8525 cml_tlatch_24.xmux.xn.S1 cml_tlatch_24.INN MOT12_P VSS sg13_lv_nmos ad=63.19999f pd=0.74u as=63.19999f ps=0.74u w=0.26u l=0.38u
X8526 cml_tlatch_21.xtail.S1 CKA1_P cml_tlatch_21.xmux.xp.S1 VSS sg13_lv_nmos ad=89.3f pd=0.85u as=89.3f ps=0.85u w=0.47u l=0.16u
X8527 cml_tlatch_43.INP cml_tlatch_43.INN cml_tlatch_21.xmux.xp.S1 VSS sg13_lv_nmos ad=56.9f pd=0.74u as=56.9f ps=0.74u w=0.17u l=0.17u
X8528 cml_tlatch_7.xtail.S1 CKB0_N cml_tlatch_7.xmux.xn.S1 VSS sg13_lv_nmos ad=89.3f pd=0.85u as=0.1598p ps=1.62u w=0.47u l=0.16u
X8529 cml_tlatch_50.xmux.xp.S1 B3_2_P B3_2_N VSS sg13_lv_nmos ad=56.9f pd=0.74u as=56.9f ps=0.74u w=0.17u l=0.17u
X8530 cml_tlatch_0.xtail.S1 CKA0_N cml_tlatch_0.xmux.xp.S1 VSS sg13_lv_nmos ad=89.3f pd=0.85u as=89.3f ps=0.85u w=0.47u l=0.16u
X8531 cml_tlatch_8.xmux.xp.S1 cml_tlatch_8.OUTN cml_tlatch_8.OUTP VSS sg13_lv_nmos ad=56.9f pd=0.74u as=56.9f ps=0.74u w=0.17u l=0.17u
X8532 MOT15_N MOT15_P cml_tlatch_6.xmux.xp.S1 VSS sg13_lv_nmos ad=56.9f pd=0.74u as=56.9f ps=0.74u w=0.17u l=0.17u
X8533 A0_2_P cml_tlatch_38.OUTN cml_tlatch_34.xmux.xn.S1 VSS sg13_lv_nmos ad=63.19999f pd=0.74u as=63.19999f ps=0.74u w=0.26u l=0.38u
X8534 cml_tlatch_93.xmux.xp.S1 CLK_W_N CLK_W_P VSS sg13_lv_nmos ad=56.9f pd=0.74u as=56.9f ps=0.74u w=0.17u l=0.17u
X8535 cml_tlatch_71.OUTP cml_tlatch_71.OUTN cml_tlatch_71.xmux.xp.S1 VSS sg13_lv_nmos ad=56.9f pd=0.74u as=56.9f ps=0.74u w=0.17u l=0.17u
X8536 cml_tlatch_77.xmux.xn.S1 CKHB2_P cml_tlatch_77.xtail.S1 VSS sg13_lv_nmos ad=89.3f pd=0.85u as=89.3f ps=0.85u w=0.47u l=0.16u
X8537 cml_tlatch_32.OUTP D0_N cml_tlatch_32.xmux.xn.S1 VSS sg13_lv_nmos ad=63.19999f pd=0.74u as=63.19999f ps=0.74u w=0.26u l=0.38u
X8538 cml_tlatch_50.xtail.S1 POLN VSS VSS sg13_lv_nmos ad=1.5637p pd=8.61u as=2.7982p ps=17.14u w=8.23u l=0.13u
X8539 cml_tlatch_88.xmux.xp.S1 cml_tlatch_74.INP cml_tlatch_74.INN VSS sg13_lv_nmos ad=56.9f pd=0.74u as=56.9f ps=0.74u w=0.17u l=0.17u
X8540 cml_tlatch_82.xtail.S1 CKB2_P cml_tlatch_82.xmux.xn.S1 VSS sg13_lv_nmos ad=89.3f pd=0.85u as=89.3f ps=0.85u w=0.47u l=0.16u
X8541 cml_tlatch_85.xmux.xn.S1 cml_tlatch_86.OUTP A2_8_N VSS sg13_lv_nmos ad=63.19999f pd=0.74u as=63.19999f ps=0.74u w=0.26u l=0.38u
X8542 cml_tlatch_65.OUTN VDD VSS rppd l=5.17u w=1u
X8543 cml_tlatch_12.xtail.S1 CKB1_P cml_tlatch_12.xmux.xp.S1 VSS sg13_lv_nmos ad=89.3f pd=0.85u as=89.3f ps=0.85u w=0.47u l=0.16u
X8544 cml_tlatch_18.xmux.xn.S1 cml_tlatch_23.OUTP cml_tlatch_18.OUTN VSS sg13_lv_nmos ad=63.19999f pd=0.74u as=63.19999f ps=0.74u w=0.26u l=0.38u
X8545 cml_tlatch_82.xmux.xp.S1 stub_bi_62.BOTP stub_bi_62.BOTN VSS sg13_lv_nmos ad=56.9f pd=0.74u as=56.9f ps=0.74u w=0.17u l=0.17u
X8546 cml_tlatch_20.OUTP cml_tlatch_20.OUTN cml_tlatch_20.xmux.xp.S1 VSS sg13_lv_nmos ad=56.9f pd=0.74u as=56.9f ps=0.74u w=0.17u l=0.17u
X8547 B0_8_N cml_tlatch_2.OUTP cml_tlatch_1.xmux.xn.S1 VSS sg13_lv_nmos ad=63.19999f pd=0.74u as=63.19999f ps=0.74u w=0.26u l=0.38u
X8548 cml_tlatch_87.xtail.S1 CKA2_P cml_tlatch_87.xmux.xp.S1 VSS sg13_lv_nmos ad=89.3f pd=0.85u as=89.3f ps=0.85u w=0.47u l=0.16u
X8549 cml_tlatch_63.INN cml_tlatch_63.INP cml_tlatch_70.xmux.xp.S1 VSS sg13_lv_nmos ad=56.9f pd=0.74u as=0.1019p ps=1.34u w=0.17u l=0.17u
X8550 MOT28_N MOT28_P cml_tlatch_44.xmux.xp.S1 VSS sg13_lv_nmos ad=56.9f pd=0.74u as=56.9f ps=0.74u w=0.17u l=0.17u
X8551 cml_tlatch_72.xmux.xn.S1 CKHB3_P cml_tlatch_72.xtail.S1 VSS sg13_lv_nmos ad=89.3f pd=0.85u as=89.3f ps=0.85u w=0.47u l=0.16u
X8552 cml_tlatch_2.xmux.xp.S1 cml_tlatch_2.OUTN cml_tlatch_2.OUTP VSS sg13_lv_nmos ad=56.9f pd=0.74u as=56.9f ps=0.74u w=0.17u l=0.17u
X8553 cml_tlatch_24.xmux.xp.S1 MOT12_P MOT12_N VSS sg13_lv_nmos ad=56.9f pd=0.74u as=56.9f ps=0.74u w=0.17u l=0.17u
X8554 stub_bi_15.BOTN cml_tlatch_4.INN cml_tlatch_11.xmux.xn.S1 VSS sg13_lv_nmos ad=63.19999f pd=0.74u as=63.19999f ps=0.74u w=0.26u l=0.38u
X8555 cml_tlatch_91.OUTN cml_tlatch_91.INP cml_tlatch_91.xmux.xn.S1 VSS sg13_lv_nmos ad=63.19999f pd=0.74u as=63.19999f ps=0.74u w=0.26u l=0.38u
X8556 cml_tlatch_26.xmux.xp.S1 MOT0_P MOT0_N VSS sg13_lv_nmos ad=56.9f pd=0.74u as=56.9f ps=0.74u w=0.17u l=0.17u
X8557 cml_tlatch_29.xmux.xp.S1 MOT6_N MOT6_P VSS sg13_lv_nmos ad=56.9f pd=0.74u as=56.9f ps=0.74u w=0.17u l=0.17u
X8558 A3_8_N A3_8_P cml_tlatch_68.xmux.xp.S1 VSS sg13_lv_nmos ad=56.9f pd=0.74u as=56.9f ps=0.74u w=0.17u l=0.17u
X8559 cml_tlatch_70.xmux.xn.S1 cml_tlatch_71.OUTN cml_tlatch_63.INP VSS sg13_lv_nmos ad=63.19999f pd=0.74u as=63.19999f ps=0.74u w=0.26u l=0.38u
X8560 cml_tlatch_30.OUTN cml_tlatch_30.OUTP cml_tlatch_30.xmux.xp.S1 VSS sg13_lv_nmos ad=56.9f pd=0.74u as=56.9f ps=0.74u w=0.17u l=0.17u
X8561 cml_tlatch_64.xmux.xp.S1 B3_8_P B3_8_N VSS sg13_lv_nmos ad=56.9f pd=0.74u as=56.9f ps=0.74u w=0.17u l=0.17u
X8562 VSS POLN cml_tlatch_62.xtail.S1 VSS sg13_lv_nmos ad=2.7982p pd=17.14u as=1.5637p ps=8.61u w=8.23u l=0.13u
X8563 cml_tlatch_77.xmux.xn.S1 B2_8_N MOT17_P VSS sg13_lv_nmos ad=63.19999f pd=0.74u as=63.19999f ps=0.74u w=0.26u l=0.38u
X8564 cml_tlatch_42.xtail.S1 CKHA1_N cml_tlatch_42.xmux.xp.S1 VSS sg13_lv_nmos ad=0.1598p pd=1.62u as=89.3f ps=0.85u w=0.47u l=0.16u
X8565 cml_tlatch_65.xmux.xn.S1 cml_tlatch_73.INN cml_tlatch_65.OUTP VSS sg13_lv_nmos ad=63.19999f pd=0.74u as=63.19999f ps=0.74u w=0.26u l=0.38u
X8566 J2_P J1_N cml_tlatch_94.xmux.xn.S1 VSS sg13_lv_nmos ad=63.19999f pd=0.74u as=63.19999f ps=0.74u w=0.26u l=0.38u
X8567 MOT22_N MOT22_P cml_tlatch_55.xmux.xp.S1 VSS sg13_lv_nmos ad=56.9f pd=0.74u as=56.9f ps=0.74u w=0.17u l=0.17u
X8568 cml_tlatch_51.OUTN cml_tlatch_51.OUTP cml_tlatch_51.xmux.xp.S1 VSS sg13_lv_nmos ad=56.9f pd=0.74u as=56.9f ps=0.74u w=0.17u l=0.17u
X8569 cml_tlatch_9.xtail.S1 CKA0_N cml_tlatch_9.xmux.xn.S1 VSS sg13_lv_nmos ad=89.3f pd=0.85u as=89.3f ps=0.85u w=0.47u l=0.16u
X8570 B1_8_N B1_8_P cml_tlatch_10.xmux.xp.S1 VSS sg13_lv_nmos ad=56.9f pd=0.74u as=56.9f ps=0.74u w=0.17u l=0.17u
X8571 stub_bi_55.BOTP VDD VSS rppd l=5.17u w=1u
X8572 cml_tlatch_40.xmux.xp.S1 CKA1_P cml_tlatch_40.xtail.S1 VSS sg13_lv_nmos ad=89.3f pd=0.85u as=89.3f ps=0.85u w=0.47u l=0.16u
X8573 cml_tlatch_56.OUTP cml_tlatch_56.OUTN cml_tlatch_56.xmux.xp.S1 VSS sg13_lv_nmos ad=56.9f pd=0.74u as=56.9f ps=0.74u w=0.17u l=0.17u
X8574 cml_tlatch_72.xmux.xp.S1 CKHB3_N cml_tlatch_72.xtail.S1 VSS sg13_lv_nmos ad=89.3f pd=0.85u as=89.3f ps=0.85u w=0.47u l=0.16u
X8575 A2_2_P cml_tlatch_61.OUTN cml_tlatch_60.xmux.xn.S1 VSS sg13_lv_nmos ad=63.19999f pd=0.74u as=63.19999f ps=0.74u w=0.26u l=0.38u
X8576 cml_tlatch_51.xtail.S1 CKB3_N cml_tlatch_51.xmux.xp.S1 VSS sg13_lv_nmos ad=89.3f pd=0.85u as=0.1598p ps=1.62u w=0.47u l=0.16u
X8577 cml_tlatch_49.xmux.xp.S1 cml_tlatch_49.OUTN cml_tlatch_49.OUTP VSS sg13_lv_nmos ad=56.9f pd=0.74u as=56.9f ps=0.74u w=0.17u l=0.17u
X8578 cml_tlatch_16.xmux.xn.S1 cml_tlatch_98.OUTP MOT5_N VSS sg13_lv_nmos ad=63.19999f pd=0.74u as=63.19999f ps=0.74u w=0.26u l=0.38u
X8579 cml_tlatch_15.xmux.xn.S1 CKHB0_P cml_tlatch_15.xtail.S1 VSS sg13_lv_nmos ad=89.3f pd=0.85u as=89.3f ps=0.85u w=0.47u l=0.16u
X8580 cml_tlatch_27.xmux.xp.S1 MOT2_N MOT2_P VSS sg13_lv_nmos ad=56.9f pd=0.74u as=56.9f ps=0.74u w=0.17u l=0.17u
X8581 cml_tlatch_69.OUTN cml_tlatch_69.OUTP cml_tlatch_69.xmux.xp.S1 VSS sg13_lv_nmos ad=56.9f pd=0.74u as=56.9f ps=0.74u w=0.17u l=0.17u
X8582 cml_tlatch_78.xmux.xp.S1 MOT19_P MOT19_N VSS sg13_lv_nmos ad=56.9f pd=0.74u as=56.9f ps=0.74u w=0.17u l=0.17u
X8583 cml_tlatch_37.xmux.xp.S1 stub_bi_31.BOTN stub_bi_31.BOTP VSS sg13_lv_nmos ad=56.9f pd=0.74u as=56.9f ps=0.74u w=0.17u l=0.17u
X8584 cml_tlatch_48.xmux.xn.S1 CKB2_P cml_tlatch_48.xtail.S1 VSS sg13_lv_nmos ad=89.3f pd=0.85u as=89.3f ps=0.85u w=0.47u l=0.16u
X8585 cml_tlatch_92.xmux.xn.S1 CLK_W_P J4_P VSS sg13_lv_nmos ad=63.19999f pd=0.74u as=63.19999f ps=0.74u w=0.26u l=0.38u
X8586 MOT10_N MOT10_P cml_tlatch_43.xmux.xp.S1 VSS sg13_lv_nmos ad=56.9f pd=0.74u as=56.9f ps=0.74u w=0.17u l=0.17u
X8587 stub_bi_29.BOTN stub_bi_29.BOTP cml_tlatch_35.xmux.xp.S1 VSS sg13_lv_nmos ad=56.9f pd=0.74u as=56.9f ps=0.74u w=0.17u l=0.17u
X8588 cml_tlatch_44.xtail.S1 CKHA3_P cml_tlatch_44.xmux.xn.S1 VSS sg13_lv_nmos ad=89.3f pd=0.85u as=89.3f ps=0.85u w=0.47u l=0.16u
X8589 cml_tlatch_38.xmux.xn.S1 CKA0_P cml_tlatch_38.xtail.S1 VSS sg13_lv_nmos ad=0.1598p pd=1.62u as=89.3f ps=0.85u w=0.47u l=0.16u
X8590 cml_gate2_7.xamp.xn.S1 ENB0_N GB2_P VSS sg13_lv_nmos ad=0.1007p pd=0.91u as=0.1007p ps=0.91u w=0.53u l=0.13u
X8591 cml_tlatch_36.xmux.xp.S1 CKB1_P cml_tlatch_36.xtail.S1 VSS sg13_lv_nmos ad=89.3f pd=0.85u as=89.3f ps=0.85u w=0.47u l=0.16u
X8592 cml_tlatch_39.xmux.xp.S1 cml_tlatch_97.INP cml_tlatch_97.INN VSS sg13_lv_nmos ad=56.9f pd=0.74u as=56.9f ps=0.74u w=0.17u l=0.17u
X8593 cml_tlatch_67.xmux.xp.S1 cml_tlatch_67.OUTN cml_tlatch_67.OUTP VSS sg13_lv_nmos ad=56.9f pd=0.74u as=56.9f ps=0.74u w=0.17u l=0.17u
X8594 stub_bi_38.BOTP stub_bi_38.BOTN cml_tlatch_46.xmux.xp.S1 VSS sg13_lv_nmos ad=56.9f pd=0.74u as=56.9f ps=0.74u w=0.17u l=0.17u
X8595 cml_tlatch_92.xtail.S1 CKJ_N cml_tlatch_92.xmux.xn.S1 VSS sg13_lv_nmos ad=89.3f pd=0.85u as=89.3f ps=0.85u w=0.47u l=0.16u
X8596 cml_tlatch_48.xmux.xp.S1 stub_bi_43.BOTP stub_bi_43.BOTN VSS sg13_lv_nmos ad=56.9f pd=0.74u as=56.9f ps=0.74u w=0.17u l=0.17u
X8597 cml_tlatch_41.OUTP cml_tlatch_41.OUTN cml_tlatch_41.xmux.xp.S1 VSS sg13_lv_nmos ad=56.9f pd=0.74u as=56.9f ps=0.74u w=0.17u l=0.17u
X8598 cml_gate2_3.xrtail.R1 CKB0_N GA0_P VSS sg13_lv_nmos ad=0.1007p pd=0.91u as=0.1802p ps=1.74u w=0.53u l=0.13u
X8599 cml_tlatch_91.OUTN cml_tlatch_91.OUTP cml_tlatch_91.xmux.xp.S1 VSS sg13_lv_nmos ad=56.9f pd=0.74u as=56.9f ps=0.74u w=0.17u l=0.17u
X8600 cml_tlatch_88.xmux.xp.S1 cml_tlatch_74.INP cml_tlatch_74.INN VSS sg13_lv_nmos ad=56.9f pd=0.74u as=56.9f ps=0.74u w=0.17u l=0.17u
X8601 GA2_N ENA1_P cml_gate2_5.xamp.xn.S1 VSS sg13_lv_nmos ad=0.1007p pd=0.91u as=0.1007p ps=0.91u w=0.53u l=0.13u
X8602 cml_tlatch_32.xmux.xp.S1 cml_tlatch_32.OUTN cml_tlatch_32.OUTP VSS sg13_lv_nmos ad=56.9f pd=0.74u as=56.9f ps=0.74u w=0.17u l=0.17u
X8603 J4_P J4_N cml_tlatch_92.xmux.xp.S1 VSS sg13_lv_nmos ad=56.9f pd=0.74u as=56.9f ps=0.74u w=0.17u l=0.17u
X8604 MOT13_N MOT13_P cml_tlatch_5.xmux.xp.S1 VSS sg13_lv_nmos ad=56.9f pd=0.74u as=56.9f ps=0.74u w=0.17u l=0.17u
X8605 VSS hs_to_clk_3.sg13_lv_nmos_2HGZLP_0.G VSS VSS sg13_lv_nmos ad=2.071p pd=11.28u as=0 ps=0 w=10.9u l=1.38u
X8606 VDD A2_8_N VSS rppd l=5.17u w=1u
X8607 cml_tlatch_61.xtail.S1 CKA2_N cml_tlatch_61.xmux.xp.S1 VSS sg13_lv_nmos ad=89.3f pd=0.85u as=89.3f ps=0.85u w=0.47u l=0.16u
X8608 MOT6_P A0_2_N cml_tlatch_29.xmux.xn.S1 VSS sg13_lv_nmos ad=63.19999f pd=0.74u as=63.19999f ps=0.74u w=0.26u l=0.38u
X8609 cml_tlatch_97.INP A1_2_N cml_tlatch_39.xmux.xn.S1 VSS sg13_lv_nmos ad=0.1082p pd=1.34u as=63.19999f ps=0.74u w=0.26u l=0.38u
X8610 cml_tlatch_16.xtail.S1 CKHB0_N cml_tlatch_16.xmux.xp.S1 VSS sg13_lv_nmos ad=89.3f pd=0.85u as=89.3f ps=0.85u w=0.47u l=0.16u
X8611 cml_tlatch_95.xmux.xp.S1 J1_N J1_P VSS sg13_lv_nmos ad=56.9f pd=0.74u as=56.9f ps=0.74u w=0.17u l=0.17u
X8612 cml_tlatch_95.xmux.xp.S1 J1_P J1_N VSS sg13_lv_nmos ad=56.9f pd=0.74u as=56.9f ps=0.74u w=0.17u l=0.17u
X8613 MOT28_N MOT28_P cml_tlatch_44.xmux.xp.S1 VSS sg13_lv_nmos ad=56.9f pd=0.74u as=0.1019p ps=1.34u w=0.17u l=0.17u
X8614 cml_tlatch_22.xtail.S1 CKA1_P cml_tlatch_22.xmux.xn.S1 VSS sg13_lv_nmos ad=89.3f pd=0.85u as=89.3f ps=0.85u w=0.47u l=0.16u
X8615 cml_tlatch_86.xmux.xn.S1 cml_tlatch_87.OUTN cml_tlatch_86.OUTP VSS sg13_lv_nmos ad=63.19999f pd=0.74u as=63.19999f ps=0.74u w=0.26u l=0.38u
X8616 cml_tlatch_34.xmux.xp.S1 A0_2_N A0_2_P VSS sg13_lv_nmos ad=56.9f pd=0.74u as=56.9f ps=0.74u w=0.17u l=0.17u
X8617 cml_tlatch_31.xtail.S1 CKB0_N cml_tlatch_31.xmux.xn.S1 VSS sg13_lv_nmos ad=89.3f pd=0.85u as=89.3f ps=0.85u w=0.47u l=0.16u
X8618 cml_tlatch_67.xmux.xp.S1 cml_tlatch_67.OUTN cml_tlatch_67.OUTP VSS sg13_lv_nmos ad=0.1019p pd=1.34u as=56.9f ps=0.74u w=0.17u l=0.17u
X8619 VSS hs_to_clk_2.sg13_lv_nmos_2HGZLP_0.G VSS VSS sg13_lv_nmos ad=2.071p pd=11.28u as=0 ps=0 w=10.9u l=1.38u
X8620 cml_tlatch_60.xmux.xp.S1 A2_2_P A2_2_N VSS sg13_lv_nmos ad=0.1019p pd=1.34u as=56.9f ps=0.74u w=0.17u l=0.17u
X8621 cml_tlatch_93.xmux.xn.S1 J2_N CLK_W_N VSS sg13_lv_nmos ad=63.19999f pd=0.74u as=63.19999f ps=0.74u w=0.26u l=0.38u
X8622 cml_drv_1.xrtail.R1 ENA_P ENA1_N VSS sg13_lv_nmos ad=56.2f pd=0.74u as=56.2f ps=0.74u w=0.16u l=0.19u
X8623 MOT9_N B1_8_P cml_tlatch_3.xmux.xn.S1 VSS sg13_lv_nmos ad=63.19999f pd=0.74u as=63.19999f ps=0.74u w=0.26u l=0.38u
X8624 cml_tlatch_65.OUTN cml_tlatch_65.OUTP cml_tlatch_65.xmux.xp.S1 VSS sg13_lv_nmos ad=56.9f pd=0.74u as=0.1019p ps=1.34u w=0.17u l=0.17u
X8625 cml_tlatch_57.xmux.xn.S1 cml_tlatch_58.OUTP A3_2_N VSS sg13_lv_nmos ad=63.19999f pd=0.74u as=63.19999f ps=0.74u w=0.26u l=0.38u
X8626 cml_tlatch_84.xmux.xn.S1 stub_bi_55.BOTP stub_bi_49.BOTN VSS sg13_lv_nmos ad=63.19999f pd=0.74u as=63.19999f ps=0.74u w=0.26u l=0.38u
X8627 CLK_W_P J2_P cml_tlatch_93.xmux.xn.S1 VSS sg13_lv_nmos ad=63.19999f pd=0.74u as=63.19999f ps=0.74u w=0.26u l=0.38u
X8628 cml_tlatch_9.xtail.S1 CKA0_P cml_tlatch_9.xmux.xp.S1 VSS sg13_lv_nmos ad=89.3f pd=0.85u as=89.3f ps=0.85u w=0.47u l=0.16u
X8629 cml_gate2_1.xamp.xn.S1 CKA0_P cml_gate2_1.xrtail.R1 VSS sg13_lv_nmos ad=0.1007p pd=0.91u as=0.1007p ps=0.91u w=0.53u l=0.13u
X8630 stub_bi_17.BOTN stub_bi_17.BOTP cml_tlatch_13.xmux.xp.S1 VSS sg13_lv_nmos ad=56.9f pd=0.74u as=56.9f ps=0.74u w=0.17u l=0.17u
X8631 cml_tlatch_95.xmux.xp.S1 J1_N J1_P VSS sg13_lv_nmos ad=0.1019p pd=1.34u as=56.9f ps=0.74u w=0.17u l=0.17u
X8632 cml_tlatch_88.xmux.xp.S1 CKB3_P cml_tlatch_88.xtail.S1 VSS sg13_lv_nmos ad=89.3f pd=0.85u as=89.3f ps=0.85u w=0.47u l=0.16u
X8633 cml_tlatch_7.OUTP VDD VSS rppd l=5.17u w=1u
X8634 A2_2_P A2_2_N cml_tlatch_60.xmux.xp.S1 VSS sg13_lv_nmos ad=56.9f pd=0.74u as=56.9f ps=0.74u w=0.17u l=0.17u
X8635 VSS hs_to_clk_5.sg13_lv_nmos_2HGZLP_0.G VSS VSS sg13_lv_nmos ad=3.706p pd=22.48u as=0 ps=0 w=10.9u l=1.38u
X8636 cml_tlatch_47.xmux.xp.S1 B2_2_N B2_2_P VSS sg13_lv_nmos ad=56.9f pd=0.74u as=56.9f ps=0.74u w=0.17u l=0.17u
X8637 MOT0_P MOT0_N cml_tlatch_26.xmux.xp.S1 VSS sg13_lv_nmos ad=56.9f pd=0.74u as=56.9f ps=0.74u w=0.17u l=0.17u
X8638 MOT3_P MOT3_N cml_tlatch_15.xmux.xp.S1 VSS sg13_lv_nmos ad=56.9f pd=0.74u as=56.9f ps=0.74u w=0.17u l=0.17u
X8639 cml_tlatch_46.xmux.xn.S1 CKB2_P cml_tlatch_46.xtail.S1 VSS sg13_lv_nmos ad=89.3f pd=0.85u as=89.3f ps=0.85u w=0.47u l=0.16u
X8640 cml_tlatch_26.xtail.S1 CKHA0_P cml_tlatch_26.xmux.xn.S1 VSS sg13_lv_nmos ad=89.3f pd=0.85u as=89.3f ps=0.85u w=0.47u l=0.16u
X8641 MOT18_P MOT18_N cml_tlatch_53.xmux.xp.S1 VSS sg13_lv_nmos ad=56.9f pd=0.74u as=56.9f ps=0.74u w=0.17u l=0.17u
X8642 cml_gate2_4.xrtail.R1 CKB3_P cml_gate2_4.xamp.xn.S1 VSS sg13_lv_nmos ad=0.1007p pd=0.91u as=0.1802p ps=1.74u w=0.53u l=0.13u
X8643 cml_gate2_2.xamp.xn.S1 ENA0_P GA1_N VSS sg13_lv_nmos ad=0.1007p pd=0.91u as=0.1007p ps=0.91u w=0.53u l=0.13u
X8644 cml_tlatch_9.xmux.xp.S1 A0_8_P A0_8_N VSS sg13_lv_nmos ad=56.9f pd=0.74u as=56.9f ps=0.74u w=0.17u l=0.17u
X8645 cml_tlatch_4.INN cml_tlatch_4.INP cml_tlatch_12.xmux.xp.S1 VSS sg13_lv_nmos ad=56.9f pd=0.74u as=56.9f ps=0.74u w=0.17u l=0.17u
X8646 cml_gate2_0.xamp.xn.S1 ENB1_N GB1_P VSS sg13_lv_nmos ad=0.1007p pd=0.91u as=0.1802p ps=1.74u w=0.53u l=0.13u
X8647 stub_bi_49.BOTP stub_bi_55.BOTN cml_tlatch_84.xmux.xn.S1 VSS sg13_lv_nmos ad=63.19999f pd=0.74u as=63.19999f ps=0.74u w=0.26u l=0.38u
X8648 cml_tlatch_23.OUTN cml_tlatch_23.OUTP cml_tlatch_23.xmux.xp.S1 VSS sg13_lv_nmos ad=56.9f pd=0.74u as=56.9f ps=0.74u w=0.17u l=0.17u
X8649 cml_tlatch_38.xmux.xp.S1 CKA0_N cml_tlatch_38.xtail.S1 VSS sg13_lv_nmos ad=89.3f pd=0.85u as=89.3f ps=0.85u w=0.47u l=0.16u
X8650 cml_tlatch_52.xmux.xp.S1 CKHA2_N cml_tlatch_52.xtail.S1 VSS sg13_lv_nmos ad=89.3f pd=0.85u as=89.3f ps=0.85u w=0.47u l=0.16u
X8651 VDD cml_tlatch_63.INP VSS rppd l=5.17u w=1u
X8652 cml_tlatch_0.xmux.xn.S1 CKA0_P cml_tlatch_0.xtail.S1 VSS sg13_lv_nmos ad=89.3f pd=0.85u as=89.3f ps=0.85u w=0.47u l=0.16u
X8653 cml_tlatch_63.xmux.xn.S1 cml_tlatch_63.INP MOT26_N VSS sg13_lv_nmos ad=63.19999f pd=0.74u as=0.1082p ps=1.34u w=0.26u l=0.38u
X8654 cml_tlatch_75.xmux.xn.S1 CKHB3_P cml_tlatch_75.xtail.S1 VSS sg13_lv_nmos ad=89.3f pd=0.85u as=89.3f ps=0.85u w=0.47u l=0.16u
X8655 cml_tlatch_45.xmux.xp.S1 MOT30_P MOT30_N VSS sg13_lv_nmos ad=56.9f pd=0.74u as=56.9f ps=0.74u w=0.17u l=0.17u
X8656 MOT21_P MOT21_N cml_tlatch_79.xmux.xp.S1 VSS sg13_lv_nmos ad=56.9f pd=0.74u as=56.9f ps=0.74u w=0.17u l=0.17u
X8657 stub_bi_55.BOTP stub_bi_55.BOTN cml_tlatch_90.xmux.xp.S1 VSS sg13_lv_nmos ad=56.9f pd=0.74u as=0.1019p ps=1.34u w=0.17u l=0.17u
X8658 cml_tlatch_1.xmux.xn.S1 cml_tlatch_2.OUTN B0_8_P VSS sg13_lv_nmos ad=63.19999f pd=0.74u as=63.19999f ps=0.74u w=0.26u l=0.38u
X8659 cml_tlatch_19.xmux.xn.S1 CKA1_N cml_tlatch_19.xtail.S1 VSS sg13_lv_nmos ad=89.3f pd=0.85u as=89.3f ps=0.85u w=0.47u l=0.16u
X8660 cml_tlatch_74.xmux.xp.S1 MOT29_P MOT29_N VSS sg13_lv_nmos ad=56.9f pd=0.74u as=56.9f ps=0.74u w=0.17u l=0.17u
X8661 cml_tlatch_39.xmux.xp.S1 cml_tlatch_97.INP cml_tlatch_97.INN VSS sg13_lv_nmos ad=56.9f pd=0.74u as=56.9f ps=0.74u w=0.17u l=0.17u
X8662 CLK_W_N CLK_W_P cml_tlatch_93.xmux.xp.S1 VSS sg13_lv_nmos ad=56.9f pd=0.74u as=56.9f ps=0.74u w=0.17u l=0.17u
X8663 cml_tlatch_1.xmux.xn.S1 cml_tlatch_2.OUTN B0_8_P VSS sg13_lv_nmos ad=63.19999f pd=0.74u as=63.19999f ps=0.74u w=0.26u l=0.38u
X8664 cml_tlatch_25.xmux.xn.S1 CKHA1_P cml_tlatch_25.xtail.S1 VSS sg13_lv_nmos ad=89.3f pd=0.85u as=89.3f ps=0.85u w=0.47u l=0.16u
X8665 cml_tlatch_73.xtail.S1 CKHB3_N cml_tlatch_73.xmux.xp.S1 VSS sg13_lv_nmos ad=89.3f pd=0.85u as=89.3f ps=0.85u w=0.47u l=0.16u
X8666 cml_tlatch_27.xmux.xp.S1 MOT2_N MOT2_P VSS sg13_lv_nmos ad=56.9f pd=0.74u as=56.9f ps=0.74u w=0.17u l=0.17u
X8667 MOT14_N MOT14_P cml_tlatch_25.xmux.xp.S1 VSS sg13_lv_nmos ad=56.9f pd=0.74u as=56.9f ps=0.74u w=0.17u l=0.17u
X8668 cml_tlatch_31.xmux.xp.S1 CKB0_P cml_tlatch_31.xtail.S1 VSS sg13_lv_nmos ad=89.3f pd=0.85u as=89.3f ps=0.85u w=0.47u l=0.16u
X8669 VSS POLN cml_tlatch_34.xtail.S1 VSS sg13_lv_nmos ad=2.7982p pd=17.14u as=1.5637p ps=8.61u w=8.23u l=0.13u
X8670 MOT15_N B1_2_P cml_tlatch_6.xmux.xn.S1 VSS sg13_lv_nmos ad=63.19999f pd=0.74u as=63.19999f ps=0.74u w=0.26u l=0.38u
X8671 cml_tlatch_91.xmux.xp.S1 cml_tlatch_91.OUTN cml_tlatch_91.OUTP VSS sg13_lv_nmos ad=56.9f pd=0.74u as=56.9f ps=0.74u w=0.17u l=0.17u
X8672 cml_tlatch_74.INP cml_tlatch_74.INN cml_tlatch_88.xmux.xp.S1 VSS sg13_lv_nmos ad=56.9f pd=0.74u as=56.9f ps=0.74u w=0.17u l=0.17u
X8673 MOT17_N MOT17_P cml_tlatch_77.xmux.xp.S1 VSS sg13_lv_nmos ad=56.9f pd=0.74u as=56.9f ps=0.74u w=0.17u l=0.17u
X8674 cml_tlatch_71.xmux.xp.S1 CKA3_N cml_tlatch_71.xtail.S1 VSS sg13_lv_nmos ad=89.3f pd=0.85u as=89.3f ps=0.85u w=0.47u l=0.16u
X8675 cml_tlatch_72.xmux.xp.S1 MOT25_P MOT25_N VSS sg13_lv_nmos ad=56.9f pd=0.74u as=56.9f ps=0.74u w=0.17u l=0.17u
X8676 cml_tlatch_39.xmux.xp.S1 cml_tlatch_97.INP cml_tlatch_97.INN VSS sg13_lv_nmos ad=56.9f pd=0.74u as=56.9f ps=0.74u w=0.17u l=0.17u
X8677 cml_tlatch_10.xmux.xp.S1 B1_8_N B1_8_P VSS sg13_lv_nmos ad=56.9f pd=0.74u as=56.9f ps=0.74u w=0.17u l=0.17u
X8678 VSS hs_to_clk_8.sg13_lv_nmos_2HGZLP_0.G VSS VSS sg13_lv_nmos ad=2.071p pd=11.28u as=0 ps=0 w=10.9u l=1.38u
X8679 cml_tlatch_99.xmux.xp.S1 cml_tlatch_99.OUTN cml_tlatch_99.OUTP VSS sg13_lv_nmos ad=56.9f pd=0.74u as=56.9f ps=0.74u w=0.17u l=0.17u
X8680 cml_tlatch_16.xmux.xp.S1 MOT5_N MOT5_P VSS sg13_lv_nmos ad=56.9f pd=0.74u as=56.9f ps=0.74u w=0.17u l=0.17u
X8681 MOT14_P MOT14_N cml_tlatch_25.xmux.xp.S1 VSS sg13_lv_nmos ad=56.9f pd=0.74u as=56.9f ps=0.74u w=0.17u l=0.17u
X8682 GB3_N ENB0_P cml_gate2_6.xamp.xn.S1 VSS sg13_lv_nmos ad=0.1007p pd=0.91u as=0.1007p ps=0.91u w=0.53u l=0.13u
X8683 cml_tlatch_42.xmux.xp.S1 CKHA1_N cml_tlatch_42.xtail.S1 VSS sg13_lv_nmos ad=89.3f pd=0.85u as=89.3f ps=0.85u w=0.47u l=0.16u
X8684 cml_tlatch_54.xmux.xp.S1 MOT20_N MOT20_P VSS sg13_lv_nmos ad=56.9f pd=0.74u as=56.9f ps=0.74u w=0.17u l=0.17u
X8685 cml_tlatch_78.xmux.xp.S1 MOT19_N MOT19_P VSS sg13_lv_nmos ad=56.9f pd=0.74u as=56.9f ps=0.74u w=0.17u l=0.17u
X8686 MOT30_N MOT30_P cml_tlatch_45.xmux.xp.S1 VSS sg13_lv_nmos ad=56.9f pd=0.74u as=56.9f ps=0.74u w=0.17u l=0.17u
X8687 cml_gate2_5.xamp.xn.S1 ENA1_N GA2_P VSS sg13_lv_nmos ad=0.1007p pd=0.91u as=0.1802p ps=1.74u w=0.53u l=0.13u
X8688 cml_tlatch_65.xmux.xp.S1 cml_tlatch_65.OUTN cml_tlatch_65.OUTP VSS sg13_lv_nmos ad=56.9f pd=0.74u as=56.9f ps=0.74u w=0.17u l=0.17u
X8689 cml_tlatch_48.xmux.xp.S1 stub_bi_43.BOTN stub_bi_43.BOTP VSS sg13_lv_nmos ad=56.9f pd=0.74u as=56.9f ps=0.74u w=0.17u l=0.17u
X8690 VSS POLN cml_tlatch_40.xtail.S1 VSS sg13_lv_nmos ad=2.7982p pd=17.14u as=1.5637p ps=8.61u w=8.23u l=0.13u
X8691 cml_tlatch_80.xmux.xp.S1 MOT23_P MOT23_N VSS sg13_lv_nmos ad=56.9f pd=0.74u as=56.9f ps=0.74u w=0.17u l=0.17u
X8692 cml_tlatch_24.xtail.S1 CKHA1_N cml_tlatch_24.xmux.xp.S1 VSS sg13_lv_nmos ad=89.3f pd=0.85u as=0.1598p ps=1.62u w=0.47u l=0.16u
X8693 cml_tlatch_32.xmux.xp.S1 cml_tlatch_32.OUTP cml_tlatch_32.OUTN VSS sg13_lv_nmos ad=56.9f pd=0.74u as=56.9f ps=0.74u w=0.17u l=0.17u
X8694 cml_tlatch_15.xtail.S1 CKHB0_P cml_tlatch_15.xmux.xn.S1 VSS sg13_lv_nmos ad=89.3f pd=0.85u as=89.3f ps=0.85u w=0.47u l=0.16u
X8695 cml_tlatch_35.xmux.xp.S1 CKB1_N cml_tlatch_35.xtail.S1 VSS sg13_lv_nmos ad=89.3f pd=0.85u as=89.3f ps=0.85u w=0.47u l=0.16u
X8696 cml_tlatch_86.xmux.xp.S1 cml_tlatch_86.OUTP cml_tlatch_86.OUTN VSS sg13_lv_nmos ad=56.9f pd=0.74u as=56.9f ps=0.74u w=0.17u l=0.17u
X8697 cml_tlatch_48.xtail.S1 CKB2_P cml_tlatch_48.xmux.xn.S1 VSS sg13_lv_nmos ad=89.3f pd=0.85u as=89.3f ps=0.85u w=0.47u l=0.16u
X8698 CKA1_P CK_P hs_to_clk_3.D2 VSS sg13_lv_nmos ad=0.228p pd=1.58u as=0.408p ps=3.08u w=1.2u l=0.2u
X8699 cml_tlatch_87.xmux.xp.S1 cml_tlatch_87.OUTP cml_tlatch_87.OUTN VSS sg13_lv_nmos ad=56.9f pd=0.74u as=56.9f ps=0.74u w=0.17u l=0.17u
X8700 cml_tlatch_76.xtail.S1 POLN VSS VSS sg13_lv_nmos ad=1.5637p pd=8.61u as=1.5637p ps=8.61u w=8.23u l=0.13u
X8701 stub_bi_63.BOTN stub_bi_63.BOTP cml_tlatch_83.xmux.xp.S1 VSS sg13_lv_nmos ad=56.9f pd=0.74u as=56.9f ps=0.74u w=0.17u l=0.17u
X8702 B0_8_N B0_8_P cml_tlatch_1.xmux.xp.S1 VSS sg13_lv_nmos ad=56.9f pd=0.74u as=56.9f ps=0.74u w=0.17u l=0.17u
X8703 cml_tlatch_33.xmux.xn.S1 A0_2_N cml_tlatch_33.OUTP VSS sg13_lv_nmos ad=63.19999f pd=0.74u as=63.19999f ps=0.74u w=0.26u l=0.38u
X8704 cml_tlatch_59.xmux.xp.S1 CKA2_N cml_tlatch_59.xtail.S1 VSS sg13_lv_nmos ad=89.3f pd=0.85u as=89.3f ps=0.85u w=0.47u l=0.16u
X8705 MOT30_P MOT30_N cml_tlatch_45.xmux.xp.S1 VSS sg13_lv_nmos ad=56.9f pd=0.74u as=56.9f ps=0.74u w=0.17u l=0.17u
X8706 cml_tlatch_52.xmux.xp.S1 MOT16_P MOT16_N VSS sg13_lv_nmos ad=56.9f pd=0.74u as=56.9f ps=0.74u w=0.17u l=0.17u
X8707 cml_tlatch_12.xtail.S1 CKB1_P cml_tlatch_12.xmux.xp.S1 VSS sg13_lv_nmos ad=89.3f pd=0.85u as=89.3f ps=0.85u w=0.47u l=0.16u
X8708 MOT24_N MOT24_P cml_tlatch_62.xmux.xp.S1 VSS sg13_lv_nmos ad=56.9f pd=0.74u as=56.9f ps=0.74u w=0.17u l=0.17u
X8709 ENB_P NS1_N cml_gate2_8.xrtail.R1 VSS sg13_lv_nmos ad=0.1007p pd=0.91u as=0.1007p ps=0.91u w=0.53u l=0.13u
X8710 B3_8_N cml_tlatch_65.OUTP cml_tlatch_64.xmux.xn.S1 VSS sg13_lv_nmos ad=63.19999f pd=0.74u as=63.19999f ps=0.74u w=0.26u l=0.38u
X8711 cml_tlatch_6.xmux.xp.S1 MOT15_P MOT15_N VSS sg13_lv_nmos ad=56.9f pd=0.74u as=56.9f ps=0.74u w=0.17u l=0.17u
X8712 cml_gate2_9.xamp.xn.S1 J1_P ENA_N VSS sg13_lv_nmos ad=0.1007p pd=0.91u as=0.1007p ps=0.91u w=0.53u l=0.13u
X8713 MOT3_P MOT3_N cml_tlatch_15.xmux.xp.S1 VSS sg13_lv_nmos ad=56.9f pd=0.74u as=56.9f ps=0.74u w=0.17u l=0.17u
X8714 cml_tlatch_8.xmux.xp.S1 CKB0_N cml_tlatch_8.xtail.S1 VSS sg13_lv_nmos ad=89.3f pd=0.85u as=89.3f ps=0.85u w=0.47u l=0.16u
X8715 cml_tlatch_40.xmux.xn.S1 CKA1_N cml_tlatch_40.xtail.S1 VSS sg13_lv_nmos ad=89.3f pd=0.85u as=89.3f ps=0.85u w=0.47u l=0.16u
X8716 cml_tlatch_13.xmux.xp.S1 CKB1_N cml_tlatch_13.xtail.S1 VSS sg13_lv_nmos ad=89.3f pd=0.85u as=89.3f ps=0.85u w=0.47u l=0.16u
X8717 cml_tlatch_92.xmux.xn.S1 CKJ_N cml_tlatch_92.xtail.S1 VSS sg13_lv_nmos ad=89.3f pd=0.85u as=0.1598p ps=1.62u w=0.47u l=0.16u
X8718 A3_8_P cml_tlatch_69.OUTN cml_tlatch_68.xmux.xn.S1 VSS sg13_lv_nmos ad=63.19999f pd=0.74u as=63.19999f ps=0.74u w=0.26u l=0.38u
X8719 cml_tlatch_72.xmux.xn.S1 CKHB3_P cml_tlatch_72.xtail.S1 VSS sg13_lv_nmos ad=89.3f pd=0.85u as=89.3f ps=0.85u w=0.47u l=0.16u
X8720 cml_tlatch_83.xmux.xn.S1 stub_bi_49.BOTP stub_bi_63.BOTN VSS sg13_lv_nmos ad=0.1082p pd=1.34u as=63.19999f ps=0.74u w=0.26u l=0.38u
X8721 cml_drv_3.xrtail.R1 ENA_N ENA0_P VSS sg13_lv_nmos ad=56.2f pd=0.74u as=56.2f ps=0.74u w=0.16u l=0.19u
X8722 cml_tlatch_66.xmux.xn.S1 CKB3_N cml_tlatch_66.xtail.S1 VSS sg13_lv_nmos ad=89.3f pd=0.85u as=89.3f ps=0.85u w=0.47u l=0.16u
X8723 cml_tlatch_85.xmux.xp.S1 A2_8_P A2_8_N VSS sg13_lv_nmos ad=56.9f pd=0.74u as=56.9f ps=0.74u w=0.17u l=0.17u
X8724 cml_tlatch_2.OUTN cml_tlatch_2.OUTP cml_tlatch_2.xmux.xp.S1 VSS sg13_lv_nmos ad=56.9f pd=0.74u as=56.9f ps=0.74u w=0.17u l=0.17u
X8725 cml_tlatch_40.xmux.xp.S1 A1_2_N A1_2_P VSS sg13_lv_nmos ad=56.9f pd=0.74u as=56.9f ps=0.74u w=0.17u l=0.17u
X8726 CLK_W_N CLK_W_P cml_tlatch_93.xmux.xp.S1 VSS sg13_lv_nmos ad=56.9f pd=0.74u as=56.9f ps=0.74u w=0.17u l=0.17u
X8727 cml_tlatch_71.OUTN cml_tlatch_71.OUTP cml_tlatch_71.xmux.xp.S1 VSS sg13_lv_nmos ad=56.9f pd=0.74u as=56.9f ps=0.74u w=0.17u l=0.17u
X8728 cml_tlatch_52.xmux.xp.S1 MOT16_N MOT16_P VSS sg13_lv_nmos ad=56.9f pd=0.74u as=56.9f ps=0.74u w=0.17u l=0.17u
X8729 cml_tlatch_16.xmux.xn.S1 CKHB0_P cml_tlatch_16.xtail.S1 VSS sg13_lv_nmos ad=0.1598p pd=1.62u as=89.3f ps=0.85u w=0.47u l=0.16u
X8730 cml_tlatch_78.xtail.S1 CKHB2_P cml_tlatch_78.xmux.xn.S1 VSS sg13_lv_nmos ad=89.3f pd=0.85u as=89.3f ps=0.85u w=0.47u l=0.16u
X8731 stub_bi_49.BOTN stub_bi_49.BOTP cml_tlatch_84.xmux.xp.S1 VSS sg13_lv_nmos ad=56.9f pd=0.74u as=56.9f ps=0.74u w=0.17u l=0.17u
X8732 cml_tlatch_23.xmux.xp.S1 cml_tlatch_23.OUTN cml_tlatch_23.OUTP VSS sg13_lv_nmos ad=56.9f pd=0.74u as=56.9f ps=0.74u w=0.17u l=0.17u
X8733 cml_gate2_5.xrtail.R1 CKB2_P cml_gate2_5.xamp.xn.S1 VSS sg13_lv_nmos ad=0.1007p pd=0.91u as=0.1007p ps=0.91u w=0.53u l=0.13u
X8734 cml_tlatch_4.INN stub_bi_17.BOTN cml_tlatch_12.xmux.xn.S1 VSS sg13_lv_nmos ad=63.19999f pd=0.74u as=63.19999f ps=0.74u w=0.26u l=0.38u
X8735 VSS POLN hs_to_clk_1.D2 VSS sg13_lv_nmos ad=1.9p pd=10.38u as=3.4p ps=20.68u w=10u l=0.13u
X8736 A1_2_N A1_2_P cml_tlatch_40.xmux.xp.S1 VSS sg13_lv_nmos ad=56.9f pd=0.74u as=56.9f ps=0.74u w=0.17u l=0.17u
X8737 cml_tlatch_89.xmux.xn.S1 cml_tlatch_56.OUTN cml_tlatch_44.INP VSS sg13_lv_nmos ad=63.19999f pd=0.74u as=63.19999f ps=0.74u w=0.26u l=0.38u
X8738 MOT21_P MOT21_N cml_tlatch_79.xmux.xp.S1 VSS sg13_lv_nmos ad=56.9f pd=0.74u as=56.9f ps=0.74u w=0.17u l=0.17u
X8739 cml_tlatch_59.xmux.xp.S1 cml_tlatch_91.INN cml_tlatch_91.INP VSS sg13_lv_nmos ad=56.9f pd=0.74u as=56.9f ps=0.74u w=0.17u l=0.17u
X8740 cml_tlatch_36.xmux.xp.S1 B1_2_P B1_2_N VSS sg13_lv_nmos ad=56.9f pd=0.74u as=56.9f ps=0.74u w=0.17u l=0.17u
X8741 cml_tlatch_74.xmux.xp.S1 MOT29_N MOT29_P VSS sg13_lv_nmos ad=56.9f pd=0.74u as=56.9f ps=0.74u w=0.17u l=0.17u
X8742 cml_tlatch_17.xmux.xp.S1 MOT7_N MOT7_P VSS sg13_lv_nmos ad=56.9f pd=0.74u as=56.9f ps=0.74u w=0.17u l=0.17u
X8743 cml_tlatch_65.xtail.S1 CKB3_N cml_tlatch_65.xmux.xp.S1 VSS sg13_lv_nmos ad=89.3f pd=0.85u as=0.1598p ps=1.62u w=0.47u l=0.16u
X8744 cml_tlatch_50.xmux.xn.S1 cml_tlatch_51.OUTN B3_2_P VSS sg13_lv_nmos ad=0.1082p pd=1.34u as=63.19999f ps=0.74u w=0.26u l=0.38u
X8745 cml_tlatch_51.xmux.xp.S1 cml_tlatch_51.OUTN cml_tlatch_51.OUTP VSS sg13_lv_nmos ad=56.9f pd=0.74u as=56.9f ps=0.74u w=0.17u l=0.17u
X8746 cml_tlatch_15.xmux.xp.S1 CKHB0_N cml_tlatch_15.xtail.S1 VSS sg13_lv_nmos ad=89.3f pd=0.85u as=89.3f ps=0.85u w=0.47u l=0.16u
X8747 MOT11_P MOT11_N cml_tlatch_4.xmux.xp.S1 VSS sg13_lv_nmos ad=56.9f pd=0.74u as=0.1019p ps=1.34u w=0.17u l=0.17u
X8748 cml_tlatch_50.xmux.xn.S1 cml_tlatch_51.OUTN B3_2_P VSS sg13_lv_nmos ad=63.19999f pd=0.74u as=63.19999f ps=0.74u w=0.26u l=0.38u
X8749 cml_tlatch_91.xmux.xp.S1 cml_tlatch_91.OUTN cml_tlatch_91.OUTP VSS sg13_lv_nmos ad=56.9f pd=0.74u as=56.9f ps=0.74u w=0.17u l=0.17u
X8750 cml_tlatch_22.xmux.xp.S1 cml_tlatch_22.OUTP cml_tlatch_22.OUTN VSS sg13_lv_nmos ad=56.9f pd=0.74u as=56.9f ps=0.74u w=0.17u l=0.17u
X8751 cml_tlatch_1.xmux.xn.S1 cml_tlatch_2.OUTP B0_8_N VSS sg13_lv_nmos ad=63.19999f pd=0.74u as=63.19999f ps=0.74u w=0.26u l=0.38u
X8752 cml_tlatch_58.OUTN cml_tlatch_58.OUTP cml_tlatch_58.xmux.xp.S1 VSS sg13_lv_nmos ad=56.9f pd=0.74u as=56.9f ps=0.74u w=0.17u l=0.17u
X8753 cml_tlatch_18.xmux.xp.S1 cml_tlatch_18.OUTN cml_tlatch_18.OUTP VSS sg13_lv_nmos ad=56.9f pd=0.74u as=56.9f ps=0.74u w=0.17u l=0.17u
X8754 cml_tlatch_40.xmux.xn.S1 cml_tlatch_41.OUTN A1_2_P VSS sg13_lv_nmos ad=63.19999f pd=0.74u as=63.19999f ps=0.74u w=0.26u l=0.38u
X8755 cml_tlatch_79.xmux.xp.S1 CKHB2_N cml_tlatch_79.xtail.S1 VSS sg13_lv_nmos ad=89.3f pd=0.85u as=89.3f ps=0.85u w=0.47u l=0.16u
X8756 cml_tlatch_18.xtail.S1 CKA0_P cml_tlatch_18.xmux.xn.S1 VSS sg13_lv_nmos ad=89.3f pd=0.85u as=89.3f ps=0.85u w=0.47u l=0.16u
X8757 cml_tlatch_72.xmux.xp.S1 MOT25_P MOT25_N VSS sg13_lv_nmos ad=56.9f pd=0.74u as=56.9f ps=0.74u w=0.17u l=0.17u
X8758 MOT20_P cml_tlatch_91.OUTN cml_tlatch_54.xmux.xn.S1 VSS sg13_lv_nmos ad=63.19999f pd=0.74u as=0.1082p ps=1.34u w=0.26u l=0.38u
X8759 cml_tlatch_31.xmux.xp.S1 B0_2_P B0_2_N VSS sg13_lv_nmos ad=56.9f pd=0.74u as=56.9f ps=0.74u w=0.17u l=0.17u
X8760 cml_tlatch_36.xmux.xp.S1 CKB1_P cml_tlatch_36.xtail.S1 VSS sg13_lv_nmos ad=89.3f pd=0.85u as=89.3f ps=0.85u w=0.47u l=0.16u
X8761 cml_tlatch_99.OUTN cml_tlatch_99.OUTP cml_tlatch_99.xmux.xp.S1 VSS sg13_lv_nmos ad=56.9f pd=0.74u as=56.9f ps=0.74u w=0.17u l=0.17u
X8762 cml_tlatch_98.OUTP cml_tlatch_98.OUTN cml_tlatch_98.xmux.xp.S1 VSS sg13_lv_nmos ad=56.9f pd=0.74u as=0.1019p ps=1.34u w=0.17u l=0.17u
X8763 cml_tlatch_34.xmux.xp.S1 CKA0_P cml_tlatch_34.xtail.S1 VSS sg13_lv_nmos ad=89.3f pd=0.85u as=0.1598p ps=1.62u w=0.47u l=0.16u
X8764 cml_tlatch_97.xtail.S1 CKA1_N cml_tlatch_97.xmux.xn.S1 VSS sg13_lv_nmos ad=89.3f pd=0.85u as=89.3f ps=0.85u w=0.47u l=0.16u
X8765 cml_tlatch_2.OUTP cml_tlatch_7.OUTN cml_tlatch_2.xmux.xn.S1 VSS sg13_lv_nmos ad=63.19999f pd=0.74u as=63.19999f ps=0.74u w=0.26u l=0.38u
X8766 MOT9_N MOT9_P cml_tlatch_3.xmux.xp.S1 VSS sg13_lv_nmos ad=56.9f pd=0.74u as=56.9f ps=0.74u w=0.17u l=0.17u
X8767 cml_gate2_2.xamp.xn.S1 CKB1_P cml_gate2_2.xrtail.R1 VSS sg13_lv_nmos ad=0.1007p pd=0.91u as=0.1007p ps=0.91u w=0.53u l=0.13u
X8768 cml_tlatch_4.xtail.S1 CKHB1_P cml_tlatch_4.xmux.xn.S1 VSS sg13_lv_nmos ad=89.3f pd=0.85u as=89.3f ps=0.85u w=0.47u l=0.16u
X8769 cml_tlatch_86.xtail.S1 CKA2_N cml_tlatch_86.xmux.xp.S1 VSS sg13_lv_nmos ad=89.3f pd=0.85u as=89.3f ps=0.85u w=0.47u l=0.16u
X8770 cml_drvb_4.xrtail.R2 GA3_P CKHA3_N VSS sg13_lv_nmos ad=0.1463p pd=1.15u as=0.2618p ps=2.22u w=0.77u l=0.21u
X8771 A1_8_N A1_8_P cml_tlatch_19.xmux.xp.S1 VSS sg13_lv_nmos ad=56.9f pd=0.74u as=56.9f ps=0.74u w=0.17u l=0.17u
X8772 cml_tlatch_61.xtail.S1 CKA2_N cml_tlatch_61.xmux.xp.S1 VSS sg13_lv_nmos ad=89.3f pd=0.85u as=89.3f ps=0.85u w=0.47u l=0.16u
X8773 MOT17_P MOT17_N cml_tlatch_77.xmux.xp.S1 VSS sg13_lv_nmos ad=56.9f pd=0.74u as=56.9f ps=0.74u w=0.17u l=0.17u
X8774 cml_tlatch_39.xmux.xn.S1 CKA1_P cml_tlatch_39.xtail.S1 VSS sg13_lv_nmos ad=89.3f pd=0.85u as=89.3f ps=0.85u w=0.47u l=0.16u
X8775 A3_2_P A3_2_N cml_tlatch_57.xmux.xp.S1 VSS sg13_lv_nmos ad=56.9f pd=0.74u as=56.9f ps=0.74u w=0.17u l=0.17u
X8776 cml_gate2_1.xrtail.R1 CKA0_N GB0_P VSS sg13_lv_nmos ad=0.1007p pd=0.91u as=0.1802p ps=1.74u w=0.53u l=0.13u
X8777 cml_tlatch_62.xmux.xp.S1 MOT24_N MOT24_P VSS sg13_lv_nmos ad=56.9f pd=0.74u as=56.9f ps=0.74u w=0.17u l=0.17u
X8778 cml_gate2_2.xrtail.R1 CKB1_P cml_gate2_2.xamp.xn.S1 VSS sg13_lv_nmos ad=0.1007p pd=0.91u as=0.1007p ps=0.91u w=0.53u l=0.13u
X8779 MOT31_N MOT31_P cml_tlatch_75.xmux.xp.S1 VSS sg13_lv_nmos ad=56.9f pd=0.74u as=56.9f ps=0.74u w=0.17u l=0.17u
X8780 GB2_N ENB0_P cml_gate2_7.xamp.xn.S1 VSS sg13_lv_nmos ad=0.1007p pd=0.91u as=0.1007p ps=0.91u w=0.53u l=0.13u
X8781 MOT10_N cml_tlatch_43.INP cml_tlatch_43.xmux.xn.S1 VSS sg13_lv_nmos ad=63.19999f pd=0.74u as=63.19999f ps=0.74u w=0.26u l=0.38u
X8782 cml_tlatch_59.xmux.xn.S1 CKA2_P cml_tlatch_59.xtail.S1 VSS sg13_lv_nmos ad=0.1598p pd=1.62u as=89.3f ps=0.85u w=0.47u l=0.16u
X8783 cml_tlatch_5.INN stub_bi_29.BOTN cml_tlatch_96.xmux.xn.S1 VSS sg13_lv_nmos ad=63.19999f pd=0.74u as=63.19999f ps=0.74u w=0.26u l=0.38u
X8784 cml_tlatch_70.xmux.xp.S1 CKA3_P cml_tlatch_70.xtail.S1 VSS sg13_lv_nmos ad=89.3f pd=0.85u as=89.3f ps=0.85u w=0.47u l=0.16u
X8785 cml_tlatch_77.xmux.xn.S1 B2_8_P MOT17_N VSS sg13_lv_nmos ad=63.19999f pd=0.74u as=63.19999f ps=0.74u w=0.26u l=0.38u
X8786 cml_tlatch_87.xmux.xp.S1 cml_tlatch_87.OUTP cml_tlatch_87.OUTN VSS sg13_lv_nmos ad=56.9f pd=0.74u as=56.9f ps=0.74u w=0.17u l=0.17u
X8787 cml_tlatch_98.xmux.xn.S1 CKB0_N cml_tlatch_98.xtail.S1 VSS sg13_lv_nmos ad=89.3f pd=0.85u as=89.3f ps=0.85u w=0.47u l=0.16u
X8788 MOT7_P B0_2_N cml_tlatch_17.xmux.xn.S1 VSS sg13_lv_nmos ad=63.19999f pd=0.74u as=63.19999f ps=0.74u w=0.26u l=0.38u
X8789 MOT4_N MOT4_P cml_tlatch_28.xmux.xp.S1 VSS sg13_lv_nmos ad=56.9f pd=0.74u as=56.9f ps=0.74u w=0.17u l=0.17u
X8790 stub_bi_63.BOTN stub_bi_63.BOTP cml_tlatch_83.xmux.xp.S1 VSS sg13_lv_nmos ad=56.9f pd=0.74u as=56.9f ps=0.74u w=0.17u l=0.17u
X8791 stub_bi_63.BOTP stub_bi_63.BOTN cml_tlatch_83.xmux.xp.S1 VSS sg13_lv_nmos ad=56.9f pd=0.74u as=56.9f ps=0.74u w=0.17u l=0.17u
X8792 MOT10_N cml_tlatch_43.INP cml_tlatch_43.xmux.xn.S1 VSS sg13_lv_nmos ad=63.19999f pd=0.74u as=63.19999f ps=0.74u w=0.26u l=0.38u
X8793 cml_tlatch_21.xmux.xp.S1 cml_tlatch_43.INN cml_tlatch_43.INP VSS sg13_lv_nmos ad=56.9f pd=0.74u as=56.9f ps=0.74u w=0.17u l=0.17u
X8794 VDD cml_tlatch_56.OUTN VSS rppd l=5.17u w=1u
X8795 cml_tlatch_6.xmux.xp.S1 MOT15_P MOT15_N VSS sg13_lv_nmos ad=56.9f pd=0.74u as=56.9f ps=0.74u w=0.17u l=0.17u
X8796 cml_tlatch_97.INP cml_tlatch_97.INN cml_tlatch_39.xmux.xp.S1 VSS sg13_lv_nmos ad=56.9f pd=0.74u as=56.9f ps=0.74u w=0.17u l=0.17u
X8797 cml_tlatch_48.xtail.S1 CKB2_N cml_tlatch_48.xmux.xp.S1 VSS sg13_lv_nmos ad=0.1598p pd=1.62u as=89.3f ps=0.85u w=0.47u l=0.16u
X8798 cml_tlatch_8.xmux.xn.S1 cml_tlatch_98.OUTN cml_tlatch_8.OUTP VSS sg13_lv_nmos ad=63.19999f pd=0.74u as=0.1082p ps=1.34u w=0.26u l=0.38u
X8799 cml_tlatch_95.xmux.xn.S1 J4_P J1_P VSS sg13_lv_nmos ad=63.19999f pd=0.74u as=63.19999f ps=0.74u w=0.26u l=0.38u
X8800 cml_tlatch_20.OUTN cml_tlatch_20.OUTP cml_tlatch_20.xmux.xp.S1 VSS sg13_lv_nmos ad=56.9f pd=0.74u as=56.9f ps=0.74u w=0.17u l=0.17u
X8801 cml_tlatch_71.xmux.xp.S1 cml_tlatch_71.OUTN cml_tlatch_71.OUTP VSS sg13_lv_nmos ad=56.9f pd=0.74u as=56.9f ps=0.74u w=0.17u l=0.17u
X8802 cml_tlatch_61.OUTP D2_N cml_tlatch_61.xmux.xn.S1 VSS sg13_lv_nmos ad=63.19999f pd=0.74u as=63.19999f ps=0.74u w=0.26u l=0.38u
X8803 cml_tlatch_97.xmux.xp.S1 CKA1_P cml_tlatch_97.xtail.S1 VSS sg13_lv_nmos ad=89.3f pd=0.85u as=0.1598p ps=1.62u w=0.47u l=0.16u
X8804 cml_tlatch_53.xmux.xp.S1 MOT18_P MOT18_N VSS sg13_lv_nmos ad=56.9f pd=0.74u as=56.9f ps=0.74u w=0.17u l=0.17u
X8805 cml_tlatch_1.xtail.S1 CKB0_N cml_tlatch_1.xmux.xn.S1 VSS sg13_lv_nmos ad=0.1598p pd=1.62u as=89.3f ps=0.85u w=0.47u l=0.16u
X8806 cml_tlatch_89.xmux.xp.S1 cml_tlatch_44.INP cml_tlatch_44.INN VSS sg13_lv_nmos ad=56.9f pd=0.74u as=56.9f ps=0.74u w=0.17u l=0.17u
X8807 cml_tlatch_26.xtail.S1 CKHA0_P cml_tlatch_26.xmux.xn.S1 VSS sg13_lv_nmos ad=89.3f pd=0.85u as=89.3f ps=0.85u w=0.47u l=0.16u
X8808 CKB1_P CK_N hs_to_clk_2.D2 VSS sg13_lv_nmos ad=0.228p pd=1.58u as=0.228p ps=1.58u w=1.2u l=0.2u
X8809 cml_tlatch_66.xmux.xp.S1 CKB3_P cml_tlatch_66.xtail.S1 VSS sg13_lv_nmos ad=89.3f pd=0.85u as=89.3f ps=0.85u w=0.47u l=0.16u
X8810 cml_tlatch_38.xmux.xp.S1 cml_tlatch_38.OUTN cml_tlatch_38.OUTP VSS sg13_lv_nmos ad=56.9f pd=0.74u as=56.9f ps=0.74u w=0.17u l=0.17u
X8811 cml_tlatch_98.OUTP cml_tlatch_98.OUTN cml_tlatch_98.xmux.xp.S1 VSS sg13_lv_nmos ad=56.9f pd=0.74u as=56.9f ps=0.74u w=0.17u l=0.17u
X8812 cml_tlatch_22.OUTP cml_tlatch_22.OUTN cml_tlatch_22.xmux.xp.S1 VSS sg13_lv_nmos ad=56.9f pd=0.74u as=56.9f ps=0.74u w=0.17u l=0.17u
X8813 stub_bi_62.BOTN stub_bi_62.BOTP cml_tlatch_82.xmux.xp.S1 VSS sg13_lv_nmos ad=56.9f pd=0.74u as=56.9f ps=0.74u w=0.17u l=0.17u
X8814 MOT14_P VDD VSS rppd l=5.17u w=1u
X8815 cml_tlatch_96.xmux.xp.S1 cml_tlatch_5.INP cml_tlatch_5.INN VSS sg13_lv_nmos ad=56.9f pd=0.74u as=56.9f ps=0.74u w=0.17u l=0.17u
X8816 cml_tlatch_0.xmux.xn.S1 CKA0_P cml_tlatch_0.xtail.S1 VSS sg13_lv_nmos ad=89.3f pd=0.85u as=89.3f ps=0.85u w=0.47u l=0.16u
X8817 cml_tlatch_22.xmux.xn.S1 cml_tlatch_24.INN cml_tlatch_22.OUTP VSS sg13_lv_nmos ad=63.19999f pd=0.74u as=63.19999f ps=0.74u w=0.26u l=0.38u
X8818 cml_gate2_6.xrtail.R1 CKA3_P cml_gate2_6.xamp.xn.S1 VSS sg13_lv_nmos ad=0.1007p pd=0.91u as=0.1802p ps=1.74u w=0.53u l=0.13u
X8819 cml_tlatch_32.OUTN D0_P cml_tlatch_32.xmux.xn.S1 VSS sg13_lv_nmos ad=63.19999f pd=0.74u as=63.19999f ps=0.74u w=0.26u l=0.38u
X8820 cml_gate2_0.xamp.xn.S1 ENB1_P GB1_N VSS sg13_lv_nmos ad=0.1007p pd=0.91u as=0.1007p ps=0.91u w=0.53u l=0.13u
X8821 cml_tlatch_36.xmux.xp.S1 B1_2_P B1_2_N VSS sg13_lv_nmos ad=56.9f pd=0.74u as=56.9f ps=0.74u w=0.17u l=0.17u
X8822 GA3_P CKB3_N cml_gate2_4.xrtail.R1 VSS sg13_lv_nmos ad=0.1007p pd=0.91u as=0.1007p ps=0.91u w=0.53u l=0.13u
X8823 cml_tlatch_22.OUTP cml_tlatch_22.OUTN cml_tlatch_22.xmux.xp.S1 VSS sg13_lv_nmos ad=56.9f pd=0.74u as=56.9f ps=0.74u w=0.17u l=0.17u
X8824 cml_tlatch_68.xmux.xp.S1 A3_8_P A3_8_N VSS sg13_lv_nmos ad=56.9f pd=0.74u as=56.9f ps=0.74u w=0.17u l=0.17u
X8825 cml_tlatch_46.xmux.xn.S1 B2_2_N stub_bi_38.BOTN VSS sg13_lv_nmos ad=63.19999f pd=0.74u as=63.19999f ps=0.74u w=0.26u l=0.38u
X8826 cml_tlatch_30.xmux.xp.S1 cml_tlatch_30.OUTP cml_tlatch_30.OUTN VSS sg13_lv_nmos ad=56.9f pd=0.74u as=56.9f ps=0.74u w=0.17u l=0.17u
X8827 cml_tlatch_22.OUTN cml_tlatch_24.INP cml_tlatch_22.xmux.xn.S1 VSS sg13_lv_nmos ad=63.19999f pd=0.74u as=63.19999f ps=0.74u w=0.26u l=0.38u
X8828 cml_tlatch_93.xmux.xn.S1 J2_P CLK_W_P VSS sg13_lv_nmos ad=63.19999f pd=0.74u as=63.19999f ps=0.74u w=0.26u l=0.38u
X8829 cml_tlatch_0.OUTN cml_tlatch_0.OUTP cml_tlatch_0.xmux.xp.S1 VSS sg13_lv_nmos ad=56.9f pd=0.74u as=56.9f ps=0.74u w=0.17u l=0.17u
X8830 MOT29_N cml_tlatch_74.INP cml_tlatch_74.xmux.xn.S1 VSS sg13_lv_nmos ad=63.19999f pd=0.74u as=63.19999f ps=0.74u w=0.26u l=0.38u
X8831 cml_tlatch_42.xmux.xn.S1 A1_8_P MOT8_N VSS sg13_lv_nmos ad=63.19999f pd=0.74u as=63.19999f ps=0.74u w=0.26u l=0.38u
X8832 cml_tlatch_44.xtail.S1 POLN VSS VSS sg13_lv_nmos ad=1.5637p pd=8.61u as=1.5637p ps=8.61u w=8.23u l=0.13u
X8833 cml_tlatch_58.OUTN cml_tlatch_58.OUTP cml_tlatch_58.xmux.xp.S1 VSS sg13_lv_nmos ad=56.9f pd=0.74u as=56.9f ps=0.74u w=0.17u l=0.17u
X8834 cml_tlatch_55.xmux.xp.S1 MOT22_P MOT22_N VSS sg13_lv_nmos ad=56.9f pd=0.74u as=56.9f ps=0.74u w=0.17u l=0.17u
X8835 cml_tlatch_31.xmux.xp.S1 CKB0_P cml_tlatch_31.xtail.S1 VSS sg13_lv_nmos ad=89.3f pd=0.85u as=89.3f ps=0.85u w=0.47u l=0.16u
X8836 cml_tlatch_18.xmux.xp.S1 cml_tlatch_18.OUTN cml_tlatch_18.OUTP VSS sg13_lv_nmos ad=56.9f pd=0.74u as=56.9f ps=0.74u w=0.17u l=0.17u
X8837 J4_N J4_P cml_tlatch_92.xmux.xp.S1 VSS sg13_lv_nmos ad=56.9f pd=0.74u as=56.9f ps=0.74u w=0.17u l=0.17u
X8838 cml_tlatch_51.xmux.xp.S1 cml_tlatch_51.OUTP cml_tlatch_51.OUTN VSS sg13_lv_nmos ad=56.9f pd=0.74u as=56.9f ps=0.74u w=0.17u l=0.17u
X8839 cml_tlatch_10.xmux.xp.S1 B1_8_P B1_8_N VSS sg13_lv_nmos ad=56.9f pd=0.74u as=56.9f ps=0.74u w=0.17u l=0.17u
X8840 cml_tlatch_13.xtail.S1 CKB1_P cml_tlatch_13.xmux.xn.S1 VSS sg13_lv_nmos ad=0.1598p pd=1.62u as=89.3f ps=0.85u w=0.47u l=0.16u
X8841 cml_tlatch_3.xmux.xp.S1 MOT9_N MOT9_P VSS sg13_lv_nmos ad=56.9f pd=0.74u as=56.9f ps=0.74u w=0.17u l=0.17u
X8842 cml_tlatch_6.xmux.xn.S1 CKHB1_P cml_tlatch_6.xtail.S1 VSS sg13_lv_nmos ad=89.3f pd=0.85u as=89.3f ps=0.85u w=0.47u l=0.16u
X8843 cml_tlatch_31.xmux.xp.S1 B0_2_P B0_2_N VSS sg13_lv_nmos ad=56.9f pd=0.74u as=56.9f ps=0.74u w=0.17u l=0.17u
X8844 cml_tlatch_56.xmux.xp.S1 cml_tlatch_56.OUTN cml_tlatch_56.OUTP VSS sg13_lv_nmos ad=56.9f pd=0.74u as=56.9f ps=0.74u w=0.17u l=0.17u
X8845 MOT2_P MOT2_N cml_tlatch_27.xmux.xp.S1 VSS sg13_lv_nmos ad=56.9f pd=0.74u as=0.1019p ps=1.34u w=0.17u l=0.17u
X8846 B1_8_P stub_bi_15.BOTP cml_tlatch_10.xmux.xn.S1 VSS sg13_lv_nmos ad=63.19999f pd=0.74u as=63.19999f ps=0.74u w=0.26u l=0.38u
X8847 cml_tlatch_78.xmux.xn.S1 CKHB2_P cml_tlatch_78.xtail.S1 VSS sg13_lv_nmos ad=89.3f pd=0.85u as=89.3f ps=0.85u w=0.47u l=0.16u
X8848 stub_bi_31.BOTP stub_bi_31.BOTN cml_tlatch_37.xmux.xp.S1 VSS sg13_lv_nmos ad=56.9f pd=0.74u as=56.9f ps=0.74u w=0.17u l=0.17u
X8849 cml_tlatch_69.xmux.xp.S1 cml_tlatch_69.OUTP cml_tlatch_69.OUTN VSS sg13_lv_nmos ad=56.9f pd=0.74u as=56.9f ps=0.74u w=0.17u l=0.17u
X8850 MOT19_N MOT19_P cml_tlatch_78.xmux.xp.S1 VSS sg13_lv_nmos ad=56.9f pd=0.74u as=56.9f ps=0.74u w=0.17u l=0.17u
X8851 cml_tlatch_7.xmux.xp.S1 cml_tlatch_7.OUTN cml_tlatch_7.OUTP VSS sg13_lv_nmos ad=56.9f pd=0.74u as=56.9f ps=0.74u w=0.17u l=0.17u
X8852 cml_tlatch_42.xmux.xp.S1 CKHA1_N cml_tlatch_42.xtail.S1 VSS sg13_lv_nmos ad=89.3f pd=0.85u as=89.3f ps=0.85u w=0.47u l=0.16u
X8853 cml_tlatch_50.xtail.S1 CKB3_P cml_tlatch_50.xmux.xp.S1 VSS sg13_lv_nmos ad=89.3f pd=0.85u as=89.3f ps=0.85u w=0.47u l=0.16u
X8854 cml_tlatch_35.xmux.xp.S1 stub_bi_29.BOTP stub_bi_29.BOTN VSS sg13_lv_nmos ad=56.9f pd=0.74u as=56.9f ps=0.74u w=0.17u l=0.17u
X8855 cml_tlatch_25.xmux.xn.S1 A1_2_P MOT14_N VSS sg13_lv_nmos ad=63.19999f pd=0.74u as=0.1082p ps=1.34u w=0.26u l=0.38u
X8856 cml_tlatch_91.xtail.S1 CKA2_P cml_tlatch_91.xmux.xp.S1 VSS sg13_lv_nmos ad=89.3f pd=0.85u as=89.3f ps=0.85u w=0.47u l=0.16u
X8857 cml_tlatch_91.INN cml_tlatch_91.INP cml_tlatch_59.xmux.xp.S1 VSS sg13_lv_nmos ad=56.9f pd=0.74u as=56.9f ps=0.74u w=0.17u l=0.17u
X8858 cml_tlatch_67.xmux.xp.S1 CKB3_N cml_tlatch_67.xtail.S1 VSS sg13_lv_nmos ad=89.3f pd=0.85u as=89.3f ps=0.85u w=0.47u l=0.16u
X8859 cml_tlatch_46.xmux.xp.S1 stub_bi_38.BOTN stub_bi_38.BOTP VSS sg13_lv_nmos ad=56.9f pd=0.74u as=56.9f ps=0.74u w=0.17u l=0.17u
X8860 MOT15_P MOT15_N cml_tlatch_6.xmux.xp.S1 VSS sg13_lv_nmos ad=56.9f pd=0.74u as=56.9f ps=0.74u w=0.17u l=0.17u
X8861 cml_tlatch_85.xmux.xn.S1 CKA2_N cml_tlatch_85.xtail.S1 VSS sg13_lv_nmos ad=89.3f pd=0.85u as=0.1598p ps=1.62u w=0.47u l=0.16u
X8862 stub_bi_43.BOTN stub_bi_43.BOTP cml_tlatch_48.xmux.xp.S1 VSS sg13_lv_nmos ad=56.9f pd=0.74u as=56.9f ps=0.74u w=0.17u l=0.17u
X8863 MOT6_P MOT6_N cml_tlatch_29.xmux.xp.S1 VSS sg13_lv_nmos ad=56.9f pd=0.74u as=56.9f ps=0.74u w=0.17u l=0.17u
X8864 MOT6_N MOT6_P cml_tlatch_29.xmux.xp.S1 VSS sg13_lv_nmos ad=56.9f pd=0.74u as=56.9f ps=0.74u w=0.17u l=0.17u
X8865 cml_tlatch_73.xmux.xn.S1 CKHB3_P cml_tlatch_73.xtail.S1 VSS sg13_lv_nmos ad=89.3f pd=0.85u as=89.3f ps=0.85u w=0.47u l=0.16u
X8866 MOT13_N VDD VSS rppd l=5.17u w=1u
X8867 ENB0_N ENB_P cml_drv_2.xrtail.R1 VSS sg13_lv_nmos ad=56.2f pd=0.74u as=56.2f ps=0.74u w=0.16u l=0.19u
X8868 MOT28_N cml_tlatch_44.INP cml_tlatch_44.xmux.xn.S1 VSS sg13_lv_nmos ad=63.19999f pd=0.74u as=63.19999f ps=0.74u w=0.26u l=0.38u
X8869 cml_gate2_8.xamp.xn.S1 NS1_P cml_gate2_8.xrtail.R1 VSS sg13_lv_nmos ad=0.1007p pd=0.91u as=0.1007p ps=0.91u w=0.53u l=0.13u
X8870 cml_tlatch_8.OUTP cml_tlatch_8.OUTN cml_tlatch_8.xmux.xp.S1 VSS sg13_lv_nmos ad=56.9f pd=0.74u as=56.9f ps=0.74u w=0.17u l=0.17u
X8871 VSS hs_to_clk_2.sg13_lv_nmos_2HGZLP_0.G VSS VSS sg13_lv_nmos ad=2.071p pd=11.28u as=0 ps=0 w=10.9u l=1.38u
X8872 cml_tlatch_38.xtail.S1 CKA0_P cml_tlatch_38.xmux.xn.S1 VSS sg13_lv_nmos ad=89.3f pd=0.85u as=89.3f ps=0.85u w=0.47u l=0.16u
X8873 cml_tlatch_36.xtail.S1 CKB1_P cml_tlatch_36.xmux.xp.S1 VSS sg13_lv_nmos ad=89.3f pd=0.85u as=0.1598p ps=1.62u w=0.47u l=0.16u
X8874 cml_tlatch_71.xmux.xp.S1 cml_tlatch_71.OUTN cml_tlatch_71.OUTP VSS sg13_lv_nmos ad=56.9f pd=0.74u as=56.9f ps=0.74u w=0.17u l=0.17u
X8875 hs_to_clk_6.sg13_lv_nmos_2HGZLP_0.G CKA3_P VSS rppd l=4.25u w=1u
X8876 cml_tlatch_67.OUTP cml_tlatch_67.OUTN cml_tlatch_67.xmux.xp.S1 VSS sg13_lv_nmos ad=56.9f pd=0.74u as=56.9f ps=0.74u w=0.17u l=0.17u
X8877 VSS POLN cml_tlatch_63.xtail.S1 VSS sg13_lv_nmos ad=2.7982p pd=17.14u as=1.5637p ps=8.61u w=8.23u l=0.13u
X8878 cml_tlatch_78.xmux.xn.S1 stub_bi_63.BOTP MOT19_P VSS sg13_lv_nmos ad=63.19999f pd=0.74u as=63.19999f ps=0.74u w=0.26u l=0.38u
X8879 cml_tlatch_53.xmux.xp.S1 MOT18_P MOT18_N VSS sg13_lv_nmos ad=0.1019p pd=1.34u as=56.9f ps=0.74u w=0.17u l=0.17u
X8880 cml_tlatch_65.xtail.S1 CKB3_P cml_tlatch_65.xmux.xn.S1 VSS sg13_lv_nmos ad=89.3f pd=0.85u as=89.3f ps=0.85u w=0.47u l=0.16u
X8881 MOT26_N MOT26_P cml_tlatch_63.xmux.xp.S1 VSS sg13_lv_nmos ad=56.9f pd=0.74u as=56.9f ps=0.74u w=0.17u l=0.17u
X8882 VDD cml_tlatch_61.OUTN VSS rppd l=5.17u w=1u
X8883 A2_2_N A2_2_P cml_tlatch_60.xmux.xp.S1 VSS sg13_lv_nmos ad=56.9f pd=0.74u as=56.9f ps=0.74u w=0.17u l=0.17u
X8884 cml_tlatch_74.INN cml_tlatch_74.INP cml_tlatch_88.xmux.xp.S1 VSS sg13_lv_nmos ad=56.9f pd=0.74u as=56.9f ps=0.74u w=0.17u l=0.17u
X8885 cml_tlatch_30.OUTP cml_tlatch_30.OUTN cml_tlatch_30.xmux.xp.S1 VSS sg13_lv_nmos ad=56.9f pd=0.74u as=56.9f ps=0.74u w=0.17u l=0.17u
X8886 cml_gate2_3.xamp.xn.S1 ENA0_P GA0_N VSS sg13_lv_nmos ad=0.1007p pd=0.91u as=0.1007p ps=0.91u w=0.53u l=0.13u
X8887 cml_tlatch_97.INN A1_2_P cml_tlatch_39.xmux.xn.S1 VSS sg13_lv_nmos ad=63.19999f pd=0.74u as=0.1082p ps=1.34u w=0.26u l=0.38u
X8888 MOT31_P MOT31_N cml_tlatch_75.xmux.xp.S1 VSS sg13_lv_nmos ad=56.9f pd=0.74u as=56.9f ps=0.74u w=0.17u l=0.17u
X8889 cml_tlatch_23.xmux.xp.S1 CKA0_P cml_tlatch_23.xtail.S1 VSS sg13_lv_nmos ad=89.3f pd=0.85u as=89.3f ps=0.85u w=0.47u l=0.16u
X8890 cml_tlatch_93.xtail.S1 CKJ_N cml_tlatch_93.xmux.xp.S1 VSS sg13_lv_nmos ad=89.3f pd=0.85u as=89.3f ps=0.85u w=0.47u l=0.16u
X8891 cml_tlatch_13.xmux.xp.S1 stub_bi_17.BOTP stub_bi_17.BOTN VSS sg13_lv_nmos ad=56.9f pd=0.74u as=56.9f ps=0.74u w=0.17u l=0.17u
X8892 VSS hs_to_clk_5.sg13_lv_nmos_2HGZLP_0.G VSS VSS sg13_lv_nmos ad=2.071p pd=11.28u as=0 ps=0 w=10.9u l=1.38u
X8893 cml_tlatch_46.xmux.xp.S1 CKB2_N cml_tlatch_46.xtail.S1 VSS sg13_lv_nmos ad=89.3f pd=0.85u as=89.3f ps=0.85u w=0.47u l=0.16u
X8894 cml_tlatch_21.xmux.xn.S1 CKA1_N cml_tlatch_21.xtail.S1 VSS sg13_lv_nmos ad=89.3f pd=0.85u as=0.1598p ps=1.62u w=0.47u l=0.16u
X8895 cml_tlatch_43.xmux.xp.S1 MOT10_P MOT10_N VSS sg13_lv_nmos ad=56.9f pd=0.74u as=56.9f ps=0.74u w=0.17u l=0.17u
X8896 NM1_P CLK_W_N cml_drvb_9.xrtail.R2 VSS sg13_lv_nmos ad=0.2618p pd=2.22u as=0.1463p ps=1.15u w=0.77u l=0.21u
X8897 cml_tlatch_96.xmux.xp.S1 cml_tlatch_5.INP cml_tlatch_5.INN VSS sg13_lv_nmos ad=56.9f pd=0.74u as=56.9f ps=0.74u w=0.17u l=0.17u
X8898 B3_2_P B3_2_N cml_tlatch_50.xmux.xp.S1 VSS sg13_lv_nmos ad=56.9f pd=0.74u as=56.9f ps=0.74u w=0.17u l=0.17u
X8899 cml_tlatch_78.xtail.S1 CKHB2_N cml_tlatch_78.xmux.xp.S1 VSS sg13_lv_nmos ad=89.3f pd=0.85u as=89.3f ps=0.85u w=0.47u l=0.16u
X8900 cml_tlatch_34.xmux.xn.S1 cml_tlatch_38.OUTN A0_2_P VSS sg13_lv_nmos ad=63.19999f pd=0.74u as=63.19999f ps=0.74u w=0.26u l=0.38u
X8901 cml_tlatch_15.xmux.xp.S1 MOT3_N MOT3_P VSS sg13_lv_nmos ad=56.9f pd=0.74u as=56.9f ps=0.74u w=0.17u l=0.17u
X8902 cml_tlatch_16.xmux.xn.S1 CKHB0_P cml_tlatch_16.xtail.S1 VSS sg13_lv_nmos ad=89.3f pd=0.85u as=89.3f ps=0.85u w=0.47u l=0.16u
X8903 cml_tlatch_28.xmux.xp.S1 MOT4_N MOT4_P VSS sg13_lv_nmos ad=56.9f pd=0.74u as=56.9f ps=0.74u w=0.17u l=0.17u
X8904 cml_tlatch_79.xmux.xp.S1 MOT21_P MOT21_N VSS sg13_lv_nmos ad=56.9f pd=0.74u as=56.9f ps=0.74u w=0.17u l=0.17u
X8905 cml_tlatch_89.xmux.xp.S1 cml_tlatch_44.INN cml_tlatch_44.INP VSS sg13_lv_nmos ad=0.1019p pd=1.34u as=56.9f ps=0.74u w=0.17u l=0.17u
X8906 cml_tlatch_18.OUTN cml_tlatch_23.OUTP cml_tlatch_18.xmux.xn.S1 VSS sg13_lv_nmos ad=63.19999f pd=0.74u as=63.19999f ps=0.74u w=0.26u l=0.38u
X8907 MOT12_N MOT12_P cml_tlatch_24.xmux.xp.S1 VSS sg13_lv_nmos ad=56.9f pd=0.74u as=56.9f ps=0.74u w=0.17u l=0.17u
X8908 A0_8_N A0_8_P cml_tlatch_9.xmux.xp.S1 VSS sg13_lv_nmos ad=56.9f pd=0.74u as=56.9f ps=0.74u w=0.17u l=0.17u
X8909 A2_8_N cml_tlatch_86.OUTP cml_tlatch_85.xmux.xn.S1 VSS sg13_lv_nmos ad=63.19999f pd=0.74u as=0.1082p ps=1.34u w=0.26u l=0.38u
X8910 cml_tlatch_23.xmux.xp.S1 cml_tlatch_23.OUTP cml_tlatch_23.OUTN VSS sg13_lv_nmos ad=56.9f pd=0.74u as=56.9f ps=0.74u w=0.17u l=0.17u
X8911 cml_tlatch_3.xmux.xn.S1 CKHB1_P cml_tlatch_3.xtail.S1 VSS sg13_lv_nmos ad=89.3f pd=0.85u as=89.3f ps=0.85u w=0.47u l=0.16u
X8912 cml_gate2_7.xrtail.R1 CKA2_P cml_gate2_7.xamp.xn.S1 VSS sg13_lv_nmos ad=0.1007p pd=0.91u as=0.1007p ps=0.91u w=0.53u l=0.13u
X8913 VSS hs_to_clk_7.sg13_lv_nmos_2HGZLP_0.G VSS VSS sg13_lv_nmos ad=2.071p pd=11.28u as=0 ps=0 w=10.9u l=1.38u
X8914 cml_tlatch_21.xmux.xn.S1 cml_tlatch_22.OUTN cml_tlatch_43.INP VSS sg13_lv_nmos ad=63.19999f pd=0.74u as=63.19999f ps=0.74u w=0.26u l=0.38u
X8915 stub_bi_15.BOTP stub_bi_15.BOTN cml_tlatch_11.xmux.xp.S1 VSS sg13_lv_nmos ad=56.9f pd=0.74u as=56.9f ps=0.74u w=0.17u l=0.17u
X8916 VSS POLN cml_tlatch_66.xtail.S1 VSS sg13_lv_nmos ad=1.5637p pd=8.61u as=1.5637p ps=8.61u w=8.23u l=0.13u
X8917 B3_8_P VDD VSS rppd l=5.17u w=1u
X8918 A0_2_P A0_2_N cml_tlatch_34.xmux.xp.S1 VSS sg13_lv_nmos ad=56.9f pd=0.74u as=56.9f ps=0.74u w=0.17u l=0.17u
X8919 cml_tlatch_11.xmux.xn.S1 cml_tlatch_4.INN stub_bi_15.BOTN VSS sg13_lv_nmos ad=63.19999f pd=0.74u as=63.19999f ps=0.74u w=0.26u l=0.38u
X8920 VSS cml_drv_2.xrtail.R1 VSS rppd l=5.65u w=1u
X8921 cml_tlatch_60.xmux.xn.S1 CKA2_N cml_tlatch_60.xtail.S1 VSS sg13_lv_nmos ad=89.3f pd=0.85u as=0.1598p ps=1.62u w=0.47u l=0.16u
X8922 cml_tlatch_55.xmux.xp.S1 MOT22_P MOT22_N VSS sg13_lv_nmos ad=56.9f pd=0.74u as=56.9f ps=0.74u w=0.17u l=0.17u
X8923 cml_tlatch_18.OUTN cml_tlatch_18.OUTP cml_tlatch_18.xmux.xp.S1 VSS sg13_lv_nmos ad=56.9f pd=0.74u as=56.9f ps=0.74u w=0.17u l=0.17u
X8924 cml_tlatch_26.xmux.xn.S1 CKHA0_P cml_tlatch_26.xtail.S1 VSS sg13_lv_nmos ad=89.3f pd=0.85u as=0.1598p ps=1.62u w=0.47u l=0.16u
X8925 cml_tlatch_68.xtail.S1 CKA3_N cml_tlatch_68.xmux.xn.S1 VSS sg13_lv_nmos ad=89.3f pd=0.85u as=89.3f ps=0.85u w=0.47u l=0.16u
X8926 cml_tlatch_11.xmux.xn.S1 cml_tlatch_4.INN stub_bi_15.BOTN VSS sg13_lv_nmos ad=63.19999f pd=0.74u as=63.19999f ps=0.74u w=0.26u l=0.38u
X8927 MOT2_P MOT2_N cml_tlatch_27.xmux.xp.S1 VSS sg13_lv_nmos ad=56.9f pd=0.74u as=56.9f ps=0.74u w=0.17u l=0.17u
X8928 cml_tlatch_25.xmux.xp.S1 MOT14_P MOT14_N VSS sg13_lv_nmos ad=56.9f pd=0.74u as=56.9f ps=0.74u w=0.17u l=0.17u
X8929 cml_tlatch_94.xmux.xn.S1 J1_N J2_P VSS sg13_lv_nmos ad=63.19999f pd=0.74u as=63.19999f ps=0.74u w=0.26u l=0.38u
X8930 cml_tlatch_70.xmux.xp.S1 cml_tlatch_63.INP cml_tlatch_63.INN VSS sg13_lv_nmos ad=56.9f pd=0.74u as=56.9f ps=0.74u w=0.17u l=0.17u
X8931 cml_tlatch_73.xmux.xp.S1 MOT27_P MOT27_N VSS sg13_lv_nmos ad=56.9f pd=0.74u as=56.9f ps=0.74u w=0.17u l=0.17u
X8932 cml_tlatch_41.xmux.xn.S1 CKA1_P cml_tlatch_41.xtail.S1 VSS sg13_lv_nmos ad=89.3f pd=0.85u as=89.3f ps=0.85u w=0.47u l=0.16u
X8933 J2_N J2_P cml_tlatch_94.xmux.xp.S1 VSS sg13_lv_nmos ad=56.9f pd=0.74u as=56.9f ps=0.74u w=0.17u l=0.17u
X8934 cml_tlatch_73.INP cml_tlatch_73.INN cml_tlatch_66.xmux.xp.S1 VSS sg13_lv_nmos ad=56.9f pd=0.74u as=56.9f ps=0.74u w=0.17u l=0.17u
X8935 cml_tlatch_47.xmux.xn.S1 stub_bi_43.BOTN B2_2_N VSS sg13_lv_nmos ad=63.19999f pd=0.74u as=63.19999f ps=0.74u w=0.26u l=0.38u
X8936 MOT11_N cml_tlatch_4.INP cml_tlatch_4.xmux.xn.S1 VSS sg13_lv_nmos ad=63.19999f pd=0.74u as=63.19999f ps=0.74u w=0.26u l=0.38u
X8937 cml_gate2_8.xrtail.R1 NS1_N ENB_P VSS sg13_lv_nmos ad=0.1007p pd=0.91u as=0.1802p ps=1.74u w=0.53u l=0.13u
X8938 cml_tlatch_88.xmux.xp.S1 cml_tlatch_74.INN cml_tlatch_74.INP VSS sg13_lv_nmos ad=56.9f pd=0.74u as=56.9f ps=0.74u w=0.17u l=0.17u
X8939 cml_tlatch_86.xtail.S1 CKA2_N cml_tlatch_86.xmux.xp.S1 VSS sg13_lv_nmos ad=89.3f pd=0.85u as=89.3f ps=0.85u w=0.47u l=0.16u
X8940 cml_tlatch_60.xmux.xn.S1 cml_tlatch_61.OUTN A2_2_P VSS sg13_lv_nmos ad=63.19999f pd=0.74u as=63.19999f ps=0.74u w=0.26u l=0.38u
X8941 cml_tlatch_99.OUTP cml_tlatch_33.OUTN cml_tlatch_99.xmux.xn.S1 VSS sg13_lv_nmos ad=63.19999f pd=0.74u as=63.19999f ps=0.74u w=0.26u l=0.38u
X8942 MOT11_N MOT11_P cml_tlatch_4.xmux.xp.S1 VSS sg13_lv_nmos ad=56.9f pd=0.74u as=56.9f ps=0.74u w=0.17u l=0.17u
X8943 cml_tlatch_46.xmux.xp.S1 stub_bi_38.BOTN stub_bi_38.BOTP VSS sg13_lv_nmos ad=56.9f pd=0.74u as=56.9f ps=0.74u w=0.17u l=0.17u
X8944 cml_tlatch_12.xmux.xp.S1 cml_tlatch_4.INN cml_tlatch_4.INP VSS sg13_lv_nmos ad=56.9f pd=0.74u as=56.9f ps=0.74u w=0.17u l=0.17u
X8945 VSS POLN cml_tlatch_13.xtail.S1 VSS sg13_lv_nmos ad=2.7982p pd=17.14u as=1.5637p ps=8.61u w=8.23u l=0.13u
X8946 cml_tlatch_2.xmux.xn.S1 CKB0_P cml_tlatch_2.xtail.S1 VSS sg13_lv_nmos ad=89.3f pd=0.85u as=89.3f ps=0.85u w=0.47u l=0.16u
X8947 cml_tlatch_99.OUTP cml_tlatch_99.OUTN cml_tlatch_99.xmux.xp.S1 VSS sg13_lv_nmos ad=56.9f pd=0.74u as=0.1019p ps=1.34u w=0.17u l=0.17u
X8948 MOT5_P MOT5_N cml_tlatch_16.xmux.xp.S1 VSS sg13_lv_nmos ad=56.9f pd=0.74u as=56.9f ps=0.74u w=0.17u l=0.17u
X8949 cml_gate2_0.xamp.xn.S1 CKA1_P cml_gate2_0.xrtail.R1 VSS sg13_lv_nmos ad=0.1007p pd=0.91u as=0.1007p ps=0.91u w=0.53u l=0.13u
X8950 B1_8_P B1_8_N cml_tlatch_10.xmux.xp.S1 VSS sg13_lv_nmos ad=56.9f pd=0.74u as=0.1019p ps=1.34u w=0.17u l=0.17u
X8951 VSS POLN cml_tlatch_89.xtail.S1 VSS sg13_lv_nmos ad=1.5637p pd=8.61u as=1.5637p ps=8.61u w=8.23u l=0.13u
X8952 cml_tlatch_25.xmux.xp.S1 MOT14_N MOT14_P VSS sg13_lv_nmos ad=56.9f pd=0.74u as=56.9f ps=0.74u w=0.17u l=0.17u
X8953 cml_drvb_6.xrtail.R2 GB3_P CKHB3_N VSS sg13_lv_nmos ad=0.1463p pd=1.15u as=0.2618p ps=2.22u w=0.77u l=0.21u
X8954 cml_tlatch_52.xmux.xn.S1 CKHA2_P cml_tlatch_52.xtail.S1 VSS sg13_lv_nmos ad=89.3f pd=0.85u as=89.3f ps=0.85u w=0.47u l=0.16u
X8955 MOT20_P MOT20_N cml_tlatch_54.xmux.xp.S1 VSS sg13_lv_nmos ad=56.9f pd=0.74u as=56.9f ps=0.74u w=0.17u l=0.17u
X8956 cml_tlatch_27.xtail.S1 CKHA0_P cml_tlatch_27.xmux.xn.S1 VSS sg13_lv_nmos ad=89.3f pd=0.85u as=89.3f ps=0.85u w=0.47u l=0.16u
X8957 cml_tlatch_87.xtail.S1 CKA2_N cml_tlatch_87.xmux.xn.S1 VSS sg13_lv_nmos ad=89.3f pd=0.85u as=89.3f ps=0.85u w=0.47u l=0.16u
X8958 stub_bi_49.BOTN VDD VSS rppd l=5.17u w=1u
X8959 J4_P CLK_W_P cml_tlatch_92.xmux.xn.S1 VSS sg13_lv_nmos ad=63.19999f pd=0.74u as=63.19999f ps=0.74u w=0.26u l=0.38u
X8960 cml_tlatch_69.xmux.xp.S1 cml_tlatch_69.OUTN cml_tlatch_69.OUTP VSS sg13_lv_nmos ad=56.9f pd=0.74u as=56.9f ps=0.74u w=0.17u l=0.17u
X8961 cml_tlatch_65.OUTP cml_tlatch_65.OUTN cml_tlatch_65.xmux.xp.S1 VSS sg13_lv_nmos ad=56.9f pd=0.74u as=56.9f ps=0.74u w=0.17u l=0.17u
X8962 cml_tlatch_82.xtail.S1 CKB2_N cml_tlatch_82.xmux.xp.S1 VSS sg13_lv_nmos ad=0.1598p pd=1.62u as=89.3f ps=0.85u w=0.47u l=0.16u
X8963 cml_tlatch_31.xtail.S1 CKB0_P cml_tlatch_31.xmux.xp.S1 VSS sg13_lv_nmos ad=89.3f pd=0.85u as=0.1598p ps=1.62u w=0.47u l=0.16u
X8964 cml_gate2_0.xrtail.R1 CKA1_P cml_gate2_0.xamp.xn.S1 VSS sg13_lv_nmos ad=0.1007p pd=0.91u as=0.1007p ps=0.91u w=0.53u l=0.13u
X8965 cml_drv_3.xrtail.R1 ENA_N ENA0_P VSS sg13_lv_nmos ad=56.2f pd=0.74u as=0.1012p ps=1.34u w=0.16u l=0.19u
X8966 cml_tlatch_51.xmux.xn.S1 D3_N cml_tlatch_51.OUTP VSS sg13_lv_nmos ad=0.1082p pd=1.34u as=63.19999f ps=0.74u w=0.26u l=0.38u
X8967 cml_tlatch_47.xmux.xp.S1 B2_2_P B2_2_N VSS sg13_lv_nmos ad=0.1019p pd=1.34u as=56.9f ps=0.74u w=0.17u l=0.17u
X8968 cml_tlatch_32.OUTN D0_P cml_tlatch_32.xmux.xn.S1 VSS sg13_lv_nmos ad=63.19999f pd=0.74u as=63.19999f ps=0.74u w=0.26u l=0.38u
X8969 MOT27_N MOT27_P cml_tlatch_73.xmux.xp.S1 VSS sg13_lv_nmos ad=56.9f pd=0.74u as=56.9f ps=0.74u w=0.17u l=0.17u
X8970 MOT1_N MOT1_P cml_tlatch_14.xmux.xp.S1 VSS sg13_lv_nmos ad=56.9f pd=0.74u as=56.9f ps=0.74u w=0.17u l=0.17u
X8971 cml_tlatch_51.xmux.xn.S1 D3_N cml_tlatch_51.OUTP VSS sg13_lv_nmos ad=63.19999f pd=0.74u as=63.19999f ps=0.74u w=0.26u l=0.38u
X8972 cml_tlatch_1.xmux.xp.S1 B0_8_P B0_8_N VSS sg13_lv_nmos ad=56.9f pd=0.74u as=56.9f ps=0.74u w=0.17u l=0.17u
X8973 cml_tlatch_45.xmux.xp.S1 MOT30_N MOT30_P VSS sg13_lv_nmos ad=56.9f pd=0.74u as=56.9f ps=0.74u w=0.17u l=0.17u
X8974 MOT16_N MOT16_P cml_tlatch_52.xmux.xp.S1 VSS sg13_lv_nmos ad=56.9f pd=0.74u as=56.9f ps=0.74u w=0.17u l=0.17u
X8975 GA0_P ENA0_N cml_gate2_3.xamp.xn.S1 VSS sg13_lv_nmos ad=0.1007p pd=0.91u as=0.1007p ps=0.91u w=0.53u l=0.13u
X8976 B3_2_P VDD VSS rppd l=5.17u w=1u
X8977 cml_tlatch_62.xmux.xp.S1 MOT24_P MOT24_N VSS sg13_lv_nmos ad=56.9f pd=0.74u as=56.9f ps=0.74u w=0.17u l=0.17u
X8978 cml_tlatch_41.xmux.xn.S1 D1_N cml_tlatch_41.OUTP VSS sg13_lv_nmos ad=63.19999f pd=0.74u as=63.19999f ps=0.74u w=0.26u l=0.38u
X8979 cml_tlatch_57.xtail.S1 CKA3_N cml_tlatch_57.xmux.xn.S1 VSS sg13_lv_nmos ad=89.3f pd=0.85u as=89.3f ps=0.85u w=0.47u l=0.16u
X8980 cml_tlatch_67.xtail.S1 CKB3_N cml_tlatch_67.xmux.xp.S1 VSS sg13_lv_nmos ad=89.3f pd=0.85u as=89.3f ps=0.85u w=0.47u l=0.16u
X8981 cml_tlatch_15.xmux.xp.S1 MOT3_N MOT3_P VSS sg13_lv_nmos ad=56.9f pd=0.74u as=56.9f ps=0.74u w=0.17u l=0.17u
X8982 cml_tlatch_28.xmux.xp.S1 MOT4_N MOT4_P VSS sg13_lv_nmos ad=56.9f pd=0.74u as=56.9f ps=0.74u w=0.17u l=0.17u
X8983 cml_tlatch_19.xtail.S1 CKA1_P cml_tlatch_19.xmux.xp.S1 VSS sg13_lv_nmos ad=89.3f pd=0.85u as=89.3f ps=0.85u w=0.47u l=0.16u
X8984 cml_tlatch_74.xtail.S1 CKHB3_N cml_tlatch_74.xmux.xp.S1 VSS sg13_lv_nmos ad=89.3f pd=0.85u as=89.3f ps=0.85u w=0.47u l=0.16u
X8985 A3_2_N cml_tlatch_58.OUTP cml_tlatch_57.xmux.xn.S1 VSS sg13_lv_nmos ad=63.19999f pd=0.74u as=63.19999f ps=0.74u w=0.26u l=0.38u
X8986 ENB1_N ENB_P cml_drv_0.xrtail.R1 VSS sg13_lv_nmos ad=56.2f pd=0.74u as=56.2f ps=0.74u w=0.16u l=0.19u
X8987 cml_tlatch_65.OUTN cml_tlatch_73.INP cml_tlatch_65.xmux.xn.S1 VSS sg13_lv_nmos ad=63.19999f pd=0.74u as=63.19999f ps=0.74u w=0.26u l=0.38u
X8988 cml_tlatch_2.xmux.xp.S1 cml_tlatch_2.OUTP cml_tlatch_2.OUTN VSS sg13_lv_nmos ad=56.9f pd=0.74u as=56.9f ps=0.74u w=0.17u l=0.17u
X8989 A2_8_N A2_8_P cml_tlatch_85.xmux.xp.S1 VSS sg13_lv_nmos ad=56.9f pd=0.74u as=56.9f ps=0.74u w=0.17u l=0.17u
X8990 B1_8_P B1_8_N cml_tlatch_10.xmux.xp.S1 VSS sg13_lv_nmos ad=56.9f pd=0.74u as=56.9f ps=0.74u w=0.17u l=0.17u
X8991 stub_bi_49.BOTN stub_bi_55.BOTP cml_tlatch_84.xmux.xn.S1 VSS sg13_lv_nmos ad=63.19999f pd=0.74u as=63.19999f ps=0.74u w=0.26u l=0.38u
X8992 VSS hs_to_clk_2.sg13_lv_nmos_2HGZLP_0.G VSS VSS sg13_lv_nmos ad=3.706p pd=22.48u as=0 ps=0 w=10.9u l=1.38u
X8993 cml_tlatch_83.xtail.S1 POLN VSS VSS sg13_lv_nmos ad=1.5637p pd=8.61u as=1.5637p ps=8.61u w=8.23u l=0.13u
X8994 MOT16_P MOT16_N cml_tlatch_52.xmux.xp.S1 VSS sg13_lv_nmos ad=56.9f pd=0.74u as=56.9f ps=0.74u w=0.17u l=0.17u
X8995 cml_tlatch_7.OUTN cml_tlatch_7.OUTP cml_tlatch_7.xmux.xp.S1 VSS sg13_lv_nmos ad=56.9f pd=0.74u as=0.1019p ps=1.34u w=0.17u l=0.17u
X8996 VDD cml_tlatch_18.OUTN VSS rppd l=5.17u w=1u
X8997 cml_tlatch_93.xmux.xp.S1 CLK_W_P CLK_W_N VSS sg13_lv_nmos ad=56.9f pd=0.74u as=56.9f ps=0.74u w=0.17u l=0.17u
X8998 cml_tlatch_17.xmux.xp.S1 MOT7_P MOT7_N VSS sg13_lv_nmos ad=56.9f pd=0.74u as=56.9f ps=0.74u w=0.17u l=0.17u
X8999 cml_tlatch_96.xtail.S1 CKB1_N cml_tlatch_96.xmux.xn.S1 VSS sg13_lv_nmos ad=0.1598p pd=1.62u as=89.3f ps=0.85u w=0.47u l=0.16u
X9000 cml_tlatch_61.xmux.xp.S1 cml_tlatch_61.OUTP cml_tlatch_61.OUTN VSS sg13_lv_nmos ad=56.9f pd=0.74u as=56.9f ps=0.74u w=0.17u l=0.17u
X9001 cml_tlatch_2.xmux.xp.S1 cml_tlatch_2.OUTN cml_tlatch_2.OUTP VSS sg13_lv_nmos ad=0.1019p pd=1.34u as=56.9f ps=0.74u w=0.17u l=0.17u
X9002 J2_N J2_P cml_tlatch_94.xmux.xp.S1 VSS sg13_lv_nmos ad=56.9f pd=0.74u as=56.9f ps=0.74u w=0.17u l=0.17u
X9003 VSS POLN cml_tlatch_27.xtail.S1 VSS sg13_lv_nmos ad=2.7982p pd=17.14u as=1.5637p ps=8.61u w=8.23u l=0.13u
X9004 cml_tlatch_23.OUTP cml_tlatch_23.OUTN cml_tlatch_23.xmux.xp.S1 VSS sg13_lv_nmos ad=56.9f pd=0.74u as=56.9f ps=0.74u w=0.17u l=0.17u
X9005 cml_tlatch_79.xmux.xp.S1 MOT21_N MOT21_P VSS sg13_lv_nmos ad=56.9f pd=0.74u as=56.9f ps=0.74u w=0.17u l=0.17u
X9006 cml_tlatch_84.xmux.xn.S1 stub_bi_55.BOTN stub_bi_49.BOTP VSS sg13_lv_nmos ad=63.19999f pd=0.74u as=0.1082p ps=1.34u w=0.26u l=0.38u
X9007 cml_tlatch_91.INP cml_tlatch_91.INN cml_tlatch_59.xmux.xp.S1 VSS sg13_lv_nmos ad=56.9f pd=0.74u as=56.9f ps=0.74u w=0.17u l=0.17u
X9008 GB3_P CKA3_N cml_gate2_6.xrtail.R1 VSS sg13_lv_nmos ad=0.1007p pd=0.91u as=0.1007p ps=0.91u w=0.53u l=0.13u
X9009 cml_tlatch_13.xtail.S1 CKB1_P cml_tlatch_13.xmux.xn.S1 VSS sg13_lv_nmos ad=89.3f pd=0.85u as=89.3f ps=0.85u w=0.47u l=0.16u
X9010 cml_tlatch_93.xmux.xp.S1 CLK_W_P CLK_W_N VSS sg13_lv_nmos ad=0.1019p pd=1.34u as=56.9f ps=0.74u w=0.17u l=0.17u
X9011 cml_tlatch_56.OUTN cml_tlatch_56.OUTP cml_tlatch_56.xmux.xp.S1 VSS sg13_lv_nmos ad=56.9f pd=0.74u as=56.9f ps=0.74u w=0.17u l=0.17u
X9012 cml_tlatch_46.xtail.S1 CKB2_N cml_tlatch_46.xmux.xp.S1 VSS sg13_lv_nmos ad=89.3f pd=0.85u as=89.3f ps=0.85u w=0.47u l=0.16u
X9013 cml_tlatch_29.xmux.xp.S1 CKHA0_N cml_tlatch_29.xtail.S1 VSS sg13_lv_nmos ad=89.3f pd=0.85u as=89.3f ps=0.85u w=0.47u l=0.16u
X9014 cml_tlatch_58.xmux.xp.S1 cml_tlatch_58.OUTN cml_tlatch_58.OUTP VSS sg13_lv_nmos ad=56.9f pd=0.74u as=56.9f ps=0.74u w=0.17u l=0.17u
X9015 B3_8_P B3_8_N cml_tlatch_64.xmux.xp.S1 VSS sg13_lv_nmos ad=56.9f pd=0.74u as=56.9f ps=0.74u w=0.17u l=0.17u
X9016 cml_tlatch_51.OUTP cml_tlatch_51.OUTN cml_tlatch_51.xmux.xp.S1 VSS sg13_lv_nmos ad=56.9f pd=0.74u as=56.9f ps=0.74u w=0.17u l=0.17u
X9017 stub_bi_15.BOTN stub_bi_15.BOTP cml_tlatch_11.xmux.xp.S1 VSS sg13_lv_nmos ad=56.9f pd=0.74u as=56.9f ps=0.74u w=0.17u l=0.17u
X9018 cml_tlatch_16.xtail.S1 CKHB0_P cml_tlatch_16.xmux.xn.S1 VSS sg13_lv_nmos ad=89.3f pd=0.85u as=89.3f ps=0.85u w=0.47u l=0.16u
X9019 MOT22_N A2_2_P cml_tlatch_55.xmux.xn.S1 VSS sg13_lv_nmos ad=0.1082p pd=1.34u as=63.19999f ps=0.74u w=0.26u l=0.38u
X9020 cml_tlatch_22.OUTN cml_tlatch_22.OUTP cml_tlatch_22.xmux.xp.S1 VSS sg13_lv_nmos ad=56.9f pd=0.74u as=56.9f ps=0.74u w=0.17u l=0.17u
X9021 cml_tlatch_84.xmux.xp.S1 stub_bi_49.BOTN stub_bi_49.BOTP VSS sg13_lv_nmos ad=56.9f pd=0.74u as=56.9f ps=0.74u w=0.17u l=0.17u
X9022 B0_8_P cml_tlatch_2.OUTN cml_tlatch_1.xmux.xn.S1 VSS sg13_lv_nmos ad=63.19999f pd=0.74u as=63.19999f ps=0.74u w=0.26u l=0.38u
X9023 cml_tlatch_77.xmux.xp.S1 MOT17_P MOT17_N VSS sg13_lv_nmos ad=56.9f pd=0.74u as=56.9f ps=0.74u w=0.17u l=0.17u
X9024 B0_2_N cml_tlatch_32.OUTP cml_tlatch_31.xmux.xn.S1 VSS sg13_lv_nmos ad=63.19999f pd=0.74u as=63.19999f ps=0.74u w=0.26u l=0.38u
X9025 MOT25_N MOT25_P cml_tlatch_72.xmux.xp.S1 VSS sg13_lv_nmos ad=56.9f pd=0.74u as=56.9f ps=0.74u w=0.17u l=0.17u
X9026 cml_tlatch_14.xmux.xn.S1 B0_8_N MOT1_P VSS sg13_lv_nmos ad=63.19999f pd=0.74u as=63.19999f ps=0.74u w=0.26u l=0.38u
X9027 cml_tlatch_33.xmux.xp.S1 cml_tlatch_33.OUTP cml_tlatch_33.OUTN VSS sg13_lv_nmos ad=56.9f pd=0.74u as=56.9f ps=0.74u w=0.17u l=0.17u
X9028 B2_8_P stub_bi_62.BOTP cml_tlatch_81.xmux.xn.S1 VSS sg13_lv_nmos ad=63.19999f pd=0.74u as=63.19999f ps=0.74u w=0.26u l=0.38u
X9029 MOT5_P MOT5_N cml_tlatch_16.xmux.xp.S1 VSS sg13_lv_nmos ad=56.9f pd=0.74u as=56.9f ps=0.74u w=0.17u l=0.17u
X9030 cml_tlatch_7.OUTN cml_tlatch_7.OUTP cml_tlatch_7.xmux.xp.S1 VSS sg13_lv_nmos ad=56.9f pd=0.74u as=56.9f ps=0.74u w=0.17u l=0.17u
X9031 VSS hs_to_clk_1.sg13_lv_nmos_2HGZLP_0.G VSS VSS sg13_lv_nmos ad=2.071p pd=11.28u as=0 ps=0 w=10.9u l=1.38u
X9032 cml_gate2_9.xrtail.R1 NM1_N ENA_P VSS sg13_lv_nmos ad=0.1007p pd=0.91u as=0.1007p ps=0.91u w=0.53u l=0.13u
X9033 VSS cml_drv_0.xrtail.R1 VSS rppd l=5.65u w=1u
X9034 cml_tlatch_19.xtail.S1 CKA1_P cml_tlatch_19.xmux.xp.S1 VSS sg13_lv_nmos ad=89.3f pd=0.85u as=89.3f ps=0.85u w=0.47u l=0.16u
X9035 VSS hs_to_clk_8.sg13_lv_nmos_2HGZLP_0.G VSS VSS sg13_lv_nmos ad=3.706p pd=22.48u as=0 ps=0 w=10.9u l=1.38u
X9036 cml_tlatch_73.xmux.xn.S1 CKHB3_P cml_tlatch_73.xtail.S1 VSS sg13_lv_nmos ad=89.3f pd=0.85u as=89.3f ps=0.85u w=0.47u l=0.16u
X9037 cml_tlatch_3.xmux.xp.S1 MOT9_P MOT9_N VSS sg13_lv_nmos ad=56.9f pd=0.74u as=56.9f ps=0.74u w=0.17u l=0.17u
X9038 cml_tlatch_87.INP cml_tlatch_87.INN cml_tlatch_76.xmux.xp.S1 VSS sg13_lv_nmos ad=56.9f pd=0.74u as=56.9f ps=0.74u w=0.17u l=0.17u
X9039 cml_tlatch_6.xmux.xn.S1 B1_2_P MOT15_N VSS sg13_lv_nmos ad=63.19999f pd=0.74u as=0.1082p ps=1.34u w=0.26u l=0.38u
X9040 B2_8_N VDD VSS rppd l=5.17u w=1u
X9041 cml_tlatch_90.xmux.xp.S1 stub_bi_55.BOTN stub_bi_55.BOTP VSS sg13_lv_nmos ad=56.9f pd=0.74u as=56.9f ps=0.74u w=0.17u l=0.17u
X9042 cml_tlatch_99.OUTN cml_tlatch_33.OUTP cml_tlatch_99.xmux.xn.S1 VSS sg13_lv_nmos ad=63.19999f pd=0.74u as=0.1082p ps=1.34u w=0.26u l=0.38u
X9043 cml_tlatch_57.xmux.xp.S1 A3_2_N A3_2_P VSS sg13_lv_nmos ad=56.9f pd=0.74u as=56.9f ps=0.74u w=0.17u l=0.17u
X9044 MOT7_P MOT7_N cml_tlatch_17.xmux.xp.S1 VSS sg13_lv_nmos ad=56.9f pd=0.74u as=56.9f ps=0.74u w=0.17u l=0.17u
X9045 MOT24_P MOT24_N cml_tlatch_62.xmux.xp.S1 VSS sg13_lv_nmos ad=56.9f pd=0.74u as=56.9f ps=0.74u w=0.17u l=0.17u
X9046 GA2_N ENA1_P cml_gate2_5.xamp.xn.S1 VSS sg13_lv_nmos ad=0.1007p pd=0.91u as=0.1007p ps=0.91u w=0.53u l=0.13u
X9047 cml_tlatch_71.xtail.S1 CKA3_P cml_tlatch_71.xmux.xn.S1 VSS sg13_lv_nmos ad=89.3f pd=0.85u as=89.3f ps=0.85u w=0.47u l=0.16u
X9048 MOT27_P MOT27_N cml_tlatch_73.xmux.xp.S1 VSS sg13_lv_nmos ad=56.9f pd=0.74u as=56.9f ps=0.74u w=0.17u l=0.17u
X9049 cml_tlatch_79.xtail.S1 CKHB2_P cml_tlatch_79.xmux.xn.S1 VSS sg13_lv_nmos ad=89.3f pd=0.85u as=89.3f ps=0.85u w=0.47u l=0.16u
X9050 cml_tlatch_32.OUTN cml_tlatch_32.OUTP cml_tlatch_32.xmux.xp.S1 VSS sg13_lv_nmos ad=56.9f pd=0.74u as=56.9f ps=0.74u w=0.17u l=0.17u
X9051 cml_tlatch_90.xmux.xn.S1 stub_bi_38.BOTP stub_bi_55.BOTN VSS sg13_lv_nmos ad=63.19999f pd=0.74u as=63.19999f ps=0.74u w=0.26u l=0.38u
X9052 cml_tlatch_41.OUTN cml_tlatch_41.OUTP cml_tlatch_41.xmux.xp.S1 VSS sg13_lv_nmos ad=56.9f pd=0.74u as=56.9f ps=0.74u w=0.17u l=0.17u
X9053 cml_tlatch_87.OUTN cml_tlatch_87.OUTP cml_tlatch_87.xmux.xp.S1 VSS sg13_lv_nmos ad=56.9f pd=0.74u as=56.9f ps=0.74u w=0.17u l=0.17u
X9054 cml_tlatch_83.xmux.xp.S1 stub_bi_63.BOTN stub_bi_63.BOTP VSS sg13_lv_nmos ad=56.9f pd=0.74u as=56.9f ps=0.74u w=0.17u l=0.17u
X9055 cml_tlatch_83.xmux.xp.S1 stub_bi_63.BOTP stub_bi_63.BOTN VSS sg13_lv_nmos ad=56.9f pd=0.74u as=56.9f ps=0.74u w=0.17u l=0.17u
X9056 cml_tlatch_42.xmux.xp.S1 MOT8_N MOT8_P VSS sg13_lv_nmos ad=56.9f pd=0.74u as=56.9f ps=0.74u w=0.17u l=0.17u
X9057 cml_tlatch_20.xtail.S1 CKA1_P cml_tlatch_20.xmux.xn.S1 VSS sg13_lv_nmos ad=89.3f pd=0.85u as=89.3f ps=0.85u w=0.47u l=0.16u
X9058 MOT15_N MOT15_P cml_tlatch_6.xmux.xp.S1 VSS sg13_lv_nmos ad=56.9f pd=0.74u as=56.9f ps=0.74u w=0.17u l=0.17u
X9059 cml_tlatch_7.OUTN cml_tlatch_8.OUTP cml_tlatch_7.xmux.xn.S1 VSS sg13_lv_nmos ad=63.19999f pd=0.74u as=63.19999f ps=0.74u w=0.26u l=0.38u
X9060 cml_tlatch_33.OUTN A0_2_P cml_tlatch_33.xmux.xn.S1 VSS sg13_lv_nmos ad=63.19999f pd=0.74u as=63.19999f ps=0.74u w=0.26u l=0.38u
X9061 cml_tlatch_20.xmux.xp.S1 cml_tlatch_20.OUTP cml_tlatch_20.OUTN VSS sg13_lv_nmos ad=56.9f pd=0.74u as=56.9f ps=0.74u w=0.17u l=0.17u
X9062 stub_bi_62.BOTP stub_bi_62.BOTN cml_tlatch_82.xmux.xp.S1 VSS sg13_lv_nmos ad=56.9f pd=0.74u as=56.9f ps=0.74u w=0.17u l=0.17u
X9063 cml_tlatch_16.xmux.xp.S1 CKHB0_N cml_tlatch_16.xtail.S1 VSS sg13_lv_nmos ad=89.3f pd=0.85u as=89.3f ps=0.85u w=0.47u l=0.16u
X9064 B1_8_N stub_bi_15.BOTN cml_tlatch_10.xmux.xn.S1 VSS sg13_lv_nmos ad=63.19999f pd=0.74u as=63.19999f ps=0.74u w=0.26u l=0.38u
X9065 MOT18_N MOT18_P cml_tlatch_53.xmux.xp.S1 VSS sg13_lv_nmos ad=56.9f pd=0.74u as=56.9f ps=0.74u w=0.17u l=0.17u
X9066 cml_tlatch_44.INN cml_tlatch_44.INP cml_tlatch_89.xmux.xp.S1 VSS sg13_lv_nmos ad=56.9f pd=0.74u as=0.1019p ps=1.34u w=0.17u l=0.17u
X9067 cml_gate2_1.xamp.xn.S1 ENB1_P GB0_N VSS sg13_lv_nmos ad=0.1007p pd=0.91u as=0.1007p ps=0.91u w=0.53u l=0.13u
X9068 MOT13_P MOT13_N cml_tlatch_5.xmux.xp.S1 VSS sg13_lv_nmos ad=56.9f pd=0.74u as=0.1019p ps=1.34u w=0.17u l=0.17u
X9069 cml_tlatch_52.xtail.S1 CKHA2_P cml_tlatch_52.xmux.xn.S1 VSS sg13_lv_nmos ad=89.3f pd=0.85u as=89.3f ps=0.85u w=0.47u l=0.16u
X9070 MOT16_N A2_8_P cml_tlatch_52.xmux.xn.S1 VSS sg13_lv_nmos ad=63.19999f pd=0.74u as=0.1082p ps=1.34u w=0.26u l=0.38u
X9071 A1_2_P A1_2_N cml_tlatch_40.xmux.xp.S1 VSS sg13_lv_nmos ad=56.9f pd=0.74u as=56.9f ps=0.74u w=0.17u l=0.17u
X9072 stub_bi_31.BOTN stub_bi_31.BOTP cml_tlatch_37.xmux.xp.S1 VSS sg13_lv_nmos ad=56.9f pd=0.74u as=56.9f ps=0.74u w=0.17u l=0.17u
X9073 cml_tlatch_59.xtail.S1 CKA2_P cml_tlatch_59.xmux.xn.S1 VSS sg13_lv_nmos ad=89.3f pd=0.85u as=89.3f ps=0.85u w=0.47u l=0.16u
X9074 cml_tlatch_64.xmux.xn.S1 cml_tlatch_65.OUTP B3_8_N VSS sg13_lv_nmos ad=63.19999f pd=0.74u as=63.19999f ps=0.74u w=0.26u l=0.38u
X9075 cml_tlatch_98.xmux.xp.S1 cml_tlatch_98.OUTN cml_tlatch_98.OUTP VSS sg13_lv_nmos ad=56.9f pd=0.74u as=56.9f ps=0.74u w=0.17u l=0.17u
X9076 cml_tlatch_0.OUTP cml_tlatch_0.OUTN cml_tlatch_0.xmux.xp.S1 VSS sg13_lv_nmos ad=56.9f pd=0.74u as=56.9f ps=0.74u w=0.17u l=0.17u
X9077 cml_tlatch_11.xtail.S1 CKB1_P cml_tlatch_11.xmux.xn.S1 VSS sg13_lv_nmos ad=89.3f pd=0.85u as=89.3f ps=0.85u w=0.47u l=0.16u
X9078 cml_tlatch_49.xmux.xp.S1 cml_tlatch_49.OUTP cml_tlatch_49.OUTN VSS sg13_lv_nmos ad=56.9f pd=0.74u as=56.9f ps=0.74u w=0.17u l=0.17u
X9079 cml_tlatch_33.xtail.S1 CKA0_P cml_tlatch_33.xmux.xn.S1 VSS sg13_lv_nmos ad=89.3f pd=0.85u as=89.3f ps=0.85u w=0.47u l=0.16u
X9080 cml_tlatch_63.xmux.xp.S1 MOT26_N MOT26_P VSS sg13_lv_nmos ad=0.1019p pd=1.34u as=56.9f ps=0.74u w=0.17u l=0.17u
X9081 cml_tlatch_8.OUTN cml_tlatch_98.OUTP cml_tlatch_8.xmux.xn.S1 VSS sg13_lv_nmos ad=63.19999f pd=0.74u as=63.19999f ps=0.74u w=0.26u l=0.38u
X9082 cml_tlatch_86.xtail.S1 CKA2_P cml_tlatch_86.xmux.xn.S1 VSS sg13_lv_nmos ad=89.3f pd=0.85u as=89.3f ps=0.85u w=0.47u l=0.16u
X9083 cml_tlatch_23.OUTP cml_tlatch_23.OUTN cml_tlatch_23.xmux.xp.S1 VSS sg13_lv_nmos ad=56.9f pd=0.74u as=56.9f ps=0.74u w=0.17u l=0.17u
X9084 GA1_P ENA0_N cml_gate2_2.xamp.xn.S1 VSS sg13_lv_nmos ad=0.1007p pd=0.91u as=0.1007p ps=0.91u w=0.53u l=0.13u
X9085 cml_tlatch_1.xmux.xn.S1 CKB0_N cml_tlatch_1.xtail.S1 VSS sg13_lv_nmos ad=89.3f pd=0.85u as=89.3f ps=0.85u w=0.47u l=0.16u
X9086 stub_bi_63.BOTN stub_bi_49.BOTP cml_tlatch_83.xmux.xn.S1 VSS sg13_lv_nmos ad=63.19999f pd=0.74u as=63.19999f ps=0.74u w=0.26u l=0.38u
X9087 cml_tlatch_5.xtail.S1 CKHB1_P cml_tlatch_5.xmux.xn.S1 VSS sg13_lv_nmos ad=89.3f pd=0.85u as=89.3f ps=0.85u w=0.47u l=0.16u
X9088 cml_tlatch_62.xtail.S1 CKHA3_P cml_tlatch_62.xmux.xn.S1 VSS sg13_lv_nmos ad=89.3f pd=0.85u as=89.3f ps=0.85u w=0.47u l=0.16u
X9089 cml_tlatch_46.xtail.S1 CKB2_P cml_tlatch_46.xmux.xn.S1 VSS sg13_lv_nmos ad=89.3f pd=0.85u as=89.3f ps=0.85u w=0.47u l=0.16u
X9090 cml_tlatch_22.xmux.xp.S1 cml_tlatch_22.OUTN cml_tlatch_22.OUTP VSS sg13_lv_nmos ad=56.9f pd=0.74u as=56.9f ps=0.74u w=0.17u l=0.17u
X9091 cml_tlatch_49.xmux.xp.S1 cml_tlatch_49.OUTP cml_tlatch_49.OUTN VSS sg13_lv_nmos ad=0.1019p pd=1.34u as=56.9f ps=0.74u w=0.17u l=0.17u
X9092 cml_tlatch_27.xmux.xp.S1 MOT2_P MOT2_N VSS sg13_lv_nmos ad=56.9f pd=0.74u as=56.9f ps=0.74u w=0.17u l=0.17u
X9093 GA1_N ENA0_P cml_gate2_2.xamp.xn.S1 VSS sg13_lv_nmos ad=0.1007p pd=0.91u as=0.1007p ps=0.91u w=0.53u l=0.13u
X9094 cml_tlatch_85.xmux.xp.S1 A2_8_N A2_8_P VSS sg13_lv_nmos ad=56.9f pd=0.74u as=56.9f ps=0.74u w=0.17u l=0.17u
X9095 cml_tlatch_38.xtail.S1 CKA0_N cml_tlatch_38.xmux.xp.S1 VSS sg13_lv_nmos ad=89.3f pd=0.85u as=89.3f ps=0.85u w=0.47u l=0.16u
X9096 cml_tlatch_44.INP cml_tlatch_56.OUTN cml_tlatch_89.xmux.xn.S1 VSS sg13_lv_nmos ad=63.19999f pd=0.74u as=63.19999f ps=0.74u w=0.26u l=0.38u
X9097 cml_tlatch_0.xmux.xp.S1 cml_tlatch_0.OUTP cml_tlatch_0.OUTN VSS sg13_lv_nmos ad=56.9f pd=0.74u as=56.9f ps=0.74u w=0.17u l=0.17u
X9098 cml_tlatch_18.xtail.S1 CKA0_N cml_tlatch_18.xmux.xp.S1 VSS sg13_lv_nmos ad=89.3f pd=0.85u as=89.3f ps=0.85u w=0.47u l=0.16u
X9099 cml_tlatch_89.xmux.xn.S1 cml_tlatch_56.OUTP cml_tlatch_44.INN VSS sg13_lv_nmos ad=63.19999f pd=0.74u as=63.19999f ps=0.74u w=0.26u l=0.38u
X9100 cml_tlatch_58.xmux.xp.S1 cml_tlatch_58.OUTP cml_tlatch_58.OUTN VSS sg13_lv_nmos ad=56.9f pd=0.74u as=56.9f ps=0.74u w=0.17u l=0.17u
X9101 cml_tlatch_78.xmux.xn.S1 stub_bi_63.BOTN MOT19_N VSS sg13_lv_nmos ad=63.19999f pd=0.74u as=63.19999f ps=0.74u w=0.26u l=0.38u
X9102 stub_bi_29.BOTP stub_bi_29.BOTN cml_tlatch_35.xmux.xp.S1 VSS sg13_lv_nmos ad=56.9f pd=0.74u as=56.9f ps=0.74u w=0.17u l=0.17u
X9103 cml_tlatch_51.OUTN D3_P cml_tlatch_51.xmux.xn.S1 VSS sg13_lv_nmos ad=63.19999f pd=0.74u as=63.19999f ps=0.74u w=0.26u l=0.38u
X9104 cml_gate2_6.xamp.xn.S1 ENB0_N GB3_P VSS sg13_lv_nmos ad=0.1007p pd=0.91u as=0.1007p ps=0.91u w=0.53u l=0.13u
X9105 cml_tlatch_92.xmux.xp.S1 J4_P J4_N VSS sg13_lv_nmos ad=56.9f pd=0.74u as=56.9f ps=0.74u w=0.17u l=0.17u
X9106 MOT9_P MOT9_N cml_tlatch_3.xmux.xp.S1 VSS sg13_lv_nmos ad=56.9f pd=0.74u as=56.9f ps=0.74u w=0.17u l=0.17u
X9107 cml_tlatch_64.xtail.S1 CKB3_N cml_tlatch_64.xmux.xn.S1 VSS sg13_lv_nmos ad=89.3f pd=0.85u as=89.3f ps=0.85u w=0.47u l=0.16u
X9108 B0_2_N B0_2_P cml_tlatch_31.xmux.xp.S1 VSS sg13_lv_nmos ad=56.9f pd=0.74u as=56.9f ps=0.74u w=0.17u l=0.17u
X9109 MOT24_P MOT24_N cml_tlatch_62.xmux.xp.S1 VSS sg13_lv_nmos ad=56.9f pd=0.74u as=0.1019p ps=1.34u w=0.17u l=0.17u
X9110 cml_tlatch_38.OUTP cml_tlatch_38.OUTN cml_tlatch_38.xmux.xp.S1 VSS sg13_lv_nmos ad=56.9f pd=0.74u as=56.9f ps=0.74u w=0.17u l=0.17u
X9111 cml_tlatch_39.xtail.S1 POLN VSS VSS sg13_lv_nmos ad=1.5637p pd=8.61u as=2.7982p ps=17.14u w=8.23u l=0.13u
X9112 cml_tlatch_99.xmux.xp.S1 cml_tlatch_99.OUTP cml_tlatch_99.OUTN VSS sg13_lv_nmos ad=56.9f pd=0.74u as=56.9f ps=0.74u w=0.17u l=0.17u
X9113 B3_2_P cml_tlatch_51.OUTN cml_tlatch_50.xmux.xn.S1 VSS sg13_lv_nmos ad=63.19999f pd=0.74u as=63.19999f ps=0.74u w=0.26u l=0.38u
X9114 cml_tlatch_65.xtail.S1 POLN VSS VSS sg13_lv_nmos ad=1.5637p pd=8.61u as=1.5637p ps=8.61u w=8.23u l=0.13u
X9115 cml_tlatch_78.xmux.xp.S1 MOT19_P MOT19_N VSS sg13_lv_nmos ad=56.9f pd=0.74u as=56.9f ps=0.74u w=0.17u l=0.17u
X9116 cml_tlatch_37.xmux.xp.S1 stub_bi_31.BOTN stub_bi_31.BOTP VSS sg13_lv_nmos ad=56.9f pd=0.74u as=56.9f ps=0.74u w=0.17u l=0.17u
X9117 cml_tlatch_62.xtail.S1 CKHA3_N cml_tlatch_62.xmux.xp.S1 VSS sg13_lv_nmos ad=89.3f pd=0.85u as=0.1598p ps=1.62u w=0.47u l=0.16u
X9118 cml_tlatch_54.xmux.xp.S1 MOT20_P MOT20_N VSS sg13_lv_nmos ad=56.9f pd=0.74u as=56.9f ps=0.74u w=0.17u l=0.17u
X9119 cml_tlatch_85.xmux.xn.S1 cml_tlatch_86.OUTP A2_8_N VSS sg13_lv_nmos ad=63.19999f pd=0.74u as=63.19999f ps=0.74u w=0.26u l=0.38u
X9120 cml_tlatch_63.INP cml_tlatch_63.INN cml_tlatch_70.xmux.xp.S1 VSS sg13_lv_nmos ad=56.9f pd=0.74u as=56.9f ps=0.74u w=0.17u l=0.17u
X9121 cml_tlatch_27.xtail.S1 CKHA0_P cml_tlatch_27.xmux.xn.S1 VSS sg13_lv_nmos ad=89.3f pd=0.85u as=89.3f ps=0.85u w=0.47u l=0.16u
X9122 cml_tlatch_9.xmux.xp.S1 A0_8_N A0_8_P VSS sg13_lv_nmos ad=56.9f pd=0.74u as=56.9f ps=0.74u w=0.17u l=0.17u
X9123 cml_tlatch_19.xmux.xp.S1 A1_8_P A1_8_N VSS sg13_lv_nmos ad=56.9f pd=0.74u as=56.9f ps=0.74u w=0.17u l=0.17u
X9124 cml_tlatch_13.xmux.xn.S1 CKB1_P cml_tlatch_13.xtail.S1 VSS sg13_lv_nmos ad=89.3f pd=0.85u as=89.3f ps=0.85u w=0.47u l=0.16u
X9125 cml_tlatch_20.xmux.xp.S1 cml_tlatch_20.OUTP cml_tlatch_20.OUTN VSS sg13_lv_nmos ad=56.9f pd=0.74u as=56.9f ps=0.74u w=0.17u l=0.17u
X9126 cml_tlatch_68.xmux.xp.S1 CKA3_P cml_tlatch_68.xtail.S1 VSS sg13_lv_nmos ad=0.1598p pd=1.62u as=89.3f ps=0.85u w=0.47u l=0.16u
X9127 cml_tlatch_2.xmux.xn.S1 cml_tlatch_7.OUTN cml_tlatch_2.OUTP VSS sg13_lv_nmos ad=63.19999f pd=0.74u as=63.19999f ps=0.74u w=0.26u l=0.38u
X9128 cml_tlatch_6.xmux.xp.S1 MOT15_N MOT15_P VSS sg13_lv_nmos ad=56.9f pd=0.74u as=56.9f ps=0.74u w=0.17u l=0.17u
X9129 cml_tlatch_29.xmux.xp.S1 MOT6_P MOT6_N VSS sg13_lv_nmos ad=56.9f pd=0.74u as=56.9f ps=0.74u w=0.17u l=0.17u
X9130 cml_tlatch_2.xmux.xn.S1 cml_tlatch_7.OUTN cml_tlatch_2.OUTP VSS sg13_lv_nmos ad=63.19999f pd=0.74u as=63.19999f ps=0.74u w=0.26u l=0.38u
X9131 cml_tlatch_4.xmux.xp.S1 MOT11_N MOT11_P VSS sg13_lv_nmos ad=56.9f pd=0.74u as=56.9f ps=0.74u w=0.17u l=0.17u
X9132 cml_tlatch_8.xmux.xp.S1 cml_tlatch_8.OUTN cml_tlatch_8.OUTP VSS sg13_lv_nmos ad=56.9f pd=0.74u as=56.9f ps=0.74u w=0.17u l=0.17u
X9133 cml_tlatch_39.xmux.xp.S1 cml_tlatch_97.INN cml_tlatch_97.INP VSS sg13_lv_nmos ad=56.9f pd=0.74u as=56.9f ps=0.74u w=0.17u l=0.17u
X9134 cml_tlatch_61.xmux.xn.S1 CKA2_P cml_tlatch_61.xtail.S1 VSS sg13_lv_nmos ad=89.3f pd=0.85u as=0.1598p ps=1.62u w=0.47u l=0.16u
X9135 cml_tlatch_4.xmux.xp.S1 CKHB1_N cml_tlatch_4.xtail.S1 VSS sg13_lv_nmos ad=89.3f pd=0.85u as=89.3f ps=0.85u w=0.47u l=0.16u
X9136 MOT3_N MOT3_P cml_tlatch_15.xmux.xp.S1 VSS sg13_lv_nmos ad=56.9f pd=0.74u as=56.9f ps=0.74u w=0.17u l=0.17u
X9137 cml_tlatch_20.xmux.xp.S1 cml_tlatch_20.OUTP cml_tlatch_20.OUTN VSS sg13_lv_nmos ad=56.9f pd=0.74u as=56.9f ps=0.74u w=0.17u l=0.17u
X9138 cml_tlatch_71.OUTP cml_tlatch_71.OUTN cml_tlatch_71.xmux.xp.S1 VSS sg13_lv_nmos ad=56.9f pd=0.74u as=56.9f ps=0.74u w=0.17u l=0.17u
X9139 cml_tlatch_21.xmux.xp.S1 cml_tlatch_43.INP cml_tlatch_43.INN VSS sg13_lv_nmos ad=56.9f pd=0.74u as=56.9f ps=0.74u w=0.17u l=0.17u
X9140 MOT18_N MOT18_P cml_tlatch_53.xmux.xp.S1 VSS sg13_lv_nmos ad=56.9f pd=0.74u as=56.9f ps=0.74u w=0.17u l=0.17u
X9141 MOT17_N B2_8_P cml_tlatch_77.xmux.xn.S1 VSS sg13_lv_nmos ad=63.19999f pd=0.74u as=63.19999f ps=0.74u w=0.26u l=0.38u
X9142 B3_2_N B3_2_P cml_tlatch_50.xmux.xp.S1 VSS sg13_lv_nmos ad=56.9f pd=0.74u as=56.9f ps=0.74u w=0.17u l=0.17u
X9143 cml_tlatch_63.xmux.xp.S1 MOT26_P MOT26_N VSS sg13_lv_nmos ad=56.9f pd=0.74u as=56.9f ps=0.74u w=0.17u l=0.17u
X9144 cml_tlatch_43.xmux.xn.S1 cml_tlatch_43.INP MOT10_N VSS sg13_lv_nmos ad=63.19999f pd=0.74u as=63.19999f ps=0.74u w=0.26u l=0.38u
X9145 cml_tlatch_60.xmux.xp.S1 A2_2_P A2_2_N VSS sg13_lv_nmos ad=56.9f pd=0.74u as=56.9f ps=0.74u w=0.17u l=0.17u
X9146 MOT0_P A0_8_N cml_tlatch_26.xmux.xn.S1 VSS sg13_lv_nmos ad=63.19999f pd=0.74u as=63.19999f ps=0.74u w=0.26u l=0.38u
X9147 cml_tlatch_75.xmux.xp.S1 MOT31_N MOT31_P VSS sg13_lv_nmos ad=56.9f pd=0.74u as=56.9f ps=0.74u w=0.17u l=0.17u
X9148 cml_tlatch_22.xtail.S1 CKA1_N cml_tlatch_22.xmux.xp.S1 VSS sg13_lv_nmos ad=89.3f pd=0.85u as=89.3f ps=0.85u w=0.47u l=0.16u
X9149 cml_tlatch_96.xmux.xn.S1 stub_bi_29.BOTN cml_tlatch_5.INN VSS sg13_lv_nmos ad=63.19999f pd=0.74u as=0.1082p ps=1.34u w=0.26u l=0.38u
X9150 cml_tlatch_98.xmux.xp.S1 cml_tlatch_98.OUTN cml_tlatch_98.OUTP VSS sg13_lv_nmos ad=56.9f pd=0.74u as=56.9f ps=0.74u w=0.17u l=0.17u
X9151 cml_tlatch_22.xmux.xp.S1 cml_tlatch_22.OUTN cml_tlatch_22.OUTP VSS sg13_lv_nmos ad=56.9f pd=0.74u as=56.9f ps=0.74u w=0.17u l=0.17u
X9152 CLK_W_P CLK_W_N cml_tlatch_93.xmux.xp.S1 VSS sg13_lv_nmos ad=56.9f pd=0.74u as=56.9f ps=0.74u w=0.17u l=0.17u
X9153 cml_tlatch_69.OUTP cml_tlatch_63.INN cml_tlatch_69.xmux.xn.S1 VSS sg13_lv_nmos ad=63.19999f pd=0.74u as=63.19999f ps=0.74u w=0.26u l=0.38u
X9154 stub_bi_17.BOTN stub_bi_17.BOTP cml_tlatch_13.xmux.xp.S1 VSS sg13_lv_nmos ad=56.9f pd=0.74u as=56.9f ps=0.74u w=0.17u l=0.17u
X9155 cml_tlatch_72.xmux.xp.S1 MOT25_N MOT25_P VSS sg13_lv_nmos ad=56.9f pd=0.74u as=56.9f ps=0.74u w=0.17u l=0.17u
X9156 cml_tlatch_61.xmux.xn.S1 D2_N cml_tlatch_61.OUTP VSS sg13_lv_nmos ad=63.19999f pd=0.74u as=63.19999f ps=0.74u w=0.26u l=0.38u
X9157 cml_tlatch_5.INN cml_tlatch_5.INP cml_tlatch_96.xmux.xp.S1 VSS sg13_lv_nmos ad=56.9f pd=0.74u as=56.9f ps=0.74u w=0.17u l=0.17u
X9158 cml_tlatch_90.xmux.xp.S1 CKB2_P cml_tlatch_90.xtail.S1 VSS sg13_lv_nmos ad=89.3f pd=0.85u as=89.3f ps=0.85u w=0.47u l=0.16u
X9159 cml_tlatch_96.xtail.S1 CKB1_N cml_tlatch_96.xmux.xn.S1 VSS sg13_lv_nmos ad=89.3f pd=0.85u as=89.3f ps=0.85u w=0.47u l=0.16u
X9160 cml_tlatch_50.xtail.S1 CKB3_N cml_tlatch_50.xmux.xn.S1 VSS sg13_lv_nmos ad=89.3f pd=0.85u as=89.3f ps=0.85u w=0.47u l=0.16u
X9161 MOT4_P MOT4_N cml_tlatch_28.xmux.xp.S1 VSS sg13_lv_nmos ad=56.9f pd=0.74u as=0.1019p ps=1.34u w=0.17u l=0.17u
X9162 MOT21_N MOT21_P cml_tlatch_79.xmux.xp.S1 VSS sg13_lv_nmos ad=56.9f pd=0.74u as=56.9f ps=0.74u w=0.17u l=0.17u
X9163 cml_tlatch_79.xmux.xn.S1 CKHB2_P cml_tlatch_79.xtail.S1 VSS sg13_lv_nmos ad=89.3f pd=0.85u as=89.3f ps=0.85u w=0.47u l=0.16u
X9164 cml_tlatch_67.xmux.xp.S1 cml_tlatch_67.OUTP cml_tlatch_67.OUTN VSS sg13_lv_nmos ad=56.9f pd=0.74u as=56.9f ps=0.74u w=0.17u l=0.17u
X9165 cml_tlatch_60.xmux.xp.S1 CKA2_P cml_tlatch_60.xtail.S1 VSS sg13_lv_nmos ad=89.3f pd=0.85u as=89.3f ps=0.85u w=0.47u l=0.16u
X9166 cml_tlatch_13.xtail.S1 CKB1_N cml_tlatch_13.xmux.xp.S1 VSS sg13_lv_nmos ad=89.3f pd=0.85u as=89.3f ps=0.85u w=0.47u l=0.16u
X9167 cml_tlatch_9.xmux.xp.S1 A0_8_P A0_8_N VSS sg13_lv_nmos ad=56.9f pd=0.74u as=56.9f ps=0.74u w=0.17u l=0.17u
X9168 cml_tlatch_23.OUTN cml_tlatch_23.OUTP cml_tlatch_23.xmux.xp.S1 VSS sg13_lv_nmos ad=56.9f pd=0.74u as=0.1019p ps=1.34u w=0.17u l=0.17u
X9169 VSS hs_to_clk_1.sg13_lv_nmos_2HGZLP_0.G VSS VSS sg13_lv_nmos ad=2.071p pd=11.28u as=0 ps=0 w=10.9u l=1.38u
X9170 B2_8_P B2_8_N cml_tlatch_81.xmux.xp.S1 VSS sg13_lv_nmos ad=56.9f pd=0.74u as=56.9f ps=0.74u w=0.17u l=0.17u
X9171 cml_tlatch_32.xmux.xn.S1 D0_P cml_tlatch_32.OUTN VSS sg13_lv_nmos ad=63.19999f pd=0.74u as=63.19999f ps=0.74u w=0.26u l=0.38u
X9172 cml_tlatch_29.xmux.xp.S1 CKHA0_N cml_tlatch_29.xtail.S1 VSS sg13_lv_nmos ad=89.3f pd=0.85u as=89.3f ps=0.85u w=0.47u l=0.16u
X9173 cml_tlatch_22.OUTP cml_tlatch_24.INN cml_tlatch_22.xmux.xn.S1 VSS sg13_lv_nmos ad=63.19999f pd=0.74u as=63.19999f ps=0.74u w=0.26u l=0.38u
X9174 VSS POLN cml_tlatch_47.xtail.S1 VSS sg13_lv_nmos ad=1.5637p pd=8.61u as=1.5637p ps=8.61u w=8.23u l=0.13u
X9175 cml_tlatch_86.OUTN cml_tlatch_87.OUTP cml_tlatch_86.xmux.xn.S1 VSS sg13_lv_nmos ad=63.19999f pd=0.74u as=63.19999f ps=0.74u w=0.26u l=0.38u
X9176 cml_tlatch_2.OUTP cml_tlatch_2.OUTN cml_tlatch_2.xmux.xp.S1 VSS sg13_lv_nmos ad=56.9f pd=0.74u as=56.9f ps=0.74u w=0.17u l=0.17u
X9177 cml_tlatch_8.OUTN cml_tlatch_8.OUTP cml_tlatch_8.xmux.xp.S1 VSS sg13_lv_nmos ad=56.9f pd=0.74u as=0.1019p ps=1.34u w=0.17u l=0.17u
X9178 cml_tlatch_74.xmux.xn.S1 CKHB3_P cml_tlatch_74.xtail.S1 VSS sg13_lv_nmos ad=89.3f pd=0.85u as=89.3f ps=0.85u w=0.47u l=0.16u
X9179 cml_tlatch_53.xmux.xp.S1 CKHA2_N cml_tlatch_53.xtail.S1 VSS sg13_lv_nmos ad=89.3f pd=0.85u as=0.1598p ps=1.62u w=0.47u l=0.16u
X9180 CKA1_N CK_N hs_to_clk_3.D2 VSS sg13_lv_nmos ad=0.408p pd=3.08u as=0.228p ps=1.58u w=1.2u l=0.2u
X9181 cml_gate2_9.xamp.xn.S1 NM1_P cml_gate2_9.xrtail.R1 VSS sg13_lv_nmos ad=0.1007p pd=0.91u as=0.1007p ps=0.91u w=0.53u l=0.13u
X9182 MOT0_N MOT0_P cml_tlatch_26.xmux.xp.S1 VSS sg13_lv_nmos ad=56.9f pd=0.74u as=56.9f ps=0.74u w=0.17u l=0.17u
X9183 cml_tlatch_92.xmux.xp.S1 J4_P J4_N VSS sg13_lv_nmos ad=56.9f pd=0.74u as=56.9f ps=0.74u w=0.17u l=0.17u
X9184 VSS POLN cml_tlatch_82.xtail.S1 VSS sg13_lv_nmos ad=2.7982p pd=17.14u as=1.5637p ps=8.61u w=8.23u l=0.13u
X9185 cml_tlatch_18.xmux.xp.S1 cml_tlatch_18.OUTP cml_tlatch_18.OUTN VSS sg13_lv_nmos ad=56.9f pd=0.74u as=56.9f ps=0.74u w=0.17u l=0.17u
X9186 cml_tlatch_17.xmux.xp.S1 CKHB0_N cml_tlatch_17.xtail.S1 VSS sg13_lv_nmos ad=89.3f pd=0.85u as=89.3f ps=0.85u w=0.47u l=0.16u
X9187 cml_tlatch_30.xmux.xp.S1 cml_tlatch_30.OUTN cml_tlatch_30.OUTP VSS sg13_lv_nmos ad=56.9f pd=0.74u as=56.9f ps=0.74u w=0.17u l=0.17u
X9188 cml_tlatch_51.OUTP VDD VSS rppd l=5.17u w=1u
X9189 cml_tlatch_74.xmux.xn.S1 cml_tlatch_74.INP MOT29_N VSS sg13_lv_nmos ad=63.19999f pd=0.74u as=63.19999f ps=0.74u w=0.26u l=0.38u
X9190 cml_tlatch_27.xmux.xp.S1 MOT2_N MOT2_P VSS sg13_lv_nmos ad=56.9f pd=0.74u as=56.9f ps=0.74u w=0.17u l=0.17u
X9191 cml_tlatch_93.xtail.S1 CKJ_P cml_tlatch_93.xmux.xn.S1 VSS sg13_lv_nmos ad=89.3f pd=0.85u as=89.3f ps=0.85u w=0.47u l=0.16u
X9192 cml_tlatch_20.OUTP cml_tlatch_20.OUTN cml_tlatch_20.xmux.xp.S1 VSS sg13_lv_nmos ad=56.9f pd=0.74u as=56.9f ps=0.74u w=0.17u l=0.17u
X9193 cml_tlatch_58.xtail.S1 CKA3_P cml_tlatch_58.xmux.xn.S1 VSS sg13_lv_nmos ad=89.3f pd=0.85u as=89.3f ps=0.85u w=0.47u l=0.16u
X9194 cml_tlatch_54.xmux.xp.S1 MOT20_P MOT20_N VSS sg13_lv_nmos ad=0.1019p pd=1.34u as=56.9f ps=0.74u w=0.17u l=0.17u
X9195 cml_tlatch_78.xmux.xp.S1 MOT19_P MOT19_N VSS sg13_lv_nmos ad=56.9f pd=0.74u as=56.9f ps=0.74u w=0.17u l=0.17u
X9196 MOT23_N B2_2_P cml_tlatch_80.xmux.xn.S1 VSS sg13_lv_nmos ad=0.1082p pd=1.34u as=63.19999f ps=0.74u w=0.26u l=0.38u
X9197 cml_tlatch_63.INP cml_tlatch_63.INN cml_tlatch_70.xmux.xp.S1 VSS sg13_lv_nmos ad=56.9f pd=0.74u as=56.9f ps=0.74u w=0.17u l=0.17u
X9198 cml_tlatch_63.INN cml_tlatch_63.INP cml_tlatch_70.xmux.xp.S1 VSS sg13_lv_nmos ad=56.9f pd=0.74u as=56.9f ps=0.74u w=0.17u l=0.17u
X9199 MOT28_N MOT28_P cml_tlatch_44.xmux.xp.S1 VSS sg13_lv_nmos ad=56.9f pd=0.74u as=56.9f ps=0.74u w=0.17u l=0.17u
X9200 CLK_W_P J2_P cml_tlatch_93.xmux.xn.S1 VSS sg13_lv_nmos ad=63.19999f pd=0.74u as=63.19999f ps=0.74u w=0.26u l=0.38u
X9201 cml_tlatch_66.xmux.xp.S1 cml_tlatch_73.INN cml_tlatch_73.INP VSS sg13_lv_nmos ad=56.9f pd=0.74u as=56.9f ps=0.74u w=0.17u l=0.17u
X9202 cml_tlatch_89.xtail.S1 CKA3_N cml_tlatch_89.xmux.xn.S1 VSS sg13_lv_nmos ad=89.3f pd=0.85u as=89.3f ps=0.85u w=0.47u l=0.16u
X9203 cml_tlatch_63.xmux.xp.S1 CKHA3_N cml_tlatch_63.xtail.S1 VSS sg13_lv_nmos ad=89.3f pd=0.85u as=89.3f ps=0.85u w=0.47u l=0.16u
X9204 cml_tlatch_9.xmux.xp.S1 A0_8_N A0_8_P VSS sg13_lv_nmos ad=0.1019p pd=1.34u as=56.9f ps=0.74u w=0.17u l=0.17u
X9205 cml_tlatch_4.xmux.xp.S1 MOT11_P MOT11_N VSS sg13_lv_nmos ad=56.9f pd=0.74u as=56.9f ps=0.74u w=0.17u l=0.17u
X9206 cml_tlatch_24.xmux.xp.S1 MOT12_P MOT12_N VSS sg13_lv_nmos ad=56.9f pd=0.74u as=56.9f ps=0.74u w=0.17u l=0.17u
X9207 stub_bi_38.BOTP stub_bi_38.BOTN cml_tlatch_46.xmux.xp.S1 VSS sg13_lv_nmos ad=56.9f pd=0.74u as=56.9f ps=0.74u w=0.17u l=0.17u
X9208 cml_tlatch_7.OUTN cml_tlatch_8.OUTP cml_tlatch_7.xmux.xn.S1 VSS sg13_lv_nmos ad=63.19999f pd=0.74u as=63.19999f ps=0.74u w=0.26u l=0.38u
X9209 cml_tlatch_79.xtail.S1 CKHB2_N cml_tlatch_79.xmux.xp.S1 VSS sg13_lv_nmos ad=89.3f pd=0.85u as=89.3f ps=0.85u w=0.47u l=0.16u
X9210 cml_tlatch_4.INP cml_tlatch_4.INN cml_tlatch_12.xmux.xp.S1 VSS sg13_lv_nmos ad=56.9f pd=0.74u as=56.9f ps=0.74u w=0.17u l=0.17u
X9211 cml_tlatch_76.xmux.xp.S1 CKA2_N cml_tlatch_76.xtail.S1 VSS sg13_lv_nmos ad=89.3f pd=0.85u as=89.3f ps=0.85u w=0.47u l=0.16u
X9212 cml_tlatch_29.xmux.xp.S1 MOT6_P MOT6_N VSS sg13_lv_nmos ad=0.1019p pd=1.34u as=56.9f ps=0.74u w=0.17u l=0.17u
X9213 cml_tlatch_16.xmux.xp.S1 MOT5_N MOT5_P VSS sg13_lv_nmos ad=56.9f pd=0.74u as=56.9f ps=0.74u w=0.17u l=0.17u
X9214 cml_tlatch_69.OUTP cml_tlatch_69.OUTN cml_tlatch_69.xmux.xp.S1 VSS sg13_lv_nmos ad=56.9f pd=0.74u as=56.9f ps=0.74u w=0.17u l=0.17u
X9215 cml_gate2_8.xamp.xn.S1 J2_P ENB_N VSS sg13_lv_nmos ad=0.1007p pd=0.91u as=0.1007p ps=0.91u w=0.53u l=0.13u
X9216 cml_tlatch_8.OUTN cml_tlatch_8.OUTP cml_tlatch_8.xmux.xp.S1 VSS sg13_lv_nmos ad=56.9f pd=0.74u as=56.9f ps=0.74u w=0.17u l=0.17u
X9217 cml_tlatch_38.xmux.xn.S1 D0_N cml_tlatch_38.OUTP VSS sg13_lv_nmos ad=63.19999f pd=0.74u as=63.19999f ps=0.74u w=0.26u l=0.38u
X9218 cml_tlatch_4.xmux.xn.S1 CKHB1_P cml_tlatch_4.xtail.S1 VSS sg13_lv_nmos ad=89.3f pd=0.85u as=89.3f ps=0.85u w=0.47u l=0.16u
X9219 cml_gate2_2.xrtail.R1 CKB1_P cml_gate2_2.xamp.xn.S1 VSS sg13_lv_nmos ad=0.1007p pd=0.91u as=0.1007p ps=0.91u w=0.53u l=0.13u
X9220 cml_tlatch_91.xmux.xp.S1 cml_tlatch_91.OUTP cml_tlatch_91.OUTN VSS sg13_lv_nmos ad=56.9f pd=0.74u as=56.9f ps=0.74u w=0.17u l=0.17u
X9221 cml_tlatch_64.xmux.xn.S1 CKB3_N cml_tlatch_64.xtail.S1 VSS sg13_lv_nmos ad=89.3f pd=0.85u as=89.3f ps=0.85u w=0.47u l=0.16u
X9222 GB2_N ENB0_P cml_gate2_7.xamp.xn.S1 VSS sg13_lv_nmos ad=0.1007p pd=0.91u as=0.1007p ps=0.91u w=0.53u l=0.13u
X9223 cml_tlatch_43.INP cml_tlatch_22.OUTN cml_tlatch_21.xmux.xn.S1 VSS sg13_lv_nmos ad=0.1082p pd=1.34u as=63.19999f ps=0.74u w=0.26u l=0.38u
X9224 cml_tlatch_60.xmux.xp.S1 A2_2_P A2_2_N VSS sg13_lv_nmos ad=56.9f pd=0.74u as=56.9f ps=0.74u w=0.17u l=0.17u
X9225 cml_tlatch_96.xmux.xp.S1 cml_tlatch_5.INN cml_tlatch_5.INP VSS sg13_lv_nmos ad=56.9f pd=0.74u as=56.9f ps=0.74u w=0.17u l=0.17u
X9226 cml_tlatch_97.INP A1_2_N cml_tlatch_39.xmux.xn.S1 VSS sg13_lv_nmos ad=63.19999f pd=0.74u as=0.1082p ps=1.34u w=0.26u l=0.38u
X9227 cml_tlatch_14.xmux.xp.S1 MOT1_P MOT1_N VSS sg13_lv_nmos ad=56.9f pd=0.74u as=56.9f ps=0.74u w=0.17u l=0.17u
X9228 cml_tlatch_91.xtail.S1 POLN VSS VSS sg13_lv_nmos ad=1.5637p pd=8.61u as=2.7982p ps=17.14u w=8.23u l=0.13u
X9229 cml_tlatch_27.xmux.xn.S1 CKHA0_P cml_tlatch_27.xtail.S1 VSS sg13_lv_nmos ad=89.3f pd=0.85u as=0.1598p ps=1.62u w=0.47u l=0.16u
X9230 cml_tlatch_98.xtail.S1 CKB0_N cml_tlatch_98.xmux.xn.S1 VSS sg13_lv_nmos ad=89.3f pd=0.85u as=89.3f ps=0.85u w=0.47u l=0.16u
X9231 cml_tlatch_81.xmux.xn.S1 stub_bi_62.BOTP B2_8_P VSS sg13_lv_nmos ad=63.19999f pd=0.74u as=63.19999f ps=0.74u w=0.26u l=0.38u
X9232 cml_tlatch_39.xmux.xp.S1 CKA1_N cml_tlatch_39.xtail.S1 VSS sg13_lv_nmos ad=89.3f pd=0.85u as=89.3f ps=0.85u w=0.47u l=0.16u
X9233 cml_tlatch_11.xtail.S1 CKB1_P cml_tlatch_11.xmux.xn.S1 VSS sg13_lv_nmos ad=89.3f pd=0.85u as=89.3f ps=0.85u w=0.47u l=0.16u
X9234 cml_tlatch_38.OUTN cml_tlatch_38.OUTP cml_tlatch_38.xmux.xp.S1 VSS sg13_lv_nmos ad=56.9f pd=0.74u as=56.9f ps=0.74u w=0.17u l=0.17u
X9235 MOT4_P MOT4_N cml_tlatch_28.xmux.xp.S1 VSS sg13_lv_nmos ad=56.9f pd=0.74u as=56.9f ps=0.74u w=0.17u l=0.17u
X9236 cml_tlatch_20.xmux.xp.S1 cml_tlatch_20.OUTN cml_tlatch_20.OUTP VSS sg13_lv_nmos ad=0.1019p pd=1.34u as=56.9f ps=0.74u w=0.17u l=0.17u
X9237 cml_tlatch_74.xmux.xp.S1 MOT29_P MOT29_N VSS sg13_lv_nmos ad=56.9f pd=0.74u as=56.9f ps=0.74u w=0.17u l=0.17u
X9238 cml_tlatch_36.xtail.S1 POLN VSS VSS sg13_lv_nmos ad=1.5637p pd=8.61u as=1.5637p ps=8.61u w=8.23u l=0.13u
X9239 VSS hs_to_clk_2.sg13_lv_nmos_2HGZLP_0.G VSS VSS sg13_lv_nmos ad=2.071p pd=11.28u as=0 ps=0 w=10.9u l=1.38u
X9240 cml_tlatch_85.xmux.xp.S1 A2_8_P A2_8_N VSS sg13_lv_nmos ad=56.9f pd=0.74u as=56.9f ps=0.74u w=0.17u l=0.17u
X9241 cml_tlatch_41.OUTP cml_tlatch_41.OUTN cml_tlatch_41.xmux.xp.S1 VSS sg13_lv_nmos ad=56.9f pd=0.74u as=56.9f ps=0.74u w=0.17u l=0.17u
X9242 cml_tlatch_9.xmux.xp.S1 A0_8_P A0_8_N VSS sg13_lv_nmos ad=56.9f pd=0.74u as=56.9f ps=0.74u w=0.17u l=0.17u
X9243 cml_tlatch_83.xmux.xn.S1 CKB2_N cml_tlatch_83.xtail.S1 VSS sg13_lv_nmos ad=89.3f pd=0.85u as=89.3f ps=0.85u w=0.47u l=0.16u
X9244 cml_tlatch_14.xmux.xp.S1 CKHB0_N cml_tlatch_14.xtail.S1 VSS sg13_lv_nmos ad=89.3f pd=0.85u as=89.3f ps=0.85u w=0.47u l=0.16u
X9245 cml_tlatch_62.xtail.S1 CKHA3_P cml_tlatch_62.xmux.xn.S1 VSS sg13_lv_nmos ad=89.3f pd=0.85u as=89.3f ps=0.85u w=0.47u l=0.16u
X9246 B2_2_P B2_2_N cml_tlatch_47.xmux.xp.S1 VSS sg13_lv_nmos ad=56.9f pd=0.74u as=56.9f ps=0.74u w=0.17u l=0.17u
X9247 cml_tlatch_41.xtail.S1 CKA1_N cml_tlatch_41.xmux.xp.S1 VSS sg13_lv_nmos ad=89.3f pd=0.85u as=89.3f ps=0.85u w=0.47u l=0.16u
X9248 J4_P J4_N cml_tlatch_92.xmux.xp.S1 VSS sg13_lv_nmos ad=56.9f pd=0.74u as=56.9f ps=0.74u w=0.17u l=0.17u
X9249 MOT7_N MOT7_P cml_tlatch_17.xmux.xp.S1 VSS sg13_lv_nmos ad=56.9f pd=0.74u as=56.9f ps=0.74u w=0.17u l=0.17u
X9250 MOT13_N MOT13_P cml_tlatch_5.xmux.xp.S1 VSS sg13_lv_nmos ad=56.9f pd=0.74u as=56.9f ps=0.74u w=0.17u l=0.17u
X9251 cml_tlatch_61.OUTN cml_tlatch_61.OUTP cml_tlatch_61.xmux.xp.S1 VSS sg13_lv_nmos ad=56.9f pd=0.74u as=56.9f ps=0.74u w=0.17u l=0.17u
X9252 cml_tlatch_2.OUTP cml_tlatch_2.OUTN cml_tlatch_2.xmux.xp.S1 VSS sg13_lv_nmos ad=56.9f pd=0.74u as=56.9f ps=0.74u w=0.17u l=0.17u
X9253 cml_tlatch_63.INN cml_tlatch_71.OUTP cml_tlatch_70.xmux.xn.S1 VSS sg13_lv_nmos ad=63.19999f pd=0.74u as=63.19999f ps=0.74u w=0.26u l=0.38u
X9254 cml_tlatch_94.xmux.xp.S1 J2_P J2_N VSS sg13_lv_nmos ad=56.9f pd=0.74u as=56.9f ps=0.74u w=0.17u l=0.17u
X9255 cml_tlatch_34.xmux.xp.S1 A0_2_N A0_2_P VSS sg13_lv_nmos ad=56.9f pd=0.74u as=56.9f ps=0.74u w=0.17u l=0.17u
X9256 VSS hs_to_clk_7.sg13_lv_nmos_2HGZLP_0.G VSS VSS sg13_lv_nmos ad=2.071p pd=11.28u as=0 ps=0 w=10.9u l=1.38u
X9257 cml_tlatch_34.xtail.S1 CKA0_N cml_tlatch_34.xmux.xn.S1 VSS sg13_lv_nmos ad=89.3f pd=0.85u as=89.3f ps=0.85u w=0.47u l=0.16u
X9258 cml_tlatch_28.xtail.S1 CKHA0_P cml_tlatch_28.xmux.xn.S1 VSS sg13_lv_nmos ad=89.3f pd=0.85u as=89.3f ps=0.85u w=0.47u l=0.16u
X9259 GA3_P CKB3_N cml_gate2_4.xrtail.R1 VSS sg13_lv_nmos ad=0.1007p pd=0.91u as=0.1007p ps=0.91u w=0.53u l=0.13u
X9260 cml_tlatch_53.xmux.xn.S1 CKHA2_P cml_tlatch_53.xtail.S1 VSS sg13_lv_nmos ad=89.3f pd=0.85u as=89.3f ps=0.85u w=0.47u l=0.16u
X9261 cml_tlatch_59.xmux.xp.S1 cml_tlatch_91.INN cml_tlatch_91.INP VSS sg13_lv_nmos ad=56.9f pd=0.74u as=56.9f ps=0.74u w=0.17u l=0.17u
X9262 cml_tlatch_18.xmux.xn.S1 cml_tlatch_23.OUTP cml_tlatch_18.OUTN VSS sg13_lv_nmos ad=63.19999f pd=0.74u as=63.19999f ps=0.74u w=0.26u l=0.38u
X9263 GB1_N ENB1_P cml_gate2_0.xamp.xn.S1 VSS sg13_lv_nmos ad=0.1007p pd=0.91u as=0.1007p ps=0.91u w=0.53u l=0.13u
X9264 cml_tlatch_56.xmux.xp.S1 cml_tlatch_56.OUTP cml_tlatch_56.OUTN VSS sg13_lv_nmos ad=56.9f pd=0.74u as=56.9f ps=0.74u w=0.17u l=0.17u
X9265 cml_tlatch_64.xmux.xp.S1 B3_8_N B3_8_P VSS sg13_lv_nmos ad=56.9f pd=0.74u as=56.9f ps=0.74u w=0.17u l=0.17u
X9266 cml_tlatch_58.OUTP cml_tlatch_58.OUTN cml_tlatch_58.xmux.xp.S1 VSS sg13_lv_nmos ad=56.9f pd=0.74u as=56.9f ps=0.74u w=0.17u l=0.17u
X9267 MOT25_P B3_8_N cml_tlatch_72.xmux.xn.S1 VSS sg13_lv_nmos ad=63.19999f pd=0.74u as=63.19999f ps=0.74u w=0.26u l=0.38u
X9268 cml_tlatch_96.xmux.xn.S1 CKB1_N cml_tlatch_96.xtail.S1 VSS sg13_lv_nmos ad=89.3f pd=0.85u as=89.3f ps=0.85u w=0.47u l=0.16u
X9269 cml_tlatch_94.xmux.xp.S1 J2_P J2_N VSS sg13_lv_nmos ad=0.1019p pd=1.34u as=56.9f ps=0.74u w=0.17u l=0.17u
X9270 cml_tlatch_50.xmux.xn.S1 CKB3_N cml_tlatch_50.xtail.S1 VSS sg13_lv_nmos ad=89.3f pd=0.85u as=89.3f ps=0.85u w=0.47u l=0.16u
X9271 MOT29_N MOT29_P cml_tlatch_74.xmux.xp.S1 VSS sg13_lv_nmos ad=56.9f pd=0.74u as=56.9f ps=0.74u w=0.17u l=0.17u
X9272 CKHA2_P GA2_N cml_drvb_5.xrtail.R2 VSS sg13_lv_nmos ad=0.2618p pd=2.22u as=0.1463p ps=1.15u w=0.77u l=0.21u
X9273 MOT0_P MOT0_N cml_tlatch_26.xmux.xp.S1 VSS sg13_lv_nmos ad=56.9f pd=0.74u as=56.9f ps=0.74u w=0.17u l=0.17u
X9274 cml_tlatch_97.INN cml_tlatch_97.INP cml_tlatch_39.xmux.xp.S1 VSS sg13_lv_nmos ad=56.9f pd=0.74u as=56.9f ps=0.74u w=0.17u l=0.17u
X9275 stub_bi_49.BOTP stub_bi_49.BOTN cml_tlatch_84.xmux.xp.S1 VSS sg13_lv_nmos ad=56.9f pd=0.74u as=56.9f ps=0.74u w=0.17u l=0.17u
X9276 stub_bi_15.BOTN cml_tlatch_4.INN cml_tlatch_11.xmux.xn.S1 VSS sg13_lv_nmos ad=63.19999f pd=0.74u as=63.19999f ps=0.74u w=0.26u l=0.38u
X9277 hs_to_clk_6.D2 CK_N CKA3_N VSS sg13_lv_nmos ad=0.228p pd=1.58u as=0.228p ps=1.58u w=1.2u l=0.2u
X9278 cml_tlatch_32.xmux.xp.S1 CKB0_N cml_tlatch_32.xtail.S1 VSS sg13_lv_nmos ad=89.3f pd=0.85u as=89.3f ps=0.85u w=0.47u l=0.16u
X9279 MOT17_N MOT17_P cml_tlatch_77.xmux.xp.S1 VSS sg13_lv_nmos ad=56.9f pd=0.74u as=0.1019p ps=1.34u w=0.17u l=0.17u
X9280 MOT12_N cml_tlatch_24.INP cml_tlatch_24.xmux.xn.S1 VSS sg13_lv_nmos ad=63.19999f pd=0.74u as=63.19999f ps=0.74u w=0.26u l=0.38u
X9281 cml_tlatch_98.xmux.xp.S1 CKB0_P cml_tlatch_98.xtail.S1 VSS sg13_lv_nmos ad=89.3f pd=0.85u as=89.3f ps=0.85u w=0.47u l=0.16u
X9282 cml_tlatch_31.xtail.S1 POLN VSS VSS sg13_lv_nmos ad=1.5637p pd=8.61u as=2.7982p ps=17.14u w=8.23u l=0.13u
X9283 cml_tlatch_16.xmux.xp.S1 MOT5_N MOT5_P VSS sg13_lv_nmos ad=56.9f pd=0.74u as=56.9f ps=0.74u w=0.17u l=0.17u
X9284 cml_tlatch_68.xmux.xp.S1 CKA3_P cml_tlatch_68.xtail.S1 VSS sg13_lv_nmos ad=89.3f pd=0.85u as=89.3f ps=0.85u w=0.47u l=0.16u
X9285 cml_tlatch_7.xmux.xp.S1 cml_tlatch_7.OUTP cml_tlatch_7.OUTN VSS sg13_lv_nmos ad=56.9f pd=0.74u as=56.9f ps=0.74u w=0.17u l=0.17u
X9286 cml_tlatch_61.OUTN D2_P cml_tlatch_61.xmux.xn.S1 VSS sg13_lv_nmos ad=63.19999f pd=0.74u as=63.19999f ps=0.74u w=0.26u l=0.38u
X9287 cml_tlatch_76.xmux.xp.S1 cml_tlatch_87.INN cml_tlatch_87.INP VSS sg13_lv_nmos ad=56.9f pd=0.74u as=56.9f ps=0.74u w=0.17u l=0.17u
X9288 cml_tlatch_97.xmux.xp.S1 CKA1_P cml_tlatch_97.xtail.S1 VSS sg13_lv_nmos ad=89.3f pd=0.85u as=89.3f ps=0.85u w=0.47u l=0.16u
X9289 cml_tlatch_97.INN cml_tlatch_97.INP cml_tlatch_39.xmux.xp.S1 VSS sg13_lv_nmos ad=56.9f pd=0.74u as=56.9f ps=0.74u w=0.17u l=0.17u
X9290 cml_tlatch_41.xmux.xp.S1 cml_tlatch_41.OUTN cml_tlatch_41.OUTP VSS sg13_lv_nmos ad=0.1019p pd=1.34u as=56.9f ps=0.74u w=0.17u l=0.17u
X9291 B3_8_P B3_8_N cml_tlatch_64.xmux.xp.S1 VSS sg13_lv_nmos ad=56.9f pd=0.74u as=56.9f ps=0.74u w=0.17u l=0.17u
X9292 cml_tlatch_91.xmux.xp.S1 cml_tlatch_91.OUTP cml_tlatch_91.OUTN VSS sg13_lv_nmos ad=56.9f pd=0.74u as=56.9f ps=0.74u w=0.17u l=0.17u
X9293 VSS POLN cml_tlatch_97.xtail.S1 VSS sg13_lv_nmos ad=1.5637p pd=8.61u as=1.5637p ps=8.61u w=8.23u l=0.13u
X9294 stub_bi_55.BOTP stub_bi_55.BOTN cml_tlatch_90.xmux.xp.S1 VSS sg13_lv_nmos ad=56.9f pd=0.74u as=56.9f ps=0.74u w=0.17u l=0.17u
X9295 A2_2_P cml_tlatch_61.OUTN cml_tlatch_60.xmux.xn.S1 VSS sg13_lv_nmos ad=63.19999f pd=0.74u as=0.1082p ps=1.34u w=0.26u l=0.38u
X9296 cml_tlatch_30.OUTP B0_2_N cml_tlatch_30.xmux.xn.S1 VSS sg13_lv_nmos ad=63.19999f pd=0.74u as=63.19999f ps=0.74u w=0.26u l=0.38u
X9297 cml_tlatch_41.xtail.S1 CKA1_N cml_tlatch_41.xmux.xp.S1 VSS sg13_lv_nmos ad=89.3f pd=0.85u as=89.3f ps=0.85u w=0.47u l=0.16u
X9298 MOT19_P MOT19_N cml_tlatch_78.xmux.xp.S1 VSS sg13_lv_nmos ad=56.9f pd=0.74u as=56.9f ps=0.74u w=0.17u l=0.17u
X9299 cml_tlatch_44.INN cml_tlatch_56.OUTP cml_tlatch_89.xmux.xn.S1 VSS sg13_lv_nmos ad=0.1082p pd=1.34u as=63.19999f ps=0.74u w=0.26u l=0.38u
X9300 cml_tlatch_73.xmux.xp.S1 MOT27_N MOT27_P VSS sg13_lv_nmos ad=56.9f pd=0.74u as=56.9f ps=0.74u w=0.17u l=0.17u
X9301 cml_tlatch_91.xmux.xp.S1 CKA2_P cml_tlatch_91.xtail.S1 VSS sg13_lv_nmos ad=0.1598p pd=1.62u as=89.3f ps=0.85u w=0.47u l=0.16u
X9302 cml_tlatch_32.xmux.xp.S1 cml_tlatch_32.OUTP cml_tlatch_32.OUTN VSS sg13_lv_nmos ad=56.9f pd=0.74u as=56.9f ps=0.74u w=0.17u l=0.17u
X9303 cml_tlatch_93.xmux.xn.S1 CKJ_P cml_tlatch_93.xtail.S1 VSS sg13_lv_nmos ad=89.3f pd=0.85u as=89.3f ps=0.85u w=0.47u l=0.16u
X9304 VSS hs_to_clk_8.sg13_lv_nmos_2HGZLP_0.G VSS VSS sg13_lv_nmos ad=2.071p pd=11.28u as=0 ps=0 w=10.9u l=1.38u
X9305 cml_tlatch_92.xmux.xn.S1 CLK_W_P J4_P VSS sg13_lv_nmos ad=63.19999f pd=0.74u as=63.19999f ps=0.74u w=0.26u l=0.38u
X9306 stub_bi_43.BOTP VDD VSS rppd l=5.17u w=1u
X9307 cml_tlatch_73.INN cml_tlatch_73.INP cml_tlatch_66.xmux.xp.S1 VSS sg13_lv_nmos ad=56.9f pd=0.74u as=56.9f ps=0.74u w=0.17u l=0.17u
X9308 cml_tlatch_69.xmux.xn.S1 CKA3_P cml_tlatch_69.xtail.S1 VSS sg13_lv_nmos ad=89.3f pd=0.85u as=89.3f ps=0.85u w=0.47u l=0.16u
X9309 J4_N CLK_W_N cml_tlatch_92.xmux.xn.S1 VSS sg13_lv_nmos ad=63.19999f pd=0.74u as=63.19999f ps=0.74u w=0.26u l=0.38u
X9310 cml_tlatch_55.xtail.S1 CKHA2_N cml_tlatch_55.xmux.xp.S1 VSS sg13_lv_nmos ad=89.3f pd=0.85u as=89.3f ps=0.85u w=0.47u l=0.16u
X9311 ENB0_P ENB_N cml_drv_2.xrtail.R1 VSS sg13_lv_nmos ad=56.2f pd=0.74u as=56.2f ps=0.74u w=0.16u l=0.19u
X9312 cml_tlatch_86.OUTN cml_tlatch_86.OUTP cml_tlatch_86.xmux.xp.S1 VSS sg13_lv_nmos ad=56.9f pd=0.74u as=56.9f ps=0.74u w=0.17u l=0.17u
X9313 cml_tlatch_82.xmux.xp.S1 stub_bi_62.BOTN stub_bi_62.BOTP VSS sg13_lv_nmos ad=56.9f pd=0.74u as=56.9f ps=0.74u w=0.17u l=0.17u
X9314 MOT17_N MOT17_P cml_tlatch_77.xmux.xp.S1 VSS sg13_lv_nmos ad=56.9f pd=0.74u as=56.9f ps=0.74u w=0.17u l=0.17u
X9315 cml_gate2_3.xamp.xn.S1 ENA0_P GA0_N VSS sg13_lv_nmos ad=0.1007p pd=0.91u as=0.1007p ps=0.91u w=0.53u l=0.13u
X9316 cml_tlatch_51.OUTP D3_N cml_tlatch_51.xmux.xn.S1 VSS sg13_lv_nmos ad=63.19999f pd=0.74u as=63.19999f ps=0.74u w=0.26u l=0.38u
X9317 cml_tlatch_33.OUTN cml_tlatch_33.OUTP cml_tlatch_33.xmux.xp.S1 VSS sg13_lv_nmos ad=56.9f pd=0.74u as=56.9f ps=0.74u w=0.17u l=0.17u
X9318 cml_tlatch_10.xmux.xp.S1 B1_8_N B1_8_P VSS sg13_lv_nmos ad=56.9f pd=0.74u as=56.9f ps=0.74u w=0.17u l=0.17u
X9319 cml_tlatch_60.xmux.xp.S1 CKA2_P cml_tlatch_60.xtail.S1 VSS sg13_lv_nmos ad=89.3f pd=0.85u as=89.3f ps=0.85u w=0.47u l=0.16u
X9320 cml_tlatch_65.xmux.xn.S1 CKB3_P cml_tlatch_65.xtail.S1 VSS sg13_lv_nmos ad=89.3f pd=0.85u as=89.3f ps=0.85u w=0.47u l=0.16u
X9321 B2_2_P B2_2_N cml_tlatch_47.xmux.xp.S1 VSS sg13_lv_nmos ad=56.9f pd=0.74u as=56.9f ps=0.74u w=0.17u l=0.17u
X9322 cml_tlatch_40.xmux.xp.S1 A1_2_N A1_2_P VSS sg13_lv_nmos ad=56.9f pd=0.74u as=56.9f ps=0.74u w=0.17u l=0.17u
X9323 cml_tlatch_10.xmux.xp.S1 CKB1_P cml_tlatch_10.xtail.S1 VSS sg13_lv_nmos ad=89.3f pd=0.85u as=89.3f ps=0.85u w=0.47u l=0.16u
X9324 cml_tlatch_83.xmux.xp.S1 CKB2_P cml_tlatch_83.xtail.S1 VSS sg13_lv_nmos ad=89.3f pd=0.85u as=89.3f ps=0.85u w=0.47u l=0.16u
X9325 cml_tlatch_0.xmux.xp.S1 cml_tlatch_0.OUTN cml_tlatch_0.OUTP VSS sg13_lv_nmos ad=56.9f pd=0.74u as=56.9f ps=0.74u w=0.17u l=0.17u
X9326 cml_tlatch_23.xtail.S1 CKA0_P cml_tlatch_23.xmux.xp.S1 VSS sg13_lv_nmos ad=89.3f pd=0.85u as=89.3f ps=0.85u w=0.47u l=0.16u
X9327 cml_tlatch_15.xmux.xn.S1 cml_tlatch_7.OUTN MOT3_P VSS sg13_lv_nmos ad=63.19999f pd=0.74u as=63.19999f ps=0.74u w=0.26u l=0.38u
X9328 cml_tlatch_70.xmux.xp.S1 CKA3_P cml_tlatch_70.xtail.S1 VSS sg13_lv_nmos ad=89.3f pd=0.85u as=89.3f ps=0.85u w=0.47u l=0.16u
X9329 cml_tlatch_53.xmux.xp.S1 MOT18_N MOT18_P VSS sg13_lv_nmos ad=56.9f pd=0.74u as=56.9f ps=0.74u w=0.17u l=0.17u
X9330 MOT26_P MOT26_N cml_tlatch_63.xmux.xp.S1 VSS sg13_lv_nmos ad=56.9f pd=0.74u as=56.9f ps=0.74u w=0.17u l=0.17u
X9331 cml_tlatch_98.OUTN VDD VSS rppd l=5.17u w=1u
X9332 cml_tlatch_84.xmux.xn.S1 stub_bi_55.BOTP stub_bi_49.BOTN VSS sg13_lv_nmos ad=63.19999f pd=0.74u as=0.1082p ps=1.34u w=0.26u l=0.38u
X9333 cml_tlatch_74.xmux.xn.S1 CKHB3_P cml_tlatch_74.xtail.S1 VSS sg13_lv_nmos ad=89.3f pd=0.85u as=89.3f ps=0.85u w=0.47u l=0.16u
X9334 cml_tlatch_80.xmux.xp.S1 MOT23_P MOT23_N VSS sg13_lv_nmos ad=56.9f pd=0.74u as=56.9f ps=0.74u w=0.17u l=0.17u
X9335 cml_tlatch_17.xmux.xp.S1 CKHB0_N cml_tlatch_17.xtail.S1 VSS sg13_lv_nmos ad=89.3f pd=0.85u as=89.3f ps=0.85u w=0.47u l=0.16u
X9336 cml_tlatch_56.xmux.xp.S1 cml_tlatch_56.OUTP cml_tlatch_56.OUTN VSS sg13_lv_nmos ad=56.9f pd=0.74u as=56.9f ps=0.74u w=0.17u l=0.17u
X9337 cml_tlatch_84.xmux.xp.S1 stub_bi_49.BOTP stub_bi_49.BOTN VSS sg13_lv_nmos ad=56.9f pd=0.74u as=56.9f ps=0.74u w=0.17u l=0.17u
X9338 cml_tlatch_49.OUTN cml_tlatch_49.OUTP cml_tlatch_49.xmux.xp.S1 VSS sg13_lv_nmos ad=56.9f pd=0.74u as=56.9f ps=0.74u w=0.17u l=0.17u
X9339 cml_tlatch_87.xmux.xp.S1 cml_tlatch_87.OUTN cml_tlatch_87.OUTP VSS sg13_lv_nmos ad=56.9f pd=0.74u as=56.9f ps=0.74u w=0.17u l=0.17u
X9340 MOT2_N MOT2_P cml_tlatch_27.xmux.xp.S1 VSS sg13_lv_nmos ad=56.9f pd=0.74u as=56.9f ps=0.74u w=0.17u l=0.17u
X9341 A2_8_P A2_8_N cml_tlatch_85.xmux.xp.S1 VSS sg13_lv_nmos ad=56.9f pd=0.74u as=0.1019p ps=1.34u w=0.17u l=0.17u
X9342 MOT29_P MOT29_N cml_tlatch_74.xmux.xp.S1 VSS sg13_lv_nmos ad=56.9f pd=0.74u as=56.9f ps=0.74u w=0.17u l=0.17u
X9343 cml_tlatch_0.OUTN cml_tlatch_0.OUTP cml_tlatch_0.xmux.xp.S1 VSS sg13_lv_nmos ad=56.9f pd=0.74u as=0.1019p ps=1.34u w=0.17u l=0.17u
X9344 GA2_P CKB2_N cml_gate2_5.xrtail.R1 VSS sg13_lv_nmos ad=0.1007p pd=0.91u as=0.1007p ps=0.91u w=0.53u l=0.13u
X9345 cml_tlatch_0.xmux.xp.S1 CKA0_N cml_tlatch_0.xtail.S1 VSS sg13_lv_nmos ad=89.3f pd=0.85u as=89.3f ps=0.85u w=0.47u l=0.16u
X9346 cml_tlatch_35.xmux.xp.S1 stub_bi_29.BOTN stub_bi_29.BOTP VSS sg13_lv_nmos ad=56.9f pd=0.74u as=56.9f ps=0.74u w=0.17u l=0.17u
X9347 MOT21_P stub_bi_55.BOTP cml_tlatch_79.xmux.xn.S1 VSS sg13_lv_nmos ad=63.19999f pd=0.74u as=63.19999f ps=0.74u w=0.26u l=0.38u
X9348 cml_tlatch_99.OUTN cml_tlatch_99.OUTP cml_tlatch_99.xmux.xp.S1 VSS sg13_lv_nmos ad=56.9f pd=0.74u as=56.9f ps=0.74u w=0.17u l=0.17u
X9349 cml_tlatch_57.xmux.xp.S1 A3_2_P A3_2_N VSS sg13_lv_nmos ad=0.1019p pd=1.34u as=56.9f ps=0.74u w=0.17u l=0.17u
X9350 cml_tlatch_7.xmux.xp.S1 cml_tlatch_7.OUTP cml_tlatch_7.OUTN VSS sg13_lv_nmos ad=56.9f pd=0.74u as=56.9f ps=0.74u w=0.17u l=0.17u
X9351 MOT20_N MOT20_P cml_tlatch_54.xmux.xp.S1 VSS sg13_lv_nmos ad=56.9f pd=0.74u as=56.9f ps=0.74u w=0.17u l=0.17u
X9352 cml_tlatch_51.xtail.S1 CKB3_P cml_tlatch_51.xmux.xn.S1 VSS sg13_lv_nmos ad=89.3f pd=0.85u as=89.3f ps=0.85u w=0.47u l=0.16u
X9353 cml_tlatch_31.xmux.xn.S1 cml_tlatch_32.OUTP B0_2_N VSS sg13_lv_nmos ad=63.19999f pd=0.74u as=63.19999f ps=0.74u w=0.26u l=0.38u
X9354 VDD hs_to_clk_6.sg13_lv_nmos_2HGZLP_0.G VSS rppd l=0.68u w=1u
X9355 cml_tlatch_53.xtail.S1 CKHA2_P cml_tlatch_53.xmux.xn.S1 VSS sg13_lv_nmos ad=89.3f pd=0.85u as=89.3f ps=0.85u w=0.47u l=0.16u
X9356 MOT18_N cml_tlatch_87.OUTP cml_tlatch_53.xmux.xn.S1 VSS sg13_lv_nmos ad=63.19999f pd=0.74u as=0.1082p ps=1.34u w=0.26u l=0.38u
X9357 hs_to_clk_5.D2 CK_P CKB3_N VSS sg13_lv_nmos ad=0.408p pd=3.08u as=0.228p ps=1.58u w=1.2u l=0.2u
X9358 cml_tlatch_67.xtail.S1 CKB3_P cml_tlatch_67.xmux.xn.S1 VSS sg13_lv_nmos ad=89.3f pd=0.85u as=0.1598p ps=1.62u w=0.47u l=0.16u
X9359 A0_8_P A0_8_N cml_tlatch_9.xmux.xp.S1 VSS sg13_lv_nmos ad=56.9f pd=0.74u as=56.9f ps=0.74u w=0.17u l=0.17u
X9360 cml_tlatch_31.xmux.xn.S1 cml_tlatch_32.OUTP B0_2_N VSS sg13_lv_nmos ad=63.19999f pd=0.74u as=63.19999f ps=0.74u w=0.26u l=0.38u
X9361 cml_tlatch_99.xmux.xp.S1 CKA0_P cml_tlatch_99.xtail.S1 VSS sg13_lv_nmos ad=89.3f pd=0.85u as=0.1598p ps=1.62u w=0.47u l=0.16u
X9362 cml_tlatch_73.xmux.xp.S1 MOT27_N MOT27_P VSS sg13_lv_nmos ad=56.9f pd=0.74u as=56.9f ps=0.74u w=0.17u l=0.17u
X9363 cml_tlatch_44.xmux.xp.S1 MOT28_N MOT28_P VSS sg13_lv_nmos ad=0.1019p pd=1.34u as=56.9f ps=0.74u w=0.17u l=0.17u
X9364 cml_tlatch_21.xmux.xn.S1 CKA1_N cml_tlatch_21.xtail.S1 VSS sg13_lv_nmos ad=89.3f pd=0.85u as=89.3f ps=0.85u w=0.47u l=0.16u
X9365 MOT6_N MOT6_P cml_tlatch_29.xmux.xp.S1 VSS sg13_lv_nmos ad=56.9f pd=0.74u as=56.9f ps=0.74u w=0.17u l=0.17u
X9366 cml_tlatch_19.xmux.xn.S1 CKA1_N cml_tlatch_19.xtail.S1 VSS sg13_lv_nmos ad=89.3f pd=0.85u as=89.3f ps=0.85u w=0.47u l=0.16u
X9367 cml_tlatch_41.xmux.xp.S1 cml_tlatch_41.OUTP cml_tlatch_41.OUTN VSS sg13_lv_nmos ad=56.9f pd=0.74u as=56.9f ps=0.74u w=0.17u l=0.17u
X9368 A2_8_P A2_8_N cml_tlatch_85.xmux.xp.S1 VSS sg13_lv_nmos ad=56.9f pd=0.74u as=56.9f ps=0.74u w=0.17u l=0.17u
X9369 cml_tlatch_77.xmux.xp.S1 MOT17_N MOT17_P VSS sg13_lv_nmos ad=56.9f pd=0.74u as=56.9f ps=0.74u w=0.17u l=0.17u
X9370 cml_gate2_0.xrtail.R1 CKA1_P cml_gate2_0.xamp.xn.S1 VSS sg13_lv_nmos ad=0.1007p pd=0.91u as=0.1007p ps=0.91u w=0.53u l=0.13u
X9371 MOT8_P MOT8_N cml_tlatch_42.xmux.xp.S1 VSS sg13_lv_nmos ad=56.9f pd=0.74u as=56.9f ps=0.74u w=0.17u l=0.17u
X9372 cml_tlatch_25.xmux.xp.S1 CKHA1_N cml_tlatch_25.xtail.S1 VSS sg13_lv_nmos ad=89.3f pd=0.85u as=89.3f ps=0.85u w=0.47u l=0.16u
X9373 cml_tlatch_63.xtail.S1 CKHA3_P cml_tlatch_63.xmux.xn.S1 VSS sg13_lv_nmos ad=89.3f pd=0.85u as=89.3f ps=0.85u w=0.47u l=0.16u
X9374 cml_tlatch_73.xtail.S1 CKHB3_N cml_tlatch_73.xmux.xp.S1 VSS sg13_lv_nmos ad=89.3f pd=0.85u as=89.3f ps=0.85u w=0.47u l=0.16u
X9375 MOT11_P MOT11_N cml_tlatch_4.xmux.xp.S1 VSS sg13_lv_nmos ad=56.9f pd=0.74u as=56.9f ps=0.74u w=0.17u l=0.17u
X9376 cml_tlatch_58.xmux.xp.S1 CKA3_N cml_tlatch_58.xtail.S1 VSS sg13_lv_nmos ad=0.1598p pd=1.62u as=89.3f ps=0.85u w=0.47u l=0.16u
X9377 cml_tlatch_75.xmux.xp.S1 MOT31_P MOT31_N VSS sg13_lv_nmos ad=56.9f pd=0.74u as=56.9f ps=0.74u w=0.17u l=0.17u
X9378 cml_tlatch_87.xmux.xn.S1 CKA2_N cml_tlatch_87.xtail.S1 VSS sg13_lv_nmos ad=0.1598p pd=1.62u as=89.3f ps=0.85u w=0.47u l=0.16u
X9379 stub_bi_15.BOTP cml_tlatch_4.INP cml_tlatch_11.xmux.xn.S1 VSS sg13_lv_nmos ad=63.19999f pd=0.74u as=63.19999f ps=0.74u w=0.26u l=0.38u
X9380 cml_tlatch_15.xmux.xp.S1 MOT3_P MOT3_N VSS sg13_lv_nmos ad=56.9f pd=0.74u as=56.9f ps=0.74u w=0.17u l=0.17u
X9381 cml_tlatch_82.xmux.xp.S1 stub_bi_62.BOTN stub_bi_62.BOTP VSS sg13_lv_nmos ad=56.9f pd=0.74u as=56.9f ps=0.74u w=0.17u l=0.17u
X9382 cml_tlatch_28.xmux.xp.S1 MOT4_P MOT4_N VSS sg13_lv_nmos ad=56.9f pd=0.74u as=56.9f ps=0.74u w=0.17u l=0.17u
X9383 cml_tlatch_1.xmux.xp.S1 B0_8_P B0_8_N VSS sg13_lv_nmos ad=0.1019p pd=1.34u as=56.9f ps=0.74u w=0.17u l=0.17u
X9384 cml_tlatch_43.INP cml_tlatch_43.INN cml_tlatch_21.xmux.xp.S1 VSS sg13_lv_nmos ad=56.9f pd=0.74u as=56.9f ps=0.74u w=0.17u l=0.17u
X9385 cml_tlatch_53.xmux.xp.S1 MOT18_P MOT18_N VSS sg13_lv_nmos ad=56.9f pd=0.74u as=56.9f ps=0.74u w=0.17u l=0.17u
X9386 VSS POLN cml_tlatch_68.xtail.S1 VSS sg13_lv_nmos ad=1.5637p pd=8.61u as=1.5637p ps=8.61u w=8.23u l=0.13u
X9387 cml_tlatch_76.xtail.S1 CKA2_P cml_tlatch_76.xmux.xn.S1 VSS sg13_lv_nmos ad=89.3f pd=0.85u as=89.3f ps=0.85u w=0.47u l=0.16u
X9388 cml_tlatch_50.xmux.xp.S1 B3_2_P B3_2_N VSS sg13_lv_nmos ad=56.9f pd=0.74u as=56.9f ps=0.74u w=0.17u l=0.17u
X9389 cml_tlatch_10.xmux.xn.S1 CKB1_N cml_tlatch_10.xtail.S1 VSS sg13_lv_nmos ad=89.3f pd=0.85u as=89.3f ps=0.85u w=0.47u l=0.16u
X9390 GA0_P ENA0_N cml_gate2_3.xamp.xn.S1 VSS sg13_lv_nmos ad=0.1007p pd=0.91u as=0.1007p ps=0.91u w=0.53u l=0.13u
X9391 cml_tlatch_20.xtail.S1 CKA1_N cml_tlatch_20.xmux.xp.S1 VSS sg13_lv_nmos ad=89.3f pd=0.85u as=89.3f ps=0.85u w=0.47u l=0.16u
X9392 cml_tlatch_93.xmux.xp.S1 CLK_W_N CLK_W_P VSS sg13_lv_nmos ad=56.9f pd=0.74u as=56.9f ps=0.74u w=0.17u l=0.17u
X9393 cml_tlatch_7.xmux.xn.S1 cml_tlatch_8.OUTP cml_tlatch_7.OUTN VSS sg13_lv_nmos ad=63.19999f pd=0.74u as=63.19999f ps=0.74u w=0.26u l=0.38u
X9394 cml_tlatch_14.xmux.xp.S1 CKHB0_N cml_tlatch_14.xtail.S1 VSS sg13_lv_nmos ad=89.3f pd=0.85u as=89.3f ps=0.85u w=0.47u l=0.16u
X9395 cml_tlatch_94.xmux.xn.S1 J1_P J2_N VSS sg13_lv_nmos ad=63.19999f pd=0.74u as=63.19999f ps=0.74u w=0.26u l=0.38u
X9396 cml_tlatch_10.xmux.xn.S1 stub_bi_15.BOTN B1_8_N VSS sg13_lv_nmos ad=63.19999f pd=0.74u as=63.19999f ps=0.74u w=0.26u l=0.38u
X9397 cml_tlatch_86.OUTP cml_tlatch_86.OUTN cml_tlatch_86.xmux.xp.S1 VSS sg13_lv_nmos ad=56.9f pd=0.74u as=56.9f ps=0.74u w=0.17u l=0.17u
X9398 VDD MOT16_N VSS rppd l=5.17u w=1u
X9399 cml_tlatch_10.xmux.xn.S1 stub_bi_15.BOTN B1_8_N VSS sg13_lv_nmos ad=63.19999f pd=0.74u as=63.19999f ps=0.74u w=0.26u l=0.38u
X9400 cml_tlatch_71.xmux.xp.S1 cml_tlatch_71.OUTP cml_tlatch_71.OUTN VSS sg13_lv_nmos ad=56.9f pd=0.74u as=56.9f ps=0.74u w=0.17u l=0.17u
X9401 cml_tlatch_79.xmux.xp.S1 MOT21_P MOT21_N VSS sg13_lv_nmos ad=56.9f pd=0.74u as=56.9f ps=0.74u w=0.17u l=0.17u
X9402 cml_tlatch_49.xtail.S1 CKB3_P cml_tlatch_49.xmux.xn.S1 VSS sg13_lv_nmos ad=89.3f pd=0.85u as=89.3f ps=0.85u w=0.47u l=0.16u
X9403 cml_tlatch_67.OUTN cml_tlatch_67.OUTP cml_tlatch_67.xmux.xp.S1 VSS sg13_lv_nmos ad=56.9f pd=0.74u as=56.9f ps=0.74u w=0.17u l=0.17u
X9404 cml_tlatch_29.xtail.S1 CKHA0_P cml_tlatch_29.xmux.xn.S1 VSS sg13_lv_nmos ad=89.3f pd=0.85u as=89.3f ps=0.85u w=0.47u l=0.16u
X9405 cml_tlatch_28.xtail.S1 CKHA0_P cml_tlatch_28.xmux.xn.S1 VSS sg13_lv_nmos ad=89.3f pd=0.85u as=89.3f ps=0.85u w=0.47u l=0.16u
X9406 cml_tlatch_19.xmux.xn.S1 cml_tlatch_20.OUTN A1_8_P VSS sg13_lv_nmos ad=63.19999f pd=0.74u as=63.19999f ps=0.74u w=0.26u l=0.38u
X9407 cml_tlatch_22.OUTP cml_tlatch_22.OUTN cml_tlatch_22.xmux.xp.S1 VSS sg13_lv_nmos ad=56.9f pd=0.74u as=56.9f ps=0.74u w=0.17u l=0.17u
X9408 cml_tlatch_8.xmux.xn.S1 cml_tlatch_98.OUTP cml_tlatch_8.OUTN VSS sg13_lv_nmos ad=63.19999f pd=0.74u as=63.19999f ps=0.74u w=0.26u l=0.38u
X9409 ENB1_P ENB_N cml_drv_0.xrtail.R1 VSS sg13_lv_nmos ad=56.2f pd=0.74u as=56.2f ps=0.74u w=0.16u l=0.19u
X9410 MOT2_N MOT2_P cml_tlatch_27.xmux.xp.S1 VSS sg13_lv_nmos ad=56.9f pd=0.74u as=56.9f ps=0.74u w=0.17u l=0.17u
X9411 cml_tlatch_55.xmux.xp.S1 CKHA2_N cml_tlatch_55.xtail.S1 VSS sg13_lv_nmos ad=89.3f pd=0.85u as=89.3f ps=0.85u w=0.47u l=0.16u
X9412 cml_tlatch_8.xmux.xn.S1 cml_tlatch_98.OUTP cml_tlatch_8.OUTN VSS sg13_lv_nmos ad=63.19999f pd=0.74u as=63.19999f ps=0.74u w=0.26u l=0.38u
X9413 cml_tlatch_59.xmux.xp.S1 CKA2_N cml_tlatch_59.xtail.S1 VSS sg13_lv_nmos ad=89.3f pd=0.85u as=0.1598p ps=1.62u w=0.47u l=0.16u
X9414 GA3_P VDD VSS rppd l=7.42u w=1u
X9415 cml_tlatch_83.xmux.xn.S1 stub_bi_49.BOTP stub_bi_63.BOTN VSS sg13_lv_nmos ad=63.19999f pd=0.74u as=63.19999f ps=0.74u w=0.26u l=0.38u
X9416 GB3_P CKA3_N cml_gate2_6.xrtail.R1 VSS sg13_lv_nmos ad=0.1007p pd=0.91u as=0.1007p ps=0.91u w=0.53u l=0.13u
X9417 cml_tlatch_18.OUTN cml_tlatch_18.OUTP cml_tlatch_18.xmux.xp.S1 VSS sg13_lv_nmos ad=56.9f pd=0.74u as=56.9f ps=0.74u w=0.17u l=0.17u
X9418 J4_N J4_P cml_tlatch_92.xmux.xp.S1 VSS sg13_lv_nmos ad=56.9f pd=0.74u as=56.9f ps=0.74u w=0.17u l=0.17u
X9419 VSS POLN cml_tlatch_60.xtail.S1 VSS sg13_lv_nmos ad=2.7982p pd=17.14u as=1.5637p ps=8.61u w=8.23u l=0.13u
X9420 cml_tlatch_40.xmux.xn.S1 CKA1_N cml_tlatch_40.xtail.S1 VSS sg13_lv_nmos ad=89.3f pd=0.85u as=89.3f ps=0.85u w=0.47u l=0.16u
X9421 cml_tlatch_89.xmux.xp.S1 cml_tlatch_44.INP cml_tlatch_44.INN VSS sg13_lv_nmos ad=56.9f pd=0.74u as=56.9f ps=0.74u w=0.17u l=0.17u
X9422 cml_tlatch_5.xmux.xp.S1 MOT13_N MOT13_P VSS sg13_lv_nmos ad=56.9f pd=0.74u as=56.9f ps=0.74u w=0.17u l=0.17u
X9423 cml_tlatch_5.xmux.xp.S1 CKHB1_N cml_tlatch_5.xtail.S1 VSS sg13_lv_nmos ad=89.3f pd=0.85u as=89.3f ps=0.85u w=0.47u l=0.16u
X9424 cml_tlatch_38.xmux.xp.S1 cml_tlatch_38.OUTN cml_tlatch_38.OUTP VSS sg13_lv_nmos ad=56.9f pd=0.74u as=56.9f ps=0.74u w=0.17u l=0.17u
X9425 VSS POLN hs_to_clk_5.D2 VSS sg13_lv_nmos ad=1.9p pd=10.38u as=3.4p ps=20.68u w=10u l=0.13u
X9426 cml_tlatch_54.xmux.xn.S1 cml_tlatch_91.OUTP MOT20_N VSS sg13_lv_nmos ad=63.19999f pd=0.74u as=63.19999f ps=0.74u w=0.26u l=0.38u
X9427 MOT5_N MOT5_P cml_tlatch_16.xmux.xp.S1 VSS sg13_lv_nmos ad=56.9f pd=0.74u as=56.9f ps=0.74u w=0.17u l=0.17u
X9428 cml_tlatch_30.OUTP B0_2_N cml_tlatch_30.xmux.xn.S1 VSS sg13_lv_nmos ad=63.19999f pd=0.74u as=63.19999f ps=0.74u w=0.26u l=0.38u
X9429 cml_tlatch_45.xmux.xp.S1 CKHA3_N cml_tlatch_45.xtail.S1 VSS sg13_lv_nmos ad=89.3f pd=0.85u as=89.3f ps=0.85u w=0.47u l=0.16u
X9430 cml_tlatch_23.xmux.xn.S1 CKA0_N cml_tlatch_23.xtail.S1 VSS sg13_lv_nmos ad=89.3f pd=0.85u as=89.3f ps=0.85u w=0.47u l=0.16u
X9431 cml_tlatch_98.xmux.xp.S1 CKB0_P cml_tlatch_98.xtail.S1 VSS sg13_lv_nmos ad=89.3f pd=0.85u as=89.3f ps=0.85u w=0.47u l=0.16u
X9432 cml_tlatch_70.xmux.xp.S1 cml_tlatch_63.INP cml_tlatch_63.INN VSS sg13_lv_nmos ad=56.9f pd=0.74u as=56.9f ps=0.74u w=0.17u l=0.17u
X9433 MOT20_N MOT20_P cml_tlatch_54.xmux.xp.S1 VSS sg13_lv_nmos ad=56.9f pd=0.74u as=56.9f ps=0.74u w=0.17u l=0.17u
X9434 MOT19_N stub_bi_63.BOTN cml_tlatch_78.xmux.xn.S1 VSS sg13_lv_nmos ad=63.19999f pd=0.74u as=63.19999f ps=0.74u w=0.26u l=0.38u
X9435 B1_2_P stub_bi_31.BOTP cml_tlatch_36.xmux.xn.S1 VSS sg13_lv_nmos ad=63.19999f pd=0.74u as=63.19999f ps=0.74u w=0.26u l=0.38u
X9436 cml_tlatch_70.xmux.xp.S1 cml_tlatch_63.INN cml_tlatch_63.INP VSS sg13_lv_nmos ad=56.9f pd=0.74u as=56.9f ps=0.74u w=0.17u l=0.17u
X9437 cml_tlatch_44.xmux.xp.S1 MOT28_P MOT28_N VSS sg13_lv_nmos ad=56.9f pd=0.74u as=56.9f ps=0.74u w=0.17u l=0.17u
X9438 A0_8_P A0_8_N cml_tlatch_9.xmux.xp.S1 VSS sg13_lv_nmos ad=56.9f pd=0.74u as=56.9f ps=0.74u w=0.17u l=0.17u
X9439 MOT2_P cml_tlatch_23.OUTN cml_tlatch_27.xmux.xn.S1 VSS sg13_lv_nmos ad=63.19999f pd=0.74u as=63.19999f ps=0.74u w=0.26u l=0.38u
X9440 stub_bi_62.BOTN stub_bi_63.BOTP cml_tlatch_82.xmux.xn.S1 VSS sg13_lv_nmos ad=63.19999f pd=0.74u as=63.19999f ps=0.74u w=0.26u l=0.38u
X9441 cml_tlatch_36.xmux.xn.S1 CKB1_N cml_tlatch_36.xtail.S1 VSS sg13_lv_nmos ad=89.3f pd=0.85u as=89.3f ps=0.85u w=0.47u l=0.16u
X9442 cml_tlatch_1.xmux.xp.S1 CKB0_P cml_tlatch_1.xtail.S1 VSS sg13_lv_nmos ad=89.3f pd=0.85u as=89.3f ps=0.85u w=0.47u l=0.16u
X9443 cml_tlatch_20.xtail.S1 CKA1_N cml_tlatch_20.xmux.xp.S1 VSS sg13_lv_nmos ad=89.3f pd=0.85u as=89.3f ps=0.85u w=0.47u l=0.16u
X9444 cml_tlatch_50.xmux.xn.S1 cml_tlatch_51.OUTN B3_2_P VSS sg13_lv_nmos ad=63.19999f pd=0.74u as=63.19999f ps=0.74u w=0.26u l=0.38u
X9445 cml_tlatch_69.OUTN cml_tlatch_69.OUTP cml_tlatch_69.xmux.xp.S1 VSS sg13_lv_nmos ad=56.9f pd=0.74u as=56.9f ps=0.74u w=0.17u l=0.17u
X9446 MOT10_N MOT10_P cml_tlatch_43.xmux.xp.S1 VSS sg13_lv_nmos ad=56.9f pd=0.74u as=0.1019p ps=1.34u w=0.17u l=0.17u
X9447 cml_tlatch_12.xmux.xp.S1 cml_tlatch_4.INN cml_tlatch_4.INP VSS sg13_lv_nmos ad=56.9f pd=0.74u as=56.9f ps=0.74u w=0.17u l=0.17u
X9448 cml_tlatch_64.xmux.xp.S1 CKB3_P cml_tlatch_64.xtail.S1 VSS sg13_lv_nmos ad=89.3f pd=0.85u as=89.3f ps=0.85u w=0.47u l=0.16u
X9449 cml_tlatch_61.OUTP cml_tlatch_61.OUTN cml_tlatch_61.xmux.xp.S1 VSS sg13_lv_nmos ad=56.9f pd=0.74u as=56.9f ps=0.74u w=0.17u l=0.17u
X9450 B3_2_P B3_2_N cml_tlatch_50.xmux.xp.S1 VSS sg13_lv_nmos ad=56.9f pd=0.74u as=56.9f ps=0.74u w=0.17u l=0.17u
X9451 cml_tlatch_30.xmux.xp.S1 CKB0_N cml_tlatch_30.xtail.S1 VSS sg13_lv_nmos ad=89.3f pd=0.85u as=89.3f ps=0.85u w=0.47u l=0.16u
X9452 cml_tlatch_8.xmux.xp.S1 cml_tlatch_8.OUTP cml_tlatch_8.OUTN VSS sg13_lv_nmos ad=56.9f pd=0.74u as=56.9f ps=0.74u w=0.17u l=0.17u
X9453 cml_tlatch_15.xmux.xp.S1 MOT3_P MOT3_N VSS sg13_lv_nmos ad=0.1019p pd=1.34u as=56.9f ps=0.74u w=0.17u l=0.17u
X9454 stub_bi_17.BOTP stub_bi_17.BOTN cml_tlatch_13.xmux.xp.S1 VSS sg13_lv_nmos ad=56.9f pd=0.74u as=56.9f ps=0.74u w=0.17u l=0.17u
X9455 cml_tlatch_43.INN cml_tlatch_43.INP cml_tlatch_21.xmux.xp.S1 VSS sg13_lv_nmos ad=56.9f pd=0.74u as=56.9f ps=0.74u w=0.17u l=0.17u
X9456 cml_tlatch_8.xtail.S1 CKB0_P cml_tlatch_8.xmux.xn.S1 VSS sg13_lv_nmos ad=89.3f pd=0.85u as=89.3f ps=0.85u w=0.47u l=0.16u
X9457 VSS POLN hs_to_clk_0.D2 VSS sg13_lv_nmos ad=1.9p pd=10.38u as=3.4p ps=20.68u w=10u l=0.13u
X9458 cml_tlatch_36.xmux.xp.S1 B1_2_N B1_2_P VSS sg13_lv_nmos ad=56.9f pd=0.74u as=56.9f ps=0.74u w=0.17u l=0.17u
X9459 cml_tlatch_2.OUTP cml_tlatch_7.OUTN cml_tlatch_2.xmux.xn.S1 VSS sg13_lv_nmos ad=63.19999f pd=0.74u as=63.19999f ps=0.74u w=0.26u l=0.38u
X9460 cml_tlatch_5.INP cml_tlatch_5.INN cml_tlatch_96.xmux.xp.S1 VSS sg13_lv_nmos ad=56.9f pd=0.74u as=0.1019p ps=1.34u w=0.17u l=0.17u
X9461 cml_tlatch_95.xmux.xp.S1 J1_P J1_N VSS sg13_lv_nmos ad=56.9f pd=0.74u as=56.9f ps=0.74u w=0.17u l=0.17u
X9462 cml_tlatch_54.xmux.xp.S1 CKHA2_N cml_tlatch_54.xtail.S1 VSS sg13_lv_nmos ad=89.3f pd=0.85u as=0.1598p ps=1.62u w=0.47u l=0.16u
X9463 B0_2_P cml_tlatch_32.OUTN cml_tlatch_31.xmux.xn.S1 VSS sg13_lv_nmos ad=63.19999f pd=0.74u as=63.19999f ps=0.74u w=0.26u l=0.38u
X9464 cml_tlatch_51.xmux.xn.S1 CKB3_P cml_tlatch_51.xtail.S1 VSS sg13_lv_nmos ad=89.3f pd=0.85u as=89.3f ps=0.85u w=0.47u l=0.16u
X9465 cml_tlatch_93.xmux.xp.S1 CLK_W_N CLK_W_P VSS sg13_lv_nmos ad=56.9f pd=0.74u as=56.9f ps=0.74u w=0.17u l=0.17u
X9466 cml_tlatch_67.xmux.xp.S1 cml_tlatch_67.OUTN cml_tlatch_67.OUTP VSS sg13_lv_nmos ad=56.9f pd=0.74u as=56.9f ps=0.74u w=0.17u l=0.17u
X9467 cml_tlatch_56.xtail.S1 CKA3_N cml_tlatch_56.xmux.xp.S1 VSS sg13_lv_nmos ad=89.3f pd=0.85u as=89.3f ps=0.85u w=0.47u l=0.16u
X9468 cml_tlatch_80.xtail.S1 CKHB2_N cml_tlatch_80.xmux.xp.S1 VSS sg13_lv_nmos ad=89.3f pd=0.85u as=89.3f ps=0.85u w=0.47u l=0.16u
X9469 cml_tlatch_7.xmux.xp.S1 cml_tlatch_7.OUTN cml_tlatch_7.OUTP VSS sg13_lv_nmos ad=56.9f pd=0.74u as=56.9f ps=0.74u w=0.17u l=0.17u
X9470 cml_tlatch_83.xmux.xp.S1 CKB2_P cml_tlatch_83.xtail.S1 VSS sg13_lv_nmos ad=89.3f pd=0.85u as=89.3f ps=0.85u w=0.47u l=0.16u
X9471 cml_tlatch_77.xmux.xn.S1 B2_8_P MOT17_N VSS sg13_lv_nmos ad=63.19999f pd=0.74u as=63.19999f ps=0.74u w=0.26u l=0.38u
X9472 cml_gate2_1.xamp.xn.S1 ENB1_P GB0_N VSS sg13_lv_nmos ad=0.1007p pd=0.91u as=0.1007p ps=0.91u w=0.53u l=0.13u
X9473 ENA1_P ENA_N cml_drv_1.xrtail.R1 VSS sg13_lv_nmos ad=0.1012p pd=1.34u as=56.2f ps=0.74u w=0.16u l=0.19u
X9474 cml_tlatch_43.xtail.S1 CKHA1_N cml_tlatch_43.xmux.xp.S1 VSS sg13_lv_nmos ad=89.3f pd=0.85u as=89.3f ps=0.85u w=0.47u l=0.16u
X9475 cml_tlatch_94.xtail.S1 CKJ_N cml_tlatch_94.xmux.xn.S1 VSS sg13_lv_nmos ad=89.3f pd=0.85u as=89.3f ps=0.85u w=0.47u l=0.16u
X9476 cml_tlatch_45.xmux.xn.S1 A3_2_N MOT30_P VSS sg13_lv_nmos ad=0.1082p pd=1.34u as=63.19999f ps=0.74u w=0.26u l=0.38u
X9477 cml_tlatch_38.xmux.xp.S1 cml_tlatch_38.OUTP cml_tlatch_38.OUTN VSS sg13_lv_nmos ad=56.9f pd=0.74u as=56.9f ps=0.74u w=0.17u l=0.17u
X9478 cml_tlatch_28.xmux.xp.S1 MOT4_N MOT4_P VSS sg13_lv_nmos ad=56.9f pd=0.74u as=56.9f ps=0.74u w=0.17u l=0.17u
X9479 cml_tlatch_79.xmux.xp.S1 MOT21_P MOT21_N VSS sg13_lv_nmos ad=56.9f pd=0.74u as=56.9f ps=0.74u w=0.17u l=0.17u
X9480 cml_tlatch_84.xtail.S1 CKB2_N cml_tlatch_84.xmux.xp.S1 VSS sg13_lv_nmos ad=89.3f pd=0.85u as=89.3f ps=0.85u w=0.47u l=0.16u
X9481 cml_tlatch_91.INN cml_tlatch_91.INP cml_tlatch_59.xmux.xp.S1 VSS sg13_lv_nmos ad=56.9f pd=0.74u as=56.9f ps=0.74u w=0.17u l=0.17u
X9482 cml_tlatch_20.OUTP cml_tlatch_20.OUTN cml_tlatch_20.xmux.xp.S1 VSS sg13_lv_nmos ad=56.9f pd=0.74u as=56.9f ps=0.74u w=0.17u l=0.17u
X9483 cml_tlatch_19.xmux.xp.S1 A1_8_N A1_8_P VSS sg13_lv_nmos ad=56.9f pd=0.74u as=56.9f ps=0.74u w=0.17u l=0.17u
X9484 cml_tlatch_44.xmux.xp.S1 CKHA3_N cml_tlatch_44.xtail.S1 VSS sg13_lv_nmos ad=89.3f pd=0.85u as=89.3f ps=0.85u w=0.47u l=0.16u
X9485 cml_tlatch_60.xmux.xn.S1 cml_tlatch_61.OUTN A2_2_P VSS sg13_lv_nmos ad=63.19999f pd=0.74u as=63.19999f ps=0.74u w=0.26u l=0.38u
X9486 MOT5_N cml_tlatch_98.OUTP cml_tlatch_16.xmux.xn.S1 VSS sg13_lv_nmos ad=63.19999f pd=0.74u as=0.1082p ps=1.34u w=0.26u l=0.38u
X9487 cml_tlatch_26.xmux.xn.S1 A0_8_N MOT0_P VSS sg13_lv_nmos ad=63.19999f pd=0.74u as=63.19999f ps=0.74u w=0.26u l=0.38u
X9488 A2_2_N cml_tlatch_61.OUTP cml_tlatch_60.xmux.xn.S1 VSS sg13_lv_nmos ad=63.19999f pd=0.74u as=63.19999f ps=0.74u w=0.26u l=0.38u
X9489 cml_tlatch_92.xmux.xp.S1 J4_N J4_P VSS sg13_lv_nmos ad=56.9f pd=0.74u as=56.9f ps=0.74u w=0.17u l=0.17u
X9490 cml_tlatch_5.xmux.xp.S1 MOT13_P MOT13_N VSS sg13_lv_nmos ad=56.9f pd=0.74u as=56.9f ps=0.74u w=0.17u l=0.17u
X9491 stub_bi_31.BOTP D1_P cml_tlatch_37.xmux.xn.S1 VSS sg13_lv_nmos ad=63.19999f pd=0.74u as=63.19999f ps=0.74u w=0.26u l=0.38u
X9492 cml_tlatch_2.xmux.xp.S1 cml_tlatch_2.OUTN cml_tlatch_2.OUTP VSS sg13_lv_nmos ad=56.9f pd=0.74u as=56.9f ps=0.74u w=0.17u l=0.17u
X9493 cml_tlatch_61.xmux.xp.S1 cml_tlatch_61.OUTP cml_tlatch_61.OUTN VSS sg13_lv_nmos ad=56.9f pd=0.74u as=56.9f ps=0.74u w=0.17u l=0.17u
X9494 VSS hs_to_clk_7.sg13_lv_nmos_2HGZLP_0.G VSS VSS sg13_lv_nmos ad=2.071p pd=11.28u as=0 ps=0 w=10.9u l=1.38u
X9495 cml_tlatch_61.OUTP D2_N cml_tlatch_61.xmux.xn.S1 VSS sg13_lv_nmos ad=63.19999f pd=0.74u as=0.1082p ps=1.34u w=0.26u l=0.38u
X9496 hs_to_clk_4.D2 POLN VSS VSS sg13_lv_nmos ad=1.9p pd=10.38u as=1.9p ps=10.38u w=10u l=0.13u
X9497 cml_tlatch_7.xmux.xp.S1 CKB0_P cml_tlatch_7.xtail.S1 VSS sg13_lv_nmos ad=89.3f pd=0.85u as=89.3f ps=0.85u w=0.47u l=0.16u
X9498 cml_tlatch_92.xmux.xn.S1 CLK_W_N J4_N VSS sg13_lv_nmos ad=63.19999f pd=0.74u as=63.19999f ps=0.74u w=0.26u l=0.38u
X9499 cml_tlatch_49.OUTN B3_2_P cml_tlatch_49.xmux.xn.S1 VSS sg13_lv_nmos ad=63.19999f pd=0.74u as=63.19999f ps=0.74u w=0.26u l=0.38u
X9500 A0_2_P A0_2_N cml_tlatch_34.xmux.xp.S1 VSS sg13_lv_nmos ad=56.9f pd=0.74u as=56.9f ps=0.74u w=0.17u l=0.17u
X9501 cml_tlatch_26.xmux.xp.S1 MOT0_P MOT0_N VSS sg13_lv_nmos ad=56.9f pd=0.74u as=56.9f ps=0.74u w=0.17u l=0.17u
X9502 cml_tlatch_64.xmux.xp.S1 B3_8_P B3_8_N VSS sg13_lv_nmos ad=56.9f pd=0.74u as=56.9f ps=0.74u w=0.17u l=0.17u
X9503 cml_tlatch_30.OUTN VDD VSS rppd l=5.17u w=1u
X9504 cml_tlatch_5.INP cml_tlatch_5.INN cml_tlatch_96.xmux.xp.S1 VSS sg13_lv_nmos ad=56.9f pd=0.74u as=56.9f ps=0.74u w=0.17u l=0.17u
X9505 cml_tlatch_13.xmux.xn.S1 cml_tlatch_5.INP stub_bi_17.BOTP VSS sg13_lv_nmos ad=0.1082p pd=1.34u as=63.19999f ps=0.74u w=0.26u l=0.38u
X9506 cml_tlatch_1.xtail.S1 CKB0_N cml_tlatch_1.xmux.xn.S1 VSS sg13_lv_nmos ad=89.3f pd=0.85u as=89.3f ps=0.85u w=0.47u l=0.16u
X9507 cml_tlatch_65.xmux.xp.S1 cml_tlatch_65.OUTP cml_tlatch_65.OUTN VSS sg13_lv_nmos ad=56.9f pd=0.74u as=56.9f ps=0.74u w=0.17u l=0.17u
X9508 cml_tlatch_30.OUTP cml_tlatch_30.OUTN cml_tlatch_30.xmux.xp.S1 VSS sg13_lv_nmos ad=56.9f pd=0.74u as=56.9f ps=0.74u w=0.17u l=0.17u
X9509 cml_tlatch_5.xmux.xn.S1 CKHB1_P cml_tlatch_5.xtail.S1 VSS sg13_lv_nmos ad=89.3f pd=0.85u as=89.3f ps=0.85u w=0.47u l=0.16u
X9510 cml_tlatch_88.xtail.S1 CKB3_N cml_tlatch_88.xmux.xn.S1 VSS sg13_lv_nmos ad=89.3f pd=0.85u as=0.1598p ps=1.62u w=0.47u l=0.16u
X9511 MOT22_N MOT22_P cml_tlatch_55.xmux.xp.S1 VSS sg13_lv_nmos ad=56.9f pd=0.74u as=56.9f ps=0.74u w=0.17u l=0.17u
X9512 GB2_P CKA2_N cml_gate2_7.xrtail.R1 VSS sg13_lv_nmos ad=0.1007p pd=0.91u as=0.1007p ps=0.91u w=0.53u l=0.13u
X9513 cml_tlatch_5.xmux.xn.S1 cml_tlatch_5.INP MOT13_N VSS sg13_lv_nmos ad=0.1082p pd=1.34u as=63.19999f ps=0.74u w=0.26u l=0.38u
X9514 cml_gate2_6.xamp.xn.S1 ENB0_N GB3_P VSS sg13_lv_nmos ad=0.1007p pd=0.91u as=0.1007p ps=0.91u w=0.53u l=0.13u
X9515 MOT6_N A0_2_P cml_tlatch_29.xmux.xn.S1 VSS sg13_lv_nmos ad=63.19999f pd=0.74u as=63.19999f ps=0.74u w=0.26u l=0.38u
X9516 cml_tlatch_49.xmux.xp.S1 cml_tlatch_49.OUTN cml_tlatch_49.OUTP VSS sg13_lv_nmos ad=56.9f pd=0.74u as=56.9f ps=0.74u w=0.17u l=0.17u
X9517 cml_tlatch_28.xmux.xn.S1 CKHA0_P cml_tlatch_28.xtail.S1 VSS sg13_lv_nmos ad=89.3f pd=0.85u as=0.1598p ps=1.62u w=0.47u l=0.16u
X9518 MOT14_N MOT14_P cml_tlatch_25.xmux.xp.S1 VSS sg13_lv_nmos ad=56.9f pd=0.74u as=56.9f ps=0.74u w=0.17u l=0.17u
X9519 GA0_N ENA0_P cml_gate2_3.xamp.xn.S1 VSS sg13_lv_nmos ad=0.1007p pd=0.91u as=0.1007p ps=0.91u w=0.53u l=0.13u
X9520 cml_tlatch_65.xmux.xp.S1 cml_tlatch_65.OUTP cml_tlatch_65.OUTN VSS sg13_lv_nmos ad=0.1019p pd=1.34u as=56.9f ps=0.74u w=0.17u l=0.17u
X9521 cml_tlatch_32.xmux.xn.S1 CKB0_P cml_tlatch_32.xtail.S1 VSS sg13_lv_nmos ad=89.3f pd=0.85u as=89.3f ps=0.85u w=0.47u l=0.16u
X9522 cml_tlatch_47.xtail.S1 CKB2_P cml_tlatch_47.xmux.xp.S1 VSS sg13_lv_nmos ad=89.3f pd=0.85u as=89.3f ps=0.85u w=0.47u l=0.16u
X9523 cml_tlatch_74.INP cml_tlatch_74.INN cml_tlatch_88.xmux.xp.S1 VSS sg13_lv_nmos ad=56.9f pd=0.74u as=56.9f ps=0.74u w=0.17u l=0.17u
X9524 cml_tlatch_93.xmux.xn.S1 J2_P CLK_W_P VSS sg13_lv_nmos ad=63.19999f pd=0.74u as=63.19999f ps=0.74u w=0.26u l=0.38u
X9525 cml_tlatch_39.xmux.xp.S1 cml_tlatch_97.INP cml_tlatch_97.INN VSS sg13_lv_nmos ad=56.9f pd=0.74u as=56.9f ps=0.74u w=0.17u l=0.17u
X9526 stub_bi_15.BOTP stub_bi_15.BOTN cml_tlatch_11.xmux.xp.S1 VSS sg13_lv_nmos ad=56.9f pd=0.74u as=56.9f ps=0.74u w=0.17u l=0.17u
X9527 cml_tlatch_67.xmux.xp.S1 cml_tlatch_67.OUTN cml_tlatch_67.OUTP VSS sg13_lv_nmos ad=56.9f pd=0.74u as=56.9f ps=0.74u w=0.17u l=0.17u
X9528 cml_tlatch_69.xmux.xp.S1 CKA3_N cml_tlatch_69.xtail.S1 VSS sg13_lv_nmos ad=0.1598p pd=1.62u as=89.3f ps=0.85u w=0.47u l=0.16u
X9529 cml_tlatch_91.xtail.S1 CKA2_N cml_tlatch_91.xmux.xn.S1 VSS sg13_lv_nmos ad=89.3f pd=0.85u as=89.3f ps=0.85u w=0.47u l=0.16u
X9530 cml_tlatch_87.INP cml_tlatch_87.INN cml_tlatch_76.xmux.xp.S1 VSS sg13_lv_nmos ad=56.9f pd=0.74u as=56.9f ps=0.74u w=0.17u l=0.17u
X9531 cml_tlatch_8.xmux.xp.S1 cml_tlatch_8.OUTP cml_tlatch_8.OUTN VSS sg13_lv_nmos ad=56.9f pd=0.74u as=56.9f ps=0.74u w=0.17u l=0.17u
X9532 cml_tlatch_41.OUTP cml_tlatch_41.OUTN cml_tlatch_41.xmux.xp.S1 VSS sg13_lv_nmos ad=56.9f pd=0.74u as=56.9f ps=0.74u w=0.17u l=0.17u
X9533 cml_tlatch_63.xtail.S1 CKHA3_P cml_tlatch_63.xmux.xn.S1 VSS sg13_lv_nmos ad=89.3f pd=0.85u as=89.3f ps=0.85u w=0.47u l=0.16u
X9534 cml_tlatch_77.xtail.S1 CKHB2_N cml_tlatch_77.xmux.xp.S1 VSS sg13_lv_nmos ad=89.3f pd=0.85u as=89.3f ps=0.85u w=0.47u l=0.16u
X9535 cml_tlatch_99.xmux.xp.S1 cml_tlatch_99.OUTN cml_tlatch_99.OUTP VSS sg13_lv_nmos ad=56.9f pd=0.74u as=56.9f ps=0.74u w=0.17u l=0.17u
X9536 cml_tlatch_91.OUTN cml_tlatch_91.OUTP cml_tlatch_91.xmux.xp.S1 VSS sg13_lv_nmos ad=56.9f pd=0.74u as=56.9f ps=0.74u w=0.17u l=0.17u
X9537 cml_tlatch_58.xmux.xp.S1 CKA3_N cml_tlatch_58.xtail.S1 VSS sg13_lv_nmos ad=89.3f pd=0.85u as=89.3f ps=0.85u w=0.47u l=0.16u
X9538 ENB0_P ENB_N cml_drv_2.xrtail.R1 VSS sg13_lv_nmos ad=56.2f pd=0.74u as=0.1012p ps=1.34u w=0.16u l=0.19u
X9539 cml_tlatch_90.xmux.xp.S1 stub_bi_55.BOTN stub_bi_55.BOTP VSS sg13_lv_nmos ad=56.9f pd=0.74u as=56.9f ps=0.74u w=0.17u l=0.17u
X9540 ENA0_N ENA_P cml_drv_3.xrtail.R1 VSS sg13_lv_nmos ad=56.2f pd=0.74u as=56.2f ps=0.74u w=0.16u l=0.19u
X9541 cml_tlatch_98.xtail.S1 CKB0_P cml_tlatch_98.xmux.xp.S1 VSS sg13_lv_nmos ad=89.3f pd=0.85u as=0.1598p ps=1.62u w=0.47u l=0.16u
X9542 cml_tlatch_33.xmux.xp.S1 CKA0_N cml_tlatch_33.xtail.S1 VSS sg13_lv_nmos ad=89.3f pd=0.85u as=0.1598p ps=1.62u w=0.47u l=0.16u
X9543 cml_tlatch_6.xmux.xp.S1 CKHB1_N cml_tlatch_6.xtail.S1 VSS sg13_lv_nmos ad=89.3f pd=0.85u as=89.3f ps=0.85u w=0.47u l=0.16u
X9544 cml_tlatch_76.xtail.S1 CKA2_P cml_tlatch_76.xmux.xn.S1 VSS sg13_lv_nmos ad=89.3f pd=0.85u as=89.3f ps=0.85u w=0.47u l=0.16u
X9545 cml_tlatch_55.xmux.xn.S1 CKHA2_P cml_tlatch_55.xtail.S1 VSS sg13_lv_nmos ad=89.3f pd=0.85u as=89.3f ps=0.85u w=0.47u l=0.16u
X9546 cml_tlatch_54.xmux.xn.S1 CKHA2_P cml_tlatch_54.xtail.S1 VSS sg13_lv_nmos ad=89.3f pd=0.85u as=89.3f ps=0.85u w=0.47u l=0.16u
X9547 cml_tlatch_79.xmux.xn.S1 stub_bi_55.BOTP MOT21_P VSS sg13_lv_nmos ad=63.19999f pd=0.74u as=63.19999f ps=0.74u w=0.26u l=0.38u
X9548 A3_8_P A3_8_N cml_tlatch_68.xmux.xp.S1 VSS sg13_lv_nmos ad=56.9f pd=0.74u as=56.9f ps=0.74u w=0.17u l=0.17u
X9549 cml_gate2_5.xrtail.R1 CKB2_N GA2_P VSS sg13_lv_nmos ad=0.1007p pd=0.91u as=0.1802p ps=1.74u w=0.53u l=0.13u
X9550 cml_tlatch_88.xtail.S1 POLN VSS VSS sg13_lv_nmos ad=1.5637p pd=8.61u as=2.7982p ps=17.14u w=8.23u l=0.13u
X9551 MOT27_P cml_tlatch_73.INN cml_tlatch_73.xmux.xn.S1 VSS sg13_lv_nmos ad=63.19999f pd=0.74u as=63.19999f ps=0.74u w=0.26u l=0.38u
X9552 B0_8_N B0_8_P cml_tlatch_1.xmux.xp.S1 VSS sg13_lv_nmos ad=56.9f pd=0.74u as=56.9f ps=0.74u w=0.17u l=0.17u
X9553 cml_tlatch_91.xtail.S1 CKA2_P cml_tlatch_91.xmux.xp.S1 VSS sg13_lv_nmos ad=89.3f pd=0.85u as=89.3f ps=0.85u w=0.47u l=0.16u
X9554 cml_tlatch_84.xtail.S1 CKB2_P cml_tlatch_84.xmux.xn.S1 VSS sg13_lv_nmos ad=0.1598p pd=1.62u as=89.3f ps=0.85u w=0.47u l=0.16u
X9555 cml_tlatch_18.xmux.xn.S1 CKA0_P cml_tlatch_18.xtail.S1 VSS sg13_lv_nmos ad=89.3f pd=0.85u as=89.3f ps=0.85u w=0.47u l=0.16u
X9556 cml_tlatch_64.xtail.S1 CKB3_P cml_tlatch_64.xmux.xp.S1 VSS sg13_lv_nmos ad=89.3f pd=0.85u as=89.3f ps=0.85u w=0.47u l=0.16u
X9557 B1_8_P B1_8_N cml_tlatch_10.xmux.xp.S1 VSS sg13_lv_nmos ad=56.9f pd=0.74u as=56.9f ps=0.74u w=0.17u l=0.17u
X9558 cml_tlatch_47.xmux.xp.S1 B2_2_N B2_2_P VSS sg13_lv_nmos ad=56.9f pd=0.74u as=56.9f ps=0.74u w=0.17u l=0.17u
X9559 cml_tlatch_25.xmux.xp.S1 MOT14_N MOT14_P VSS sg13_lv_nmos ad=56.9f pd=0.74u as=56.9f ps=0.74u w=0.17u l=0.17u
X9560 MOT3_P MOT3_N cml_tlatch_15.xmux.xp.S1 VSS sg13_lv_nmos ad=56.9f pd=0.74u as=56.9f ps=0.74u w=0.17u l=0.17u
X9561 cml_tlatch_0.OUTP cml_tlatch_0.OUTN cml_tlatch_0.xmux.xp.S1 VSS sg13_lv_nmos ad=56.9f pd=0.74u as=56.9f ps=0.74u w=0.17u l=0.17u
X9562 cml_tlatch_39.xtail.S1 CKA1_P cml_tlatch_39.xmux.xn.S1 VSS sg13_lv_nmos ad=89.3f pd=0.85u as=89.3f ps=0.85u w=0.47u l=0.16u
X9563 MOT18_P MOT18_N cml_tlatch_53.xmux.xp.S1 VSS sg13_lv_nmos ad=56.9f pd=0.74u as=56.9f ps=0.74u w=0.17u l=0.17u
X9564 B2_8_P stub_bi_62.BOTP cml_tlatch_81.xmux.xn.S1 VSS sg13_lv_nmos ad=63.19999f pd=0.74u as=63.19999f ps=0.74u w=0.26u l=0.38u
X9565 cml_tlatch_63.xmux.xp.S1 MOT26_N MOT26_P VSS sg13_lv_nmos ad=56.9f pd=0.74u as=56.9f ps=0.74u w=0.17u l=0.17u
X9566 cml_tlatch_7.xmux.xn.S1 cml_tlatch_8.OUTN cml_tlatch_7.OUTP VSS sg13_lv_nmos ad=63.19999f pd=0.74u as=0.1082p ps=1.34u w=0.26u l=0.38u
X9567 cml_tlatch_2.OUTN cml_tlatch_2.OUTP cml_tlatch_2.xmux.xp.S1 VSS sg13_lv_nmos ad=56.9f pd=0.74u as=56.9f ps=0.74u w=0.17u l=0.17u
X9568 cml_tlatch_65.OUTP cml_tlatch_65.OUTN cml_tlatch_65.xmux.xp.S1 VSS sg13_lv_nmos ad=56.9f pd=0.74u as=56.9f ps=0.74u w=0.17u l=0.17u
X9569 cml_tlatch_17.xtail.S1 CKHB0_P cml_tlatch_17.xmux.xn.S1 VSS sg13_lv_nmos ad=89.3f pd=0.85u as=89.3f ps=0.85u w=0.47u l=0.16u
X9570 cml_tlatch_37.xmux.xp.S1 CKB1_N cml_tlatch_37.xtail.S1 VSS sg13_lv_nmos ad=89.3f pd=0.85u as=89.3f ps=0.85u w=0.47u l=0.16u
X9571 cml_tlatch_52.xmux.xp.S1 MOT16_N MOT16_P VSS sg13_lv_nmos ad=56.9f pd=0.74u as=56.9f ps=0.74u w=0.17u l=0.17u
X9572 cml_tlatch_90.xtail.S1 CKB2_P cml_tlatch_90.xmux.xp.S1 VSS sg13_lv_nmos ad=89.3f pd=0.85u as=89.3f ps=0.85u w=0.47u l=0.16u
X9573 cml_tlatch_34.xmux.xp.S1 A0_2_P A0_2_N VSS sg13_lv_nmos ad=56.9f pd=0.74u as=56.9f ps=0.74u w=0.17u l=0.17u
X9574 MOT23_N MOT23_P cml_tlatch_80.xmux.xp.S1 VSS sg13_lv_nmos ad=56.9f pd=0.74u as=56.9f ps=0.74u w=0.17u l=0.17u
X9575 cml_tlatch_56.OUTN cml_tlatch_56.OUTP cml_tlatch_56.xmux.xp.S1 VSS sg13_lv_nmos ad=56.9f pd=0.74u as=56.9f ps=0.74u w=0.17u l=0.17u
X9576 stub_bi_49.BOTN stub_bi_49.BOTP cml_tlatch_84.xmux.xp.S1 VSS sg13_lv_nmos ad=56.9f pd=0.74u as=0.1019p ps=1.34u w=0.17u l=0.17u
X9577 cml_tlatch_70.xmux.xn.S1 cml_tlatch_71.OUTP cml_tlatch_63.INN VSS sg13_lv_nmos ad=63.19999f pd=0.74u as=63.19999f ps=0.74u w=0.26u l=0.38u
X9578 cml_tlatch_80.xmux.xp.S1 CKHB2_N cml_tlatch_80.xtail.S1 VSS sg13_lv_nmos ad=89.3f pd=0.85u as=89.3f ps=0.85u w=0.47u l=0.16u
X9579 cml_tlatch_35.xtail.S1 CKB1_P cml_tlatch_35.xmux.xn.S1 VSS sg13_lv_nmos ad=89.3f pd=0.85u as=89.3f ps=0.85u w=0.47u l=0.16u
X9580 ENA_P J1_N cml_gate2_9.xamp.xn.S1 VSS sg13_lv_nmos ad=0.1007p pd=0.91u as=0.1007p ps=0.91u w=0.53u l=0.13u
X9581 cml_tlatch_87.OUTP cml_tlatch_87.OUTN cml_tlatch_87.xmux.xp.S1 VSS sg13_lv_nmos ad=56.9f pd=0.74u as=56.9f ps=0.74u w=0.17u l=0.17u
X9582 cml_tlatch_83.xtail.S1 CKB2_P cml_tlatch_83.xmux.xp.S1 VSS sg13_lv_nmos ad=89.3f pd=0.85u as=0.1598p ps=1.62u w=0.47u l=0.16u
X9583 cml_tlatch_27.xmux.xp.S1 MOT2_P MOT2_N VSS sg13_lv_nmos ad=56.9f pd=0.74u as=56.9f ps=0.74u w=0.17u l=0.17u
X9584 MOT21_P MOT21_N cml_tlatch_79.xmux.xp.S1 VSS sg13_lv_nmos ad=56.9f pd=0.74u as=56.9f ps=0.74u w=0.17u l=0.17u
X9585 cml_tlatch_74.xmux.xp.S1 MOT29_N MOT29_P VSS sg13_lv_nmos ad=56.9f pd=0.74u as=56.9f ps=0.74u w=0.17u l=0.17u
X9586 cml_tlatch_59.xtail.S1 CKA2_P cml_tlatch_59.xmux.xn.S1 VSS sg13_lv_nmos ad=89.3f pd=0.85u as=89.3f ps=0.85u w=0.47u l=0.16u
X9587 cml_tlatch_23.xmux.xn.S1 CKA0_N cml_tlatch_23.xtail.S1 VSS sg13_lv_nmos ad=89.3f pd=0.85u as=89.3f ps=0.85u w=0.47u l=0.16u
X9588 cml_tlatch_94.xmux.xn.S1 CKJ_N cml_tlatch_94.xtail.S1 VSS sg13_lv_nmos ad=89.3f pd=0.85u as=89.3f ps=0.85u w=0.47u l=0.16u
X9589 cml_tlatch_39.xmux.xp.S1 cml_tlatch_97.INP cml_tlatch_97.INN VSS sg13_lv_nmos ad=56.9f pd=0.74u as=56.9f ps=0.74u w=0.17u l=0.17u
X9590 stub_bi_29.BOTP stub_bi_29.BOTN cml_tlatch_35.xmux.xp.S1 VSS sg13_lv_nmos ad=56.9f pd=0.74u as=56.9f ps=0.74u w=0.17u l=0.17u
X9591 cml_tlatch_67.xtail.S1 POLN VSS VSS sg13_lv_nmos ad=1.5637p pd=8.61u as=1.5637p ps=8.61u w=8.23u l=0.13u
X9592 MOT14_N MOT14_P cml_tlatch_25.xmux.xp.S1 VSS sg13_lv_nmos ad=56.9f pd=0.74u as=56.9f ps=0.74u w=0.17u l=0.17u
X9593 cml_tlatch_11.xmux.xp.S1 stub_bi_15.BOTP stub_bi_15.BOTN VSS sg13_lv_nmos ad=0.1019p pd=1.34u as=56.9f ps=0.74u w=0.17u l=0.17u
X9594 cml_tlatch_91.OUTP cml_tlatch_91.INN cml_tlatch_91.xmux.xn.S1 VSS sg13_lv_nmos ad=63.19999f pd=0.74u as=63.19999f ps=0.74u w=0.26u l=0.38u
X9595 cml_tlatch_75.xmux.xp.S1 CKHB3_N cml_tlatch_75.xtail.S1 VSS sg13_lv_nmos ad=89.3f pd=0.85u as=89.3f ps=0.85u w=0.47u l=0.16u
X9596 cml_tlatch_72.xmux.xn.S1 B3_8_N MOT25_P VSS sg13_lv_nmos ad=63.19999f pd=0.74u as=63.19999f ps=0.74u w=0.26u l=0.38u
X9597 cml_tlatch_91.xmux.xp.S1 cml_tlatch_91.OUTN cml_tlatch_91.OUTP VSS sg13_lv_nmos ad=56.9f pd=0.74u as=56.9f ps=0.74u w=0.17u l=0.17u
X9598 cml_tlatch_66.xtail.S1 CKB3_P cml_tlatch_66.xmux.xp.S1 VSS sg13_lv_nmos ad=89.3f pd=0.85u as=89.3f ps=0.85u w=0.47u l=0.16u
X9599 cml_tlatch_21.xmux.xp.S1 CKA1_P cml_tlatch_21.xtail.S1 VSS sg13_lv_nmos ad=0.1598p pd=1.62u as=89.3f ps=0.85u w=0.47u l=0.16u
X9600 cml_tlatch_72.xmux.xp.S1 MOT25_P MOT25_N VSS sg13_lv_nmos ad=56.9f pd=0.74u as=56.9f ps=0.74u w=0.17u l=0.17u
X9601 cml_tlatch_3.xmux.xp.S1 CKHB1_N cml_tlatch_3.xtail.S1 VSS sg13_lv_nmos ad=89.3f pd=0.85u as=89.3f ps=0.85u w=0.47u l=0.16u
X9602 B0_2_P cml_tlatch_32.OUTN cml_tlatch_31.xmux.xn.S1 VSS sg13_lv_nmos ad=63.19999f pd=0.74u as=63.19999f ps=0.74u w=0.26u l=0.38u
X9603 cml_tlatch_30.xmux.xp.S1 CKB0_N cml_tlatch_30.xtail.S1 VSS sg13_lv_nmos ad=89.3f pd=0.85u as=89.3f ps=0.85u w=0.47u l=0.16u
X9604 cml_tlatch_95.xtail.S1 CKJ_P cml_tlatch_95.xmux.xn.S1 VSS sg13_lv_nmos ad=89.3f pd=0.85u as=89.3f ps=0.85u w=0.47u l=0.16u
X9605 cml_tlatch_63.xtail.S1 CKHA3_N cml_tlatch_63.xmux.xp.S1 VSS sg13_lv_nmos ad=0.1598p pd=1.62u as=89.3f ps=0.85u w=0.47u l=0.16u
X9606 MOT8_N MOT8_P cml_tlatch_42.xmux.xp.S1 VSS sg13_lv_nmos ad=56.9f pd=0.74u as=56.9f ps=0.74u w=0.17u l=0.17u
X9607 cml_tlatch_54.xmux.xp.S1 MOT20_N MOT20_P VSS sg13_lv_nmos ad=56.9f pd=0.74u as=56.9f ps=0.74u w=0.17u l=0.17u
X9608 cml_tlatch_78.xmux.xp.S1 MOT19_N MOT19_P VSS sg13_lv_nmos ad=56.9f pd=0.74u as=56.9f ps=0.74u w=0.17u l=0.17u
X9609 MOT28_P MOT28_N cml_tlatch_44.xmux.xp.S1 VSS sg13_lv_nmos ad=56.9f pd=0.74u as=56.9f ps=0.74u w=0.17u l=0.17u
X9610 MOT27_P MOT27_N cml_tlatch_73.xmux.xp.S1 VSS sg13_lv_nmos ad=56.9f pd=0.74u as=56.9f ps=0.74u w=0.17u l=0.17u
X9611 A3_8_N cml_tlatch_69.OUTP cml_tlatch_68.xmux.xn.S1 VSS sg13_lv_nmos ad=63.19999f pd=0.74u as=63.19999f ps=0.74u w=0.26u l=0.38u
X9612 cml_tlatch_68.xtail.S1 CKA3_N cml_tlatch_68.xmux.xn.S1 VSS sg13_lv_nmos ad=89.3f pd=0.85u as=89.3f ps=0.85u w=0.47u l=0.16u
X9613 cml_tlatch_8.xtail.S1 CKB0_P cml_tlatch_8.xmux.xn.S1 VSS sg13_lv_nmos ad=89.3f pd=0.85u as=89.3f ps=0.85u w=0.47u l=0.16u
X9614 VDD MOT4_P VSS rppd l=5.17u w=1u
X9615 MOT17_P MOT17_N cml_tlatch_77.xmux.xp.S1 VSS sg13_lv_nmos ad=56.9f pd=0.74u as=56.9f ps=0.74u w=0.17u l=0.17u
X9616 cml_gate2_8.xamp.xn.S1 J2_P ENB_N VSS sg13_lv_nmos ad=0.1007p pd=0.91u as=0.1007p ps=0.91u w=0.53u l=0.13u
X9617 cml_tlatch_51.OUTP cml_tlatch_51.OUTN cml_tlatch_51.xmux.xp.S1 VSS sg13_lv_nmos ad=56.9f pd=0.74u as=56.9f ps=0.74u w=0.17u l=0.17u
X9618 cml_tlatch_97.xmux.xp.S1 cml_tlatch_24.INP cml_tlatch_24.INN VSS sg13_lv_nmos ad=56.9f pd=0.74u as=56.9f ps=0.74u w=0.17u l=0.17u
X9619 A3_2_P A3_2_N cml_tlatch_57.xmux.xp.S1 VSS sg13_lv_nmos ad=56.9f pd=0.74u as=56.9f ps=0.74u w=0.17u l=0.17u
X9620 cml_tlatch_4.xmux.xp.S1 MOT11_N MOT11_P VSS sg13_lv_nmos ad=56.9f pd=0.74u as=56.9f ps=0.74u w=0.17u l=0.17u
X9621 cml_tlatch_30.xmux.xn.S1 B0_2_N cml_tlatch_30.OUTP VSS sg13_lv_nmos ad=63.19999f pd=0.74u as=63.19999f ps=0.74u w=0.26u l=0.38u
X9622 MOT31_N MOT31_P cml_tlatch_75.xmux.xp.S1 VSS sg13_lv_nmos ad=56.9f pd=0.74u as=56.9f ps=0.74u w=0.17u l=0.17u
X9623 cml_tlatch_22.OUTN cml_tlatch_22.OUTP cml_tlatch_22.xmux.xp.S1 VSS sg13_lv_nmos ad=56.9f pd=0.74u as=56.9f ps=0.74u w=0.17u l=0.17u
X9624 cml_tlatch_41.xmux.xn.S1 CKA1_P cml_tlatch_41.xtail.S1 VSS sg13_lv_nmos ad=89.3f pd=0.85u as=89.3f ps=0.85u w=0.47u l=0.16u
X9625 stub_bi_62.BOTP stub_bi_62.BOTN cml_tlatch_82.xmux.xp.S1 VSS sg13_lv_nmos ad=56.9f pd=0.74u as=56.9f ps=0.74u w=0.17u l=0.17u
X9626 MOT3_N MOT3_P cml_tlatch_15.xmux.xp.S1 VSS sg13_lv_nmos ad=56.9f pd=0.74u as=56.9f ps=0.74u w=0.17u l=0.17u
X9627 MOT4_N MOT4_P cml_tlatch_28.xmux.xp.S1 VSS sg13_lv_nmos ad=56.9f pd=0.74u as=56.9f ps=0.74u w=0.17u l=0.17u
X9628 cml_tlatch_47.xmux.xp.S1 CKB2_P cml_tlatch_47.xtail.S1 VSS sg13_lv_nmos ad=89.3f pd=0.85u as=89.3f ps=0.85u w=0.47u l=0.16u
X9629 stub_bi_63.BOTP stub_bi_63.BOTN cml_tlatch_83.xmux.xp.S1 VSS sg13_lv_nmos ad=56.9f pd=0.74u as=56.9f ps=0.74u w=0.17u l=0.17u
X9630 B0_8_N B0_8_P cml_tlatch_1.xmux.xp.S1 VSS sg13_lv_nmos ad=56.9f pd=0.74u as=56.9f ps=0.74u w=0.17u l=0.17u
X9631 cml_tlatch_43.xtail.S1 CKHA1_N cml_tlatch_43.xmux.xp.S1 VSS sg13_lv_nmos ad=89.3f pd=0.85u as=89.3f ps=0.85u w=0.47u l=0.16u
X9632 cml_tlatch_82.xmux.xn.S1 stub_bi_63.BOTP stub_bi_62.BOTN VSS sg13_lv_nmos ad=63.19999f pd=0.74u as=63.19999f ps=0.74u w=0.26u l=0.38u
X9633 cml_tlatch_14.xtail.S1 POLN VSS VSS sg13_lv_nmos ad=1.5637p pd=8.61u as=1.5637p ps=8.61u w=8.23u l=0.13u
X9634 cml_tlatch_14.xtail.S1 CKHB0_P cml_tlatch_14.xmux.xn.S1 VSS sg13_lv_nmos ad=89.3f pd=0.85u as=89.3f ps=0.85u w=0.47u l=0.16u
X9635 cml_tlatch_89.xmux.xn.S1 cml_tlatch_56.OUTP cml_tlatch_44.INN VSS sg13_lv_nmos ad=63.19999f pd=0.74u as=63.19999f ps=0.74u w=0.26u l=0.38u
X9636 cml_tlatch_57.xmux.xp.S1 CKA3_P cml_tlatch_57.xtail.S1 VSS sg13_lv_nmos ad=89.3f pd=0.85u as=0.1598p ps=1.62u w=0.47u l=0.16u
X9637 MOT24_N MOT24_P cml_tlatch_62.xmux.xp.S1 VSS sg13_lv_nmos ad=56.9f pd=0.74u as=56.9f ps=0.74u w=0.17u l=0.17u
X9638 cml_tlatch_33.xmux.xp.S1 cml_tlatch_33.OUTP cml_tlatch_33.OUTN VSS sg13_lv_nmos ad=56.9f pd=0.74u as=56.9f ps=0.74u w=0.17u l=0.17u
X9639 cml_tlatch_6.xmux.xp.S1 MOT15_P MOT15_N VSS sg13_lv_nmos ad=56.9f pd=0.74u as=56.9f ps=0.74u w=0.17u l=0.17u
X9640 stub_bi_31.BOTN D1_N cml_tlatch_37.xmux.xn.S1 VSS sg13_lv_nmos ad=63.19999f pd=0.74u as=63.19999f ps=0.74u w=0.26u l=0.38u
X9641 VDD A1_2_N VSS rppd l=5.17u w=1u
X9642 ENB1_P ENB_N cml_drv_0.xrtail.R1 VSS sg13_lv_nmos ad=56.2f pd=0.74u as=0.1012p ps=1.34u w=0.16u l=0.19u
X9643 cml_gate2_3.xrtail.R1 CKB0_P cml_gate2_3.xamp.xn.S1 VSS sg13_lv_nmos ad=0.1007p pd=0.91u as=0.1802p ps=1.74u w=0.53u l=0.13u
X9644 cml_tlatch_50.xmux.xn.S1 cml_tlatch_51.OUTP B3_2_N VSS sg13_lv_nmos ad=0.1082p pd=1.34u as=63.19999f ps=0.74u w=0.26u l=0.38u
X9645 cml_tlatch_77.xmux.xp.S1 CKHB2_N cml_tlatch_77.xtail.S1 VSS sg13_lv_nmos ad=89.3f pd=0.85u as=89.3f ps=0.85u w=0.47u l=0.16u
X9646 cml_tlatch_49.xtail.S1 CKB3_N cml_tlatch_49.xmux.xp.S1 VSS sg13_lv_nmos ad=89.3f pd=0.85u as=89.3f ps=0.85u w=0.47u l=0.16u
X9647 VSS POLN cml_tlatch_58.xtail.S1 VSS sg13_lv_nmos ad=1.5637p pd=8.61u as=1.5637p ps=8.61u w=8.23u l=0.13u
X9648 cml_tlatch_75.xmux.xn.S1 B3_2_N MOT31_P VSS sg13_lv_nmos ad=0.1082p pd=1.34u as=63.19999f ps=0.74u w=0.26u l=0.38u
X9649 cml_tlatch_87.xtail.S1 CKA2_N cml_tlatch_87.xmux.xn.S1 VSS sg13_lv_nmos ad=89.3f pd=0.85u as=89.3f ps=0.85u w=0.47u l=0.16u
X9650 cml_tlatch_37.xmux.xn.S1 CKB1_P cml_tlatch_37.xtail.S1 VSS sg13_lv_nmos ad=89.3f pd=0.85u as=89.3f ps=0.85u w=0.47u l=0.16u
X9651 B2_8_N B2_8_P cml_tlatch_81.xmux.xp.S1 VSS sg13_lv_nmos ad=56.9f pd=0.74u as=56.9f ps=0.74u w=0.17u l=0.17u
X9652 cml_tlatch_51.xmux.xn.S1 D3_N cml_tlatch_51.OUTP VSS sg13_lv_nmos ad=63.19999f pd=0.74u as=63.19999f ps=0.74u w=0.26u l=0.38u
X9653 cml_tlatch_37.xmux.xp.S1 stub_bi_31.BOTP stub_bi_31.BOTN VSS sg13_lv_nmos ad=0.1019p pd=1.34u as=56.9f ps=0.74u w=0.17u l=0.17u
X9654 cml_tlatch_50.xmux.xn.S1 cml_tlatch_51.OUTP B3_2_N VSS sg13_lv_nmos ad=63.19999f pd=0.74u as=63.19999f ps=0.74u w=0.26u l=0.38u
X9655 cml_tlatch_71.OUTN cml_tlatch_71.OUTP cml_tlatch_71.xmux.xp.S1 VSS sg13_lv_nmos ad=56.9f pd=0.74u as=56.9f ps=0.74u w=0.17u l=0.17u
X9656 cml_tlatch_52.xmux.xp.S1 MOT16_N MOT16_P VSS sg13_lv_nmos ad=0.1019p pd=1.34u as=56.9f ps=0.74u w=0.17u l=0.17u
X9657 MOT24_P MOT24_N cml_tlatch_62.xmux.xp.S1 VSS sg13_lv_nmos ad=56.9f pd=0.74u as=56.9f ps=0.74u w=0.17u l=0.17u
X9658 cml_tlatch_85.xtail.S1 POLN VSS VSS sg13_lv_nmos ad=1.5637p pd=8.61u as=2.7982p ps=17.14u w=8.23u l=0.13u
X9659 cml_tlatch_40.xmux.xn.S1 cml_tlatch_41.OUTP A1_2_N VSS sg13_lv_nmos ad=63.19999f pd=0.74u as=63.19999f ps=0.74u w=0.26u l=0.38u
X9660 cml_tlatch_54.xtail.S1 CKHA2_P cml_tlatch_54.xmux.xn.S1 VSS sg13_lv_nmos ad=89.3f pd=0.85u as=89.3f ps=0.85u w=0.47u l=0.16u
X9661 cml_gate2_5.xamp.xn.S1 ENA1_N GA2_P VSS sg13_lv_nmos ad=0.1007p pd=0.91u as=0.1007p ps=0.91u w=0.53u l=0.13u
X9662 cml_tlatch_23.xmux.xp.S1 cml_tlatch_23.OUTN cml_tlatch_23.OUTP VSS sg13_lv_nmos ad=56.9f pd=0.74u as=56.9f ps=0.74u w=0.17u l=0.17u
X9663 cml_tlatch_72.xmux.xp.S1 CKHB3_N cml_tlatch_72.xtail.S1 VSS sg13_lv_nmos ad=89.3f pd=0.85u as=89.3f ps=0.85u w=0.47u l=0.16u
X9664 VSS POLN cml_tlatch_84.xtail.S1 VSS sg13_lv_nmos ad=2.7982p pd=17.14u as=1.5637p ps=8.61u w=8.23u l=0.13u
X9665 cml_tlatch_27.xmux.xp.S1 MOT2_P MOT2_N VSS sg13_lv_nmos ad=56.9f pd=0.74u as=56.9f ps=0.74u w=0.17u l=0.17u
X9666 cml_tlatch_83.xtail.S1 CKB2_N cml_tlatch_83.xmux.xn.S1 VSS sg13_lv_nmos ad=89.3f pd=0.85u as=89.3f ps=0.85u w=0.47u l=0.16u
X9667 cml_tlatch_42.xmux.xp.S1 MOT8_N MOT8_P VSS sg13_lv_nmos ad=56.9f pd=0.74u as=56.9f ps=0.74u w=0.17u l=0.17u
X9668 cml_tlatch_36.xmux.xp.S1 B1_2_P B1_2_N VSS sg13_lv_nmos ad=56.9f pd=0.74u as=56.9f ps=0.74u w=0.17u l=0.17u
X9669 cml_tlatch_74.xmux.xp.S1 MOT29_N MOT29_P VSS sg13_lv_nmos ad=56.9f pd=0.74u as=56.9f ps=0.74u w=0.17u l=0.17u
X9670 stub_bi_38.BOTN stub_bi_38.BOTP cml_tlatch_46.xmux.xp.S1 VSS sg13_lv_nmos ad=56.9f pd=0.74u as=56.9f ps=0.74u w=0.17u l=0.17u
X9671 cml_tlatch_94.xmux.xp.S1 CKJ_P cml_tlatch_94.xtail.S1 VSS sg13_lv_nmos ad=89.3f pd=0.85u as=89.3f ps=0.85u w=0.47u l=0.16u
X9672 cml_tlatch_9.xmux.xn.S1 cml_tlatch_18.OUTN A0_8_P VSS sg13_lv_nmos ad=63.19999f pd=0.74u as=63.19999f ps=0.74u w=0.26u l=0.38u
X9673 cml_drv_3.xrtail.R1 ENA_P ENA0_N VSS sg13_lv_nmos ad=56.2f pd=0.74u as=56.2f ps=0.74u w=0.16u l=0.19u
X9674 cml_tlatch_57.xtail.S1 CKA3_N cml_tlatch_57.xmux.xn.S1 VSS sg13_lv_nmos ad=89.3f pd=0.85u as=89.3f ps=0.85u w=0.47u l=0.16u
X9675 cml_tlatch_44.INN cml_tlatch_44.INP cml_tlatch_89.xmux.xp.S1 VSS sg13_lv_nmos ad=56.9f pd=0.74u as=56.9f ps=0.74u w=0.17u l=0.17u
X9676 cml_tlatch_74.xtail.S1 CKHB3_N cml_tlatch_74.xmux.xp.S1 VSS sg13_lv_nmos ad=89.3f pd=0.85u as=89.3f ps=0.85u w=0.47u l=0.16u
X9677 MOT13_P MOT13_N cml_tlatch_5.xmux.xp.S1 VSS sg13_lv_nmos ad=56.9f pd=0.74u as=56.9f ps=0.74u w=0.17u l=0.17u
X9678 cml_tlatch_44.xtail.S1 CKHA3_P cml_tlatch_44.xmux.xn.S1 VSS sg13_lv_nmos ad=89.3f pd=0.85u as=89.3f ps=0.85u w=0.47u l=0.16u
X9679 cml_tlatch_69.xmux.xn.S1 cml_tlatch_63.INP cml_tlatch_69.OUTN VSS sg13_lv_nmos ad=63.19999f pd=0.74u as=63.19999f ps=0.74u w=0.26u l=0.38u
X9680 cml_tlatch_38.OUTP cml_tlatch_38.OUTN cml_tlatch_38.xmux.xp.S1 VSS sg13_lv_nmos ad=56.9f pd=0.74u as=56.9f ps=0.74u w=0.17u l=0.17u
X9681 stub_bi_15.BOTN VDD VSS rppd l=5.17u w=1u
X9682 cml_tlatch_98.xmux.xn.S1 cml_tlatch_30.OUTP cml_tlatch_98.OUTN VSS sg13_lv_nmos ad=0.1082p pd=1.34u as=63.19999f ps=0.74u w=0.26u l=0.38u
X9683 cml_tlatch_16.xmux.xp.S1 MOT5_P MOT5_N VSS sg13_lv_nmos ad=56.9f pd=0.74u as=56.9f ps=0.74u w=0.17u l=0.17u
X9684 cml_tlatch_22.xmux.xp.S1 cml_tlatch_22.OUTP cml_tlatch_22.OUTN VSS sg13_lv_nmos ad=0.1019p pd=1.34u as=56.9f ps=0.74u w=0.17u l=0.17u
X9685 stub_bi_55.BOTN stub_bi_55.BOTP cml_tlatch_90.xmux.xp.S1 VSS sg13_lv_nmos ad=56.9f pd=0.74u as=56.9f ps=0.74u w=0.17u l=0.17u
X9686 cml_tlatch_18.xmux.xp.S1 cml_tlatch_18.OUTN cml_tlatch_18.OUTP VSS sg13_lv_nmos ad=56.9f pd=0.74u as=56.9f ps=0.74u w=0.17u l=0.17u
X9687 cml_tlatch_91.INN A2_2_P cml_tlatch_59.xmux.xn.S1 VSS sg13_lv_nmos ad=63.19999f pd=0.74u as=63.19999f ps=0.74u w=0.26u l=0.38u
X9688 cml_tlatch_54.xmux.xp.S1 MOT20_P MOT20_N VSS sg13_lv_nmos ad=56.9f pd=0.74u as=56.9f ps=0.74u w=0.17u l=0.17u
X9689 MOT7_N B0_2_P cml_tlatch_17.xmux.xn.S1 VSS sg13_lv_nmos ad=63.19999f pd=0.74u as=63.19999f ps=0.74u w=0.26u l=0.38u
X9690 cml_tlatch_31.xmux.xp.S1 B0_2_P B0_2_N VSS sg13_lv_nmos ad=56.9f pd=0.74u as=56.9f ps=0.74u w=0.17u l=0.17u
X9691 J1_P J4_P cml_tlatch_95.xmux.xn.S1 VSS sg13_lv_nmos ad=63.19999f pd=0.74u as=0.1082p ps=1.34u w=0.26u l=0.38u
X9692 cml_tlatch_9.xmux.xp.S1 A0_8_N A0_8_P VSS sg13_lv_nmos ad=56.9f pd=0.74u as=56.9f ps=0.74u w=0.17u l=0.17u
X9693 cml_tlatch_69.xmux.xp.S1 CKA3_N cml_tlatch_69.xtail.S1 VSS sg13_lv_nmos ad=89.3f pd=0.85u as=89.3f ps=0.85u w=0.47u l=0.16u
X9694 MOT31_N MOT31_P cml_tlatch_75.xmux.xp.S1 VSS sg13_lv_nmos ad=56.9f pd=0.74u as=0.1019p ps=1.34u w=0.17u l=0.17u
X9695 GB0_N ENB1_P cml_gate2_1.xamp.xn.S1 VSS sg13_lv_nmos ad=0.1007p pd=0.91u as=0.1007p ps=0.91u w=0.53u l=0.13u
X9696 cml_tlatch_91.xtail.S1 CKA2_N cml_tlatch_91.xmux.xn.S1 VSS sg13_lv_nmos ad=89.3f pd=0.85u as=89.3f ps=0.85u w=0.47u l=0.16u
X9697 cml_tlatch_95.xmux.xn.S1 J4_N J1_N VSS sg13_lv_nmos ad=63.19999f pd=0.74u as=63.19999f ps=0.74u w=0.26u l=0.38u
X9698 cml_tlatch_61.xmux.xn.S1 D2_N cml_tlatch_61.OUTP VSS sg13_lv_nmos ad=63.19999f pd=0.74u as=63.19999f ps=0.74u w=0.26u l=0.38u
X9699 cml_tlatch_69.xmux.xp.S1 cml_tlatch_69.OUTP cml_tlatch_69.OUTN VSS sg13_lv_nmos ad=56.9f pd=0.74u as=56.9f ps=0.74u w=0.17u l=0.17u
X9700 cml_tlatch_33.OUTP cml_tlatch_33.OUTN cml_tlatch_33.xmux.xp.S1 VSS sg13_lv_nmos ad=56.9f pd=0.74u as=56.9f ps=0.74u w=0.17u l=0.17u
X9701 cml_tlatch_31.xtail.S1 POLN VSS VSS sg13_lv_nmos ad=1.5637p pd=8.61u as=1.5637p ps=8.61u w=8.23u l=0.13u
X9702 VDD MOT18_N VSS rppd l=5.17u w=1u
X9703 cml_tlatch_85.xmux.xp.S1 A2_8_N A2_8_P VSS sg13_lv_nmos ad=56.9f pd=0.74u as=56.9f ps=0.74u w=0.17u l=0.17u
X9704 A3_2_P A3_2_N cml_tlatch_57.xmux.xp.S1 VSS sg13_lv_nmos ad=56.9f pd=0.74u as=56.9f ps=0.74u w=0.17u l=0.17u
X9705 cml_tlatch_72.xmux.xp.S1 MOT25_N MOT25_P VSS sg13_lv_nmos ad=56.9f pd=0.74u as=56.9f ps=0.74u w=0.17u l=0.17u
X9706 cml_tlatch_20.OUTN cml_tlatch_20.OUTP cml_tlatch_20.xmux.xp.S1 VSS sg13_lv_nmos ad=56.9f pd=0.74u as=56.9f ps=0.74u w=0.17u l=0.17u
X9707 cml_tlatch_50.xmux.xp.S1 B3_2_N B3_2_P VSS sg13_lv_nmos ad=56.9f pd=0.74u as=56.9f ps=0.74u w=0.17u l=0.17u
X9708 VSS POLN hs_to_clk_1.D2 VSS sg13_lv_nmos ad=1.9p pd=10.38u as=1.9p ps=10.38u w=10u l=0.13u
X9709 cml_gate2_2.xamp.xn.S1 ENA0_N GA1_P VSS sg13_lv_nmos ad=0.1007p pd=0.91u as=0.1802p ps=1.74u w=0.53u l=0.13u
X9710 VSS POLN cml_tlatch_97.xtail.S1 VSS sg13_lv_nmos ad=2.7982p pd=17.14u as=1.5637p ps=8.61u w=8.23u l=0.13u
X9711 B0_2_N cml_tlatch_32.OUTP cml_tlatch_31.xmux.xn.S1 VSS sg13_lv_nmos ad=63.19999f pd=0.74u as=63.19999f ps=0.74u w=0.26u l=0.38u
X9712 cml_tlatch_90.xtail.S1 CKB2_N cml_tlatch_90.xmux.xn.S1 VSS sg13_lv_nmos ad=0.1598p pd=1.62u as=89.3f ps=0.85u w=0.47u l=0.16u
X9713 MOT4_N MOT4_P cml_tlatch_28.xmux.xp.S1 VSS sg13_lv_nmos ad=56.9f pd=0.74u as=56.9f ps=0.74u w=0.17u l=0.17u
X9714 cml_tlatch_51.xmux.xp.S1 CKB3_N cml_tlatch_51.xtail.S1 VSS sg13_lv_nmos ad=89.3f pd=0.85u as=89.3f ps=0.85u w=0.47u l=0.16u
X9715 stub_bi_63.BOTP stub_bi_63.BOTN cml_tlatch_83.xmux.xp.S1 VSS sg13_lv_nmos ad=56.9f pd=0.74u as=56.9f ps=0.74u w=0.17u l=0.17u
X9716 MOT9_P MOT9_N cml_tlatch_3.xmux.xp.S1 VSS sg13_lv_nmos ad=56.9f pd=0.74u as=56.9f ps=0.74u w=0.17u l=0.17u
X9717 cml_tlatch_21.xmux.xp.S1 cml_tlatch_43.INP cml_tlatch_43.INN VSS sg13_lv_nmos ad=56.9f pd=0.74u as=56.9f ps=0.74u w=0.17u l=0.17u
X9718 cml_tlatch_21.xmux.xp.S1 cml_tlatch_43.INN cml_tlatch_43.INP VSS sg13_lv_nmos ad=56.9f pd=0.74u as=56.9f ps=0.74u w=0.17u l=0.17u
X9719 cml_tlatch_80.xmux.xn.S1 CKHB2_P cml_tlatch_80.xtail.S1 VSS sg13_lv_nmos ad=89.3f pd=0.85u as=89.3f ps=0.85u w=0.47u l=0.16u
X9720 B1_2_P B1_2_N cml_tlatch_36.xmux.xp.S1 VSS sg13_lv_nmos ad=56.9f pd=0.74u as=56.9f ps=0.74u w=0.17u l=0.17u
X9721 cml_tlatch_8.OUTP cml_tlatch_8.OUTN cml_tlatch_8.xmux.xp.S1 VSS sg13_lv_nmos ad=56.9f pd=0.74u as=56.9f ps=0.74u w=0.17u l=0.17u
X9722 VSS POLN hs_to_clk_6.D2 VSS sg13_lv_nmos ad=1.9p pd=10.38u as=3.4p ps=20.68u w=10u l=0.13u
X9723 cml_tlatch_20.OUTN cml_tlatch_20.OUTP cml_tlatch_20.xmux.xp.S1 VSS sg13_lv_nmos ad=56.9f pd=0.74u as=56.9f ps=0.74u w=0.17u l=0.17u
X9724 CLK_W_P CLK_W_N cml_tlatch_93.xmux.xp.S1 VSS sg13_lv_nmos ad=56.9f pd=0.74u as=56.9f ps=0.74u w=0.17u l=0.17u
X9725 cml_gate2_9.xrtail.R1 NM1_P cml_gate2_9.xamp.xn.S1 VSS sg13_lv_nmos ad=0.1007p pd=0.91u as=0.1802p ps=1.74u w=0.53u l=0.13u
X9726 cml_tlatch_71.xmux.xp.S1 cml_tlatch_71.OUTN cml_tlatch_71.OUTP VSS sg13_lv_nmos ad=56.9f pd=0.74u as=56.9f ps=0.74u w=0.17u l=0.17u
X9727 cml_tlatch_42.xtail.S1 CKHA1_P cml_tlatch_42.xmux.xn.S1 VSS sg13_lv_nmos ad=89.3f pd=0.85u as=0.1598p ps=1.62u w=0.47u l=0.16u
X9728 cml_gate2_7.xrtail.R1 CKA2_N GB2_P VSS sg13_lv_nmos ad=0.1007p pd=0.91u as=0.1802p ps=1.74u w=0.53u l=0.13u
X9729 cml_tlatch_30.xtail.S1 CKB0_N cml_tlatch_30.xmux.xp.S1 VSS sg13_lv_nmos ad=89.3f pd=0.85u as=0.1598p ps=1.62u w=0.47u l=0.16u
X9730 cml_tlatch_7.OUTP cml_tlatch_7.OUTN cml_tlatch_7.xmux.xp.S1 VSS sg13_lv_nmos ad=56.9f pd=0.74u as=56.9f ps=0.74u w=0.17u l=0.17u
X9731 VSS POLN cml_tlatch_19.xtail.S1 VSS sg13_lv_nmos ad=1.5637p pd=8.61u as=1.5637p ps=8.61u w=8.23u l=0.13u
X9732 cml_drv_3.xrtail.R1 VSS VSS rppd l=5.65u w=1u
X9733 MOT26_N MOT26_P cml_tlatch_63.xmux.xp.S1 VSS sg13_lv_nmos ad=56.9f pd=0.74u as=56.9f ps=0.74u w=0.17u l=0.17u
X9734 cml_tlatch_74.xmux.xn.S1 cml_tlatch_74.INP MOT29_N VSS sg13_lv_nmos ad=63.19999f pd=0.74u as=0.1082p ps=1.34u w=0.26u l=0.38u
X9735 cml_tlatch_19.xtail.S1 CKA1_P cml_tlatch_19.xmux.xp.S1 VSS sg13_lv_nmos ad=89.3f pd=0.85u as=89.3f ps=0.85u w=0.47u l=0.16u
X9736 cml_tlatch_11.xmux.xn.S1 cml_tlatch_4.INP stub_bi_15.BOTP VSS sg13_lv_nmos ad=63.19999f pd=0.74u as=0.1082p ps=1.34u w=0.26u l=0.38u
X9737 GB3_P ENB0_N cml_gate2_6.xamp.xn.S1 VSS sg13_lv_nmos ad=0.1007p pd=0.91u as=0.1007p ps=0.91u w=0.53u l=0.13u
X9738 cml_tlatch_11.xmux.xp.S1 CKB1_N cml_tlatch_11.xtail.S1 VSS sg13_lv_nmos ad=89.3f pd=0.85u as=89.3f ps=0.85u w=0.47u l=0.16u
X9739 cml_tlatch_98.OUTP cml_tlatch_98.OUTN cml_tlatch_98.xmux.xp.S1 VSS sg13_lv_nmos ad=56.9f pd=0.74u as=56.9f ps=0.74u w=0.17u l=0.17u
X9740 cml_tlatch_38.OUTN cml_tlatch_38.OUTP cml_tlatch_38.xmux.xp.S1 VSS sg13_lv_nmos ad=56.9f pd=0.74u as=56.9f ps=0.74u w=0.17u l=0.17u
X9741 cml_tlatch_59.xmux.xp.S1 cml_tlatch_91.INP cml_tlatch_91.INN VSS sg13_lv_nmos ad=56.9f pd=0.74u as=56.9f ps=0.74u w=0.17u l=0.17u
X9742 cml_tlatch_13.xmux.xp.S1 stub_bi_17.BOTP stub_bi_17.BOTN VSS sg13_lv_nmos ad=56.9f pd=0.74u as=56.9f ps=0.74u w=0.17u l=0.17u
X9743 cml_gate2_4.xamp.xn.S1 ENA1_P GA3_N VSS sg13_lv_nmos ad=0.1007p pd=0.91u as=0.1007p ps=0.91u w=0.53u l=0.13u
X9744 cml_tlatch_6.xmux.xp.S1 MOT15_N MOT15_P VSS sg13_lv_nmos ad=56.9f pd=0.74u as=56.9f ps=0.74u w=0.17u l=0.17u
X9745 MOT25_P MOT25_N cml_tlatch_72.xmux.xp.S1 VSS sg13_lv_nmos ad=56.9f pd=0.74u as=56.9f ps=0.74u w=0.17u l=0.17u
X9746 MOT4_P cml_tlatch_99.OUTN cml_tlatch_28.xmux.xn.S1 VSS sg13_lv_nmos ad=63.19999f pd=0.74u as=63.19999f ps=0.74u w=0.26u l=0.38u
X9747 cml_tlatch_26.xtail.S1 CKHA0_N cml_tlatch_26.xmux.xp.S1 VSS sg13_lv_nmos ad=89.3f pd=0.85u as=89.3f ps=0.85u w=0.47u l=0.16u
X9748 B1_8_N stub_bi_15.BOTN cml_tlatch_10.xmux.xn.S1 VSS sg13_lv_nmos ad=63.19999f pd=0.74u as=63.19999f ps=0.74u w=0.26u l=0.38u
X9749 cml_tlatch_35.xtail.S1 CKB1_P cml_tlatch_35.xmux.xn.S1 VSS sg13_lv_nmos ad=89.3f pd=0.85u as=89.3f ps=0.85u w=0.47u l=0.16u
X9750 cml_tlatch_10.xtail.S1 CKB1_P cml_tlatch_10.xmux.xp.S1 VSS sg13_lv_nmos ad=89.3f pd=0.85u as=89.3f ps=0.85u w=0.47u l=0.16u
X9751 VDD MOT6_N VSS rppd l=5.17u w=1u
X9752 MOT12_N MOT12_P cml_tlatch_24.xmux.xp.S1 VSS sg13_lv_nmos ad=56.9f pd=0.74u as=0.1019p ps=1.34u w=0.17u l=0.17u
X9753 cml_tlatch_23.xmux.xp.S1 cml_tlatch_23.OUTP cml_tlatch_23.OUTN VSS sg13_lv_nmos ad=56.9f pd=0.74u as=56.9f ps=0.74u w=0.17u l=0.17u
X9754 A1_8_P cml_tlatch_20.OUTN cml_tlatch_19.xmux.xn.S1 VSS sg13_lv_nmos ad=63.19999f pd=0.74u as=63.19999f ps=0.74u w=0.26u l=0.38u
X9755 cml_tlatch_88.xmux.xn.S1 cml_tlatch_49.OUTN cml_tlatch_74.INP VSS sg13_lv_nmos ad=0.1082p pd=1.34u as=63.19999f ps=0.74u w=0.26u l=0.38u
X9756 cml_tlatch_45.xtail.S1 CKHA3_P cml_tlatch_45.xmux.xn.S1 VSS sg13_lv_nmos ad=89.3f pd=0.85u as=89.3f ps=0.85u w=0.47u l=0.16u
X9757 cml_tlatch_30.xmux.xp.S1 cml_tlatch_30.OUTN cml_tlatch_30.OUTP VSS sg13_lv_nmos ad=56.9f pd=0.74u as=56.9f ps=0.74u w=0.17u l=0.17u
X9758 cml_tlatch_16.xmux.xp.S1 MOT5_P MOT5_N VSS sg13_lv_nmos ad=0.1019p pd=1.34u as=56.9f ps=0.74u w=0.17u l=0.17u
X9759 cml_tlatch_49.xmux.xp.S1 CKB3_N cml_tlatch_49.xtail.S1 VSS sg13_lv_nmos ad=89.3f pd=0.85u as=89.3f ps=0.85u w=0.47u l=0.16u
X9760 cml_tlatch_8.OUTN cml_tlatch_98.OUTP cml_tlatch_8.xmux.xn.S1 VSS sg13_lv_nmos ad=63.19999f pd=0.74u as=63.19999f ps=0.74u w=0.26u l=0.38u
X9761 cml_tlatch_55.xmux.xp.S1 MOT22_P MOT22_N VSS sg13_lv_nmos ad=56.9f pd=0.74u as=56.9f ps=0.74u w=0.17u l=0.17u
X9762 cml_tlatch_51.xmux.xp.S1 cml_tlatch_51.OUTP cml_tlatch_51.OUTN VSS sg13_lv_nmos ad=56.9f pd=0.74u as=56.9f ps=0.74u w=0.17u l=0.17u
X9763 cml_tlatch_88.xmux.xn.S1 cml_tlatch_49.OUTN cml_tlatch_74.INP VSS sg13_lv_nmos ad=63.19999f pd=0.74u as=63.19999f ps=0.74u w=0.26u l=0.38u
X9764 cml_tlatch_97.xmux.xn.S1 cml_tlatch_97.INN cml_tlatch_24.INP VSS sg13_lv_nmos ad=63.19999f pd=0.74u as=63.19999f ps=0.74u w=0.26u l=0.38u
X9765 cml_tlatch_21.xtail.S1 CKA1_P cml_tlatch_21.xmux.xp.S1 VSS sg13_lv_nmos ad=89.3f pd=0.85u as=89.3f ps=0.85u w=0.47u l=0.16u
X9766 MOT20_N cml_tlatch_91.OUTP cml_tlatch_54.xmux.xn.S1 VSS sg13_lv_nmos ad=63.19999f pd=0.74u as=63.19999f ps=0.74u w=0.26u l=0.38u
X9767 MOT2_P MOT2_N cml_tlatch_27.xmux.xp.S1 VSS sg13_lv_nmos ad=56.9f pd=0.74u as=56.9f ps=0.74u w=0.17u l=0.17u
X9768 cml_tlatch_25.xmux.xp.S1 MOT14_P MOT14_N VSS sg13_lv_nmos ad=56.9f pd=0.74u as=56.9f ps=0.74u w=0.17u l=0.17u
X9769 cml_tlatch_69.xmux.xp.S1 cml_tlatch_69.OUTP cml_tlatch_69.OUTN VSS sg13_lv_nmos ad=56.9f pd=0.74u as=56.9f ps=0.74u w=0.17u l=0.17u
X9770 MOT19_N MOT19_P cml_tlatch_78.xmux.xp.S1 VSS sg13_lv_nmos ad=56.9f pd=0.74u as=56.9f ps=0.74u w=0.17u l=0.17u
X9771 cml_tlatch_0.xtail.S1 CKA0_N cml_tlatch_0.xmux.xp.S1 VSS sg13_lv_nmos ad=89.3f pd=0.85u as=89.3f ps=0.85u w=0.47u l=0.16u
X9772 cml_tlatch_95.xtail.S1 CKJ_P cml_tlatch_95.xmux.xn.S1 VSS sg13_lv_nmos ad=89.3f pd=0.85u as=89.3f ps=0.85u w=0.47u l=0.16u
X9773 cml_tlatch_65.OUTN cml_tlatch_65.OUTP cml_tlatch_65.xmux.xp.S1 VSS sg13_lv_nmos ad=56.9f pd=0.74u as=56.9f ps=0.74u w=0.17u l=0.17u
X9774 cml_tlatch_78.xmux.xn.S1 stub_bi_63.BOTN MOT19_N VSS sg13_lv_nmos ad=63.19999f pd=0.74u as=63.19999f ps=0.74u w=0.26u l=0.38u
X9775 cml_tlatch_24.xtail.S1 CKHA1_N cml_tlatch_24.xmux.xp.S1 VSS sg13_lv_nmos ad=89.3f pd=0.85u as=89.3f ps=0.85u w=0.47u l=0.16u
X9776 cml_tlatch_36.xmux.xn.S1 stub_bi_31.BOTP B1_2_P VSS sg13_lv_nmos ad=63.19999f pd=0.74u as=63.19999f ps=0.74u w=0.26u l=0.38u
X9777 cml_tlatch_88.xmux.xp.S1 cml_tlatch_74.INN cml_tlatch_74.INP VSS sg13_lv_nmos ad=56.9f pd=0.74u as=56.9f ps=0.74u w=0.17u l=0.17u
X9778 cml_tlatch_77.xmux.xn.S1 CKHB2_P cml_tlatch_77.xtail.S1 VSS sg13_lv_nmos ad=89.3f pd=0.85u as=89.3f ps=0.85u w=0.47u l=0.16u
X9779 cml_gate2_8.xamp.xn.S1 J2_N ENB_P VSS sg13_lv_nmos ad=0.1007p pd=0.91u as=0.1007p ps=0.91u w=0.53u l=0.13u
X9780 cml_tlatch_36.xmux.xn.S1 stub_bi_31.BOTP B1_2_P VSS sg13_lv_nmos ad=63.19999f pd=0.74u as=63.19999f ps=0.74u w=0.26u l=0.38u
X9781 cml_tlatch_85.xmux.xp.S1 CKA2_P cml_tlatch_85.xtail.S1 VSS sg13_lv_nmos ad=89.3f pd=0.85u as=89.3f ps=0.85u w=0.47u l=0.16u
X9782 MOT11_N MOT11_P cml_tlatch_4.xmux.xp.S1 VSS sg13_lv_nmos ad=56.9f pd=0.74u as=56.9f ps=0.74u w=0.17u l=0.17u
X9783 cml_tlatch_11.xmux.xp.S1 stub_bi_15.BOTN stub_bi_15.BOTP VSS sg13_lv_nmos ad=56.9f pd=0.74u as=56.9f ps=0.74u w=0.17u l=0.17u
X9784 cml_tlatch_46.xmux.xp.S1 stub_bi_38.BOTN stub_bi_38.BOTP VSS sg13_lv_nmos ad=56.9f pd=0.74u as=56.9f ps=0.74u w=0.17u l=0.17u
X9785 cml_tlatch_27.xmux.xn.S1 cml_tlatch_23.OUTN MOT2_P VSS sg13_lv_nmos ad=63.19999f pd=0.74u as=63.19999f ps=0.74u w=0.26u l=0.38u
X9786 hs_to_clk_7.D2 POLN VSS VSS sg13_lv_nmos ad=1.9p pd=10.38u as=1.9p ps=10.38u w=10u l=0.13u
X9787 cml_tlatch_74.INN cml_tlatch_74.INP cml_tlatch_88.xmux.xp.S1 VSS sg13_lv_nmos ad=56.9f pd=0.74u as=56.9f ps=0.74u w=0.17u l=0.17u
X9788 MOT0_N MOT0_P cml_tlatch_26.xmux.xp.S1 VSS sg13_lv_nmos ad=56.9f pd=0.74u as=56.9f ps=0.74u w=0.17u l=0.17u
X9789 cml_tlatch_58.xmux.xn.S1 D3_P cml_tlatch_58.OUTN VSS sg13_lv_nmos ad=63.19999f pd=0.74u as=63.19999f ps=0.74u w=0.26u l=0.38u
X9790 cml_drvb_5.xrtail.R2 GA2_P CKHA2_N VSS sg13_lv_nmos ad=0.1463p pd=1.15u as=0.2618p ps=2.22u w=0.77u l=0.21u
X9791 cml_tlatch_67.OUTP cml_tlatch_67.OUTN cml_tlatch_67.xmux.xp.S1 VSS sg13_lv_nmos ad=56.9f pd=0.74u as=56.9f ps=0.74u w=0.17u l=0.17u
X9792 cml_tlatch_43.INP cml_tlatch_22.OUTN cml_tlatch_21.xmux.xn.S1 VSS sg13_lv_nmos ad=63.19999f pd=0.74u as=0.1082p ps=1.34u w=0.26u l=0.38u
X9793 cml_tlatch_74.INP cml_tlatch_74.INN cml_tlatch_88.xmux.xp.S1 VSS sg13_lv_nmos ad=56.9f pd=0.74u as=56.9f ps=0.74u w=0.17u l=0.17u
X9794 cml_tlatch_25.xtail.S1 CKHA1_N cml_tlatch_25.xmux.xp.S1 VSS sg13_lv_nmos ad=89.3f pd=0.85u as=89.3f ps=0.85u w=0.47u l=0.16u
X9795 cml_tlatch_31.xmux.xn.S1 cml_tlatch_32.OUTN B0_2_P VSS sg13_lv_nmos ad=63.19999f pd=0.74u as=63.19999f ps=0.74u w=0.26u l=0.38u
X9796 cml_tlatch_13.xmux.xp.S1 stub_bi_17.BOTP stub_bi_17.BOTN VSS sg13_lv_nmos ad=56.9f pd=0.74u as=56.9f ps=0.74u w=0.17u l=0.17u
X9797 cml_tlatch_52.xtail.S1 POLN VSS VSS sg13_lv_nmos ad=1.5637p pd=8.61u as=2.7982p ps=17.14u w=8.23u l=0.13u
X9798 cml_tlatch_43.xmux.xp.S1 MOT10_P MOT10_N VSS sg13_lv_nmos ad=56.9f pd=0.74u as=56.9f ps=0.74u w=0.17u l=0.17u
X9799 A1_8_P A1_8_N cml_tlatch_19.xmux.xp.S1 VSS sg13_lv_nmos ad=56.9f pd=0.74u as=56.9f ps=0.74u w=0.17u l=0.17u
X9800 cml_gate2_1.xrtail.R1 CKA0_P cml_gate2_1.xamp.xn.S1 VSS sg13_lv_nmos ad=0.1007p pd=0.91u as=0.1802p ps=1.74u w=0.53u l=0.13u
X9801 cml_tlatch_56.xmux.xn.S1 CKA3_P cml_tlatch_56.xtail.S1 VSS sg13_lv_nmos ad=89.3f pd=0.85u as=89.3f ps=0.85u w=0.47u l=0.16u
X9802 GB2_P ENB0_N cml_gate2_7.xamp.xn.S1 VSS sg13_lv_nmos ad=0.1007p pd=0.91u as=0.1007p ps=0.91u w=0.53u l=0.13u
X9803 cml_tlatch_15.xmux.xp.S1 MOT3_N MOT3_P VSS sg13_lv_nmos ad=56.9f pd=0.74u as=56.9f ps=0.74u w=0.17u l=0.17u
X9804 cml_tlatch_40.xmux.xp.S1 CKA1_P cml_tlatch_40.xtail.S1 VSS sg13_lv_nmos ad=89.3f pd=0.85u as=89.3f ps=0.85u w=0.47u l=0.16u
X9805 cml_tlatch_82.xmux.xn.S1 CKB2_P cml_tlatch_82.xtail.S1 VSS sg13_lv_nmos ad=89.3f pd=0.85u as=89.3f ps=0.85u w=0.47u l=0.16u
X9806 cml_tlatch_2.OUTN cml_tlatch_7.OUTP cml_tlatch_2.xmux.xn.S1 VSS sg13_lv_nmos ad=63.19999f pd=0.74u as=63.19999f ps=0.74u w=0.26u l=0.38u
X9807 cml_tlatch_20.xmux.xn.S1 cml_tlatch_43.INN cml_tlatch_20.OUTP VSS sg13_lv_nmos ad=63.19999f pd=0.74u as=63.19999f ps=0.74u w=0.26u l=0.38u
X9808 cml_tlatch_51.xtail.S1 CKB3_N cml_tlatch_51.xmux.xp.S1 VSS sg13_lv_nmos ad=89.3f pd=0.85u as=89.3f ps=0.85u w=0.47u l=0.16u
X9809 cml_tlatch_69.xmux.xn.S1 CKA3_P cml_tlatch_69.xtail.S1 VSS sg13_lv_nmos ad=89.3f pd=0.85u as=89.3f ps=0.85u w=0.47u l=0.16u
X9810 cml_tlatch_2.xmux.xp.S1 cml_tlatch_2.OUTP cml_tlatch_2.OUTN VSS sg13_lv_nmos ad=56.9f pd=0.74u as=56.9f ps=0.74u w=0.17u l=0.17u
X9811 GA0_P CKB0_N cml_gate2_3.xrtail.R1 VSS sg13_lv_nmos ad=0.1007p pd=0.91u as=0.1007p ps=0.91u w=0.53u l=0.13u
X9812 cml_tlatch_49.OUTP B3_2_N cml_tlatch_49.xmux.xn.S1 VSS sg13_lv_nmos ad=63.19999f pd=0.74u as=63.19999f ps=0.74u w=0.26u l=0.38u
X9813 MOT30_P A3_2_N cml_tlatch_45.xmux.xn.S1 VSS sg13_lv_nmos ad=63.19999f pd=0.74u as=63.19999f ps=0.74u w=0.26u l=0.38u
X9814 cml_tlatch_5.xtail.S1 POLN VSS VSS sg13_lv_nmos ad=1.5637p pd=8.61u as=1.5637p ps=8.61u w=8.23u l=0.13u
X9815 A0_2_N A0_2_P cml_tlatch_34.xmux.xp.S1 VSS sg13_lv_nmos ad=56.9f pd=0.74u as=56.9f ps=0.74u w=0.17u l=0.17u
X9816 MOT16_P MOT16_N cml_tlatch_52.xmux.xp.S1 VSS sg13_lv_nmos ad=56.9f pd=0.74u as=56.9f ps=0.74u w=0.17u l=0.17u
X9817 VSS hs_to_clk_7.sg13_lv_nmos_2HGZLP_0.G VSS VSS sg13_lv_nmos ad=2.071p pd=11.28u as=0 ps=0 w=10.9u l=1.38u
X9818 cml_tlatch_13.xmux.xn.S1 cml_tlatch_5.INN stub_bi_17.BOTN VSS sg13_lv_nmos ad=0.1082p pd=1.34u as=63.19999f ps=0.74u w=0.26u l=0.38u
X9819 cml_tlatch_60.xmux.xn.S1 cml_tlatch_61.OUTP A2_2_N VSS sg13_lv_nmos ad=63.19999f pd=0.74u as=63.19999f ps=0.74u w=0.26u l=0.38u
X9820 cml_tlatch_96.xmux.xp.S1 cml_tlatch_5.INN cml_tlatch_5.INP VSS sg13_lv_nmos ad=56.9f pd=0.74u as=56.9f ps=0.74u w=0.17u l=0.17u
X9821 cml_tlatch_49.xmux.xn.S1 CKB3_P cml_tlatch_49.xtail.S1 VSS sg13_lv_nmos ad=89.3f pd=0.85u as=89.3f ps=0.85u w=0.47u l=0.16u
X9822 cml_tlatch_44.xtail.S1 CKHA3_P cml_tlatch_44.xmux.xn.S1 VSS sg13_lv_nmos ad=89.3f pd=0.85u as=89.3f ps=0.85u w=0.47u l=0.16u
X9823 cml_tlatch_14.xmux.xp.S1 MOT1_P MOT1_N VSS sg13_lv_nmos ad=56.9f pd=0.74u as=56.9f ps=0.74u w=0.17u l=0.17u
X9824 cml_tlatch_29.xmux.xn.S1 CKHA0_P cml_tlatch_29.xtail.S1 VSS sg13_lv_nmos ad=89.3f pd=0.85u as=89.3f ps=0.85u w=0.47u l=0.16u
X9825 cml_tlatch_87.xmux.xp.S1 cml_tlatch_87.OUTN cml_tlatch_87.OUTP VSS sg13_lv_nmos ad=56.9f pd=0.74u as=56.9f ps=0.74u w=0.17u l=0.17u
X9826 cml_tlatch_99.xtail.S1 CKA0_N cml_tlatch_99.xmux.xn.S1 VSS sg13_lv_nmos ad=89.3f pd=0.85u as=89.3f ps=0.85u w=0.47u l=0.16u
X9827 ENB_N J2_P cml_gate2_8.xamp.xn.S1 VSS sg13_lv_nmos ad=0.1007p pd=0.91u as=0.1007p ps=0.91u w=0.53u l=0.13u
X9828 MOT30_N MOT30_P cml_tlatch_45.xmux.xp.S1 VSS sg13_lv_nmos ad=56.9f pd=0.74u as=56.9f ps=0.74u w=0.17u l=0.17u
X9829 cml_tlatch_37.xmux.xn.S1 D1_P stub_bi_31.BOTP VSS sg13_lv_nmos ad=63.19999f pd=0.74u as=0.1082p ps=1.34u w=0.26u l=0.38u
X9830 cml_tlatch_92.xtail.S1 CKJ_N cml_tlatch_92.xmux.xn.S1 VSS sg13_lv_nmos ad=89.3f pd=0.85u as=89.3f ps=0.85u w=0.47u l=0.16u
X9831 cml_tlatch_34.xmux.xp.S1 CKA0_P cml_tlatch_34.xtail.S1 VSS sg13_lv_nmos ad=89.3f pd=0.85u as=89.3f ps=0.85u w=0.47u l=0.16u
X9832 J4_N CLK_W_N cml_tlatch_92.xmux.xn.S1 VSS sg13_lv_nmos ad=63.19999f pd=0.74u as=63.19999f ps=0.74u w=0.26u l=0.38u
X9833 cml_tlatch_25.xmux.xp.S1 MOT14_P MOT14_N VSS sg13_lv_nmos ad=56.9f pd=0.74u as=56.9f ps=0.74u w=0.17u l=0.17u
X9834 cml_tlatch_87.INN cml_tlatch_87.INP cml_tlatch_76.xmux.xp.S1 VSS sg13_lv_nmos ad=56.9f pd=0.74u as=56.9f ps=0.74u w=0.17u l=0.17u
X9835 cml_gate2_0.xamp.xn.S1 ENB1_N GB1_P VSS sg13_lv_nmos ad=0.1007p pd=0.91u as=0.1007p ps=0.91u w=0.53u l=0.13u
X9836 stub_bi_15.BOTN stub_bi_15.BOTP cml_tlatch_11.xmux.xp.S1 VSS sg13_lv_nmos ad=56.9f pd=0.74u as=56.9f ps=0.74u w=0.17u l=0.17u
X9837 stub_bi_17.BOTP cml_tlatch_5.INP cml_tlatch_13.xmux.xn.S1 VSS sg13_lv_nmos ad=63.19999f pd=0.74u as=63.19999f ps=0.74u w=0.26u l=0.38u
X9838 cml_tlatch_73.INN cml_tlatch_73.INP cml_tlatch_66.xmux.xp.S1 VSS sg13_lv_nmos ad=56.9f pd=0.74u as=56.9f ps=0.74u w=0.17u l=0.17u
X9839 cml_tlatch_60.xmux.xp.S1 A2_2_N A2_2_P VSS sg13_lv_nmos ad=56.9f pd=0.74u as=56.9f ps=0.74u w=0.17u l=0.17u
X9840 MOT13_N cml_tlatch_5.INP cml_tlatch_5.xmux.xn.S1 VSS sg13_lv_nmos ad=63.19999f pd=0.74u as=63.19999f ps=0.74u w=0.26u l=0.38u
X9841 cml_tlatch_26.xmux.xp.S1 MOT0_N MOT0_P VSS sg13_lv_nmos ad=56.9f pd=0.74u as=56.9f ps=0.74u w=0.17u l=0.17u
X9842 VSS POLN hs_to_clk_3.D2 VSS sg13_lv_nmos ad=1.9p pd=10.38u as=1.9p ps=10.38u w=10u l=0.13u
X9843 cml_tlatch_91.OUTP cml_tlatch_91.OUTN cml_tlatch_91.xmux.xp.S1 VSS sg13_lv_nmos ad=56.9f pd=0.74u as=0.1019p ps=1.34u w=0.17u l=0.17u
X9844 MOT7_N MOT7_P cml_tlatch_17.xmux.xp.S1 VSS sg13_lv_nmos ad=56.9f pd=0.74u as=56.9f ps=0.74u w=0.17u l=0.17u
X9845 cml_tlatch_77.xmux.xp.S1 MOT17_P MOT17_N VSS sg13_lv_nmos ad=56.9f pd=0.74u as=56.9f ps=0.74u w=0.17u l=0.17u
X9846 cml_gate2_4.xamp.xn.S1 CKB3_P cml_gate2_4.xrtail.R1 VSS sg13_lv_nmos ad=0.1007p pd=0.91u as=0.1007p ps=0.91u w=0.53u l=0.13u
X9847 MOT13_N cml_tlatch_5.INP cml_tlatch_5.xmux.xn.S1 VSS sg13_lv_nmos ad=63.19999f pd=0.74u as=63.19999f ps=0.74u w=0.26u l=0.38u
X9848 cml_tlatch_42.xmux.xn.S1 A1_8_N MOT8_P VSS sg13_lv_nmos ad=63.19999f pd=0.74u as=63.19999f ps=0.74u w=0.26u l=0.38u
X9849 MOT11_N MOT11_P cml_tlatch_4.xmux.xp.S1 VSS sg13_lv_nmos ad=56.9f pd=0.74u as=56.9f ps=0.74u w=0.17u l=0.17u
X9850 cml_tlatch_97.INN cml_tlatch_97.INP cml_tlatch_39.xmux.xp.S1 VSS sg13_lv_nmos ad=56.9f pd=0.74u as=56.9f ps=0.74u w=0.17u l=0.17u
X9851 cml_tlatch_12.xmux.xp.S1 cml_tlatch_4.INP cml_tlatch_4.INN VSS sg13_lv_nmos ad=56.9f pd=0.74u as=56.9f ps=0.74u w=0.17u l=0.17u
X9852 MOT5_P MOT5_N cml_tlatch_16.xmux.xp.S1 VSS sg13_lv_nmos ad=56.9f pd=0.74u as=56.9f ps=0.74u w=0.17u l=0.17u
X9853 cml_tlatch_65.xmux.xp.S1 CKB3_N cml_tlatch_65.xtail.S1 VSS sg13_lv_nmos ad=89.3f pd=0.85u as=89.3f ps=0.85u w=0.47u l=0.16u
X9854 cml_tlatch_42.xmux.xp.S1 MOT8_P MOT8_N VSS sg13_lv_nmos ad=56.9f pd=0.74u as=56.9f ps=0.74u w=0.17u l=0.17u
X9855 MOT20_P MOT20_N cml_tlatch_54.xmux.xp.S1 VSS sg13_lv_nmos ad=56.9f pd=0.74u as=56.9f ps=0.74u w=0.17u l=0.17u
X9856 MOT19_P MOT19_N cml_tlatch_78.xmux.xp.S1 VSS sg13_lv_nmos ad=56.9f pd=0.74u as=0.1019p ps=1.34u w=0.17u l=0.17u
X9857 cml_tlatch_30.xmux.xn.S1 CKB0_P cml_tlatch_30.xtail.S1 VSS sg13_lv_nmos ad=89.3f pd=0.85u as=89.3f ps=0.85u w=0.47u l=0.16u
X9858 cml_tlatch_44.xmux.xp.S1 MOT28_N MOT28_P VSS sg13_lv_nmos ad=56.9f pd=0.74u as=56.9f ps=0.74u w=0.17u l=0.17u
X9859 cml_tlatch_65.OUTP cml_tlatch_65.OUTN cml_tlatch_65.xmux.xp.S1 VSS sg13_lv_nmos ad=56.9f pd=0.74u as=56.9f ps=0.74u w=0.17u l=0.17u
X9860 VSS hs_to_clk_8.sg13_lv_nmos_2HGZLP_0.G VSS VSS sg13_lv_nmos ad=2.071p pd=11.28u as=0 ps=0 w=10.9u l=1.38u
X9861 cml_tlatch_77.xmux.xp.S1 MOT17_N MOT17_P VSS sg13_lv_nmos ad=56.9f pd=0.74u as=56.9f ps=0.74u w=0.17u l=0.17u
X9862 cml_tlatch_64.xmux.xp.S1 B3_8_N B3_8_P VSS sg13_lv_nmos ad=56.9f pd=0.74u as=56.9f ps=0.74u w=0.17u l=0.17u
X9863 cml_tlatch_69.OUTN cml_tlatch_63.INP cml_tlatch_69.xmux.xn.S1 VSS sg13_lv_nmos ad=0.1082p pd=1.34u as=63.19999f ps=0.74u w=0.26u l=0.38u
X9864 cml_tlatch_32.OUTN cml_tlatch_32.OUTP cml_tlatch_32.xmux.xp.S1 VSS sg13_lv_nmos ad=56.9f pd=0.74u as=56.9f ps=0.74u w=0.17u l=0.17u
X9865 cml_tlatch_58.xtail.S1 CKA3_P cml_tlatch_58.xmux.xn.S1 VSS sg13_lv_nmos ad=89.3f pd=0.85u as=89.3f ps=0.85u w=0.47u l=0.16u
X9866 VSS POLN hs_to_clk_0.D2 VSS sg13_lv_nmos ad=1.9p pd=10.38u as=1.9p ps=10.38u w=10u l=0.13u
X9867 cml_tlatch_95.xmux.xn.S1 CKJ_P cml_tlatch_95.xtail.S1 VSS sg13_lv_nmos ad=89.3f pd=0.85u as=0.1598p ps=1.62u w=0.47u l=0.16u
X9868 cml_tlatch_38.xmux.xp.S1 CKA0_N cml_tlatch_38.xtail.S1 VSS sg13_lv_nmos ad=89.3f pd=0.85u as=89.3f ps=0.85u w=0.47u l=0.16u
X9869 cml_tlatch_28.xmux.xp.S1 MOT4_P MOT4_N VSS sg13_lv_nmos ad=56.9f pd=0.74u as=56.9f ps=0.74u w=0.17u l=0.17u
X9870 cml_tlatch_63.xmux.xp.S1 CKHA3_N cml_tlatch_63.xtail.S1 VSS sg13_lv_nmos ad=89.3f pd=0.85u as=89.3f ps=0.85u w=0.47u l=0.16u
X9871 cml_tlatch_52.xmux.xp.S1 CKHA2_N cml_tlatch_52.xtail.S1 VSS sg13_lv_nmos ad=0.1598p pd=1.62u as=89.3f ps=0.85u w=0.47u l=0.16u
X9872 cml_tlatch_1.xmux.xp.S1 B0_8_P B0_8_N VSS sg13_lv_nmos ad=56.9f pd=0.74u as=56.9f ps=0.74u w=0.17u l=0.17u
X9873 cml_tlatch_62.xmux.xp.S1 MOT24_P MOT24_N VSS sg13_lv_nmos ad=56.9f pd=0.74u as=56.9f ps=0.74u w=0.17u l=0.17u
X9874 cml_tlatch_2.xmux.xp.S1 CKB0_N cml_tlatch_2.xtail.S1 VSS sg13_lv_nmos ad=89.3f pd=0.85u as=89.3f ps=0.85u w=0.47u l=0.16u
X9875 cml_tlatch_33.OUTN cml_tlatch_33.OUTP cml_tlatch_33.xmux.xp.S1 VSS sg13_lv_nmos ad=56.9f pd=0.74u as=56.9f ps=0.74u w=0.17u l=0.17u
X9876 cml_tlatch_91.OUTP cml_tlatch_91.OUTN cml_tlatch_91.xmux.xp.S1 VSS sg13_lv_nmos ad=56.9f pd=0.74u as=56.9f ps=0.74u w=0.17u l=0.17u
X9877 cml_tlatch_76.xmux.xp.S1 CKA2_N cml_tlatch_76.xtail.S1 VSS sg13_lv_nmos ad=89.3f pd=0.85u as=89.3f ps=0.85u w=0.47u l=0.16u
X9878 MOT21_P stub_bi_55.BOTP cml_tlatch_79.xmux.xn.S1 VSS sg13_lv_nmos ad=63.19999f pd=0.74u as=63.19999f ps=0.74u w=0.26u l=0.38u
X9879 stub_bi_29.BOTP B1_2_P cml_tlatch_35.xmux.xn.S1 VSS sg13_lv_nmos ad=63.19999f pd=0.74u as=63.19999f ps=0.74u w=0.26u l=0.38u
X9880 cml_tlatch_73.xmux.xn.S1 cml_tlatch_73.INN MOT27_P VSS sg13_lv_nmos ad=63.19999f pd=0.74u as=63.19999f ps=0.74u w=0.26u l=0.38u
X9881 cml_tlatch_2.xmux.xp.S1 cml_tlatch_2.OUTP cml_tlatch_2.OUTN VSS sg13_lv_nmos ad=56.9f pd=0.74u as=56.9f ps=0.74u w=0.17u l=0.17u
X9882 cml_tlatch_65.xmux.xp.S1 cml_tlatch_65.OUTN cml_tlatch_65.OUTP VSS sg13_lv_nmos ad=56.9f pd=0.74u as=56.9f ps=0.74u w=0.17u l=0.17u
X9883 cml_tlatch_81.xmux.xp.S1 B2_8_P B2_8_N VSS sg13_lv_nmos ad=56.9f pd=0.74u as=56.9f ps=0.74u w=0.17u l=0.17u
X9884 MOT1_P MOT1_N cml_tlatch_14.xmux.xp.S1 VSS sg13_lv_nmos ad=56.9f pd=0.74u as=56.9f ps=0.74u w=0.17u l=0.17u
X9885 cml_tlatch_88.xtail.S1 CKB3_P cml_tlatch_88.xmux.xp.S1 VSS sg13_lv_nmos ad=89.3f pd=0.85u as=89.3f ps=0.85u w=0.47u l=0.16u
X9886 stub_bi_31.BOTN stub_bi_31.BOTP cml_tlatch_37.xmux.xp.S1 VSS sg13_lv_nmos ad=56.9f pd=0.74u as=56.9f ps=0.74u w=0.17u l=0.17u
X9887 cml_gate2_6.xamp.xn.S1 ENB0_P GB3_N VSS sg13_lv_nmos ad=0.1007p pd=0.91u as=0.1007p ps=0.91u w=0.53u l=0.13u
X9888 A1_2_P A1_2_N cml_tlatch_40.xmux.xp.S1 VSS sg13_lv_nmos ad=56.9f pd=0.74u as=56.9f ps=0.74u w=0.17u l=0.17u
X9889 VDD MOT16_P VSS rppd l=5.17u w=1u
X9890 MOT16_P MOT16_N cml_tlatch_52.xmux.xp.S1 VSS sg13_lv_nmos ad=56.9f pd=0.74u as=56.9f ps=0.74u w=0.17u l=0.17u
X9891 A0_2_N A0_2_P cml_tlatch_34.xmux.xp.S1 VSS sg13_lv_nmos ad=56.9f pd=0.74u as=56.9f ps=0.74u w=0.17u l=0.17u
X9892 cml_tlatch_62.xmux.xp.S1 MOT24_N MOT24_P VSS sg13_lv_nmos ad=56.9f pd=0.74u as=56.9f ps=0.74u w=0.17u l=0.17u
X9893 MOT19_P MOT19_N cml_tlatch_78.xmux.xp.S1 VSS sg13_lv_nmos ad=56.9f pd=0.74u as=56.9f ps=0.74u w=0.17u l=0.17u
X9894 MOT1_P B0_8_N cml_tlatch_14.xmux.xn.S1 VSS sg13_lv_nmos ad=63.19999f pd=0.74u as=0.1082p ps=1.34u w=0.26u l=0.38u
X9895 cml_tlatch_57.xtail.S1 CKA3_P cml_tlatch_57.xmux.xp.S1 VSS sg13_lv_nmos ad=89.3f pd=0.85u as=89.3f ps=0.85u w=0.47u l=0.16u
X9896 VSS hs_to_clk_0.sg13_lv_nmos_2HGZLP_0.G VSS VSS sg13_lv_nmos ad=2.071p pd=11.28u as=0 ps=0 w=10.9u l=1.38u
X9897 stub_bi_43.BOTP stub_bi_43.BOTN cml_tlatch_48.xmux.xp.S1 VSS sg13_lv_nmos ad=56.9f pd=0.74u as=56.9f ps=0.74u w=0.17u l=0.17u
X9898 cml_tlatch_84.xmux.xp.S1 CKB2_N cml_tlatch_84.xtail.S1 VSS sg13_lv_nmos ad=89.3f pd=0.85u as=89.3f ps=0.85u w=0.47u l=0.16u
X9899 cml_tlatch_81.xmux.xn.S1 stub_bi_62.BOTP B2_8_P VSS sg13_lv_nmos ad=63.19999f pd=0.74u as=0.1082p ps=1.34u w=0.26u l=0.38u
X9900 cml_tlatch_14.xmux.xn.S1 B0_8_P MOT1_N VSS sg13_lv_nmos ad=63.19999f pd=0.74u as=63.19999f ps=0.74u w=0.26u l=0.38u
X9901 cml_tlatch_23.OUTP cml_tlatch_23.OUTN cml_tlatch_23.xmux.xp.S1 VSS sg13_lv_nmos ad=56.9f pd=0.74u as=56.9f ps=0.74u w=0.17u l=0.17u
X9902 cml_drvb_8.xrtail.R2 J4_N NS1_N VSS sg13_lv_nmos ad=0.1463p pd=1.15u as=0.2618p ps=2.22u w=0.77u l=0.21u
X9903 cml_tlatch_71.xmux.xp.S1 CKA3_N cml_tlatch_71.xtail.S1 VSS sg13_lv_nmos ad=89.3f pd=0.85u as=89.3f ps=0.85u w=0.47u l=0.16u
X9904 cml_tlatch_44.xtail.S1 CKHA3_N cml_tlatch_44.xmux.xp.S1 VSS sg13_lv_nmos ad=0.1598p pd=1.62u as=89.3f ps=0.85u w=0.47u l=0.16u
X9905 VDD MOT7_N VSS rppd l=5.17u w=1u
X9906 cml_tlatch_79.xmux.xp.S1 MOT21_N MOT21_P VSS sg13_lv_nmos ad=56.9f pd=0.74u as=56.9f ps=0.74u w=0.17u l=0.17u
X9907 B2_8_N stub_bi_62.BOTN cml_tlatch_81.xmux.xn.S1 VSS sg13_lv_nmos ad=63.19999f pd=0.74u as=63.19999f ps=0.74u w=0.26u l=0.38u
X9908 B1_2_N B1_2_P cml_tlatch_36.xmux.xp.S1 VSS sg13_lv_nmos ad=56.9f pd=0.74u as=0.1019p ps=1.34u w=0.17u l=0.17u
X9909 MOT29_P MOT29_N cml_tlatch_74.xmux.xp.S1 VSS sg13_lv_nmos ad=56.9f pd=0.74u as=56.9f ps=0.74u w=0.17u l=0.17u
X9910 cml_tlatch_46.xmux.xp.S1 stub_bi_38.BOTP stub_bi_38.BOTN VSS sg13_lv_nmos ad=56.9f pd=0.74u as=56.9f ps=0.74u w=0.17u l=0.17u
X9911 cml_tlatch_61.xtail.S1 POLN VSS VSS sg13_lv_nmos ad=1.5637p pd=8.61u as=2.7982p ps=17.14u w=8.23u l=0.13u
X9912 cml_tlatch_86.OUTN cml_tlatch_86.OUTP cml_tlatch_86.xmux.xp.S1 VSS sg13_lv_nmos ad=56.9f pd=0.74u as=56.9f ps=0.74u w=0.17u l=0.17u
X9913 cml_tlatch_39.xmux.xp.S1 CKA1_N cml_tlatch_39.xtail.S1 VSS sg13_lv_nmos ad=89.3f pd=0.85u as=89.3f ps=0.85u w=0.47u l=0.16u
X9914 cml_tlatch_49.xmux.xp.S1 cml_tlatch_49.OUTP cml_tlatch_49.OUTN VSS sg13_lv_nmos ad=56.9f pd=0.74u as=56.9f ps=0.74u w=0.17u l=0.17u
X9915 cml_tlatch_51.OUTP cml_tlatch_51.OUTN cml_tlatch_51.xmux.xp.S1 VSS sg13_lv_nmos ad=56.9f pd=0.74u as=56.9f ps=0.74u w=0.17u l=0.17u
X9916 GA1_P CKB1_N cml_gate2_2.xrtail.R1 VSS sg13_lv_nmos ad=0.1007p pd=0.91u as=0.1007p ps=0.91u w=0.53u l=0.13u
X9917 cml_tlatch_75.xtail.S1 CKHB3_P cml_tlatch_75.xmux.xn.S1 VSS sg13_lv_nmos ad=89.3f pd=0.85u as=89.3f ps=0.85u w=0.47u l=0.16u
X9918 cml_tlatch_29.xtail.S1 POLN VSS VSS sg13_lv_nmos ad=1.5637p pd=8.61u as=2.7982p ps=17.14u w=8.23u l=0.13u
X9919 cml_tlatch_5.xmux.xp.S1 MOT13_N MOT13_P VSS sg13_lv_nmos ad=56.9f pd=0.74u as=56.9f ps=0.74u w=0.17u l=0.17u
X9920 cml_tlatch_89.xmux.xp.S1 cml_tlatch_44.INP cml_tlatch_44.INN VSS sg13_lv_nmos ad=56.9f pd=0.74u as=56.9f ps=0.74u w=0.17u l=0.17u
X9921 cml_tlatch_0.xmux.xp.S1 cml_tlatch_0.OUTP cml_tlatch_0.OUTN VSS sg13_lv_nmos ad=56.9f pd=0.74u as=56.9f ps=0.74u w=0.17u l=0.17u
X9922 ENA_N J1_P cml_gate2_9.xamp.xn.S1 VSS sg13_lv_nmos ad=0.1007p pd=0.91u as=0.1007p ps=0.91u w=0.53u l=0.13u
X9923 MOT5_N MOT5_P cml_tlatch_16.xmux.xp.S1 VSS sg13_lv_nmos ad=56.9f pd=0.74u as=56.9f ps=0.74u w=0.17u l=0.17u
X9924 cml_tlatch_3.xmux.xn.S1 B1_8_N MOT9_P VSS sg13_lv_nmos ad=0.1082p pd=1.34u as=63.19999f ps=0.74u w=0.26u l=0.38u
X9925 cml_tlatch_22.OUTN cml_tlatch_22.OUTP cml_tlatch_22.xmux.xp.S1 VSS sg13_lv_nmos ad=56.9f pd=0.74u as=56.9f ps=0.74u w=0.17u l=0.17u
X9926 cml_tlatch_63.INN cml_tlatch_71.OUTP cml_tlatch_70.xmux.xn.S1 VSS sg13_lv_nmos ad=63.19999f pd=0.74u as=0.1082p ps=1.34u w=0.26u l=0.38u
X9927 cml_tlatch_90.xmux.xn.S1 stub_bi_38.BOTN stub_bi_55.BOTP VSS sg13_lv_nmos ad=63.19999f pd=0.74u as=63.19999f ps=0.74u w=0.26u l=0.38u
X9928 cml_tlatch_24.xtail.S1 CKHA1_N cml_tlatch_24.xmux.xp.S1 VSS sg13_lv_nmos ad=89.3f pd=0.85u as=89.3f ps=0.85u w=0.47u l=0.16u
X9929 cml_tlatch_15.xtail.S1 CKHB0_P cml_tlatch_15.xmux.xn.S1 VSS sg13_lv_nmos ad=89.3f pd=0.85u as=89.3f ps=0.85u w=0.47u l=0.16u
X9930 MOT25_N MOT25_P cml_tlatch_72.xmux.xp.S1 VSS sg13_lv_nmos ad=56.9f pd=0.74u as=56.9f ps=0.74u w=0.17u l=0.17u
X9931 cml_tlatch_35.xmux.xp.S1 CKB1_N cml_tlatch_35.xtail.S1 VSS sg13_lv_nmos ad=89.3f pd=0.85u as=89.3f ps=0.85u w=0.47u l=0.16u
X9932 cml_tlatch_91.xmux.xn.S1 cml_tlatch_91.INN cml_tlatch_91.OUTP VSS sg13_lv_nmos ad=63.19999f pd=0.74u as=63.19999f ps=0.74u w=0.26u l=0.38u
X9933 cml_drv_3.xrtail.R1 ENA_N ENA0_P VSS sg13_lv_nmos ad=0.1012p pd=1.34u as=56.2f ps=0.74u w=0.16u l=0.19u
X9934 cml_tlatch_7.OUTN cml_tlatch_7.OUTP cml_tlatch_7.xmux.xp.S1 VSS sg13_lv_nmos ad=56.9f pd=0.74u as=56.9f ps=0.74u w=0.17u l=0.17u
X9935 cml_tlatch_99.xmux.xp.S1 cml_tlatch_99.OUTP cml_tlatch_99.OUTN VSS sg13_lv_nmos ad=56.9f pd=0.74u as=56.9f ps=0.74u w=0.17u l=0.17u
X9936 cml_tlatch_33.xmux.xp.S1 cml_tlatch_33.OUTN cml_tlatch_33.OUTP VSS sg13_lv_nmos ad=56.9f pd=0.74u as=56.9f ps=0.74u w=0.17u l=0.17u
X9937 cml_drv_2.xrtail.R1 ENB_N ENB0_P VSS sg13_lv_nmos ad=56.2f pd=0.74u as=56.2f ps=0.74u w=0.16u l=0.19u
X9938 cml_tlatch_84.xmux.xp.S1 stub_bi_49.BOTP stub_bi_49.BOTN VSS sg13_lv_nmos ad=56.9f pd=0.74u as=56.9f ps=0.74u w=0.17u l=0.17u
X9939 hs_to_clk_0.D2 CK_N CKA0_N VSS sg13_lv_nmos ad=0.228p pd=1.58u as=0.228p ps=1.58u w=1.2u l=0.2u
X9940 cml_tlatch_92.xmux.xn.S1 CKJ_N cml_tlatch_92.xtail.S1 VSS sg13_lv_nmos ad=89.3f pd=0.85u as=89.3f ps=0.85u w=0.47u l=0.16u
X9941 cml_tlatch_77.xmux.xp.S1 MOT17_N MOT17_P VSS sg13_lv_nmos ad=56.9f pd=0.74u as=56.9f ps=0.74u w=0.17u l=0.17u
X9942 cml_tlatch_24.INN cml_tlatch_24.INP cml_tlatch_97.xmux.xp.S1 VSS sg13_lv_nmos ad=56.9f pd=0.74u as=56.9f ps=0.74u w=0.17u l=0.17u
X9943 A2_8_P A2_8_N cml_tlatch_85.xmux.xp.S1 VSS sg13_lv_nmos ad=56.9f pd=0.74u as=56.9f ps=0.74u w=0.17u l=0.17u
X9944 cml_tlatch_51.xmux.xp.S1 cml_tlatch_51.OUTN cml_tlatch_51.OUTP VSS sg13_lv_nmos ad=56.9f pd=0.74u as=56.9f ps=0.74u w=0.17u l=0.17u
X9945 B1_2_N B1_2_P cml_tlatch_36.xmux.xp.S1 VSS sg13_lv_nmos ad=56.9f pd=0.74u as=56.9f ps=0.74u w=0.17u l=0.17u
X9946 cml_tlatch_57.xmux.xp.S1 A3_2_N A3_2_P VSS sg13_lv_nmos ad=56.9f pd=0.74u as=56.9f ps=0.74u w=0.17u l=0.17u
X9947 cml_tlatch_30.xtail.S1 POLN VSS VSS sg13_lv_nmos ad=1.5637p pd=8.61u as=2.7982p ps=17.14u w=8.23u l=0.13u
X9948 cml_tlatch_25.xtail.S1 POLN VSS VSS sg13_lv_nmos ad=1.5637p pd=8.61u as=1.5637p ps=8.61u w=8.23u l=0.13u
X9949 cml_tlatch_28.xmux.xp.S1 MOT4_P MOT4_N VSS sg13_lv_nmos ad=56.9f pd=0.74u as=56.9f ps=0.74u w=0.17u l=0.17u
X9950 cml_tlatch_83.xmux.xp.S1 stub_bi_63.BOTN stub_bi_63.BOTP VSS sg13_lv_nmos ad=56.9f pd=0.74u as=56.9f ps=0.74u w=0.17u l=0.17u
X9951 cml_tlatch_3.xmux.xp.S1 MOT9_N MOT9_P VSS sg13_lv_nmos ad=56.9f pd=0.74u as=56.9f ps=0.74u w=0.17u l=0.17u
X9952 cml_tlatch_2.OUTN cml_tlatch_7.OUTP cml_tlatch_2.xmux.xn.S1 VSS sg13_lv_nmos ad=63.19999f pd=0.74u as=63.19999f ps=0.74u w=0.26u l=0.38u
X9953 cml_tlatch_36.xmux.xp.S1 B1_2_N B1_2_P VSS sg13_lv_nmos ad=56.9f pd=0.74u as=56.9f ps=0.74u w=0.17u l=0.17u
X9954 VSS POLN cml_tlatch_56.xtail.S1 VSS sg13_lv_nmos ad=2.7982p pd=17.14u as=1.5637p ps=8.61u w=8.23u l=0.13u
X9955 cml_tlatch_95.xmux.xp.S1 CKJ_N cml_tlatch_95.xtail.S1 VSS sg13_lv_nmos ad=89.3f pd=0.85u as=89.3f ps=0.85u w=0.47u l=0.16u
X9956 cml_tlatch_8.xmux.xp.S1 cml_tlatch_8.OUTN cml_tlatch_8.OUTP VSS sg13_lv_nmos ad=56.9f pd=0.74u as=56.9f ps=0.74u w=0.17u l=0.17u
X9957 MOT15_N MOT15_P cml_tlatch_6.xmux.xp.S1 VSS sg13_lv_nmos ad=56.9f pd=0.74u as=56.9f ps=0.74u w=0.17u l=0.17u
X9958 cml_drvb_7.xrtail.R2 GB2_P CKHB2_N VSS sg13_lv_nmos ad=0.1463p pd=1.15u as=0.2618p ps=2.22u w=0.77u l=0.21u
X9959 cml_tlatch_20.xmux.xp.S1 cml_tlatch_20.OUTP cml_tlatch_20.OUTN VSS sg13_lv_nmos ad=56.9f pd=0.74u as=56.9f ps=0.74u w=0.17u l=0.17u
X9960 cml_tlatch_74.INP VDD VSS rppd l=5.17u w=1u
X9961 cml_tlatch_18.OUTP cml_tlatch_18.OUTN cml_tlatch_18.xmux.xp.S1 VSS sg13_lv_nmos ad=56.9f pd=0.74u as=56.9f ps=0.74u w=0.17u l=0.17u
X9962 cml_tlatch_71.OUTP cml_tlatch_71.OUTN cml_tlatch_71.xmux.xp.S1 VSS sg13_lv_nmos ad=56.9f pd=0.74u as=0.1019p ps=1.34u w=0.17u l=0.17u
X9963 cml_tlatch_6.xtail.S1 CKHB1_N cml_tlatch_6.xmux.xp.S1 VSS sg13_lv_nmos ad=89.3f pd=0.85u as=89.3f ps=0.85u w=0.47u l=0.16u
X9964 cml_tlatch_55.xtail.S1 CKHA2_P cml_tlatch_55.xmux.xn.S1 VSS sg13_lv_nmos ad=89.3f pd=0.85u as=89.3f ps=0.85u w=0.47u l=0.16u
X9965 cml_tlatch_7.xmux.xp.S1 cml_tlatch_7.OUTN cml_tlatch_7.OUTP VSS sg13_lv_nmos ad=56.9f pd=0.74u as=56.9f ps=0.74u w=0.17u l=0.17u
X9966 B3_2_N B3_2_P cml_tlatch_50.xmux.xp.S1 VSS sg13_lv_nmos ad=56.9f pd=0.74u as=56.9f ps=0.74u w=0.17u l=0.17u
X9967 MOT18_N MOT18_P cml_tlatch_53.xmux.xp.S1 VSS sg13_lv_nmos ad=56.9f pd=0.74u as=56.9f ps=0.74u w=0.17u l=0.17u
X9968 VDD MOT1_N VSS rppd l=5.17u w=1u
X9969 cml_tlatch_65.xtail.S1 CKB3_N cml_tlatch_65.xmux.xp.S1 VSS sg13_lv_nmos ad=89.3f pd=0.85u as=89.3f ps=0.85u w=0.47u l=0.16u
X9970 cml_tlatch_63.xmux.xp.S1 MOT26_P MOT26_N VSS sg13_lv_nmos ad=56.9f pd=0.74u as=56.9f ps=0.74u w=0.17u l=0.17u
X9971 cml_tlatch_82.xmux.xn.S1 CKB2_P cml_tlatch_82.xtail.S1 VSS sg13_lv_nmos ad=89.3f pd=0.85u as=89.3f ps=0.85u w=0.47u l=0.16u
X9972 hs_to_clk_0.D2 CK_P CKA0_P VSS sg13_lv_nmos ad=0.228p pd=1.58u as=0.228p ps=1.58u w=1.2u l=0.2u
X9973 cml_tlatch_46.xtail.S1 POLN VSS VSS sg13_lv_nmos ad=1.5637p pd=8.61u as=2.7982p ps=17.14u w=8.23u l=0.13u
X9974 A1_8_N A1_8_P cml_tlatch_19.xmux.xp.S1 VSS sg13_lv_nmos ad=56.9f pd=0.74u as=0.1019p ps=1.34u w=0.17u l=0.17u
X9975 cml_tlatch_44.INN cml_tlatch_56.OUTP cml_tlatch_89.xmux.xn.S1 VSS sg13_lv_nmos ad=63.19999f pd=0.74u as=63.19999f ps=0.74u w=0.26u l=0.38u
X9976 cml_tlatch_98.xmux.xp.S1 cml_tlatch_98.OUTN cml_tlatch_98.OUTP VSS sg13_lv_nmos ad=56.9f pd=0.74u as=56.9f ps=0.74u w=0.17u l=0.17u
X9977 cml_tlatch_37.xmux.xn.S1 D1_N stub_bi_31.BOTN VSS sg13_lv_nmos ad=63.19999f pd=0.74u as=63.19999f ps=0.74u w=0.26u l=0.38u
X9978 cml_tlatch_91.INN cml_tlatch_91.INP cml_tlatch_59.xmux.xp.S1 VSS sg13_lv_nmos ad=56.9f pd=0.74u as=56.9f ps=0.74u w=0.17u l=0.17u
X9979 cml_tlatch_49.xmux.xp.S1 cml_tlatch_49.OUTP cml_tlatch_49.OUTN VSS sg13_lv_nmos ad=56.9f pd=0.74u as=56.9f ps=0.74u w=0.17u l=0.17u
X9980 stub_bi_62.BOTN stub_bi_63.BOTP cml_tlatch_82.xmux.xn.S1 VSS sg13_lv_nmos ad=63.19999f pd=0.74u as=63.19999f ps=0.74u w=0.26u l=0.38u
X9981 cml_tlatch_8.xtail.S1 CKB0_N cml_tlatch_8.xmux.xp.S1 VSS sg13_lv_nmos ad=0.1598p pd=1.62u as=89.3f ps=0.85u w=0.47u l=0.16u
X9982 VSS POLN cml_tlatch_41.xtail.S1 VSS sg13_lv_nmos ad=1.5637p pd=8.61u as=1.5637p ps=8.61u w=8.23u l=0.13u
X9983 cml_tlatch_41.xtail.S1 CKA1_N cml_tlatch_41.xmux.xp.S1 VSS sg13_lv_nmos ad=89.3f pd=0.85u as=89.3f ps=0.85u w=0.47u l=0.16u
X9984 cml_tlatch_72.xtail.S1 CKHB3_P cml_tlatch_72.xmux.xn.S1 VSS sg13_lv_nmos ad=89.3f pd=0.85u as=89.3f ps=0.85u w=0.47u l=0.16u
X9985 cml_tlatch_86.xmux.xp.S1 cml_tlatch_86.OUTN cml_tlatch_86.OUTP VSS sg13_lv_nmos ad=0.1019p pd=1.34u as=56.9f ps=0.74u w=0.17u l=0.17u
X9986 VDD cml_tlatch_86.OUTN VSS rppd l=5.17u w=1u
X9987 cml_tlatch_37.xmux.xn.S1 D1_N stub_bi_31.BOTN VSS sg13_lv_nmos ad=63.19999f pd=0.74u as=63.19999f ps=0.74u w=0.26u l=0.38u
X9988 cml_tlatch_66.xtail.S1 CKB3_N cml_tlatch_66.xmux.xn.S1 VSS sg13_lv_nmos ad=89.3f pd=0.85u as=89.3f ps=0.85u w=0.47u l=0.16u
X9989 cml_tlatch_58.OUTN D3_P cml_tlatch_58.xmux.xn.S1 VSS sg13_lv_nmos ad=0.1082p pd=1.34u as=63.19999f ps=0.74u w=0.26u l=0.38u
X9990 cml_tlatch_18.xtail.S1 CKA0_P cml_tlatch_18.xmux.xn.S1 VSS sg13_lv_nmos ad=89.3f pd=0.85u as=89.3f ps=0.85u w=0.47u l=0.16u
X9991 GB0_P CKA0_N cml_gate2_1.xrtail.R1 VSS sg13_lv_nmos ad=0.1007p pd=0.91u as=0.1007p ps=0.91u w=0.53u l=0.13u
X9992 B3_2_N cml_tlatch_51.OUTP cml_tlatch_50.xmux.xn.S1 VSS sg13_lv_nmos ad=63.19999f pd=0.74u as=63.19999f ps=0.74u w=0.26u l=0.38u
X9993 MOT31_P B3_2_N cml_tlatch_75.xmux.xn.S1 VSS sg13_lv_nmos ad=63.19999f pd=0.74u as=63.19999f ps=0.74u w=0.26u l=0.38u
X9994 cml_tlatch_97.INP cml_tlatch_97.INN cml_tlatch_39.xmux.xp.S1 VSS sg13_lv_nmos ad=56.9f pd=0.74u as=0.1019p ps=1.34u w=0.17u l=0.17u
X9995 cml_tlatch_64.xtail.S1 POLN VSS VSS sg13_lv_nmos ad=1.5637p pd=8.61u as=2.7982p ps=17.14u w=8.23u l=0.13u
X9996 cml_tlatch_34.xmux.xp.S1 CKA0_P cml_tlatch_34.xtail.S1 VSS sg13_lv_nmos ad=89.3f pd=0.85u as=89.3f ps=0.85u w=0.47u l=0.16u
X9997 A3_2_P cml_tlatch_58.OUTN cml_tlatch_57.xmux.xn.S1 VSS sg13_lv_nmos ad=63.19999f pd=0.74u as=63.19999f ps=0.74u w=0.26u l=0.38u
X9998 cml_tlatch_22.xtail.S1 CKA1_P cml_tlatch_22.xmux.xn.S1 VSS sg13_lv_nmos ad=89.3f pd=0.85u as=89.3f ps=0.85u w=0.47u l=0.16u
X9999 cml_tlatch_17.xmux.xn.S1 CKHB0_P cml_tlatch_17.xtail.S1 VSS sg13_lv_nmos ad=89.3f pd=0.85u as=89.3f ps=0.85u w=0.47u l=0.16u
X10000 cml_tlatch_37.xtail.S1 CKB1_N cml_tlatch_37.xmux.xp.S1 VSS sg13_lv_nmos ad=89.3f pd=0.85u as=89.3f ps=0.85u w=0.47u l=0.16u
X10001 B2_8_P B2_8_N cml_tlatch_81.xmux.xp.S1 VSS sg13_lv_nmos ad=56.9f pd=0.74u as=56.9f ps=0.74u w=0.17u l=0.17u
X10002 cml_tlatch_97.xmux.xp.S1 cml_tlatch_24.INN cml_tlatch_24.INP VSS sg13_lv_nmos ad=56.9f pd=0.74u as=56.9f ps=0.74u w=0.17u l=0.17u
X10003 ENA_P J1_N cml_gate2_9.xamp.xn.S1 VSS sg13_lv_nmos ad=0.1802p pd=1.74u as=0.1007p ps=0.91u w=0.53u l=0.13u
X10004 cml_tlatch_91.INP A2_2_N cml_tlatch_59.xmux.xn.S1 VSS sg13_lv_nmos ad=63.19999f pd=0.74u as=63.19999f ps=0.74u w=0.26u l=0.38u
X10005 cml_tlatch_92.xmux.xp.S1 J4_P J4_N VSS sg13_lv_nmos ad=56.9f pd=0.74u as=56.9f ps=0.74u w=0.17u l=0.17u
X10006 cml_tlatch_15.xtail.S1 CKHB0_N cml_tlatch_15.xmux.xp.S1 VSS sg13_lv_nmos ad=89.3f pd=0.85u as=89.3f ps=0.85u w=0.47u l=0.16u
X10007 cml_tlatch_70.xmux.xp.S1 CKA3_P cml_tlatch_70.xtail.S1 VSS sg13_lv_nmos ad=89.3f pd=0.85u as=89.3f ps=0.85u w=0.47u l=0.16u
X10008 cml_tlatch_99.xmux.xp.S1 cml_tlatch_99.OUTP cml_tlatch_99.OUTN VSS sg13_lv_nmos ad=0.1019p pd=1.34u as=56.9f ps=0.74u w=0.17u l=0.17u
X10009 cml_tlatch_43.xtail.S1 CKHA1_P cml_tlatch_43.xmux.xn.S1 VSS sg13_lv_nmos ad=89.3f pd=0.85u as=0.1598p ps=1.62u w=0.47u l=0.16u
X10010 cml_tlatch_69.OUTN cml_tlatch_69.OUTP cml_tlatch_69.xmux.xp.S1 VSS sg13_lv_nmos ad=56.9f pd=0.74u as=56.9f ps=0.74u w=0.17u l=0.17u
X10011 cml_tlatch_78.xmux.xp.S1 MOT19_P MOT19_N VSS sg13_lv_nmos ad=56.9f pd=0.74u as=56.9f ps=0.74u w=0.17u l=0.17u
X10012 cml_tlatch_67.OUTN cml_tlatch_67.OUTP cml_tlatch_67.xmux.xp.S1 VSS sg13_lv_nmos ad=56.9f pd=0.74u as=56.9f ps=0.74u w=0.17u l=0.17u
X10013 cml_tlatch_63.INN cml_tlatch_63.INP cml_tlatch_70.xmux.xp.S1 VSS sg13_lv_nmos ad=56.9f pd=0.74u as=56.9f ps=0.74u w=0.17u l=0.17u
X10014 MOT28_N MOT28_P cml_tlatch_44.xmux.xp.S1 VSS sg13_lv_nmos ad=56.9f pd=0.74u as=56.9f ps=0.74u w=0.17u l=0.17u
X10015 cml_tlatch_70.xtail.S1 POLN VSS VSS sg13_lv_nmos ad=1.5637p pd=8.61u as=2.7982p ps=17.14u w=8.23u l=0.13u
X10016 cml_gate2_6.xamp.xn.S1 CKA3_P cml_gate2_6.xrtail.R1 VSS sg13_lv_nmos ad=0.1007p pd=0.91u as=0.1007p ps=0.91u w=0.53u l=0.13u
X10017 MOT0_N A0_8_P cml_tlatch_26.xmux.xn.S1 VSS sg13_lv_nmos ad=63.19999f pd=0.74u as=63.19999f ps=0.74u w=0.26u l=0.38u
X10018 cml_tlatch_92.xmux.xp.S1 CKJ_P cml_tlatch_92.xtail.S1 VSS sg13_lv_nmos ad=89.3f pd=0.85u as=89.3f ps=0.85u w=0.47u l=0.16u
X10019 cml_tlatch_20.xmux.xp.S1 cml_tlatch_20.OUTP cml_tlatch_20.OUTN VSS sg13_lv_nmos ad=56.9f pd=0.74u as=56.9f ps=0.74u w=0.17u l=0.17u
X10020 cml_tlatch_4.xmux.xp.S1 MOT11_P MOT11_N VSS sg13_lv_nmos ad=56.9f pd=0.74u as=56.9f ps=0.74u w=0.17u l=0.17u
X10021 stub_bi_15.BOTP stub_bi_15.BOTN cml_tlatch_11.xmux.xp.S1 VSS sg13_lv_nmos ad=56.9f pd=0.74u as=56.9f ps=0.74u w=0.17u l=0.17u
X10022 cml_tlatch_66.xmux.xp.S1 CKB3_P cml_tlatch_66.xtail.S1 VSS sg13_lv_nmos ad=89.3f pd=0.85u as=89.3f ps=0.85u w=0.47u l=0.16u
X10023 stub_bi_38.BOTP stub_bi_38.BOTN cml_tlatch_46.xmux.xp.S1 VSS sg13_lv_nmos ad=56.9f pd=0.74u as=0.1019p ps=1.34u w=0.17u l=0.17u
X10024 cml_tlatch_29.xmux.xp.S1 MOT6_P MOT6_N VSS sg13_lv_nmos ad=56.9f pd=0.74u as=56.9f ps=0.74u w=0.17u l=0.17u
X10025 cml_tlatch_3.xtail.S1 CKHB1_N cml_tlatch_3.xmux.xp.S1 VSS sg13_lv_nmos ad=89.3f pd=0.85u as=89.3f ps=0.85u w=0.47u l=0.16u
X10026 A3_8_N A3_8_P cml_tlatch_68.xmux.xp.S1 VSS sg13_lv_nmos ad=56.9f pd=0.74u as=56.9f ps=0.74u w=0.17u l=0.17u
X10027 cml_tlatch_61.xmux.xp.S1 cml_tlatch_61.OUTN cml_tlatch_61.OUTP VSS sg13_lv_nmos ad=0.1019p pd=1.34u as=56.9f ps=0.74u w=0.17u l=0.17u
X10028 cml_tlatch_61.xmux.xp.S1 CKA2_N cml_tlatch_61.xtail.S1 VSS sg13_lv_nmos ad=89.3f pd=0.85u as=89.3f ps=0.85u w=0.47u l=0.16u
X10029 cml_tlatch_8.xmux.xp.S1 cml_tlatch_8.OUTN cml_tlatch_8.OUTP VSS sg13_lv_nmos ad=56.9f pd=0.74u as=56.9f ps=0.74u w=0.17u l=0.17u
X10030 VSS POLN cml_tlatch_35.xtail.S1 VSS sg13_lv_nmos ad=1.5637p pd=8.61u as=1.5637p ps=8.61u w=8.23u l=0.13u
X10031 cml_tlatch_31.xmux.xn.S1 CKB0_N cml_tlatch_31.xtail.S1 VSS sg13_lv_nmos ad=89.3f pd=0.85u as=89.3f ps=0.85u w=0.47u l=0.16u
X10032 cml_tlatch_22.xtail.S1 CKA1_P cml_tlatch_22.xmux.xn.S1 VSS sg13_lv_nmos ad=89.3f pd=0.85u as=89.3f ps=0.85u w=0.47u l=0.16u
X10033 cml_tlatch_13.xmux.xp.S1 stub_bi_17.BOTN stub_bi_17.BOTP VSS sg13_lv_nmos ad=0.1019p pd=1.34u as=56.9f ps=0.74u w=0.17u l=0.17u
X10034 J2_P J2_N cml_tlatch_94.xmux.xp.S1 VSS sg13_lv_nmos ad=56.9f pd=0.74u as=56.9f ps=0.74u w=0.17u l=0.17u
X10035 cml_drv_0.xrtail.R1 ENB_N ENB1_P VSS sg13_lv_nmos ad=56.2f pd=0.74u as=56.2f ps=0.74u w=0.16u l=0.19u
X10036 cml_tlatch_63.xmux.xp.S1 MOT26_P MOT26_N VSS sg13_lv_nmos ad=56.9f pd=0.74u as=56.9f ps=0.74u w=0.17u l=0.17u
X10037 cml_tlatch_60.xmux.xp.S1 A2_2_P A2_2_N VSS sg13_lv_nmos ad=56.9f pd=0.74u as=56.9f ps=0.74u w=0.17u l=0.17u
X10038 cml_tlatch_56.OUTP cml_tlatch_56.OUTN cml_tlatch_56.xmux.xp.S1 VSS sg13_lv_nmos ad=56.9f pd=0.74u as=56.9f ps=0.74u w=0.17u l=0.17u
X10039 cml_gate2_7.xrtail.R1 VSS VSS rppd l=4.86u w=1u
X10040 stub_bi_17.BOTN stub_bi_17.BOTP cml_tlatch_13.xmux.xp.S1 VSS sg13_lv_nmos ad=56.9f pd=0.74u as=56.9f ps=0.74u w=0.17u l=0.17u
X10041 MOT10_N MOT10_P cml_tlatch_43.xmux.xp.S1 VSS sg13_lv_nmos ad=56.9f pd=0.74u as=56.9f ps=0.74u w=0.17u l=0.17u
X10042 cml_tlatch_97.xtail.S1 CKA1_P cml_tlatch_97.xmux.xp.S1 VSS sg13_lv_nmos ad=89.3f pd=0.85u as=89.3f ps=0.85u w=0.47u l=0.16u
X10043 cml_tlatch_14.xmux.xn.S1 CKHB0_P cml_tlatch_14.xtail.S1 VSS sg13_lv_nmos ad=89.3f pd=0.85u as=89.3f ps=0.85u w=0.47u l=0.16u
X10044 cml_tlatch_57.xtail.S1 CKA3_P cml_tlatch_57.xmux.xp.S1 VSS sg13_lv_nmos ad=89.3f pd=0.85u as=89.3f ps=0.85u w=0.47u l=0.16u
X10045 cml_tlatch_81.xtail.S1 CKB2_P cml_tlatch_81.xmux.xp.S1 VSS sg13_lv_nmos ad=89.3f pd=0.85u as=89.3f ps=0.85u w=0.47u l=0.16u
X10046 MOT4_P MOT4_N cml_tlatch_28.xmux.xp.S1 VSS sg13_lv_nmos ad=56.9f pd=0.74u as=56.9f ps=0.74u w=0.17u l=0.17u
X10047 MOT21_N MOT21_P cml_tlatch_79.xmux.xp.S1 VSS sg13_lv_nmos ad=56.9f pd=0.74u as=56.9f ps=0.74u w=0.17u l=0.17u
X10048 cml_tlatch_0.OUTP cml_tlatch_99.OUTN cml_tlatch_0.xmux.xn.S1 VSS sg13_lv_nmos ad=0.1082p pd=1.34u as=63.19999f ps=0.74u w=0.26u l=0.38u
X10049 cml_tlatch_44.INP cml_tlatch_44.INN cml_tlatch_89.xmux.xp.S1 VSS sg13_lv_nmos ad=56.9f pd=0.74u as=56.9f ps=0.74u w=0.17u l=0.17u
X10050 cml_gate2_9.xamp.xn.S1 J1_N ENA_P VSS sg13_lv_nmos ad=0.1007p pd=0.91u as=0.1007p ps=0.91u w=0.53u l=0.13u
X10051 VSS hs_to_clk_7.sg13_lv_nmos_2HGZLP_0.G VSS VSS sg13_lv_nmos ad=2.071p pd=11.28u as=0 ps=0 w=10.9u l=1.38u
X10052 cml_tlatch_9.xmux.xp.S1 A0_8_P A0_8_N VSS sg13_lv_nmos ad=56.9f pd=0.74u as=56.9f ps=0.74u w=0.17u l=0.17u
X10053 cml_tlatch_0.OUTP cml_tlatch_99.OUTN cml_tlatch_0.xmux.xn.S1 VSS sg13_lv_nmos ad=63.19999f pd=0.74u as=63.19999f ps=0.74u w=0.26u l=0.38u
X10054 cml_tlatch_78.xmux.xn.S1 CKHB2_P cml_tlatch_78.xtail.S1 VSS sg13_lv_nmos ad=89.3f pd=0.85u as=89.3f ps=0.85u w=0.47u l=0.16u
X10055 cml_tlatch_0.xtail.S1 CKA0_P cml_tlatch_0.xmux.xn.S1 VSS sg13_lv_nmos ad=89.3f pd=0.85u as=89.3f ps=0.85u w=0.47u l=0.16u
X10056 stub_bi_63.BOTP stub_bi_49.BOTN cml_tlatch_83.xmux.xn.S1 VSS sg13_lv_nmos ad=63.19999f pd=0.74u as=63.19999f ps=0.74u w=0.26u l=0.38u
X10057 MOT13_N MOT13_P cml_tlatch_5.xmux.xp.S1 VSS sg13_lv_nmos ad=56.9f pd=0.74u as=56.9f ps=0.74u w=0.17u l=0.17u
X10058 cml_tlatch_5.INP cml_tlatch_5.INN cml_tlatch_96.xmux.xp.S1 VSS sg13_lv_nmos ad=56.9f pd=0.74u as=56.9f ps=0.74u w=0.17u l=0.17u
X10059 cml_tlatch_96.xtail.S1 CKB1_P cml_tlatch_96.xmux.xp.S1 VSS sg13_lv_nmos ad=89.3f pd=0.85u as=89.3f ps=0.85u w=0.47u l=0.16u
X10060 cml_tlatch_95.xmux.xp.S1 J1_P J1_N VSS sg13_lv_nmos ad=56.9f pd=0.74u as=56.9f ps=0.74u w=0.17u l=0.17u
X10061 cml_tlatch_50.xtail.S1 CKB3_P cml_tlatch_50.xmux.xp.S1 VSS sg13_lv_nmos ad=0.1598p pd=1.62u as=89.3f ps=0.85u w=0.47u l=0.16u
X10062 cml_tlatch_28.xmux.xn.S1 cml_tlatch_99.OUTN MOT4_P VSS sg13_lv_nmos ad=63.19999f pd=0.74u as=63.19999f ps=0.74u w=0.26u l=0.38u
X10063 MOT1_N MOT1_P cml_tlatch_14.xmux.xp.S1 VSS sg13_lv_nmos ad=56.9f pd=0.74u as=56.9f ps=0.74u w=0.17u l=0.17u
X10064 cml_gate2_1.xamp.xn.S1 ENB1_N GB0_P VSS sg13_lv_nmos ad=0.1007p pd=0.91u as=0.1007p ps=0.91u w=0.53u l=0.13u
X10065 cml_tlatch_91.xtail.S1 CKA2_P cml_tlatch_91.xmux.xp.S1 VSS sg13_lv_nmos ad=89.3f pd=0.85u as=89.3f ps=0.85u w=0.47u l=0.16u
X10066 cml_tlatch_82.xtail.S1 CKB2_P cml_tlatch_82.xmux.xn.S1 VSS sg13_lv_nmos ad=89.3f pd=0.85u as=0.1598p ps=1.62u w=0.47u l=0.16u
X10067 cml_tlatch_34.xmux.xp.S1 A0_2_N A0_2_P VSS sg13_lv_nmos ad=56.9f pd=0.74u as=56.9f ps=0.74u w=0.17u l=0.17u
X10068 cml_tlatch_12.xtail.S1 CKB1_P cml_tlatch_12.xmux.xp.S1 VSS sg13_lv_nmos ad=89.3f pd=0.85u as=89.3f ps=0.85u w=0.47u l=0.16u
X10069 GB1_P CKA1_N cml_gate2_0.xrtail.R1 VSS sg13_lv_nmos ad=0.1007p pd=0.91u as=0.1007p ps=0.91u w=0.53u l=0.13u
X10070 cml_tlatch_38.OUTP D0_N cml_tlatch_38.xmux.xn.S1 VSS sg13_lv_nmos ad=63.19999f pd=0.74u as=0.1082p ps=1.34u w=0.26u l=0.38u
X10071 cml_tlatch_27.xmux.xp.S1 MOT2_N MOT2_P VSS sg13_lv_nmos ad=56.9f pd=0.74u as=56.9f ps=0.74u w=0.17u l=0.17u
X10072 MOT14_N MOT14_P cml_tlatch_25.xmux.xp.S1 VSS sg13_lv_nmos ad=56.9f pd=0.74u as=56.9f ps=0.74u w=0.17u l=0.17u
X10073 cml_tlatch_20.OUTP cml_tlatch_20.OUTN cml_tlatch_20.xmux.xp.S1 VSS sg13_lv_nmos ad=56.9f pd=0.74u as=56.9f ps=0.74u w=0.17u l=0.17u
X10074 cml_tlatch_11.xmux.xp.S1 stub_bi_15.BOTP stub_bi_15.BOTN VSS sg13_lv_nmos ad=56.9f pd=0.74u as=56.9f ps=0.74u w=0.17u l=0.17u
X10075 cml_tlatch_63.INN cml_tlatch_63.INP cml_tlatch_70.xmux.xp.S1 VSS sg13_lv_nmos ad=56.9f pd=0.74u as=56.9f ps=0.74u w=0.17u l=0.17u
X10076 MOT27_N MOT27_P cml_tlatch_73.xmux.xp.S1 VSS sg13_lv_nmos ad=56.9f pd=0.74u as=56.9f ps=0.74u w=0.17u l=0.17u
X10077 cml_tlatch_74.INP cml_tlatch_49.OUTN cml_tlatch_88.xmux.xn.S1 VSS sg13_lv_nmos ad=63.19999f pd=0.74u as=63.19999f ps=0.74u w=0.26u l=0.38u
X10078 cml_tlatch_66.xmux.xp.S1 cml_tlatch_73.INP cml_tlatch_73.INN VSS sg13_lv_nmos ad=56.9f pd=0.74u as=56.9f ps=0.74u w=0.17u l=0.17u
X10079 cml_tlatch_66.xmux.xp.S1 cml_tlatch_73.INN cml_tlatch_73.INP VSS sg13_lv_nmos ad=56.9f pd=0.74u as=56.9f ps=0.74u w=0.17u l=0.17u
X10080 A2_2_P A2_2_N cml_tlatch_60.xmux.xp.S1 VSS sg13_lv_nmos ad=56.9f pd=0.74u as=56.9f ps=0.74u w=0.17u l=0.17u
X10081 VSS POLN hs_to_clk_2.D2 VSS sg13_lv_nmos ad=1.9p pd=10.38u as=1.9p ps=10.38u w=10u l=0.13u
X10082 MOT0_P MOT0_N cml_tlatch_26.xmux.xp.S1 VSS sg13_lv_nmos ad=56.9f pd=0.74u as=56.9f ps=0.74u w=0.17u l=0.17u
X10083 A0_8_N cml_tlatch_18.OUTP cml_tlatch_9.xmux.xn.S1 VSS sg13_lv_nmos ad=63.19999f pd=0.74u as=63.19999f ps=0.74u w=0.26u l=0.38u
X10084 cml_tlatch_65.xtail.S1 CKB3_P cml_tlatch_65.xmux.xn.S1 VSS sg13_lv_nmos ad=89.3f pd=0.85u as=89.3f ps=0.85u w=0.47u l=0.16u
X10085 cml_tlatch_54.xmux.xn.S1 cml_tlatch_91.OUTP MOT20_N VSS sg13_lv_nmos ad=63.19999f pd=0.74u as=63.19999f ps=0.74u w=0.26u l=0.38u
X10086 cml_tlatch_53.xtail.S1 POLN VSS VSS sg13_lv_nmos ad=1.5637p pd=8.61u as=2.7982p ps=17.14u w=8.23u l=0.13u
X10087 cml_tlatch_4.xmux.xp.S1 MOT11_P MOT11_N VSS sg13_lv_nmos ad=56.9f pd=0.74u as=56.9f ps=0.74u w=0.17u l=0.17u
X10088 cml_tlatch_20.xmux.xn.S1 CKA1_P cml_tlatch_20.xtail.S1 VSS sg13_lv_nmos ad=0.1598p pd=1.62u as=89.3f ps=0.85u w=0.47u l=0.16u
X10089 cml_tlatch_24.xmux.xp.S1 MOT12_P MOT12_N VSS sg13_lv_nmos ad=56.9f pd=0.74u as=56.9f ps=0.74u w=0.17u l=0.17u
X10090 cml_tlatch_4.INN cml_tlatch_4.INP cml_tlatch_12.xmux.xp.S1 VSS sg13_lv_nmos ad=56.9f pd=0.74u as=56.9f ps=0.74u w=0.17u l=0.17u
X10091 cml_tlatch_23.xmux.xp.S1 CKA0_P cml_tlatch_23.xtail.S1 VSS sg13_lv_nmos ad=89.3f pd=0.85u as=89.3f ps=0.85u w=0.47u l=0.16u
X10092 cml_tlatch_81.xmux.xn.S1 stub_bi_62.BOTN B2_8_N VSS sg13_lv_nmos ad=63.19999f pd=0.74u as=63.19999f ps=0.74u w=0.26u l=0.38u
X10093 cml_tlatch_42.xtail.S1 CKHA1_N cml_tlatch_42.xmux.xp.S1 VSS sg13_lv_nmos ad=89.3f pd=0.85u as=89.3f ps=0.85u w=0.47u l=0.16u
X10094 hs_to_clk_8.D2 POLN VSS VSS sg13_lv_nmos ad=3.4p pd=20.68u as=1.9p ps=10.38u w=10u l=0.13u
X10095 cml_tlatch_16.xmux.xp.S1 MOT5_N MOT5_P VSS sg13_lv_nmos ad=56.9f pd=0.74u as=56.9f ps=0.74u w=0.17u l=0.17u
X10096 cml_tlatch_18.xmux.xn.S1 cml_tlatch_23.OUTN cml_tlatch_18.OUTP VSS sg13_lv_nmos ad=63.19999f pd=0.74u as=63.19999f ps=0.74u w=0.26u l=0.38u
X10097 cml_tlatch_9.xtail.S1 CKA0_N cml_tlatch_9.xmux.xn.S1 VSS sg13_lv_nmos ad=89.3f pd=0.85u as=89.3f ps=0.85u w=0.47u l=0.16u
X10098 B1_2_P stub_bi_31.BOTP cml_tlatch_36.xmux.xn.S1 VSS sg13_lv_nmos ad=63.19999f pd=0.74u as=63.19999f ps=0.74u w=0.26u l=0.38u
X10099 cml_tlatch_76.xmux.xp.S1 cml_tlatch_87.INN cml_tlatch_87.INP VSS sg13_lv_nmos ad=56.9f pd=0.74u as=56.9f ps=0.74u w=0.17u l=0.17u
X10100 cml_tlatch_8.OUTN cml_tlatch_8.OUTP cml_tlatch_8.xmux.xp.S1 VSS sg13_lv_nmos ad=56.9f pd=0.74u as=56.9f ps=0.74u w=0.17u l=0.17u
X10101 cml_tlatch_6.xtail.S1 POLN VSS VSS sg13_lv_nmos ad=1.5637p pd=8.61u as=1.5637p ps=8.61u w=8.23u l=0.13u
X10102 cml_tlatch_85.xtail.S1 CKA2_N cml_tlatch_85.xmux.xn.S1 VSS sg13_lv_nmos ad=89.3f pd=0.85u as=89.3f ps=0.85u w=0.47u l=0.16u
X10103 stub_bi_55.BOTP stub_bi_55.BOTN cml_tlatch_90.xmux.xp.S1 VSS sg13_lv_nmos ad=56.9f pd=0.74u as=56.9f ps=0.74u w=0.17u l=0.17u
X10104 CKHB1_P GB1_N cml_drvb_0.xrtail.R2 VSS sg13_lv_nmos ad=0.2618p pd=2.22u as=0.1463p ps=1.15u w=0.77u l=0.21u
X10105 cml_tlatch_32.xmux.xp.S1 cml_tlatch_32.OUTP cml_tlatch_32.OUTN VSS sg13_lv_nmos ad=56.9f pd=0.74u as=56.9f ps=0.74u w=0.17u l=0.17u
X10106 B2_2_N B2_2_P cml_tlatch_47.xmux.xp.S1 VSS sg13_lv_nmos ad=56.9f pd=0.74u as=56.9f ps=0.74u w=0.17u l=0.17u
X10107 cml_gate2_9.xrtail.R1 NM1_P cml_gate2_9.xamp.xn.S1 VSS sg13_lv_nmos ad=0.1007p pd=0.91u as=0.1007p ps=0.91u w=0.53u l=0.13u
X10108 cml_tlatch_38.xmux.xn.S1 CKA0_P cml_tlatch_38.xtail.S1 VSS sg13_lv_nmos ad=89.3f pd=0.85u as=89.3f ps=0.85u w=0.47u l=0.16u
X10109 cml_tlatch_20.xtail.S1 CKA1_N cml_tlatch_20.xmux.xp.S1 VSS sg13_lv_nmos ad=89.3f pd=0.85u as=89.3f ps=0.85u w=0.47u l=0.16u
X10110 ENB_P NS1_N cml_gate2_8.xrtail.R1 VSS sg13_lv_nmos ad=0.1007p pd=0.91u as=0.1007p ps=0.91u w=0.53u l=0.13u
X10111 cml_tlatch_71.xmux.xn.S1 CKA3_P cml_tlatch_71.xtail.S1 VSS sg13_lv_nmos ad=0.1598p pd=1.62u as=89.3f ps=0.85u w=0.47u l=0.16u
X10112 cml_gate2_4.xamp.xn.S1 ENA1_N GA3_P VSS sg13_lv_nmos ad=0.1007p pd=0.91u as=0.1007p ps=0.91u w=0.53u l=0.13u
X10113 cml_tlatch_81.xtail.S1 CKB2_N cml_tlatch_81.xmux.xn.S1 VSS sg13_lv_nmos ad=89.3f pd=0.85u as=89.3f ps=0.85u w=0.47u l=0.16u
X10114 cml_tlatch_80.xtail.S1 CKHB2_P cml_tlatch_80.xmux.xn.S1 VSS sg13_lv_nmos ad=89.3f pd=0.85u as=89.3f ps=0.85u w=0.47u l=0.16u
X10115 VSS POLN cml_tlatch_19.xtail.S1 VSS sg13_lv_nmos ad=2.7982p pd=17.14u as=1.5637p ps=8.61u w=8.23u l=0.13u
X10116 cml_tlatch_68.xtail.S1 CKA3_N cml_tlatch_68.xmux.xn.S1 VSS sg13_lv_nmos ad=89.3f pd=0.85u as=89.3f ps=0.85u w=0.47u l=0.16u
X10117 cml_tlatch_72.xmux.xn.S1 B3_8_N MOT25_P VSS sg13_lv_nmos ad=63.19999f pd=0.74u as=0.1082p ps=1.34u w=0.26u l=0.38u
X10118 cml_tlatch_97.xtail.S1 CKA1_N cml_tlatch_97.xmux.xn.S1 VSS sg13_lv_nmos ad=89.3f pd=0.85u as=89.3f ps=0.85u w=0.47u l=0.16u
X10119 VDD cml_tlatch_33.OUTP VSS rppd l=5.17u w=1u
X10120 MOT25_N B3_8_P cml_tlatch_72.xmux.xn.S1 VSS sg13_lv_nmos ad=63.19999f pd=0.74u as=63.19999f ps=0.74u w=0.26u l=0.38u
X10121 B2_8_N B2_8_P cml_tlatch_81.xmux.xp.S1 VSS sg13_lv_nmos ad=56.9f pd=0.74u as=56.9f ps=0.74u w=0.17u l=0.17u
X10122 cml_tlatch_2.OUTN cml_tlatch_2.OUTP cml_tlatch_2.xmux.xp.S1 VSS sg13_lv_nmos ad=56.9f pd=0.74u as=56.9f ps=0.74u w=0.17u l=0.17u
X10123 cml_tlatch_41.OUTP cml_tlatch_41.OUTN cml_tlatch_41.xmux.xp.S1 VSS sg13_lv_nmos ad=56.9f pd=0.74u as=56.9f ps=0.74u w=0.17u l=0.17u
X10124 cml_tlatch_14.xmux.xp.S1 MOT1_N MOT1_P VSS sg13_lv_nmos ad=56.9f pd=0.74u as=56.9f ps=0.74u w=0.17u l=0.17u
X10125 CKHA1_N VDD VSS rppd l=13.09u w=1u
X10126 cml_tlatch_21.xtail.S1 CKA1_N cml_tlatch_21.xmux.xn.S1 VSS sg13_lv_nmos ad=89.3f pd=0.85u as=89.3f ps=0.85u w=0.47u l=0.16u
X10127 cml_tlatch_37.xmux.xp.S1 stub_bi_31.BOTP stub_bi_31.BOTN VSS sg13_lv_nmos ad=56.9f pd=0.74u as=56.9f ps=0.74u w=0.17u l=0.17u
X10128 cml_tlatch_10.xmux.xp.S1 B1_8_N B1_8_P VSS sg13_lv_nmos ad=56.9f pd=0.74u as=56.9f ps=0.74u w=0.17u l=0.17u
X10129 cml_gate2_4.xamp.xn.S1 ENA1_P GA3_N VSS sg13_lv_nmos ad=0.1007p pd=0.91u as=0.1007p ps=0.91u w=0.53u l=0.13u
X10130 cml_tlatch_52.xtail.S1 CKHA2_N cml_tlatch_52.xmux.xp.S1 VSS sg13_lv_nmos ad=89.3f pd=0.85u as=89.3f ps=0.85u w=0.47u l=0.16u
X10131 MOT14_P MOT14_N cml_tlatch_25.xmux.xp.S1 VSS sg13_lv_nmos ad=56.9f pd=0.74u as=56.9f ps=0.74u w=0.17u l=0.17u
X10132 cml_tlatch_52.xmux.xp.S1 MOT16_N MOT16_P VSS sg13_lv_nmos ad=56.9f pd=0.74u as=56.9f ps=0.74u w=0.17u l=0.17u
X10133 cml_tlatch_43.xmux.xn.S1 cml_tlatch_43.INN MOT10_P VSS sg13_lv_nmos ad=63.19999f pd=0.74u as=63.19999f ps=0.74u w=0.26u l=0.38u
X10134 cml_tlatch_11.xtail.S1 CKB1_N cml_tlatch_11.xmux.xp.S1 VSS sg13_lv_nmos ad=89.3f pd=0.85u as=89.3f ps=0.85u w=0.47u l=0.16u
X10135 MOT13_N MOT13_P cml_tlatch_5.xmux.xp.S1 VSS sg13_lv_nmos ad=56.9f pd=0.74u as=56.9f ps=0.74u w=0.17u l=0.17u
X10136 cml_tlatch_48.xmux.xp.S1 stub_bi_43.BOTN stub_bi_43.BOTP VSS sg13_lv_nmos ad=56.9f pd=0.74u as=56.9f ps=0.74u w=0.17u l=0.17u
X10137 cml_tlatch_2.xmux.xn.S1 cml_tlatch_7.OUTP cml_tlatch_2.OUTN VSS sg13_lv_nmos ad=63.19999f pd=0.74u as=63.19999f ps=0.74u w=0.26u l=0.38u
X10138 cml_tlatch_23.xmux.xp.S1 cml_tlatch_23.OUTN cml_tlatch_23.OUTP VSS sg13_lv_nmos ad=56.9f pd=0.74u as=56.9f ps=0.74u w=0.17u l=0.17u
X10139 cml_tlatch_20.OUTP cml_tlatch_43.INN cml_tlatch_20.xmux.xn.S1 VSS sg13_lv_nmos ad=63.19999f pd=0.74u as=63.19999f ps=0.74u w=0.26u l=0.38u
X10140 VSS POLN cml_tlatch_90.xtail.S1 VSS sg13_lv_nmos ad=1.5637p pd=8.61u as=1.5637p ps=8.61u w=8.23u l=0.13u
X10141 cml_tlatch_34.xmux.xp.S1 A0_2_N A0_2_P VSS sg13_lv_nmos ad=0.1019p pd=1.34u as=56.9f ps=0.74u w=0.17u l=0.17u
X10142 MOT21_P MOT21_N cml_tlatch_79.xmux.xp.S1 VSS sg13_lv_nmos ad=56.9f pd=0.74u as=0.1019p ps=1.34u w=0.17u l=0.17u
X10143 cml_tlatch_80.xmux.xp.S1 MOT23_P MOT23_N VSS sg13_lv_nmos ad=56.9f pd=0.74u as=56.9f ps=0.74u w=0.17u l=0.17u
X10144 stub_bi_38.BOTN stub_bi_38.BOTP cml_tlatch_46.xmux.xp.S1 VSS sg13_lv_nmos ad=56.9f pd=0.74u as=56.9f ps=0.74u w=0.17u l=0.17u
X10145 cml_tlatch_56.xtail.S1 CKA3_N cml_tlatch_56.xmux.xp.S1 VSS sg13_lv_nmos ad=89.3f pd=0.85u as=89.3f ps=0.85u w=0.47u l=0.16u
X10146 cml_tlatch_12.xtail.S1 CKB1_N cml_tlatch_12.xmux.xn.S1 VSS sg13_lv_nmos ad=89.3f pd=0.85u as=89.3f ps=0.85u w=0.47u l=0.16u
X10147 cml_tlatch_86.xmux.xp.S1 cml_tlatch_86.OUTP cml_tlatch_86.OUTN VSS sg13_lv_nmos ad=56.9f pd=0.74u as=56.9f ps=0.74u w=0.17u l=0.17u
X10148 cml_tlatch_56.xmux.xp.S1 cml_tlatch_56.OUTP cml_tlatch_56.OUTN VSS sg13_lv_nmos ad=56.9f pd=0.74u as=56.9f ps=0.74u w=0.17u l=0.17u
X10149 cml_tlatch_15.xtail.S1 CKHB0_N cml_tlatch_15.xmux.xp.S1 VSS sg13_lv_nmos ad=89.3f pd=0.85u as=89.3f ps=0.85u w=0.47u l=0.16u
X10150 cml_tlatch_87.xtail.S1 CKA2_N cml_tlatch_87.xmux.xn.S1 VSS sg13_lv_nmos ad=89.3f pd=0.85u as=89.3f ps=0.85u w=0.47u l=0.16u
X10151 MOT30_P MOT30_N cml_tlatch_45.xmux.xp.S1 VSS sg13_lv_nmos ad=56.9f pd=0.74u as=56.9f ps=0.74u w=0.17u l=0.17u
X10152 cml_tlatch_11.xmux.xp.S1 stub_bi_15.BOTP stub_bi_15.BOTN VSS sg13_lv_nmos ad=56.9f pd=0.74u as=56.9f ps=0.74u w=0.17u l=0.17u
X10153 stub_bi_17.BOTN cml_tlatch_5.INN cml_tlatch_13.xmux.xn.S1 VSS sg13_lv_nmos ad=63.19999f pd=0.74u as=63.19999f ps=0.74u w=0.26u l=0.38u
X10154 A2_2_N cml_tlatch_61.OUTP cml_tlatch_60.xmux.xn.S1 VSS sg13_lv_nmos ad=63.19999f pd=0.74u as=0.1082p ps=1.34u w=0.26u l=0.38u
X10155 cml_tlatch_60.xtail.S1 CKA2_N cml_tlatch_60.xmux.xn.S1 VSS sg13_lv_nmos ad=89.3f pd=0.85u as=89.3f ps=0.85u w=0.47u l=0.16u
X10156 VSS hs_to_clk_7.sg13_lv_nmos_2HGZLP_0.G VSS VSS sg13_lv_nmos ad=3.706p pd=22.48u as=0 ps=0 w=10.9u l=1.38u
X10157 MOT0_P MOT0_N cml_tlatch_26.xmux.xp.S1 VSS sg13_lv_nmos ad=56.9f pd=0.74u as=56.9f ps=0.74u w=0.17u l=0.17u
X10158 cml_tlatch_44.xmux.xp.S1 CKHA3_N cml_tlatch_44.xtail.S1 VSS sg13_lv_nmos ad=89.3f pd=0.85u as=89.3f ps=0.85u w=0.47u l=0.16u
X10159 cml_tlatch_35.xmux.xp.S1 stub_bi_29.BOTN stub_bi_29.BOTP VSS sg13_lv_nmos ad=56.9f pd=0.74u as=56.9f ps=0.74u w=0.17u l=0.17u
X10160 cml_tlatch_92.xmux.xn.S1 CLK_W_N J4_N VSS sg13_lv_nmos ad=63.19999f pd=0.74u as=63.19999f ps=0.74u w=0.26u l=0.38u
X10161 cml_tlatch_3.xtail.S1 POLN VSS VSS sg13_lv_nmos ad=1.5637p pd=8.61u as=1.5637p ps=8.61u w=8.23u l=0.13u
X10162 cml_tlatch_7.xmux.xp.S1 cml_tlatch_7.OUTP cml_tlatch_7.OUTN VSS sg13_lv_nmos ad=56.9f pd=0.74u as=56.9f ps=0.74u w=0.17u l=0.17u
X10163 cml_tlatch_99.OUTN cml_tlatch_99.OUTP cml_tlatch_99.xmux.xp.S1 VSS sg13_lv_nmos ad=56.9f pd=0.74u as=56.9f ps=0.74u w=0.17u l=0.17u
X10164 cml_tlatch_47.xtail.S1 CKB2_N cml_tlatch_47.xmux.xn.S1 VSS sg13_lv_nmos ad=89.3f pd=0.85u as=89.3f ps=0.85u w=0.47u l=0.16u
X10165 cml_tlatch_33.OUTP cml_tlatch_33.OUTN cml_tlatch_33.xmux.xp.S1 VSS sg13_lv_nmos ad=56.9f pd=0.74u as=56.9f ps=0.74u w=0.17u l=0.17u
X10166 cml_tlatch_97.xtail.S1 CKA1_N cml_tlatch_97.xmux.xn.S1 VSS sg13_lv_nmos ad=89.3f pd=0.85u as=89.3f ps=0.85u w=0.47u l=0.16u
X10167 cml_tlatch_86.xmux.xp.S1 CKA2_N cml_tlatch_86.xtail.S1 VSS sg13_lv_nmos ad=89.3f pd=0.85u as=89.3f ps=0.85u w=0.47u l=0.16u
X10168 cml_tlatch_56.xmux.xn.S1 A3_2_P cml_tlatch_56.OUTN VSS sg13_lv_nmos ad=63.19999f pd=0.74u as=63.19999f ps=0.74u w=0.26u l=0.38u
X10169 stub_bi_29.BOTN VDD VSS rppd l=5.17u w=1u
X10170 cml_tlatch_57.xtail.S1 CKA3_N cml_tlatch_57.xmux.xn.S1 VSS sg13_lv_nmos ad=89.3f pd=0.85u as=89.3f ps=0.85u w=0.47u l=0.16u
X10171 cml_tlatch_76.xmux.xp.S1 cml_tlatch_87.INN cml_tlatch_87.INP VSS sg13_lv_nmos ad=56.9f pd=0.74u as=56.9f ps=0.74u w=0.17u l=0.17u
X10172 cml_tlatch_98.xmux.xn.S1 cml_tlatch_30.OUTN cml_tlatch_98.OUTP VSS sg13_lv_nmos ad=63.19999f pd=0.74u as=0.1082p ps=1.34u w=0.26u l=0.38u
X10173 cml_tlatch_5.xmux.xn.S1 cml_tlatch_5.INP MOT13_N VSS sg13_lv_nmos ad=63.19999f pd=0.74u as=63.19999f ps=0.74u w=0.26u l=0.38u
X10174 stub_bi_49.BOTN stub_bi_49.BOTP cml_tlatch_84.xmux.xp.S1 VSS sg13_lv_nmos ad=56.9f pd=0.74u as=56.9f ps=0.74u w=0.17u l=0.17u
X10175 B3_8_P B3_8_N cml_tlatch_64.xmux.xp.S1 VSS sg13_lv_nmos ad=56.9f pd=0.74u as=56.9f ps=0.74u w=0.17u l=0.17u
X10176 VDD MOT18_P VSS rppd l=5.17u w=1u
X10177 MOT21_P MOT21_N cml_tlatch_79.xmux.xp.S1 VSS sg13_lv_nmos ad=56.9f pd=0.74u as=56.9f ps=0.74u w=0.17u l=0.17u
X10178 stub_bi_55.BOTP stub_bi_55.BOTN cml_tlatch_90.xmux.xp.S1 VSS sg13_lv_nmos ad=56.9f pd=0.74u as=56.9f ps=0.74u w=0.17u l=0.17u
X10179 cml_tlatch_2.xtail.S1 CKB0_P cml_tlatch_2.xmux.xn.S1 VSS sg13_lv_nmos ad=0.1598p pd=1.62u as=89.3f ps=0.85u w=0.47u l=0.16u
X10180 cml_tlatch_97.xmux.xp.S1 cml_tlatch_24.INP cml_tlatch_24.INN VSS sg13_lv_nmos ad=56.9f pd=0.74u as=56.9f ps=0.74u w=0.17u l=0.17u
X10181 MOT3_P cml_tlatch_7.OUTN cml_tlatch_15.xmux.xn.S1 VSS sg13_lv_nmos ad=63.19999f pd=0.74u as=0.1082p ps=1.34u w=0.26u l=0.38u
X10182 cml_tlatch_25.xmux.xn.S1 CKHA1_P cml_tlatch_25.xtail.S1 VSS sg13_lv_nmos ad=89.3f pd=0.85u as=89.3f ps=0.85u w=0.47u l=0.16u
X10183 cml_tlatch_58.OUTP D3_N cml_tlatch_58.xmux.xn.S1 VSS sg13_lv_nmos ad=63.19999f pd=0.74u as=63.19999f ps=0.74u w=0.26u l=0.38u
X10184 cml_tlatch_77.xtail.S1 CKHB2_P cml_tlatch_77.xmux.xn.S1 VSS sg13_lv_nmos ad=89.3f pd=0.85u as=89.3f ps=0.85u w=0.47u l=0.16u
X10185 cml_tlatch_73.xmux.xp.S1 MOT27_N MOT27_P VSS sg13_lv_nmos ad=56.9f pd=0.74u as=56.9f ps=0.74u w=0.17u l=0.17u
X10186 cml_tlatch_32.xmux.xp.S1 cml_tlatch_32.OUTP cml_tlatch_32.OUTN VSS sg13_lv_nmos ad=56.9f pd=0.74u as=56.9f ps=0.74u w=0.17u l=0.17u
X10187 cml_tlatch_15.xmux.xn.S1 cml_tlatch_7.OUTP MOT3_N VSS sg13_lv_nmos ad=63.19999f pd=0.74u as=63.19999f ps=0.74u w=0.26u l=0.38u
X10188 MOT10_P MOT10_N cml_tlatch_43.xmux.xp.S1 VSS sg13_lv_nmos ad=56.9f pd=0.74u as=56.9f ps=0.74u w=0.17u l=0.17u
X10189 MOT8_P MOT8_N cml_tlatch_42.xmux.xp.S1 VSS sg13_lv_nmos ad=56.9f pd=0.74u as=0.1019p ps=1.34u w=0.17u l=0.17u
X10190 cml_tlatch_91.xmux.xp.S1 cml_tlatch_91.OUTN cml_tlatch_91.OUTP VSS sg13_lv_nmos ad=56.9f pd=0.74u as=56.9f ps=0.74u w=0.17u l=0.17u
X10191 cml_tlatch_82.xmux.xp.S1 stub_bi_62.BOTN stub_bi_62.BOTP VSS sg13_lv_nmos ad=56.9f pd=0.74u as=56.9f ps=0.74u w=0.17u l=0.17u
X10192 cml_tlatch_69.xmux.xn.S1 cml_tlatch_63.INP cml_tlatch_69.OUTN VSS sg13_lv_nmos ad=63.19999f pd=0.74u as=63.19999f ps=0.74u w=0.26u l=0.38u
X10193 MOT17_N MOT17_P cml_tlatch_77.xmux.xp.S1 VSS sg13_lv_nmos ad=56.9f pd=0.74u as=56.9f ps=0.74u w=0.17u l=0.17u
X10194 MOT14_P A1_2_N cml_tlatch_25.xmux.xn.S1 VSS sg13_lv_nmos ad=63.19999f pd=0.74u as=63.19999f ps=0.74u w=0.26u l=0.38u
X10195 stub_bi_29.BOTN B1_2_N cml_tlatch_35.xmux.xn.S1 VSS sg13_lv_nmos ad=63.19999f pd=0.74u as=63.19999f ps=0.74u w=0.26u l=0.38u
X10196 cml_tlatch_72.xmux.xp.S1 MOT25_P MOT25_N VSS sg13_lv_nmos ad=56.9f pd=0.74u as=56.9f ps=0.74u w=0.17u l=0.17u
X10197 cml_tlatch_50.xmux.xp.S1 B3_2_P B3_2_N VSS sg13_lv_nmos ad=56.9f pd=0.74u as=56.9f ps=0.74u w=0.17u l=0.17u
X10198 cml_tlatch_14.xmux.xp.S1 MOT1_N MOT1_P VSS sg13_lv_nmos ad=0.1019p pd=1.34u as=56.9f ps=0.74u w=0.17u l=0.17u
X10199 cml_tlatch_4.xmux.xn.S1 cml_tlatch_4.INN MOT11_P VSS sg13_lv_nmos ad=0.1082p pd=1.34u as=63.19999f ps=0.74u w=0.26u l=0.38u
X10200 cml_tlatch_37.xmux.xp.S1 stub_bi_31.BOTP stub_bi_31.BOTN VSS sg13_lv_nmos ad=56.9f pd=0.74u as=56.9f ps=0.74u w=0.17u l=0.17u
X10201 cml_tlatch_52.xtail.S1 POLN VSS VSS sg13_lv_nmos ad=1.5637p pd=8.61u as=1.5637p ps=8.61u w=8.23u l=0.13u
X10202 cml_tlatch_40.xmux.xp.S1 A1_2_N A1_2_P VSS sg13_lv_nmos ad=56.9f pd=0.74u as=56.9f ps=0.74u w=0.17u l=0.17u
X10203 cml_tlatch_96.xtail.S1 POLN VSS VSS sg13_lv_nmos ad=1.5637p pd=8.61u as=1.5637p ps=8.61u w=8.23u l=0.13u
X10204 cml_tlatch_7.xtail.S1 CKB0_N cml_tlatch_7.xmux.xn.S1 VSS sg13_lv_nmos ad=89.3f pd=0.85u as=89.3f ps=0.85u w=0.47u l=0.16u
X10205 cml_tlatch_98.OUTP cml_tlatch_98.OUTN cml_tlatch_98.xmux.xp.S1 VSS sg13_lv_nmos ad=56.9f pd=0.74u as=56.9f ps=0.74u w=0.17u l=0.17u
X10206 cml_tlatch_16.xtail.S1 CKHB0_P cml_tlatch_16.xmux.xn.S1 VSS sg13_lv_nmos ad=89.3f pd=0.85u as=89.3f ps=0.85u w=0.47u l=0.16u
X10207 cml_tlatch_67.xmux.xp.S1 CKB3_N cml_tlatch_67.xtail.S1 VSS sg13_lv_nmos ad=89.3f pd=0.85u as=89.3f ps=0.85u w=0.47u l=0.16u
X10208 GB2_P ENB0_N cml_gate2_7.xamp.xn.S1 VSS sg13_lv_nmos ad=0.1007p pd=0.91u as=0.1007p ps=0.91u w=0.53u l=0.13u
X10209 cml_tlatch_79.xmux.xn.S1 stub_bi_55.BOTP MOT21_P VSS sg13_lv_nmos ad=63.19999f pd=0.74u as=63.19999f ps=0.74u w=0.26u l=0.38u
X10210 cml_tlatch_59.xtail.S1 POLN VSS VSS sg13_lv_nmos ad=1.5637p pd=8.61u as=1.5637p ps=8.61u w=8.23u l=0.13u
X10211 MOT26_P MOT26_N cml_tlatch_63.xmux.xp.S1 VSS sg13_lv_nmos ad=56.9f pd=0.74u as=56.9f ps=0.74u w=0.17u l=0.17u
X10212 cml_tlatch_86.OUTP cml_tlatch_86.OUTN cml_tlatch_86.xmux.xp.S1 VSS sg13_lv_nmos ad=56.9f pd=0.74u as=56.9f ps=0.74u w=0.17u l=0.17u
X10213 cml_tlatch_41.OUTN cml_tlatch_41.OUTP cml_tlatch_41.xmux.xp.S1 VSS sg13_lv_nmos ad=56.9f pd=0.74u as=0.1019p ps=1.34u w=0.17u l=0.17u
X10214 cml_tlatch_96.xtail.S1 CKB1_P cml_tlatch_96.xmux.xp.S1 VSS sg13_lv_nmos ad=89.3f pd=0.85u as=89.3f ps=0.85u w=0.47u l=0.16u
X10215 cml_tlatch_23.xmux.xp.S1 cml_tlatch_23.OUTN cml_tlatch_23.OUTP VSS sg13_lv_nmos ad=56.9f pd=0.74u as=56.9f ps=0.74u w=0.17u l=0.17u
X10216 GA0_P CKB0_N cml_gate2_3.xrtail.R1 VSS sg13_lv_nmos ad=0.1007p pd=0.91u as=0.1007p ps=0.91u w=0.53u l=0.13u
X10217 CKA1_P CK_P hs_to_clk_3.D2 VSS sg13_lv_nmos ad=0.408p pd=3.08u as=0.228p ps=1.58u w=1.2u l=0.2u
X10218 cml_gate2_5.xamp.xn.S1 ENA1_P GA2_N VSS sg13_lv_nmos ad=0.1007p pd=0.91u as=0.1007p ps=0.91u w=0.53u l=0.13u
X10219 cml_tlatch_35.xmux.xn.S1 B1_2_P stub_bi_29.BOTP VSS sg13_lv_nmos ad=63.19999f pd=0.74u as=0.1082p ps=1.34u w=0.26u l=0.38u
X10220 cml_tlatch_80.xmux.xp.S1 MOT23_P MOT23_N VSS sg13_lv_nmos ad=0.1019p pd=1.34u as=56.9f ps=0.74u w=0.17u l=0.17u
X10221 MOT31_N MOT31_P cml_tlatch_75.xmux.xp.S1 VSS sg13_lv_nmos ad=56.9f pd=0.74u as=56.9f ps=0.74u w=0.17u l=0.17u
X10222 cml_tlatch_87.xmux.xp.S1 cml_tlatch_87.OUTP cml_tlatch_87.OUTN VSS sg13_lv_nmos ad=56.9f pd=0.74u as=56.9f ps=0.74u w=0.17u l=0.17u
X10223 cml_tlatch_49.OUTN cml_tlatch_49.OUTP cml_tlatch_49.xmux.xp.S1 VSS sg13_lv_nmos ad=56.9f pd=0.74u as=56.9f ps=0.74u w=0.17u l=0.17u
X10224 stub_bi_63.BOTN stub_bi_63.BOTP cml_tlatch_83.xmux.xp.S1 VSS sg13_lv_nmos ad=56.9f pd=0.74u as=56.9f ps=0.74u w=0.17u l=0.17u
X10225 MOT2_N MOT2_P cml_tlatch_27.xmux.xp.S1 VSS sg13_lv_nmos ad=56.9f pd=0.74u as=56.9f ps=0.74u w=0.17u l=0.17u
X10226 cml_tlatch_81.xmux.xp.S1 B2_8_N B2_8_P VSS sg13_lv_nmos ad=56.9f pd=0.74u as=56.9f ps=0.74u w=0.17u l=0.17u
X10227 cml_tlatch_8.xmux.xp.S1 CKB0_N cml_tlatch_8.xtail.S1 VSS sg13_lv_nmos ad=89.3f pd=0.85u as=89.3f ps=0.85u w=0.47u l=0.16u
X10228 B3_2_N B3_2_P cml_tlatch_50.xmux.xp.S1 VSS sg13_lv_nmos ad=56.9f pd=0.74u as=56.9f ps=0.74u w=0.17u l=0.17u
X10229 cml_tlatch_51.xtail.S1 POLN VSS VSS sg13_lv_nmos ad=1.5637p pd=8.61u as=2.7982p ps=17.14u w=8.23u l=0.13u
X10230 cml_tlatch_6.xmux.xp.S1 MOT15_P MOT15_N VSS sg13_lv_nmos ad=56.9f pd=0.74u as=56.9f ps=0.74u w=0.17u l=0.17u
X10231 cml_tlatch_35.xmux.xp.S1 stub_bi_29.BOTN stub_bi_29.BOTP VSS sg13_lv_nmos ad=56.9f pd=0.74u as=56.9f ps=0.74u w=0.17u l=0.17u
X10232 cml_tlatch_43.INN cml_tlatch_22.OUTP cml_tlatch_21.xmux.xn.S1 VSS sg13_lv_nmos ad=63.19999f pd=0.74u as=63.19999f ps=0.74u w=0.26u l=0.38u
X10233 cml_tlatch_38.xmux.xp.S1 cml_tlatch_38.OUTN cml_tlatch_38.OUTP VSS sg13_lv_nmos ad=56.9f pd=0.74u as=56.9f ps=0.74u w=0.17u l=0.17u
X10234 cml_tlatch_99.OUTN cml_tlatch_99.OUTP cml_tlatch_99.xmux.xp.S1 VSS sg13_lv_nmos ad=56.9f pd=0.74u as=56.9f ps=0.74u w=0.17u l=0.17u
X10235 cml_tlatch_20.xtail.S1 CKA1_P cml_tlatch_20.xmux.xn.S1 VSS sg13_lv_nmos ad=89.3f pd=0.85u as=89.3f ps=0.85u w=0.47u l=0.16u
X10236 cml_tlatch_67.OUTN VDD VSS rppd l=5.17u w=1u
X10237 MOT9_P B1_8_N cml_tlatch_3.xmux.xn.S1 VSS sg13_lv_nmos ad=63.19999f pd=0.74u as=63.19999f ps=0.74u w=0.26u l=0.38u
X10238 MOT20_N MOT20_P cml_tlatch_54.xmux.xp.S1 VSS sg13_lv_nmos ad=56.9f pd=0.74u as=56.9f ps=0.74u w=0.17u l=0.17u
X10239 cml_tlatch_44.xmux.xp.S1 MOT28_P MOT28_N VSS sg13_lv_nmos ad=56.9f pd=0.74u as=56.9f ps=0.74u w=0.17u l=0.17u
X10240 VDD MOT3_N VSS rppd l=5.17u w=1u
X10241 cml_gate2_4.xamp.xn.S1 CKB3_P cml_gate2_4.xrtail.R1 VSS sg13_lv_nmos ad=0.1007p pd=0.91u as=0.1007p ps=0.91u w=0.53u l=0.13u
X10242 MOT9_P B1_8_N cml_tlatch_3.xmux.xn.S1 VSS sg13_lv_nmos ad=63.19999f pd=0.74u as=63.19999f ps=0.74u w=0.26u l=0.38u
X10243 A0_8_P A0_8_N cml_tlatch_9.xmux.xp.S1 VSS sg13_lv_nmos ad=56.9f pd=0.74u as=56.9f ps=0.74u w=0.17u l=0.17u
X10244 cml_tlatch_4.INN VDD VSS rppd l=5.17u w=1u
X10245 GB1_P ENB1_N cml_gate2_0.xamp.xn.S1 VSS sg13_lv_nmos ad=0.1007p pd=0.91u as=0.1007p ps=0.91u w=0.53u l=0.13u
X10246 cml_tlatch_36.xmux.xp.S1 B1_2_P B1_2_N VSS sg13_lv_nmos ad=56.9f pd=0.74u as=56.9f ps=0.74u w=0.17u l=0.17u
X10247 J2_N J1_P cml_tlatch_94.xmux.xn.S1 VSS sg13_lv_nmos ad=63.19999f pd=0.74u as=0.1082p ps=1.34u w=0.26u l=0.38u
X10248 cml_tlatch_15.xmux.xp.S1 CKHB0_N cml_tlatch_15.xtail.S1 VSS sg13_lv_nmos ad=89.3f pd=0.85u as=0.1598p ps=1.62u w=0.47u l=0.16u
X10249 cml_tlatch_89.xmux.xn.S1 CKA3_N cml_tlatch_89.xtail.S1 VSS sg13_lv_nmos ad=0.1598p pd=1.62u as=89.3f ps=0.85u w=0.47u l=0.16u
X10250 cml_tlatch_73.xtail.S1 CKHB3_P cml_tlatch_73.xmux.xn.S1 VSS sg13_lv_nmos ad=89.3f pd=0.85u as=89.3f ps=0.85u w=0.47u l=0.16u
X10251 cml_tlatch_91.OUTP cml_tlatch_91.INN cml_tlatch_91.xmux.xn.S1 VSS sg13_lv_nmos ad=63.19999f pd=0.74u as=0.1082p ps=1.34u w=0.26u l=0.38u
X10252 MOT6_N MOT6_P cml_tlatch_29.xmux.xp.S1 VSS sg13_lv_nmos ad=56.9f pd=0.74u as=56.9f ps=0.74u w=0.17u l=0.17u
X10253 cml_tlatch_68.xmux.xp.S1 A3_8_P A3_8_N VSS sg13_lv_nmos ad=56.9f pd=0.74u as=56.9f ps=0.74u w=0.17u l=0.17u
X10254 VDD CKHB0_P VSS rppd l=13.09u w=1u
X10255 cml_tlatch_61.OUTP cml_tlatch_61.OUTN cml_tlatch_61.xmux.xp.S1 VSS sg13_lv_nmos ad=56.9f pd=0.74u as=56.9f ps=0.74u w=0.17u l=0.17u
X10256 cml_tlatch_81.xmux.xp.S1 B2_8_N B2_8_P VSS sg13_lv_nmos ad=56.9f pd=0.74u as=56.9f ps=0.74u w=0.17u l=0.17u
X10257 B2_2_P stub_bi_43.BOTP cml_tlatch_47.xmux.xn.S1 VSS sg13_lv_nmos ad=63.19999f pd=0.74u as=63.19999f ps=0.74u w=0.26u l=0.38u
X10258 cml_tlatch_8.OUTP cml_tlatch_8.OUTN cml_tlatch_8.xmux.xp.S1 VSS sg13_lv_nmos ad=56.9f pd=0.74u as=56.9f ps=0.74u w=0.17u l=0.17u
X10259 cml_tlatch_19.xmux.xn.S1 cml_tlatch_20.OUTP A1_8_N VSS sg13_lv_nmos ad=63.19999f pd=0.74u as=63.19999f ps=0.74u w=0.26u l=0.38u
X10260 cml_tlatch_71.xmux.xn.S1 CKA3_P cml_tlatch_71.xtail.S1 VSS sg13_lv_nmos ad=89.3f pd=0.85u as=89.3f ps=0.85u w=0.47u l=0.16u
X10261 cml_tlatch_15.xmux.xp.S1 MOT3_P MOT3_N VSS sg13_lv_nmos ad=56.9f pd=0.74u as=56.9f ps=0.74u w=0.17u l=0.17u
X10262 cml_tlatch_20.OUTN cml_tlatch_20.OUTP cml_tlatch_20.xmux.xp.S1 VSS sg13_lv_nmos ad=56.9f pd=0.74u as=56.9f ps=0.74u w=0.17u l=0.17u
X10263 cml_tlatch_58.OUTN cml_tlatch_58.OUTP cml_tlatch_58.xmux.xp.S1 VSS sg13_lv_nmos ad=56.9f pd=0.74u as=56.9f ps=0.74u w=0.17u l=0.17u
X10264 cml_tlatch_18.xmux.xp.S1 cml_tlatch_18.OUTN cml_tlatch_18.OUTP VSS sg13_lv_nmos ad=56.9f pd=0.74u as=56.9f ps=0.74u w=0.17u l=0.17u
X10265 stub_bi_17.BOTP stub_bi_17.BOTN cml_tlatch_13.xmux.xp.S1 VSS sg13_lv_nmos ad=56.9f pd=0.74u as=56.9f ps=0.74u w=0.17u l=0.17u
X10266 VSS POLN cml_tlatch_50.xtail.S1 VSS sg13_lv_nmos ad=2.7982p pd=17.14u as=1.5637p ps=8.61u w=8.23u l=0.13u
X10267 cml_tlatch_43.INN cml_tlatch_43.INP cml_tlatch_21.xmux.xp.S1 VSS sg13_lv_nmos ad=56.9f pd=0.74u as=56.9f ps=0.74u w=0.17u l=0.17u
X10268 cml_tlatch_53.xmux.xp.S1 MOT18_P MOT18_N VSS sg13_lv_nmos ad=56.9f pd=0.74u as=56.9f ps=0.74u w=0.17u l=0.17u
X10269 cml_tlatch_31.xmux.xp.S1 B0_2_P B0_2_N VSS sg13_lv_nmos ad=56.9f pd=0.74u as=56.9f ps=0.74u w=0.17u l=0.17u
X10270 A2_2_N A2_2_P cml_tlatch_60.xmux.xp.S1 VSS sg13_lv_nmos ad=56.9f pd=0.74u as=0.1019p ps=1.34u w=0.17u l=0.17u
X10271 MOT26_N MOT26_P cml_tlatch_63.xmux.xp.S1 VSS sg13_lv_nmos ad=56.9f pd=0.74u as=56.9f ps=0.74u w=0.17u l=0.17u
X10272 cml_tlatch_56.xmux.xp.S1 cml_tlatch_56.OUTN cml_tlatch_56.OUTP VSS sg13_lv_nmos ad=56.9f pd=0.74u as=56.9f ps=0.74u w=0.17u l=0.17u
X10273 cml_tlatch_93.xmux.xp.S1 CKJ_N cml_tlatch_93.xtail.S1 VSS sg13_lv_nmos ad=89.3f pd=0.85u as=89.3f ps=0.85u w=0.47u l=0.16u
X10274 VDD hs_to_clk_8.sg13_lv_nmos_2HGZLP_0.G VSS rppd l=0.68u w=1u
X10275 cml_tlatch_98.OUTP cml_tlatch_98.OUTN cml_tlatch_98.xmux.xp.S1 VSS sg13_lv_nmos ad=56.9f pd=0.74u as=56.9f ps=0.74u w=0.17u l=0.17u
X10276 cml_tlatch_42.xtail.S1 POLN VSS VSS sg13_lv_nmos ad=1.5637p pd=8.61u as=2.7982p ps=17.14u w=8.23u l=0.13u
X10277 cml_tlatch_93.xmux.xp.S1 CLK_W_N CLK_W_P VSS sg13_lv_nmos ad=56.9f pd=0.74u as=56.9f ps=0.74u w=0.17u l=0.17u
X10278 cml_tlatch_30.xmux.xn.S1 B0_2_P cml_tlatch_30.OUTN VSS sg13_lv_nmos ad=63.19999f pd=0.74u as=0.1082p ps=1.34u w=0.26u l=0.38u
X10279 cml_tlatch_38.xtail.S1 CKA0_N cml_tlatch_38.xmux.xp.S1 VSS sg13_lv_nmos ad=89.3f pd=0.85u as=89.3f ps=0.85u w=0.47u l=0.16u
X10280 cml_tlatch_89.xmux.xp.S1 CKA3_P cml_tlatch_89.xtail.S1 VSS sg13_lv_nmos ad=89.3f pd=0.85u as=89.3f ps=0.85u w=0.47u l=0.16u
X10281 cml_tlatch_16.xtail.S1 CKHB0_N cml_tlatch_16.xmux.xp.S1 VSS sg13_lv_nmos ad=89.3f pd=0.85u as=89.3f ps=0.85u w=0.47u l=0.16u
X10282 cml_tlatch_78.xmux.xp.S1 CKHB2_N cml_tlatch_78.xtail.S1 VSS sg13_lv_nmos ad=89.3f pd=0.85u as=89.3f ps=0.85u w=0.47u l=0.16u
X10283 cml_tlatch_43.xmux.xp.S1 MOT10_P MOT10_N VSS sg13_lv_nmos ad=56.9f pd=0.74u as=56.9f ps=0.74u w=0.17u l=0.17u
X10284 cml_tlatch_82.xmux.xp.S1 stub_bi_62.BOTP stub_bi_62.BOTN VSS sg13_lv_nmos ad=0.1019p pd=1.34u as=56.9f ps=0.74u w=0.17u l=0.17u
X10285 cml_tlatch_24.xtail.S1 CKHA1_P cml_tlatch_24.xmux.xn.S1 VSS sg13_lv_nmos ad=89.3f pd=0.85u as=0.1598p ps=1.62u w=0.47u l=0.16u
X10286 cml_tlatch_79.xmux.xp.S1 MOT21_P MOT21_N VSS sg13_lv_nmos ad=56.9f pd=0.74u as=56.9f ps=0.74u w=0.17u l=0.17u
X10287 CKHB1_N VDD VSS rppd l=13.09u w=1u
X10288 cml_tlatch_67.OUTN cml_tlatch_67.OUTP cml_tlatch_67.xmux.xp.S1 VSS sg13_lv_nmos ad=56.9f pd=0.74u as=56.9f ps=0.74u w=0.17u l=0.17u
X10289 cml_gate2_6.xamp.xn.S1 ENB0_P GB3_N VSS sg13_lv_nmos ad=0.1007p pd=0.91u as=0.1007p ps=0.91u w=0.53u l=0.13u
X10290 MOT5_P cml_tlatch_98.OUTN cml_tlatch_16.xmux.xn.S1 VSS sg13_lv_nmos ad=0.1082p pd=1.34u as=63.19999f ps=0.74u w=0.26u l=0.38u
X10291 MOT15_P MOT15_N cml_tlatch_6.xmux.xp.S1 VSS sg13_lv_nmos ad=56.9f pd=0.74u as=56.9f ps=0.74u w=0.17u l=0.17u
X10292 cml_tlatch_82.xmux.xn.S1 stub_bi_63.BOTP stub_bi_62.BOTN VSS sg13_lv_nmos ad=63.19999f pd=0.74u as=0.1082p ps=1.34u w=0.26u l=0.38u
X10293 B1_2_N stub_bi_31.BOTN cml_tlatch_36.xmux.xn.S1 VSS sg13_lv_nmos ad=63.19999f pd=0.74u as=63.19999f ps=0.74u w=0.26u l=0.38u
X10294 ENB0_N ENB_P cml_drv_2.xrtail.R1 VSS sg13_lv_nmos ad=56.2f pd=0.74u as=56.2f ps=0.74u w=0.16u l=0.19u
X10295 cml_tlatch_48.xtail.S1 CKB2_N cml_tlatch_48.xmux.xp.S1 VSS sg13_lv_nmos ad=89.3f pd=0.85u as=89.3f ps=0.85u w=0.47u l=0.16u
X10296 VDD A0_2_P VSS rppd l=5.17u w=1u
X10297 cml_tlatch_12.xtail.S1 CKB1_N cml_tlatch_12.xmux.xn.S1 VSS sg13_lv_nmos ad=89.3f pd=0.85u as=89.3f ps=0.85u w=0.47u l=0.16u
X10298 cml_tlatch_92.xmux.xp.S1 J4_N J4_P VSS sg13_lv_nmos ad=56.9f pd=0.74u as=56.9f ps=0.74u w=0.17u l=0.17u
X10299 MOT2_N cml_tlatch_23.OUTP cml_tlatch_27.xmux.xn.S1 VSS sg13_lv_nmos ad=63.19999f pd=0.74u as=63.19999f ps=0.74u w=0.26u l=0.38u
X10300 cml_tlatch_88.xmux.xp.S1 CKB3_P cml_tlatch_88.xtail.S1 VSS sg13_lv_nmos ad=89.3f pd=0.85u as=89.3f ps=0.85u w=0.47u l=0.16u
X10301 hs_to_clk_1.D2 CK_P CKB0_N VSS sg13_lv_nmos ad=0.228p pd=1.58u as=0.408p ps=3.08u w=1.2u l=0.2u
X10302 stub_bi_31.BOTN D1_N cml_tlatch_37.xmux.xn.S1 VSS sg13_lv_nmos ad=63.19999f pd=0.74u as=63.19999f ps=0.74u w=0.26u l=0.38u
X10303 cml_tlatch_5.xmux.xp.S1 MOT13_P MOT13_N VSS sg13_lv_nmos ad=56.9f pd=0.74u as=56.9f ps=0.74u w=0.17u l=0.17u
X10304 cml_tlatch_24.INP cml_tlatch_24.INN cml_tlatch_97.xmux.xp.S1 VSS sg13_lv_nmos ad=56.9f pd=0.74u as=56.9f ps=0.74u w=0.17u l=0.17u
X10305 J1_N J1_P cml_tlatch_95.xmux.xp.S1 VSS sg13_lv_nmos ad=56.9f pd=0.74u as=56.9f ps=0.74u w=0.17u l=0.17u
X10306 cml_tlatch_50.xmux.xn.S1 cml_tlatch_51.OUTP B3_2_N VSS sg13_lv_nmos ad=63.19999f pd=0.74u as=63.19999f ps=0.74u w=0.26u l=0.38u
X10307 VSS cml_gate2_0.xrtail.R1 VSS rppd l=4.86u w=1u
X10308 cml_tlatch_13.xmux.xn.S1 CKB1_P cml_tlatch_13.xtail.S1 VSS sg13_lv_nmos ad=89.3f pd=0.85u as=89.3f ps=0.85u w=0.47u l=0.16u
X10309 cml_tlatch_71.xmux.xp.S1 cml_tlatch_71.OUTN cml_tlatch_71.OUTP VSS sg13_lv_nmos ad=56.9f pd=0.74u as=56.9f ps=0.74u w=0.17u l=0.17u
X10310 cml_tlatch_58.xmux.xn.S1 D3_P cml_tlatch_58.OUTN VSS sg13_lv_nmos ad=63.19999f pd=0.74u as=63.19999f ps=0.74u w=0.26u l=0.38u
X10311 cml_tlatch_46.xmux.xn.S1 CKB2_P cml_tlatch_46.xtail.S1 VSS sg13_lv_nmos ad=89.3f pd=0.85u as=89.3f ps=0.85u w=0.47u l=0.16u
X10312 A0_2_P A0_2_N cml_tlatch_34.xmux.xp.S1 VSS sg13_lv_nmos ad=56.9f pd=0.74u as=56.9f ps=0.74u w=0.17u l=0.17u
X10313 hs_to_clk_6.D2 CK_P CKA3_P VSS sg13_lv_nmos ad=0.228p pd=1.58u as=0.228p ps=1.58u w=1.2u l=0.2u
X10314 J4_N J4_P cml_tlatch_92.xmux.xp.S1 VSS sg13_lv_nmos ad=56.9f pd=0.74u as=56.9f ps=0.74u w=0.17u l=0.17u
X10315 cml_tlatch_56.xmux.xn.S1 CKA3_P cml_tlatch_56.xtail.S1 VSS sg13_lv_nmos ad=89.3f pd=0.85u as=89.3f ps=0.85u w=0.47u l=0.16u
X10316 CKB2_P hs_to_clk_4.sg13_lv_nmos_2HGZLP_0.G VSS rppd l=4.25u w=1u
X10317 A2_2_N A2_2_P cml_tlatch_60.xmux.xp.S1 VSS sg13_lv_nmos ad=56.9f pd=0.74u as=56.9f ps=0.74u w=0.17u l=0.17u
X10318 cml_tlatch_74.INN cml_tlatch_74.INP cml_tlatch_88.xmux.xp.S1 VSS sg13_lv_nmos ad=56.9f pd=0.74u as=56.9f ps=0.74u w=0.17u l=0.17u
X10319 cml_tlatch_30.OUTP cml_tlatch_30.OUTN cml_tlatch_30.xmux.xp.S1 VSS sg13_lv_nmos ad=56.9f pd=0.74u as=56.9f ps=0.74u w=0.17u l=0.17u
X10320 cml_tlatch_38.xmux.xp.S1 cml_tlatch_38.OUTN cml_tlatch_38.OUTP VSS sg13_lv_nmos ad=0.1019p pd=1.34u as=56.9f ps=0.74u w=0.17u l=0.17u
X10321 MOT31_P MOT31_N cml_tlatch_75.xmux.xp.S1 VSS sg13_lv_nmos ad=56.9f pd=0.74u as=56.9f ps=0.74u w=0.17u l=0.17u
X10322 VDD A2_8_P VSS rppd l=5.17u w=1u
X10323 cml_tlatch_71.OUTN cml_tlatch_44.INP cml_tlatch_71.xmux.xn.S1 VSS sg13_lv_nmos ad=63.19999f pd=0.74u as=63.19999f ps=0.74u w=0.26u l=0.38u
X10324 J1_P J1_N cml_tlatch_95.xmux.xp.S1 VSS sg13_lv_nmos ad=56.9f pd=0.74u as=56.9f ps=0.74u w=0.17u l=0.17u
X10325 cml_tlatch_67.xmux.xp.S1 cml_tlatch_67.OUTP cml_tlatch_67.OUTN VSS sg13_lv_nmos ad=56.9f pd=0.74u as=56.9f ps=0.74u w=0.17u l=0.17u
X10326 cml_tlatch_70.xmux.xp.S1 cml_tlatch_63.INP cml_tlatch_63.INN VSS sg13_lv_nmos ad=56.9f pd=0.74u as=56.9f ps=0.74u w=0.17u l=0.17u
X10327 cml_tlatch_50.xmux.xp.S1 CKB3_P cml_tlatch_50.xtail.S1 VSS sg13_lv_nmos ad=89.3f pd=0.85u as=89.3f ps=0.85u w=0.47u l=0.16u
X10328 cml_tlatch_44.xmux.xp.S1 MOT28_P MOT28_N VSS sg13_lv_nmos ad=56.9f pd=0.74u as=56.9f ps=0.74u w=0.17u l=0.17u
X10329 cml_tlatch_96.xmux.xp.S1 cml_tlatch_5.INP cml_tlatch_5.INN VSS sg13_lv_nmos ad=56.9f pd=0.74u as=56.9f ps=0.74u w=0.17u l=0.17u
X10330 cml_tlatch_60.xmux.xp.S1 A2_2_N A2_2_P VSS sg13_lv_nmos ad=56.9f pd=0.74u as=56.9f ps=0.74u w=0.17u l=0.17u
X10331 cml_tlatch_26.xmux.xp.S1 MOT0_N MOT0_P VSS sg13_lv_nmos ad=56.9f pd=0.74u as=56.9f ps=0.74u w=0.17u l=0.17u
X10332 hs_to_clk_1.D2 CK_N CKB0_P VSS sg13_lv_nmos ad=0.228p pd=1.58u as=0.408p ps=3.08u w=1.2u l=0.2u
X10333 cml_tlatch_34.xmux.xn.S1 cml_tlatch_38.OUTP A0_2_N VSS sg13_lv_nmos ad=63.19999f pd=0.74u as=63.19999f ps=0.74u w=0.26u l=0.38u
X10334 MOT11_N MOT11_P cml_tlatch_4.xmux.xp.S1 VSS sg13_lv_nmos ad=56.9f pd=0.74u as=56.9f ps=0.74u w=0.17u l=0.17u
X10335 cml_tlatch_65.xmux.xp.S1 cml_tlatch_65.OUTP cml_tlatch_65.OUTN VSS sg13_lv_nmos ad=56.9f pd=0.74u as=56.9f ps=0.74u w=0.17u l=0.17u
X10336 MOT12_N MOT12_P cml_tlatch_24.xmux.xp.S1 VSS sg13_lv_nmos ad=56.9f pd=0.74u as=56.9f ps=0.74u w=0.17u l=0.17u
X10337 cml_tlatch_62.xmux.xp.S1 CKHA3_N cml_tlatch_62.xtail.S1 VSS sg13_lv_nmos ad=89.3f pd=0.85u as=89.3f ps=0.85u w=0.47u l=0.16u
X10338 A0_8_N A0_8_P cml_tlatch_9.xmux.xp.S1 VSS sg13_lv_nmos ad=56.9f pd=0.74u as=56.9f ps=0.74u w=0.17u l=0.17u
X10339 cml_tlatch_15.xmux.xn.S1 CKHB0_P cml_tlatch_15.xtail.S1 VSS sg13_lv_nmos ad=89.3f pd=0.85u as=89.3f ps=0.85u w=0.47u l=0.16u
X10340 cml_tlatch_12.xmux.xp.S1 cml_tlatch_4.INP cml_tlatch_4.INN VSS sg13_lv_nmos ad=56.9f pd=0.74u as=56.9f ps=0.74u w=0.17u l=0.17u
X10341 cml_gate2_5.xamp.xn.S1 CKB2_P cml_gate2_5.xrtail.R1 VSS sg13_lv_nmos ad=0.1007p pd=0.91u as=0.1007p ps=0.91u w=0.53u l=0.13u
X10342 cml_tlatch_45.xmux.xn.S1 A3_2_P MOT30_N VSS sg13_lv_nmos ad=0.1082p pd=1.34u as=63.19999f ps=0.74u w=0.26u l=0.38u
X10343 cml_tlatch_48.xmux.xp.S1 stub_bi_43.BOTP stub_bi_43.BOTN VSS sg13_lv_nmos ad=0.1019p pd=1.34u as=56.9f ps=0.74u w=0.17u l=0.17u
X10344 cml_tlatch_8.xmux.xp.S1 cml_tlatch_8.OUTP cml_tlatch_8.OUTN VSS sg13_lv_nmos ad=56.9f pd=0.74u as=56.9f ps=0.74u w=0.17u l=0.17u
X10345 cml_tlatch_30.xtail.S1 POLN VSS VSS sg13_lv_nmos ad=1.5637p pd=8.61u as=1.5637p ps=8.61u w=8.23u l=0.13u
X10346 cml_tlatch_6.xmux.xn.S1 CKHB1_P cml_tlatch_6.xtail.S1 VSS sg13_lv_nmos ad=89.3f pd=0.85u as=89.3f ps=0.85u w=0.47u l=0.16u
X10347 cml_tlatch_79.xmux.xn.S1 CKHB2_P cml_tlatch_79.xtail.S1 VSS sg13_lv_nmos ad=89.3f pd=0.85u as=89.3f ps=0.85u w=0.47u l=0.16u
X10348 cml_tlatch_55.xmux.xp.S1 MOT22_P MOT22_N VSS sg13_lv_nmos ad=56.9f pd=0.74u as=56.9f ps=0.74u w=0.17u l=0.17u
X10349 cml_tlatch_60.xmux.xn.S1 cml_tlatch_61.OUTP A2_2_N VSS sg13_lv_nmos ad=63.19999f pd=0.74u as=63.19999f ps=0.74u w=0.26u l=0.38u
X10350 cml_tlatch_26.xmux.xn.S1 A0_8_P MOT0_N VSS sg13_lv_nmos ad=63.19999f pd=0.74u as=63.19999f ps=0.74u w=0.26u l=0.38u
X10351 cml_tlatch_55.xmux.xn.S1 A2_2_N MOT22_P VSS sg13_lv_nmos ad=63.19999f pd=0.74u as=63.19999f ps=0.74u w=0.26u l=0.38u
X10352 cml_tlatch_95.xmux.xp.S1 J1_P J1_N VSS sg13_lv_nmos ad=56.9f pd=0.74u as=56.9f ps=0.74u w=0.17u l=0.17u
X10353 VSS POLN cml_tlatch_26.xtail.S1 VSS sg13_lv_nmos ad=1.5637p pd=8.61u as=1.5637p ps=8.61u w=8.23u l=0.13u
X10354 cml_tlatch_61.xtail.S1 CKA2_P cml_tlatch_61.xmux.xn.S1 VSS sg13_lv_nmos ad=89.3f pd=0.85u as=89.3f ps=0.85u w=0.47u l=0.16u
X10355 MOT2_P MOT2_N cml_tlatch_27.xmux.xp.S1 VSS sg13_lv_nmos ad=56.9f pd=0.74u as=56.9f ps=0.74u w=0.17u l=0.17u
X10356 cml_tlatch_7.xmux.xp.S1 cml_tlatch_7.OUTN cml_tlatch_7.OUTP VSS sg13_lv_nmos ad=0.1019p pd=1.34u as=56.9f ps=0.74u w=0.17u l=0.17u
X10357 cml_tlatch_7.xtail.S1 CKB0_N cml_tlatch_7.xmux.xn.S1 VSS sg13_lv_nmos ad=89.3f pd=0.85u as=89.3f ps=0.85u w=0.47u l=0.16u
X10358 A3_8_P A3_8_N cml_tlatch_68.xmux.xp.S1 VSS sg13_lv_nmos ad=56.9f pd=0.74u as=56.9f ps=0.74u w=0.17u l=0.17u
X10359 MOT15_P B1_2_N cml_tlatch_6.xmux.xn.S1 VSS sg13_lv_nmos ad=63.19999f pd=0.74u as=63.19999f ps=0.74u w=0.26u l=0.38u
X10360 cml_tlatch_88.xmux.xp.S1 cml_tlatch_74.INN cml_tlatch_74.INP VSS sg13_lv_nmos ad=56.9f pd=0.74u as=56.9f ps=0.74u w=0.17u l=0.17u
X10361 cml_tlatch_56.OUTN A3_2_P cml_tlatch_56.xmux.xn.S1 VSS sg13_lv_nmos ad=0.1082p pd=1.34u as=63.19999f ps=0.74u w=0.26u l=0.38u
X10362 cml_tlatch_28.xmux.xp.S1 MOT4_N MOT4_P VSS sg13_lv_nmos ad=56.9f pd=0.74u as=56.9f ps=0.74u w=0.17u l=0.17u
X10363 cml_drv_1.xrtail.R1 ENA_P ENA1_N VSS sg13_lv_nmos ad=56.2f pd=0.74u as=56.2f ps=0.74u w=0.16u l=0.19u
X10364 stub_bi_62.BOTP VDD VSS rppd l=5.17u w=1u
X10365 cml_tlatch_22.xmux.xp.S1 CKA1_N cml_tlatch_22.xtail.S1 VSS sg13_lv_nmos ad=89.3f pd=0.85u as=89.3f ps=0.85u w=0.47u l=0.16u
X10366 MOT29_N MOT29_P cml_tlatch_74.xmux.xp.S1 VSS sg13_lv_nmos ad=56.9f pd=0.74u as=56.9f ps=0.74u w=0.17u l=0.17u
X10367 VDD A2_2_P VSS rppd l=5.17u w=1u
X10368 cml_tlatch_46.xmux.xp.S1 stub_bi_38.BOTN stub_bi_38.BOTP VSS sg13_lv_nmos ad=56.9f pd=0.74u as=56.9f ps=0.74u w=0.17u l=0.17u
X10369 cml_tlatch_70.xmux.xn.S1 CKA3_N cml_tlatch_70.xtail.S1 VSS sg13_lv_nmos ad=89.3f pd=0.85u as=89.3f ps=0.85u w=0.47u l=0.16u
X10370 cml_tlatch_19.xmux.xp.S1 A1_8_N A1_8_P VSS sg13_lv_nmos ad=56.9f pd=0.74u as=56.9f ps=0.74u w=0.17u l=0.17u
X10371 cml_tlatch_48.xtail.S1 CKB2_P cml_tlatch_48.xmux.xn.S1 VSS sg13_lv_nmos ad=89.3f pd=0.85u as=89.3f ps=0.85u w=0.47u l=0.16u
X10372 MOT1_P MOT1_N cml_tlatch_14.xmux.xp.S1 VSS sg13_lv_nmos ad=56.9f pd=0.74u as=56.9f ps=0.74u w=0.17u l=0.17u
X10373 B1_8_P B1_8_N cml_tlatch_10.xmux.xp.S1 VSS sg13_lv_nmos ad=56.9f pd=0.74u as=56.9f ps=0.74u w=0.17u l=0.17u
X10374 VSS POLN cml_tlatch_41.xtail.S1 VSS sg13_lv_nmos ad=2.7982p pd=17.14u as=1.5637p ps=8.61u w=8.23u l=0.13u
X10375 cml_tlatch_25.xmux.xp.S1 MOT14_N MOT14_P VSS sg13_lv_nmos ad=56.9f pd=0.74u as=56.9f ps=0.74u w=0.17u l=0.17u
X10376 cml_tlatch_58.xtail.S1 CKA3_P cml_tlatch_58.xmux.xn.S1 VSS sg13_lv_nmos ad=89.3f pd=0.85u as=89.3f ps=0.85u w=0.47u l=0.16u
X10377 cml_tlatch_5.xmux.xp.S1 MOT13_P MOT13_N VSS sg13_lv_nmos ad=56.9f pd=0.74u as=56.9f ps=0.74u w=0.17u l=0.17u
X10378 cml_tlatch_0.xmux.xn.S1 cml_tlatch_99.OUTP cml_tlatch_0.OUTN VSS sg13_lv_nmos ad=63.19999f pd=0.74u as=63.19999f ps=0.74u w=0.26u l=0.38u
X10379 GB0_P CKA0_N cml_gate2_1.xrtail.R1 VSS sg13_lv_nmos ad=0.1007p pd=0.91u as=0.1007p ps=0.91u w=0.53u l=0.13u
X10380 J1_N J1_P cml_tlatch_95.xmux.xp.S1 VSS sg13_lv_nmos ad=56.9f pd=0.74u as=56.9f ps=0.74u w=0.17u l=0.17u
X10381 cml_tlatch_73.INP cml_tlatch_67.OUTN cml_tlatch_66.xmux.xn.S1 VSS sg13_lv_nmos ad=63.19999f pd=0.74u as=63.19999f ps=0.74u w=0.26u l=0.38u
X10382 stub_bi_43.BOTP stub_bi_43.BOTN cml_tlatch_48.xmux.xp.S1 VSS sg13_lv_nmos ad=56.9f pd=0.74u as=56.9f ps=0.74u w=0.17u l=0.17u
X10383 cml_gate2_7.xamp.xn.S1 ENB0_P GB2_N VSS sg13_lv_nmos ad=0.1007p pd=0.91u as=0.1007p ps=0.91u w=0.53u l=0.13u
X10384 cml_tlatch_13.xmux.xp.S1 CKB1_N cml_tlatch_13.xtail.S1 VSS sg13_lv_nmos ad=89.3f pd=0.85u as=89.3f ps=0.85u w=0.47u l=0.16u
X10385 A0_2_P A0_2_N cml_tlatch_34.xmux.xp.S1 VSS sg13_lv_nmos ad=56.9f pd=0.74u as=56.9f ps=0.74u w=0.17u l=0.17u
X10386 cml_tlatch_0.xmux.xn.S1 cml_tlatch_99.OUTN cml_tlatch_0.OUTP VSS sg13_lv_nmos ad=63.19999f pd=0.74u as=63.19999f ps=0.74u w=0.26u l=0.38u
X10387 cml_tlatch_10.xmux.xn.S1 stub_bi_15.BOTP B1_8_P VSS sg13_lv_nmos ad=0.1082p pd=1.34u as=63.19999f ps=0.74u w=0.26u l=0.38u
X10388 cml_tlatch_93.xtail.S1 CKJ_N cml_tlatch_93.xmux.xp.S1 VSS sg13_lv_nmos ad=89.3f pd=0.85u as=89.3f ps=0.85u w=0.47u l=0.16u
X10389 cml_tlatch_66.xmux.xn.S1 CKB3_N cml_tlatch_66.xtail.S1 VSS sg13_lv_nmos ad=89.3f pd=0.85u as=89.3f ps=0.85u w=0.47u l=0.16u
X10390 MOT23_N MOT23_P cml_tlatch_80.xmux.xp.S1 VSS sg13_lv_nmos ad=56.9f pd=0.74u as=56.9f ps=0.74u w=0.17u l=0.17u
X10391 cml_tlatch_29.xtail.S1 CKHA0_N cml_tlatch_29.xmux.xp.S1 VSS sg13_lv_nmos ad=89.3f pd=0.85u as=89.3f ps=0.85u w=0.47u l=0.16u
X10392 cml_tlatch_65.xmux.xp.S1 cml_tlatch_65.OUTP cml_tlatch_65.OUTN VSS sg13_lv_nmos ad=56.9f pd=0.74u as=56.9f ps=0.74u w=0.17u l=0.17u
X10393 cml_tlatch_56.OUTN cml_tlatch_56.OUTP cml_tlatch_56.xmux.xp.S1 VSS sg13_lv_nmos ad=56.9f pd=0.74u as=0.1019p ps=1.34u w=0.17u l=0.17u
X10394 MOT21_N stub_bi_55.BOTN cml_tlatch_79.xmux.xn.S1 VSS sg13_lv_nmos ad=63.19999f pd=0.74u as=0.1082p ps=1.34u w=0.26u l=0.38u
X10395 VSS POLN cml_tlatch_91.xtail.S1 VSS sg13_lv_nmos ad=2.7982p pd=17.14u as=1.5637p ps=8.61u w=8.23u l=0.13u
X10396 cml_tlatch_86.OUTN cml_tlatch_86.OUTP cml_tlatch_86.xmux.xp.S1 VSS sg13_lv_nmos ad=56.9f pd=0.74u as=56.9f ps=0.74u w=0.17u l=0.17u
X10397 cml_tlatch_78.xtail.S1 CKHB2_N cml_tlatch_78.xmux.xp.S1 VSS sg13_lv_nmos ad=89.3f pd=0.85u as=89.3f ps=0.85u w=0.47u l=0.16u
X10398 hs_to_clk_5.D2 CK_P CKB3_N VSS sg13_lv_nmos ad=0.228p pd=1.58u as=0.408p ps=3.08u w=1.2u l=0.2u
X10399 VSS hs_to_clk_7.sg13_lv_nmos_2HGZLP_0.G VSS VSS sg13_lv_nmos ad=2.071p pd=11.28u as=0 ps=0 w=10.9u l=1.38u
X10400 cml_tlatch_45.xmux.xp.S1 MOT30_P MOT30_N VSS sg13_lv_nmos ad=56.9f pd=0.74u as=56.9f ps=0.74u w=0.17u l=0.17u
X10401 cml_tlatch_45.xmux.xp.S1 MOT30_N MOT30_P VSS sg13_lv_nmos ad=56.9f pd=0.74u as=56.9f ps=0.74u w=0.17u l=0.17u
X10402 cml_tlatch_99.xmux.xp.S1 CKA0_P cml_tlatch_99.xtail.S1 VSS sg13_lv_nmos ad=89.3f pd=0.85u as=89.3f ps=0.85u w=0.47u l=0.16u
X10403 cml_tlatch_15.xmux.xp.S1 MOT3_N MOT3_P VSS sg13_lv_nmos ad=56.9f pd=0.74u as=56.9f ps=0.74u w=0.17u l=0.17u
X10404 cml_tlatch_26.xmux.xp.S1 MOT0_N MOT0_P VSS sg13_lv_nmos ad=56.9f pd=0.74u as=56.9f ps=0.74u w=0.17u l=0.17u
X10405 cml_tlatch_19.xtail.S1 CKA1_N cml_tlatch_19.xmux.xn.S1 VSS sg13_lv_nmos ad=89.3f pd=0.85u as=89.3f ps=0.85u w=0.47u l=0.16u
X10406 ENB1_N ENB_P cml_drv_0.xrtail.R1 VSS sg13_lv_nmos ad=56.2f pd=0.74u as=56.2f ps=0.74u w=0.16u l=0.19u
X10407 hs_to_clk_5.D2 CK_N CKB3_P VSS sg13_lv_nmos ad=0.408p pd=3.08u as=0.228p ps=1.58u w=1.2u l=0.2u
X10408 cml_tlatch_5.INP stub_bi_29.BOTP cml_tlatch_96.xmux.xn.S1 VSS sg13_lv_nmos ad=63.19999f pd=0.74u as=63.19999f ps=0.74u w=0.26u l=0.38u
X10409 cml_tlatch_3.xmux.xn.S1 CKHB1_P cml_tlatch_3.xtail.S1 VSS sg13_lv_nmos ad=89.3f pd=0.85u as=89.3f ps=0.85u w=0.47u l=0.16u
X10410 cml_tlatch_76.xmux.xp.S1 cml_tlatch_87.INP cml_tlatch_87.INN VSS sg13_lv_nmos ad=0.1019p pd=1.34u as=56.9f ps=0.74u w=0.17u l=0.17u
X10411 cml_tlatch_73.xtail.S1 CKHB3_N cml_tlatch_73.xmux.xp.S1 VSS sg13_lv_nmos ad=89.3f pd=0.85u as=89.3f ps=0.85u w=0.47u l=0.16u
X10412 cml_tlatch_88.xmux.xn.S1 cml_tlatch_49.OUTN cml_tlatch_74.INP VSS sg13_lv_nmos ad=63.19999f pd=0.74u as=63.19999f ps=0.74u w=0.26u l=0.38u
X10413 cml_tlatch_73.xmux.xn.S1 cml_tlatch_73.INN MOT27_P VSS sg13_lv_nmos ad=63.19999f pd=0.74u as=0.1082p ps=1.34u w=0.26u l=0.38u
X10414 VSS hs_to_clk_5.sg13_lv_nmos_2HGZLP_0.G VSS VSS sg13_lv_nmos ad=2.071p pd=11.28u as=0 ps=0 w=10.9u l=1.38u
X10415 cml_tlatch_89.xmux.xn.S1 CKA3_N cml_tlatch_89.xtail.S1 VSS sg13_lv_nmos ad=89.3f pd=0.85u as=89.3f ps=0.85u w=0.47u l=0.16u
X10416 cml_tlatch_7.OUTN cml_tlatch_7.OUTP cml_tlatch_7.xmux.xp.S1 VSS sg13_lv_nmos ad=56.9f pd=0.74u as=56.9f ps=0.74u w=0.17u l=0.17u
X10417 cml_tlatch_17.xmux.xp.S1 MOT7_P MOT7_N VSS sg13_lv_nmos ad=56.9f pd=0.74u as=56.9f ps=0.74u w=0.17u l=0.17u
X10418 cml_gate2_6.xamp.xn.S1 CKA3_P cml_gate2_6.xrtail.R1 VSS sg13_lv_nmos ad=0.1007p pd=0.91u as=0.1007p ps=0.91u w=0.53u l=0.13u
X10419 MOT27_N cml_tlatch_73.INP cml_tlatch_73.xmux.xn.S1 VSS sg13_lv_nmos ad=63.19999f pd=0.74u as=63.19999f ps=0.74u w=0.26u l=0.38u
X10420 cml_tlatch_87.INP cml_tlatch_87.INN cml_tlatch_76.xmux.xp.S1 VSS sg13_lv_nmos ad=56.9f pd=0.74u as=56.9f ps=0.74u w=0.17u l=0.17u
X10421 cml_tlatch_84.xmux.xp.S1 stub_bi_49.BOTP stub_bi_49.BOTN VSS sg13_lv_nmos ad=56.9f pd=0.74u as=56.9f ps=0.74u w=0.17u l=0.17u
X10422 cml_tlatch_45.xtail.S1 CKHA3_P cml_tlatch_45.xmux.xn.S1 VSS sg13_lv_nmos ad=89.3f pd=0.85u as=89.3f ps=0.85u w=0.47u l=0.16u
X10423 cml_tlatch_40.xmux.xp.S1 A1_2_P A1_2_N VSS sg13_lv_nmos ad=56.9f pd=0.74u as=56.9f ps=0.74u w=0.17u l=0.17u
X10424 cml_tlatch_90.xmux.xp.S1 stub_bi_55.BOTN stub_bi_55.BOTP VSS sg13_lv_nmos ad=56.9f pd=0.74u as=56.9f ps=0.74u w=0.17u l=0.17u
X10425 cml_tlatch_24.xmux.xn.S1 cml_tlatch_24.INN MOT12_P VSS sg13_lv_nmos ad=63.19999f pd=0.74u as=63.19999f ps=0.74u w=0.26u l=0.38u
X10426 cml_tlatch_78.xmux.xp.S1 MOT19_N MOT19_P VSS sg13_lv_nmos ad=56.9f pd=0.74u as=56.9f ps=0.74u w=0.17u l=0.17u
X10427 cml_tlatch_32.OUTN cml_tlatch_32.OUTP cml_tlatch_32.xmux.xp.S1 VSS sg13_lv_nmos ad=56.9f pd=0.74u as=56.9f ps=0.74u w=0.17u l=0.17u
X10428 B2_8_N stub_bi_62.BOTN cml_tlatch_81.xmux.xn.S1 VSS sg13_lv_nmos ad=63.19999f pd=0.74u as=63.19999f ps=0.74u w=0.26u l=0.38u
X10429 VSS POLN cml_tlatch_35.xtail.S1 VSS sg13_lv_nmos ad=2.7982p pd=17.14u as=1.5637p ps=8.61u w=8.23u l=0.13u
X10430 cml_tlatch_43.xmux.xp.S1 MOT10_N MOT10_P VSS sg13_lv_nmos ad=56.9f pd=0.74u as=56.9f ps=0.74u w=0.17u l=0.17u
X10431 cml_tlatch_64.xmux.xp.S1 B3_8_N B3_8_P VSS sg13_lv_nmos ad=56.9f pd=0.74u as=56.9f ps=0.74u w=0.17u l=0.17u
X10432 hs_to_clk_6.sg13_lv_nmos_2HGZLP_0.G CKA3_N VSS rppd l=4.25u w=1u
X10433 cml_tlatch_91.OUTP cml_tlatch_91.OUTN cml_tlatch_91.xmux.xp.S1 VSS sg13_lv_nmos ad=56.9f pd=0.74u as=56.9f ps=0.74u w=0.17u l=0.17u
X10434 cml_tlatch_16.xtail.S1 CKHB0_N cml_tlatch_16.xmux.xp.S1 VSS sg13_lv_nmos ad=89.3f pd=0.85u as=89.3f ps=0.85u w=0.47u l=0.16u
X10435 cml_tlatch_67.xmux.xn.S1 CKB3_P cml_tlatch_67.xtail.S1 VSS sg13_lv_nmos ad=89.3f pd=0.85u as=89.3f ps=0.85u w=0.47u l=0.16u
X10436 cml_tlatch_77.xmux.xp.S1 MOT17_P MOT17_N VSS sg13_lv_nmos ad=56.9f pd=0.74u as=56.9f ps=0.74u w=0.17u l=0.17u
X10437 stub_bi_62.BOTP stub_bi_62.BOTN cml_tlatch_82.xmux.xp.S1 VSS sg13_lv_nmos ad=56.9f pd=0.74u as=0.1019p ps=1.34u w=0.17u l=0.17u
X10438 cml_tlatch_2.xmux.xn.S1 CKB0_P cml_tlatch_2.xtail.S1 VSS sg13_lv_nmos ad=89.3f pd=0.85u as=89.3f ps=0.85u w=0.47u l=0.16u
X10439 VSS hs_to_clk_0.sg13_lv_nmos_2HGZLP_0.G VSS VSS sg13_lv_nmos ad=2.071p pd=11.28u as=0 ps=0 w=10.9u l=1.38u
X10440 VSS POLN cml_tlatch_74.xtail.S1 VSS sg13_lv_nmos ad=1.5637p pd=8.61u as=1.5637p ps=8.61u w=8.23u l=0.13u
X10441 cml_tlatch_52.xmux.xn.S1 CKHA2_P cml_tlatch_52.xtail.S1 VSS sg13_lv_nmos ad=89.3f pd=0.85u as=0.1598p ps=1.62u w=0.47u l=0.16u
X10442 cml_tlatch_33.xmux.xp.S1 cml_tlatch_33.OUTP cml_tlatch_33.OUTN VSS sg13_lv_nmos ad=56.9f pd=0.74u as=56.9f ps=0.74u w=0.17u l=0.17u
X10443 VDD MOT1_P VSS rppd l=5.17u w=1u
X10444 cml_tlatch_85.xmux.xp.S1 CKA2_P cml_tlatch_85.xtail.S1 VSS sg13_lv_nmos ad=89.3f pd=0.85u as=89.3f ps=0.85u w=0.47u l=0.16u
X10445 B1_8_P B1_8_N cml_tlatch_10.xmux.xp.S1 VSS sg13_lv_nmos ad=56.9f pd=0.74u as=56.9f ps=0.74u w=0.17u l=0.17u
X10446 cml_tlatch_82.xtail.S1 CKB2_N cml_tlatch_82.xmux.xp.S1 VSS sg13_lv_nmos ad=89.3f pd=0.85u as=89.3f ps=0.85u w=0.47u l=0.16u
X10447 cml_tlatch_25.xmux.xp.S1 MOT14_N MOT14_P VSS sg13_lv_nmos ad=0.1019p pd=1.34u as=56.9f ps=0.74u w=0.17u l=0.17u
X10448 cml_tlatch_96.xmux.xn.S1 CKB1_N cml_tlatch_96.xtail.S1 VSS sg13_lv_nmos ad=89.3f pd=0.85u as=89.3f ps=0.85u w=0.47u l=0.16u
X10449 VSS POLN cml_tlatch_28.xtail.S1 VSS sg13_lv_nmos ad=1.5637p pd=8.61u as=1.5637p ps=8.61u w=8.23u l=0.13u
X10450 cml_tlatch_42.xmux.xp.S1 MOT8_P MOT8_N VSS sg13_lv_nmos ad=56.9f pd=0.74u as=56.9f ps=0.74u w=0.17u l=0.17u
X10451 cml_tlatch_4.xtail.S1 POLN VSS VSS sg13_lv_nmos ad=1.5637p pd=8.61u as=1.5637p ps=8.61u w=8.23u l=0.13u
X10452 cml_tlatch_40.xtail.S1 CKA1_N cml_tlatch_40.xmux.xn.S1 VSS sg13_lv_nmos ad=89.3f pd=0.85u as=89.3f ps=0.85u w=0.47u l=0.16u
X10453 cml_tlatch_91.xmux.xn.S1 cml_tlatch_91.INN cml_tlatch_91.OUTP VSS sg13_lv_nmos ad=63.19999f pd=0.74u as=63.19999f ps=0.74u w=0.26u l=0.38u
X10454 cml_tlatch_63.xmux.xp.S1 MOT26_N MOT26_P VSS sg13_lv_nmos ad=56.9f pd=0.74u as=56.9f ps=0.74u w=0.17u l=0.17u
X10455 cml_tlatch_65.OUTP cml_tlatch_65.OUTN cml_tlatch_65.xmux.xp.S1 VSS sg13_lv_nmos ad=56.9f pd=0.74u as=56.9f ps=0.74u w=0.17u l=0.17u
X10456 cml_tlatch_86.xmux.xp.S1 cml_tlatch_86.OUTN cml_tlatch_86.OUTP VSS sg13_lv_nmos ad=56.9f pd=0.74u as=56.9f ps=0.74u w=0.17u l=0.17u
X10457 cml_tlatch_91.OUTN cml_tlatch_91.INP cml_tlatch_91.xmux.xn.S1 VSS sg13_lv_nmos ad=63.19999f pd=0.74u as=63.19999f ps=0.74u w=0.26u l=0.38u
X10458 cml_tlatch_72.xmux.xn.S1 B3_8_P MOT25_N VSS sg13_lv_nmos ad=63.19999f pd=0.74u as=63.19999f ps=0.74u w=0.26u l=0.38u
X10459 cml_tlatch_47.xmux.xn.S1 stub_bi_43.BOTP B2_2_P VSS sg13_lv_nmos ad=63.19999f pd=0.74u as=63.19999f ps=0.74u w=0.26u l=0.38u
X10460 cml_tlatch_34.xmux.xp.S1 A0_2_P A0_2_N VSS sg13_lv_nmos ad=56.9f pd=0.74u as=56.9f ps=0.74u w=0.17u l=0.17u
X10461 cml_tlatch_62.xmux.xn.S1 CKHA3_P cml_tlatch_62.xtail.S1 VSS sg13_lv_nmos ad=89.3f pd=0.85u as=89.3f ps=0.85u w=0.47u l=0.16u
X10462 MOT24_P MOT24_N cml_tlatch_62.xmux.xp.S1 VSS sg13_lv_nmos ad=56.9f pd=0.74u as=56.9f ps=0.74u w=0.17u l=0.17u
X10463 MOT23_N MOT23_P cml_tlatch_80.xmux.xp.S1 VSS sg13_lv_nmos ad=56.9f pd=0.74u as=56.9f ps=0.74u w=0.17u l=0.17u
X10464 cml_tlatch_46.xmux.xn.S1 CKB2_P cml_tlatch_46.xtail.S1 VSS sg13_lv_nmos ad=89.3f pd=0.85u as=89.3f ps=0.85u w=0.47u l=0.16u
X10465 cml_tlatch_81.xmux.xp.S1 CKB2_P cml_tlatch_81.xtail.S1 VSS sg13_lv_nmos ad=89.3f pd=0.85u as=89.3f ps=0.85u w=0.47u l=0.16u
X10466 cml_tlatch_75.xmux.xp.S1 MOT31_P MOT31_N VSS sg13_lv_nmos ad=56.9f pd=0.74u as=56.9f ps=0.74u w=0.17u l=0.17u
X10467 cml_tlatch_68.xmux.xp.S1 CKA3_P cml_tlatch_68.xtail.S1 VSS sg13_lv_nmos ad=89.3f pd=0.85u as=89.3f ps=0.85u w=0.47u l=0.16u
X10468 cml_tlatch_87.OUTN cml_tlatch_87.OUTP cml_tlatch_87.xmux.xp.S1 VSS sg13_lv_nmos ad=56.9f pd=0.74u as=56.9f ps=0.74u w=0.17u l=0.17u
X10469 stub_bi_43.BOTN D2_N cml_tlatch_48.xmux.xn.S1 VSS sg13_lv_nmos ad=63.19999f pd=0.74u as=63.19999f ps=0.74u w=0.26u l=0.38u
X10470 cml_tlatch_83.xmux.xp.S1 stub_bi_63.BOTP stub_bi_63.BOTN VSS sg13_lv_nmos ad=56.9f pd=0.74u as=56.9f ps=0.74u w=0.17u l=0.17u
X10471 cml_tlatch_27.xmux.xp.S1 MOT2_P MOT2_N VSS sg13_lv_nmos ad=56.9f pd=0.74u as=56.9f ps=0.74u w=0.17u l=0.17u
X10472 cml_tlatch_78.xtail.S1 CKHB2_P cml_tlatch_78.xmux.xn.S1 VSS sg13_lv_nmos ad=89.3f pd=0.85u as=89.3f ps=0.85u w=0.47u l=0.16u
X10473 cml_tlatch_38.OUTN D0_P cml_tlatch_38.xmux.xn.S1 VSS sg13_lv_nmos ad=63.19999f pd=0.74u as=63.19999f ps=0.74u w=0.26u l=0.38u
X10474 cml_gate2_1.xamp.xn.S1 ENB1_N GB0_P VSS sg13_lv_nmos ad=0.1007p pd=0.91u as=0.1007p ps=0.91u w=0.53u l=0.13u
X10475 cml_tlatch_74.xmux.xp.S1 MOT29_N MOT29_P VSS sg13_lv_nmos ad=56.9f pd=0.74u as=56.9f ps=0.74u w=0.17u l=0.17u
X10476 cml_tlatch_1.xmux.xp.S1 CKB0_P cml_tlatch_1.xtail.S1 VSS sg13_lv_nmos ad=89.3f pd=0.85u as=89.3f ps=0.85u w=0.47u l=0.16u
X10477 cml_tlatch_0.xmux.xn.S1 CKA0_P cml_tlatch_0.xtail.S1 VSS sg13_lv_nmos ad=89.3f pd=0.85u as=89.3f ps=0.85u w=0.47u l=0.16u
X10478 stub_bi_29.BOTP stub_bi_29.BOTN cml_tlatch_35.xmux.xp.S1 VSS sg13_lv_nmos ad=56.9f pd=0.74u as=56.9f ps=0.74u w=0.17u l=0.17u
X10479 cml_gate2_5.xrtail.R1 CKB2_N GA2_P VSS sg13_lv_nmos ad=0.1007p pd=0.91u as=0.1007p ps=0.91u w=0.53u l=0.13u
X10480 MOT12_P MOT12_N cml_tlatch_24.xmux.xp.S1 VSS sg13_lv_nmos ad=56.9f pd=0.74u as=56.9f ps=0.74u w=0.17u l=0.17u
X10481 cml_tlatch_44.INN cml_tlatch_44.INP cml_tlatch_89.xmux.xp.S1 VSS sg13_lv_nmos ad=56.9f pd=0.74u as=56.9f ps=0.74u w=0.17u l=0.17u
X10482 cml_tlatch_40.xmux.xp.S1 CKA1_P cml_tlatch_40.xtail.S1 VSS sg13_lv_nmos ad=89.3f pd=0.85u as=0.1598p ps=1.62u w=0.47u l=0.16u
X10483 cml_tlatch_38.OUTP cml_tlatch_38.OUTN cml_tlatch_38.xmux.xp.S1 VSS sg13_lv_nmos ad=56.9f pd=0.74u as=56.9f ps=0.74u w=0.17u l=0.17u
X10484 cml_tlatch_12.xmux.xp.S1 CKB1_P cml_tlatch_12.xtail.S1 VSS sg13_lv_nmos ad=89.3f pd=0.85u as=89.3f ps=0.85u w=0.47u l=0.16u
X10485 cml_tlatch_69.xmux.xn.S1 CKA3_P cml_tlatch_69.xtail.S1 VSS sg13_lv_nmos ad=89.3f pd=0.85u as=89.3f ps=0.85u w=0.47u l=0.16u
X10486 cml_tlatch_82.xmux.xn.S1 stub_bi_63.BOTN stub_bi_62.BOTP VSS sg13_lv_nmos ad=63.19999f pd=0.74u as=63.19999f ps=0.74u w=0.26u l=0.38u
X10487 A3_2_N A3_2_P cml_tlatch_57.xmux.xp.S1 VSS sg13_lv_nmos ad=56.9f pd=0.74u as=56.9f ps=0.74u w=0.17u l=0.17u
X10488 stub_bi_55.BOTN stub_bi_55.BOTP cml_tlatch_90.xmux.xp.S1 VSS sg13_lv_nmos ad=56.9f pd=0.74u as=56.9f ps=0.74u w=0.17u l=0.17u
X10489 cml_tlatch_7.OUTN cml_tlatch_7.OUTP cml_tlatch_7.xmux.xp.S1 VSS sg13_lv_nmos ad=56.9f pd=0.74u as=56.9f ps=0.74u w=0.17u l=0.17u
X10490 cml_tlatch_99.xmux.xp.S1 cml_tlatch_99.OUTP cml_tlatch_99.OUTN VSS sg13_lv_nmos ad=56.9f pd=0.74u as=56.9f ps=0.74u w=0.17u l=0.17u
X10491 cml_tlatch_27.xmux.xp.S1 CKHA0_N cml_tlatch_27.xtail.S1 VSS sg13_lv_nmos ad=89.3f pd=0.85u as=89.3f ps=0.85u w=0.47u l=0.16u
X10492 cml_tlatch_87.xmux.xp.S1 CKA2_P cml_tlatch_87.xtail.S1 VSS sg13_lv_nmos ad=89.3f pd=0.85u as=89.3f ps=0.85u w=0.47u l=0.16u
X10493 cml_tlatch_56.xmux.xn.S1 A3_2_N cml_tlatch_56.OUTP VSS sg13_lv_nmos ad=63.19999f pd=0.74u as=63.19999f ps=0.74u w=0.26u l=0.38u
X10494 cml_tlatch_32.xtail.S1 CKB0_N cml_tlatch_32.xmux.xp.S1 VSS sg13_lv_nmos ad=0.1598p pd=1.62u as=89.3f ps=0.85u w=0.47u l=0.16u
X10495 cml_tlatch_53.xtail.S1 POLN VSS VSS sg13_lv_nmos ad=1.5637p pd=8.61u as=1.5637p ps=8.61u w=8.23u l=0.13u
X10496 cml_tlatch_29.xmux.xp.S1 CKHA0_N cml_tlatch_29.xtail.S1 VSS sg13_lv_nmos ad=89.3f pd=0.85u as=89.3f ps=0.85u w=0.47u l=0.16u
X10497 B1_2_N B1_2_P cml_tlatch_36.xmux.xp.S1 VSS sg13_lv_nmos ad=56.9f pd=0.74u as=56.9f ps=0.74u w=0.17u l=0.17u
X10498 MOT28_P MOT28_N cml_tlatch_44.xmux.xp.S1 VSS sg13_lv_nmos ad=56.9f pd=0.74u as=56.9f ps=0.74u w=0.17u l=0.17u
X10499 MOT27_P MOT27_N cml_tlatch_73.xmux.xp.S1 VSS sg13_lv_nmos ad=56.9f pd=0.74u as=56.9f ps=0.74u w=0.17u l=0.17u
X10500 cml_tlatch_65.xmux.xn.S1 CKB3_P cml_tlatch_65.xtail.S1 VSS sg13_lv_nmos ad=89.3f pd=0.85u as=89.3f ps=0.85u w=0.47u l=0.16u
X10501 cml_gate2_7.xamp.xn.S1 CKA2_P cml_gate2_7.xrtail.R1 VSS sg13_lv_nmos ad=0.1007p pd=0.91u as=0.1007p ps=0.91u w=0.53u l=0.13u
X10502 cml_tlatch_75.xmux.xn.S1 B3_2_P MOT31_N VSS sg13_lv_nmos ad=0.1082p pd=1.34u as=63.19999f ps=0.74u w=0.26u l=0.38u
X10503 cml_tlatch_22.xmux.xp.S1 cml_tlatch_22.OUTN cml_tlatch_22.OUTP VSS sg13_lv_nmos ad=56.9f pd=0.74u as=56.9f ps=0.74u w=0.17u l=0.17u
X10504 A3_8_N A3_8_P cml_tlatch_68.xmux.xp.S1 VSS sg13_lv_nmos ad=56.9f pd=0.74u as=56.9f ps=0.74u w=0.17u l=0.17u
X10505 MOT17_P MOT17_N cml_tlatch_77.xmux.xp.S1 VSS sg13_lv_nmos ad=56.9f pd=0.74u as=56.9f ps=0.74u w=0.17u l=0.17u
X10506 cml_tlatch_85.xmux.xp.S1 A2_8_N A2_8_P VSS sg13_lv_nmos ad=56.9f pd=0.74u as=56.9f ps=0.74u w=0.17u l=0.17u
X10507 cml_tlatch_23.xtail.S1 CKA0_P cml_tlatch_23.xmux.xp.S1 VSS sg13_lv_nmos ad=89.3f pd=0.85u as=89.3f ps=0.85u w=0.47u l=0.16u
X10508 cml_tlatch_51.OUTP cml_tlatch_51.OUTN cml_tlatch_51.xmux.xp.S1 VSS sg13_lv_nmos ad=56.9f pd=0.74u as=56.9f ps=0.74u w=0.17u l=0.17u
X10509 cml_tlatch_42.xmux.xp.S1 CKHA1_N cml_tlatch_42.xtail.S1 VSS sg13_lv_nmos ad=89.3f pd=0.85u as=89.3f ps=0.85u w=0.47u l=0.16u
X10510 cml_tlatch_61.xmux.xp.S1 cml_tlatch_61.OUTN cml_tlatch_61.OUTP VSS sg13_lv_nmos ad=56.9f pd=0.74u as=56.9f ps=0.74u w=0.17u l=0.17u
X10511 cml_tlatch_28.xmux.xn.S1 cml_tlatch_99.OUTP MOT4_N VSS sg13_lv_nmos ad=63.19999f pd=0.74u as=63.19999f ps=0.74u w=0.26u l=0.38u
X10512 cml_tlatch_22.OUTN cml_tlatch_22.OUTP cml_tlatch_22.xmux.xp.S1 VSS sg13_lv_nmos ad=56.9f pd=0.74u as=56.9f ps=0.74u w=0.17u l=0.17u
X10513 cml_tlatch_58.xmux.xp.S1 cml_tlatch_58.OUTP cml_tlatch_58.OUTN VSS sg13_lv_nmos ad=56.9f pd=0.74u as=56.9f ps=0.74u w=0.17u l=0.17u
X10514 cml_tlatch_80.xmux.xn.S1 B2_2_N MOT23_P VSS sg13_lv_nmos ad=63.19999f pd=0.74u as=63.19999f ps=0.74u w=0.26u l=0.38u
X10515 cml_tlatch_18.OUTP cml_tlatch_18.OUTN cml_tlatch_18.xmux.xp.S1 VSS sg13_lv_nmos ad=56.9f pd=0.74u as=56.9f ps=0.74u w=0.17u l=0.17u
X10516 MOT3_N MOT3_P cml_tlatch_15.xmux.xp.S1 VSS sg13_lv_nmos ad=56.9f pd=0.74u as=56.9f ps=0.74u w=0.17u l=0.17u
X10517 MOT4_N MOT4_P cml_tlatch_28.xmux.xp.S1 VSS sg13_lv_nmos ad=56.9f pd=0.74u as=56.9f ps=0.74u w=0.17u l=0.17u
X10518 cml_tlatch_13.xmux.xp.S1 stub_bi_17.BOTN stub_bi_17.BOTP VSS sg13_lv_nmos ad=56.9f pd=0.74u as=56.9f ps=0.74u w=0.17u l=0.17u
X10519 MOT9_P MOT9_N cml_tlatch_3.xmux.xp.S1 VSS sg13_lv_nmos ad=56.9f pd=0.74u as=56.9f ps=0.74u w=0.17u l=0.17u
X10520 MOT18_N MOT18_P cml_tlatch_53.xmux.xp.S1 VSS sg13_lv_nmos ad=56.9f pd=0.74u as=0.1019p ps=1.34u w=0.17u l=0.17u
X10521 B0_2_N B0_2_P cml_tlatch_31.xmux.xp.S1 VSS sg13_lv_nmos ad=56.9f pd=0.74u as=56.9f ps=0.74u w=0.17u l=0.17u
X10522 cml_tlatch_56.OUTP cml_tlatch_56.OUTN cml_tlatch_56.xmux.xp.S1 VSS sg13_lv_nmos ad=56.9f pd=0.74u as=56.9f ps=0.74u w=0.17u l=0.17u
X10523 cml_tlatch_33.xmux.xp.S1 cml_tlatch_33.OUTP cml_tlatch_33.OUTN VSS sg13_lv_nmos ad=0.1019p pd=1.34u as=56.9f ps=0.74u w=0.17u l=0.17u
X10524 A0_8_P cml_tlatch_18.OUTN cml_tlatch_9.xmux.xn.S1 VSS sg13_lv_nmos ad=63.19999f pd=0.74u as=0.1082p ps=1.34u w=0.26u l=0.38u
X10525 cml_gate2_2.xrtail.R1 CKB1_N GA1_P VSS sg13_lv_nmos ad=0.1007p pd=0.91u as=0.1802p ps=1.74u w=0.53u l=0.13u
X10526 ENB_P NS1_N cml_gate2_8.xrtail.R1 VSS sg13_lv_nmos ad=0.1007p pd=0.91u as=0.1007p ps=0.91u w=0.53u l=0.13u
X10527 cml_tlatch_21.xmux.xn.S1 cml_tlatch_22.OUTP cml_tlatch_43.INN VSS sg13_lv_nmos ad=63.19999f pd=0.74u as=63.19999f ps=0.74u w=0.26u l=0.38u
X10528 cml_gate2_4.xamp.xn.S1 ENA1_N GA3_P VSS sg13_lv_nmos ad=0.1007p pd=0.91u as=0.1007p ps=0.91u w=0.53u l=0.13u
X10529 cml_tlatch_7.OUTP cml_tlatch_7.OUTN cml_tlatch_7.xmux.xp.S1 VSS sg13_lv_nmos ad=56.9f pd=0.74u as=56.9f ps=0.74u w=0.17u l=0.17u
X10530 cml_tlatch_69.OUTN cml_tlatch_63.INP cml_tlatch_69.xmux.xn.S1 VSS sg13_lv_nmos ad=63.19999f pd=0.74u as=63.19999f ps=0.74u w=0.26u l=0.38u
X10531 cml_tlatch_86.xmux.xp.S1 cml_tlatch_86.OUTN cml_tlatch_86.OUTP VSS sg13_lv_nmos ad=56.9f pd=0.74u as=56.9f ps=0.74u w=0.17u l=0.17u
X10532 cml_tlatch_19.xmux.xp.S1 A1_8_P A1_8_N VSS sg13_lv_nmos ad=56.9f pd=0.74u as=56.9f ps=0.74u w=0.17u l=0.17u
X10533 cml_tlatch_38.xtail.S1 CKA0_P cml_tlatch_38.xmux.xn.S1 VSS sg13_lv_nmos ad=89.3f pd=0.85u as=89.3f ps=0.85u w=0.47u l=0.16u
X10534 MOT11_P cml_tlatch_4.INN cml_tlatch_4.xmux.xn.S1 VSS sg13_lv_nmos ad=63.19999f pd=0.74u as=63.19999f ps=0.74u w=0.26u l=0.38u
X10535 cml_tlatch_35.xmux.xn.S1 B1_2_N stub_bi_29.BOTN VSS sg13_lv_nmos ad=63.19999f pd=0.74u as=0.1082p ps=1.34u w=0.26u l=0.38u
X10536 cml_tlatch_60.xtail.S1 CKA2_P cml_tlatch_60.xmux.xp.S1 VSS sg13_lv_nmos ad=89.3f pd=0.85u as=89.3f ps=0.85u w=0.47u l=0.16u
X10537 cml_tlatch_13.xmux.xp.S1 CKB1_N cml_tlatch_13.xtail.S1 VSS sg13_lv_nmos ad=89.3f pd=0.85u as=89.3f ps=0.85u w=0.47u l=0.16u
X10538 cml_tlatch_59.xmux.xp.S1 cml_tlatch_91.INP cml_tlatch_91.INN VSS sg13_lv_nmos ad=56.9f pd=0.74u as=56.9f ps=0.74u w=0.17u l=0.17u
X10539 cml_tlatch_6.xmux.xp.S1 MOT15_N MOT15_P VSS sg13_lv_nmos ad=56.9f pd=0.74u as=56.9f ps=0.74u w=0.17u l=0.17u
X10540 MOT11_P cml_tlatch_4.INN cml_tlatch_4.xmux.xn.S1 VSS sg13_lv_nmos ad=63.19999f pd=0.74u as=63.19999f ps=0.74u w=0.26u l=0.38u
X10541 J1_N J4_N cml_tlatch_95.xmux.xn.S1 VSS sg13_lv_nmos ad=63.19999f pd=0.74u as=0.1082p ps=1.34u w=0.26u l=0.38u
X10542 cml_tlatch_43.INP cml_tlatch_43.INN cml_tlatch_21.xmux.xp.S1 VSS sg13_lv_nmos ad=56.9f pd=0.74u as=0.1019p ps=1.34u w=0.17u l=0.17u
X10543 cml_gate2_5.xrtail.R1 CKB2_P cml_gate2_5.xamp.xn.S1 VSS sg13_lv_nmos ad=0.1007p pd=0.91u as=0.1802p ps=1.74u w=0.53u l=0.13u
X10544 cml_tlatch_16.xmux.xp.S1 CKHB0_N cml_tlatch_16.xtail.S1 VSS sg13_lv_nmos ad=89.3f pd=0.85u as=0.1598p ps=1.62u w=0.47u l=0.16u
X10545 cml_tlatch_42.xmux.xp.S1 MOT8_N MOT8_P VSS sg13_lv_nmos ad=56.9f pd=0.74u as=56.9f ps=0.74u w=0.17u l=0.17u
X10546 cml_tlatch_39.xmux.xp.S1 cml_tlatch_97.INN cml_tlatch_97.INP VSS sg13_lv_nmos ad=56.9f pd=0.74u as=56.9f ps=0.74u w=0.17u l=0.17u
X10547 cml_tlatch_67.xtail.S1 CKB3_P cml_tlatch_67.xmux.xn.S1 VSS sg13_lv_nmos ad=89.3f pd=0.85u as=89.3f ps=0.85u w=0.47u l=0.16u
X10548 cml_tlatch_74.xtail.S1 CKHB3_P cml_tlatch_74.xmux.xn.S1 VSS sg13_lv_nmos ad=89.3f pd=0.85u as=89.3f ps=0.85u w=0.47u l=0.16u
X10549 cml_tlatch_99.xmux.xp.S1 CKA0_P cml_tlatch_99.xtail.S1 VSS sg13_lv_nmos ad=89.3f pd=0.85u as=89.3f ps=0.85u w=0.47u l=0.16u
X10550 cml_tlatch_71.OUTP cml_tlatch_71.OUTN cml_tlatch_71.xmux.xp.S1 VSS sg13_lv_nmos ad=56.9f pd=0.74u as=56.9f ps=0.74u w=0.17u l=0.17u
X10551 cml_tlatch_17.xtail.S1 CKHB0_N cml_tlatch_17.xmux.xp.S1 VSS sg13_lv_nmos ad=89.3f pd=0.85u as=89.3f ps=0.85u w=0.47u l=0.16u
X10552 cml_tlatch_44.INN cml_tlatch_44.INP cml_tlatch_89.xmux.xp.S1 VSS sg13_lv_nmos ad=56.9f pd=0.74u as=56.9f ps=0.74u w=0.17u l=0.17u
X10553 MOT18_N MOT18_P cml_tlatch_53.xmux.xp.S1 VSS sg13_lv_nmos ad=56.9f pd=0.74u as=56.9f ps=0.74u w=0.17u l=0.17u
X10554 cml_tlatch_11.xtail.S1 CKB1_P cml_tlatch_11.xmux.xn.S1 VSS sg13_lv_nmos ad=89.3f pd=0.85u as=89.3f ps=0.85u w=0.47u l=0.16u
X10555 cml_tlatch_88.xmux.xp.S1 cml_tlatch_74.INP cml_tlatch_74.INN VSS sg13_lv_nmos ad=56.9f pd=0.74u as=56.9f ps=0.74u w=0.17u l=0.17u
X10556 cml_tlatch_30.xmux.xp.S1 cml_tlatch_30.OUTN cml_tlatch_30.OUTP VSS sg13_lv_nmos ad=56.9f pd=0.74u as=56.9f ps=0.74u w=0.17u l=0.17u
X10557 cml_tlatch_38.OUTP cml_tlatch_38.OUTN cml_tlatch_38.xmux.xp.S1 VSS sg13_lv_nmos ad=56.9f pd=0.74u as=56.9f ps=0.74u w=0.17u l=0.17u
X10558 cml_tlatch_87.OUTP cml_tlatch_87.INN cml_tlatch_87.xmux.xn.S1 VSS sg13_lv_nmos ad=63.19999f pd=0.74u as=63.19999f ps=0.74u w=0.26u l=0.38u
X10559 cml_tlatch_75.xmux.xp.S1 MOT31_N MOT31_P VSS sg13_lv_nmos ad=56.9f pd=0.74u as=56.9f ps=0.74u w=0.17u l=0.17u
X10560 cml_tlatch_9.xmux.xp.S1 CKA0_P cml_tlatch_9.xtail.S1 VSS sg13_lv_nmos ad=89.3f pd=0.85u as=0.1598p ps=1.62u w=0.47u l=0.16u
X10561 cml_tlatch_16.xmux.xp.S1 MOT5_P MOT5_N VSS sg13_lv_nmos ad=56.9f pd=0.74u as=56.9f ps=0.74u w=0.17u l=0.17u
X10562 cml_tlatch_73.xtail.S1 CKHB3_N cml_tlatch_73.xmux.xp.S1 VSS sg13_lv_nmos ad=89.3f pd=0.85u as=89.3f ps=0.85u w=0.47u l=0.16u
X10563 cml_tlatch_54.xmux.xp.S1 MOT20_P MOT20_N VSS sg13_lv_nmos ad=56.9f pd=0.74u as=56.9f ps=0.74u w=0.17u l=0.17u
X10564 MOT28_N MOT28_P cml_tlatch_44.xmux.xp.S1 VSS sg13_lv_nmos ad=56.9f pd=0.74u as=56.9f ps=0.74u w=0.17u l=0.17u
X10565 VSS POLN cml_tlatch_81.xtail.S1 VSS sg13_lv_nmos ad=1.5637p pd=8.61u as=1.5637p ps=8.61u w=8.23u l=0.13u
X10566 cml_tlatch_5.INN cml_tlatch_5.INP cml_tlatch_96.xmux.xp.S1 VSS sg13_lv_nmos ad=56.9f pd=0.74u as=56.9f ps=0.74u w=0.17u l=0.17u
X10567 VSS POLN cml_tlatch_45.xtail.S1 VSS sg13_lv_nmos ad=1.5637p pd=8.61u as=1.5637p ps=8.61u w=8.23u l=0.13u
X10568 cml_tlatch_46.xtail.S1 CKB2_P cml_tlatch_46.xmux.xn.S1 VSS sg13_lv_nmos ad=89.3f pd=0.85u as=0.1598p ps=1.62u w=0.47u l=0.16u
X10569 VDD cml_tlatch_61.OUTP VSS rppd l=5.17u w=1u
X10570 cml_tlatch_43.xtail.S1 POLN VSS VSS sg13_lv_nmos ad=1.5637p pd=8.61u as=2.7982p ps=17.14u w=8.23u l=0.13u
X10571 cml_tlatch_33.xmux.xp.S1 CKA0_N cml_tlatch_33.xtail.S1 VSS sg13_lv_nmos ad=89.3f pd=0.85u as=89.3f ps=0.85u w=0.47u l=0.16u
X10572 cml_tlatch_69.xmux.xp.S1 cml_tlatch_69.OUTP cml_tlatch_69.OUTN VSS sg13_lv_nmos ad=56.9f pd=0.74u as=56.9f ps=0.74u w=0.17u l=0.17u
X10573 cml_tlatch_79.xmux.xp.S1 CKHB2_N cml_tlatch_79.xtail.S1 VSS sg13_lv_nmos ad=89.3f pd=0.85u as=89.3f ps=0.85u w=0.47u l=0.16u
X10574 cml_tlatch_24.xmux.xp.S1 MOT12_P MOT12_N VSS sg13_lv_nmos ad=56.9f pd=0.74u as=56.9f ps=0.74u w=0.17u l=0.17u
X10575 cml_tlatch_61.xmux.xp.S1 cml_tlatch_61.OUTN cml_tlatch_61.OUTP VSS sg13_lv_nmos ad=56.9f pd=0.74u as=56.9f ps=0.74u w=0.17u l=0.17u
X10576 cml_tlatch_3.xmux.xn.S1 B1_8_N MOT9_P VSS sg13_lv_nmos ad=63.19999f pd=0.74u as=63.19999f ps=0.74u w=0.26u l=0.38u
X10577 cml_tlatch_88.xmux.xn.S1 CKB3_N cml_tlatch_88.xtail.S1 VSS sg13_lv_nmos ad=89.3f pd=0.85u as=89.3f ps=0.85u w=0.47u l=0.16u
X10578 B2_8_P B2_8_N cml_tlatch_81.xmux.xp.S1 VSS sg13_lv_nmos ad=56.9f pd=0.74u as=56.9f ps=0.74u w=0.17u l=0.17u
X10579 cml_gate2_8.xrtail.R1 NS1_P cml_gate2_8.xamp.xn.S1 VSS sg13_lv_nmos ad=0.1007p pd=0.91u as=0.1007p ps=0.91u w=0.53u l=0.13u
X10580 cml_tlatch_50.xmux.xp.S1 B3_2_N B3_2_P VSS sg13_lv_nmos ad=56.9f pd=0.74u as=56.9f ps=0.74u w=0.17u l=0.17u
X10581 cml_tlatch_75.xtail.S1 CKHB3_P cml_tlatch_75.xmux.xn.S1 VSS sg13_lv_nmos ad=89.3f pd=0.85u as=89.3f ps=0.85u w=0.47u l=0.16u
X10582 cml_tlatch_11.xmux.xp.S1 stub_bi_15.BOTN stub_bi_15.BOTP VSS sg13_lv_nmos ad=56.9f pd=0.74u as=56.9f ps=0.74u w=0.17u l=0.17u
X10583 cml_tlatch_8.OUTN cml_tlatch_8.OUTP cml_tlatch_8.xmux.xp.S1 VSS sg13_lv_nmos ad=56.9f pd=0.74u as=56.9f ps=0.74u w=0.17u l=0.17u
X10584 MOT22_N MOT22_P cml_tlatch_55.xmux.xp.S1 VSS sg13_lv_nmos ad=56.9f pd=0.74u as=56.9f ps=0.74u w=0.17u l=0.17u
X10585 cml_tlatch_49.xtail.S1 CKB3_P cml_tlatch_49.xmux.xn.S1 VSS sg13_lv_nmos ad=89.3f pd=0.85u as=89.3f ps=0.85u w=0.47u l=0.16u
X10586 cml_tlatch_18.xmux.xp.S1 cml_tlatch_18.OUTP cml_tlatch_18.OUTN VSS sg13_lv_nmos ad=56.9f pd=0.74u as=56.9f ps=0.74u w=0.17u l=0.17u
X10587 cml_tlatch_39.xmux.xn.S1 CKA1_P cml_tlatch_39.xtail.S1 VSS sg13_lv_nmos ad=0.1598p pd=1.62u as=89.3f ps=0.85u w=0.47u l=0.16u
X10588 cml_tlatch_13.xmux.xp.S1 stub_bi_17.BOTN stub_bi_17.BOTP VSS sg13_lv_nmos ad=56.9f pd=0.74u as=56.9f ps=0.74u w=0.17u l=0.17u
X10589 MOT9_P MOT9_N cml_tlatch_3.xmux.xp.S1 VSS sg13_lv_nmos ad=56.9f pd=0.74u as=56.9f ps=0.74u w=0.17u l=0.17u
X10590 cml_tlatch_21.xmux.xp.S1 cml_tlatch_43.INP cml_tlatch_43.INN VSS sg13_lv_nmos ad=56.9f pd=0.74u as=56.9f ps=0.74u w=0.17u l=0.17u
X10591 hs_to_clk_5.D2 POLN VSS VSS sg13_lv_nmos ad=3.4p pd=20.68u as=1.9p ps=10.38u w=10u l=0.13u
X10592 cml_tlatch_48.xmux.xn.S1 D2_P stub_bi_43.BOTP VSS sg13_lv_nmos ad=63.19999f pd=0.74u as=63.19999f ps=0.74u w=0.26u l=0.38u
X10593 CLK_W_P CLK_W_N cml_tlatch_93.xmux.xp.S1 VSS sg13_lv_nmos ad=56.9f pd=0.74u as=56.9f ps=0.74u w=0.17u l=0.17u
X10594 cml_tlatch_78.xmux.xp.S1 MOT19_P MOT19_N VSS sg13_lv_nmos ad=56.9f pd=0.74u as=56.9f ps=0.74u w=0.17u l=0.17u
X10595 cml_tlatch_98.xmux.xn.S1 CKB0_N cml_tlatch_98.xtail.S1 VSS sg13_lv_nmos ad=89.3f pd=0.85u as=89.3f ps=0.85u w=0.47u l=0.16u
X10596 A1_8_N cml_tlatch_20.OUTP cml_tlatch_19.xmux.xn.S1 VSS sg13_lv_nmos ad=63.19999f pd=0.74u as=63.19999f ps=0.74u w=0.26u l=0.38u
X10597 cml_tlatch_31.xtail.S1 CKB0_P cml_tlatch_31.xmux.xp.S1 VSS sg13_lv_nmos ad=89.3f pd=0.85u as=89.3f ps=0.85u w=0.47u l=0.16u
X10598 VSS hs_to_clk_1.sg13_lv_nmos_2HGZLP_0.G VSS VSS sg13_lv_nmos ad=2.071p pd=11.28u as=0 ps=0 w=10.9u l=1.38u
X10599 cml_tlatch_63.INP cml_tlatch_63.INN cml_tlatch_70.xmux.xp.S1 VSS sg13_lv_nmos ad=56.9f pd=0.74u as=56.9f ps=0.74u w=0.17u l=0.17u
X10600 cml_tlatch_7.OUTP cml_tlatch_7.OUTN cml_tlatch_7.xmux.xp.S1 VSS sg13_lv_nmos ad=56.9f pd=0.74u as=56.9f ps=0.74u w=0.17u l=0.17u
X10601 cml_tlatch_68.xmux.xp.S1 A3_8_N A3_8_P VSS sg13_lv_nmos ad=56.9f pd=0.74u as=56.9f ps=0.74u w=0.17u l=0.17u
X10602 VDD cml_tlatch_24.INN VSS rppd l=5.17u w=1u
X10603 cml_tlatch_88.xmux.xn.S1 cml_tlatch_49.OUTP cml_tlatch_74.INN VSS sg13_lv_nmos ad=0.1082p pd=1.34u as=63.19999f ps=0.74u w=0.26u l=0.38u
X10604 cml_tlatch_10.xtail.S1 CKB1_N cml_tlatch_10.xmux.xn.S1 VSS sg13_lv_nmos ad=0.1598p pd=1.62u as=89.3f ps=0.85u w=0.47u l=0.16u
X10605 cml_tlatch_59.xmux.xp.S1 cml_tlatch_91.INP cml_tlatch_91.INN VSS sg13_lv_nmos ad=56.9f pd=0.74u as=56.9f ps=0.74u w=0.17u l=0.17u
X10606 stub_bi_38.BOTP stub_bi_38.BOTN cml_tlatch_46.xmux.xp.S1 VSS sg13_lv_nmos ad=56.9f pd=0.74u as=56.9f ps=0.74u w=0.17u l=0.17u
X10607 cml_tlatch_14.xtail.S1 CKHB0_N cml_tlatch_14.xmux.xp.S1 VSS sg13_lv_nmos ad=89.3f pd=0.85u as=89.3f ps=0.85u w=0.47u l=0.16u
X10608 cml_tlatch_6.xmux.xp.S1 MOT15_N MOT15_P VSS sg13_lv_nmos ad=0.1019p pd=1.34u as=56.9f ps=0.74u w=0.17u l=0.17u
X10609 cml_tlatch_88.xmux.xn.S1 cml_tlatch_49.OUTP cml_tlatch_74.INN VSS sg13_lv_nmos ad=63.19999f pd=0.74u as=63.19999f ps=0.74u w=0.26u l=0.38u
X10610 MOT14_P MOT14_N cml_tlatch_25.xmux.xp.S1 VSS sg13_lv_nmos ad=56.9f pd=0.74u as=56.9f ps=0.74u w=0.17u l=0.17u
X10611 cml_tlatch_97.xmux.xn.S1 cml_tlatch_97.INP cml_tlatch_24.INN VSS sg13_lv_nmos ad=63.19999f pd=0.74u as=63.19999f ps=0.74u w=0.26u l=0.38u
X10612 MOT13_N MOT13_P cml_tlatch_5.xmux.xp.S1 VSS sg13_lv_nmos ad=56.9f pd=0.74u as=56.9f ps=0.74u w=0.17u l=0.17u
X10613 cml_tlatch_16.xmux.xn.S1 CKHB0_P cml_tlatch_16.xtail.S1 VSS sg13_lv_nmos ad=89.3f pd=0.85u as=89.3f ps=0.85u w=0.47u l=0.16u
X10614 cml_tlatch_67.xtail.S1 CKB3_N cml_tlatch_67.xmux.xp.S1 VSS sg13_lv_nmos ad=89.3f pd=0.85u as=89.3f ps=0.85u w=0.47u l=0.16u
X10615 cml_tlatch_16.xmux.xn.S1 cml_tlatch_98.OUTN MOT5_P VSS sg13_lv_nmos ad=63.19999f pd=0.74u as=63.19999f ps=0.74u w=0.26u l=0.38u
X10616 cml_tlatch_1.xmux.xp.S1 CKB0_P cml_tlatch_1.xtail.S1 VSS sg13_lv_nmos ad=89.3f pd=0.85u as=89.3f ps=0.85u w=0.47u l=0.16u
X10617 cml_tlatch_34.xmux.xp.S1 A0_2_N A0_2_P VSS sg13_lv_nmos ad=56.9f pd=0.74u as=56.9f ps=0.74u w=0.17u l=0.17u
X10618 cml_tlatch_36.xmux.xn.S1 stub_bi_31.BOTN B1_2_N VSS sg13_lv_nmos ad=63.19999f pd=0.74u as=63.19999f ps=0.74u w=0.26u l=0.38u
X10619 cml_tlatch_60.xmux.xp.S1 A2_2_P A2_2_N VSS sg13_lv_nmos ad=56.9f pd=0.74u as=56.9f ps=0.74u w=0.17u l=0.17u
X10620 cml_tlatch_16.xmux.xn.S1 cml_tlatch_98.OUTN MOT5_P VSS sg13_lv_nmos ad=63.19999f pd=0.74u as=63.19999f ps=0.74u w=0.26u l=0.38u
X10621 cml_tlatch_10.xtail.S1 POLN VSS VSS sg13_lv_nmos ad=1.5637p pd=8.61u as=1.5637p ps=8.61u w=8.23u l=0.13u
X10622 cml_tlatch_96.xmux.xp.S1 cml_tlatch_5.INN cml_tlatch_5.INP VSS sg13_lv_nmos ad=56.9f pd=0.74u as=56.9f ps=0.74u w=0.17u l=0.17u
X10623 cml_tlatch_36.xmux.xn.S1 stub_bi_31.BOTN B1_2_N VSS sg13_lv_nmos ad=63.19999f pd=0.74u as=63.19999f ps=0.74u w=0.26u l=0.38u
X10624 cml_tlatch_55.xtail.S1 CKHA2_N cml_tlatch_55.xmux.xp.S1 VSS sg13_lv_nmos ad=89.3f pd=0.85u as=89.3f ps=0.85u w=0.47u l=0.16u
X10625 cml_tlatch_30.xmux.xp.S1 cml_tlatch_30.OUTN cml_tlatch_30.OUTP VSS sg13_lv_nmos ad=56.9f pd=0.74u as=56.9f ps=0.74u w=0.17u l=0.17u
X10626 cml_tlatch_14.xmux.xp.S1 MOT1_P MOT1_N VSS sg13_lv_nmos ad=56.9f pd=0.74u as=56.9f ps=0.74u w=0.17u l=0.17u
X10627 cml_tlatch_59.xtail.S1 CKA2_N cml_tlatch_59.xmux.xp.S1 VSS sg13_lv_nmos ad=89.3f pd=0.85u as=89.3f ps=0.85u w=0.47u l=0.16u
X10628 cml_tlatch_71.OUTP cml_tlatch_44.INN cml_tlatch_71.xmux.xn.S1 VSS sg13_lv_nmos ad=63.19999f pd=0.74u as=63.19999f ps=0.74u w=0.26u l=0.38u
X10629 cml_tlatch_27.xmux.xn.S1 cml_tlatch_23.OUTP MOT2_N VSS sg13_lv_nmos ad=63.19999f pd=0.74u as=63.19999f ps=0.74u w=0.26u l=0.38u
X10630 cml_tlatch_40.xmux.xn.S1 cml_tlatch_41.OUTN A1_2_P VSS sg13_lv_nmos ad=63.19999f pd=0.74u as=63.19999f ps=0.74u w=0.26u l=0.38u
X10631 cml_tlatch_58.OUTN D3_P cml_tlatch_58.xmux.xn.S1 VSS sg13_lv_nmos ad=63.19999f pd=0.74u as=63.19999f ps=0.74u w=0.26u l=0.38u
X10632 MOT30_N MOT30_P cml_tlatch_45.xmux.xp.S1 VSS sg13_lv_nmos ad=56.9f pd=0.74u as=56.9f ps=0.74u w=0.17u l=0.17u
X10633 MOT30_P MOT30_N cml_tlatch_45.xmux.xp.S1 VSS sg13_lv_nmos ad=56.9f pd=0.74u as=56.9f ps=0.74u w=0.17u l=0.17u
X10634 cml_tlatch_27.xmux.xp.S1 CKHA0_N cml_tlatch_27.xtail.S1 VSS sg13_lv_nmos ad=89.3f pd=0.85u as=89.3f ps=0.85u w=0.47u l=0.16u
X10635 cml_tlatch_68.xmux.xp.S1 A3_8_N A3_8_P VSS sg13_lv_nmos ad=56.9f pd=0.74u as=56.9f ps=0.74u w=0.17u l=0.17u
X10636 cml_gate2_7.xrtail.R1 CKA2_N GB2_P VSS sg13_lv_nmos ad=0.1007p pd=0.91u as=0.1007p ps=0.91u w=0.53u l=0.13u
X10637 cml_tlatch_8.xtail.S1 CKB0_N cml_tlatch_8.xmux.xp.S1 VSS sg13_lv_nmos ad=89.3f pd=0.85u as=89.3f ps=0.85u w=0.47u l=0.16u
X10638 MOT3_P MOT3_N cml_tlatch_15.xmux.xp.S1 VSS sg13_lv_nmos ad=56.9f pd=0.74u as=56.9f ps=0.74u w=0.17u l=0.17u
X10639 MOT4_P MOT4_N cml_tlatch_28.xmux.xp.S1 VSS sg13_lv_nmos ad=56.9f pd=0.74u as=56.9f ps=0.74u w=0.17u l=0.17u
X10640 cml_tlatch_13.xtail.S1 CKB1_N cml_tlatch_13.xmux.xp.S1 VSS sg13_lv_nmos ad=89.3f pd=0.85u as=0.1598p ps=1.62u w=0.47u l=0.16u
X10641 cml_tlatch_72.xtail.S1 CKHB3_P cml_tlatch_72.xmux.xn.S1 VSS sg13_lv_nmos ad=89.3f pd=0.85u as=89.3f ps=0.85u w=0.47u l=0.16u
X10642 cml_tlatch_8.xtail.S1 CKB0_P cml_tlatch_8.xmux.xn.S1 VSS sg13_lv_nmos ad=89.3f pd=0.85u as=89.3f ps=0.85u w=0.47u l=0.16u
X10643 cml_tlatch_25.xmux.xp.S1 MOT14_P MOT14_N VSS sg13_lv_nmos ad=56.9f pd=0.74u as=56.9f ps=0.74u w=0.17u l=0.17u
X10644 cml_tlatch_71.xmux.xn.S1 cml_tlatch_44.INP cml_tlatch_71.OUTN VSS sg13_lv_nmos ad=63.19999f pd=0.74u as=63.19999f ps=0.74u w=0.26u l=0.38u
X10645 cml_tlatch_87.INN cml_tlatch_87.INP cml_tlatch_76.xmux.xp.S1 VSS sg13_lv_nmos ad=56.9f pd=0.74u as=56.9f ps=0.74u w=0.17u l=0.17u
X10646 cml_tlatch_65.OUTN cml_tlatch_65.OUTP cml_tlatch_65.xmux.xp.S1 VSS sg13_lv_nmos ad=56.9f pd=0.74u as=56.9f ps=0.74u w=0.17u l=0.17u
X10647 cml_tlatch_73.xmux.xp.S1 MOT27_P MOT27_N VSS sg13_lv_nmos ad=56.9f pd=0.74u as=56.9f ps=0.74u w=0.17u l=0.17u
X10648 VSS hs_to_clk_5.sg13_lv_nmos_2HGZLP_0.G VSS VSS sg13_lv_nmos ad=2.071p pd=11.28u as=0 ps=0 w=10.9u l=1.38u
X10649 cml_tlatch_46.xtail.S1 CKB2_N cml_tlatch_46.xmux.xp.S1 VSS sg13_lv_nmos ad=89.3f pd=0.85u as=89.3f ps=0.85u w=0.47u l=0.16u
X10650 cml_tlatch_9.xmux.xp.S1 A0_8_P A0_8_N VSS sg13_lv_nmos ad=56.9f pd=0.74u as=56.9f ps=0.74u w=0.17u l=0.17u
X10651 cml_tlatch_41.xtail.S1 CKA1_P cml_tlatch_41.xmux.xn.S1 VSS sg13_lv_nmos ad=89.3f pd=0.85u as=89.3f ps=0.85u w=0.47u l=0.16u
X10652 cml_tlatch_56.xtail.S1 CKA3_N cml_tlatch_56.xmux.xp.S1 VSS sg13_lv_nmos ad=89.3f pd=0.85u as=89.3f ps=0.85u w=0.47u l=0.16u
X10653 MOT7_N MOT7_P cml_tlatch_17.xmux.xp.S1 VSS sg13_lv_nmos ad=56.9f pd=0.74u as=56.9f ps=0.74u w=0.17u l=0.17u
X10654 MOT16_P A2_8_N cml_tlatch_52.xmux.xn.S1 VSS sg13_lv_nmos ad=63.19999f pd=0.74u as=63.19999f ps=0.74u w=0.26u l=0.38u
X10655 cml_tlatch_83.xmux.xp.S1 CKB2_P cml_tlatch_83.xtail.S1 VSS sg13_lv_nmos ad=89.3f pd=0.85u as=89.3f ps=0.85u w=0.47u l=0.16u
X10656 cml_tlatch_11.xmux.xp.S1 stub_bi_15.BOTN stub_bi_15.BOTP VSS sg13_lv_nmos ad=56.9f pd=0.74u as=56.9f ps=0.74u w=0.17u l=0.17u
X10657 cml_tlatch_36.xtail.S1 CKB1_N cml_tlatch_36.xmux.xn.S1 VSS sg13_lv_nmos ad=0.1598p pd=1.62u as=89.3f ps=0.85u w=0.47u l=0.16u
X10658 cml_tlatch_67.OUTP cml_tlatch_67.OUTN cml_tlatch_67.xmux.xp.S1 VSS sg13_lv_nmos ad=56.9f pd=0.74u as=56.9f ps=0.74u w=0.17u l=0.17u
X10659 cml_tlatch_17.xmux.xp.S1 CKHB0_N cml_tlatch_17.xtail.S1 VSS sg13_lv_nmos ad=89.3f pd=0.85u as=89.3f ps=0.85u w=0.47u l=0.16u
X10660 cml_tlatch_48.xmux.xn.S1 D2_N stub_bi_43.BOTN VSS sg13_lv_nmos ad=63.19999f pd=0.74u as=63.19999f ps=0.74u w=0.26u l=0.38u
X10661 cml_tlatch_8.OUTN cml_tlatch_8.OUTP cml_tlatch_8.xmux.xp.S1 VSS sg13_lv_nmos ad=56.9f pd=0.74u as=56.9f ps=0.74u w=0.17u l=0.17u
X10662 cml_tlatch_69.xmux.xp.S1 cml_tlatch_69.OUTN cml_tlatch_69.OUTP VSS sg13_lv_nmos ad=0.1019p pd=1.34u as=56.9f ps=0.74u w=0.17u l=0.17u
X10663 VDD J1_N VSS rppd l=5.17u w=1u
X10664 CLK_W_N CLK_W_P cml_tlatch_93.xmux.xp.S1 VSS sg13_lv_nmos ad=56.9f pd=0.74u as=56.9f ps=0.74u w=0.17u l=0.17u
X10665 MOT30_N A3_2_P cml_tlatch_45.xmux.xn.S1 VSS sg13_lv_nmos ad=63.19999f pd=0.74u as=63.19999f ps=0.74u w=0.26u l=0.38u
X10666 GB0_P ENB1_N cml_gate2_1.xamp.xn.S1 VSS sg13_lv_nmos ad=0.1007p pd=0.91u as=0.1007p ps=0.91u w=0.53u l=0.13u
X10667 cml_tlatch_74.INP cml_tlatch_74.INN cml_tlatch_88.xmux.xp.S1 VSS sg13_lv_nmos ad=56.9f pd=0.74u as=56.9f ps=0.74u w=0.17u l=0.17u
X10668 MOT22_P A2_2_N cml_tlatch_55.xmux.xn.S1 VSS sg13_lv_nmos ad=63.19999f pd=0.74u as=63.19999f ps=0.74u w=0.26u l=0.38u
X10669 cml_tlatch_56.OUTP A3_2_N cml_tlatch_56.xmux.xn.S1 VSS sg13_lv_nmos ad=0.1082p pd=1.34u as=63.19999f ps=0.74u w=0.26u l=0.38u
X10670 cml_tlatch_79.xtail.S1 CKHB2_N cml_tlatch_79.xmux.xp.S1 VSS sg13_lv_nmos ad=89.3f pd=0.85u as=89.3f ps=0.85u w=0.47u l=0.16u
X10671 MOT17_N MOT17_P cml_tlatch_77.xmux.xp.S1 VSS sg13_lv_nmos ad=56.9f pd=0.74u as=56.9f ps=0.74u w=0.17u l=0.17u
X10672 cml_gate2_3.xamp.xn.S1 ENA0_P GA0_N VSS sg13_lv_nmos ad=0.1007p pd=0.91u as=0.1007p ps=0.91u w=0.53u l=0.13u
X10673 cml_gate2_0.xrtail.R1 CKA1_N GB1_P VSS sg13_lv_nmos ad=0.1007p pd=0.91u as=0.1802p ps=1.74u w=0.53u l=0.13u
X10674 cml_tlatch_88.xtail.S1 CKB3_N cml_tlatch_88.xmux.xn.S1 VSS sg13_lv_nmos ad=89.3f pd=0.85u as=89.3f ps=0.85u w=0.47u l=0.16u
X10675 cml_tlatch_33.OUTN cml_tlatch_33.OUTP cml_tlatch_33.xmux.xp.S1 VSS sg13_lv_nmos ad=56.9f pd=0.74u as=56.9f ps=0.74u w=0.17u l=0.17u
X10676 cml_tlatch_10.xmux.xp.S1 B1_8_N B1_8_P VSS sg13_lv_nmos ad=56.9f pd=0.74u as=56.9f ps=0.74u w=0.17u l=0.17u
X10677 cml_tlatch_16.xmux.xp.S1 MOT5_N MOT5_P VSS sg13_lv_nmos ad=56.9f pd=0.74u as=56.9f ps=0.74u w=0.17u l=0.17u
X10678 cml_tlatch_23.OUTN cml_tlatch_0.OUTP cml_tlatch_23.xmux.xn.S1 VSS sg13_lv_nmos ad=63.19999f pd=0.74u as=63.19999f ps=0.74u w=0.26u l=0.38u
X10679 MOT14_P MOT14_N cml_tlatch_25.xmux.xp.S1 VSS sg13_lv_nmos ad=56.9f pd=0.74u as=56.9f ps=0.74u w=0.17u l=0.17u
X10680 cml_tlatch_4.xmux.xn.S1 CKHB1_P cml_tlatch_4.xtail.S1 VSS sg13_lv_nmos ad=89.3f pd=0.85u as=89.3f ps=0.85u w=0.47u l=0.16u
X10681 MOT30_N MOT30_P cml_tlatch_45.xmux.xp.S1 VSS sg13_lv_nmos ad=56.9f pd=0.74u as=0.1019p ps=1.34u w=0.17u l=0.17u
X10682 cml_tlatch_61.xmux.xp.S1 CKA2_N cml_tlatch_61.xtail.S1 VSS sg13_lv_nmos ad=89.3f pd=0.85u as=89.3f ps=0.85u w=0.47u l=0.16u
X10683 cml_tlatch_65.xmux.xp.S1 cml_tlatch_65.OUTN cml_tlatch_65.OUTP VSS sg13_lv_nmos ad=56.9f pd=0.74u as=56.9f ps=0.74u w=0.17u l=0.17u
X10684 cml_tlatch_74.xtail.S1 CKHB3_N cml_tlatch_74.xmux.xp.S1 VSS sg13_lv_nmos ad=89.3f pd=0.85u as=89.3f ps=0.85u w=0.47u l=0.16u
X10685 cml_tlatch_2.xmux.xp.S1 cml_tlatch_2.OUTP cml_tlatch_2.OUTN VSS sg13_lv_nmos ad=56.9f pd=0.74u as=56.9f ps=0.74u w=0.17u l=0.17u
X10686 cml_tlatch_32.xmux.xn.S1 D0_N cml_tlatch_32.OUTP VSS sg13_lv_nmos ad=0.1082p pd=1.34u as=63.19999f ps=0.74u w=0.26u l=0.38u
.ends sr16_rx4
