* NGSPICE file created from sr16_tx.ext - technology: ihp-sg13g2

.subckt sg13_lv_nmos_5A5R5E G sub D0 a_80_n77# S1
X0 S1 G D0 sub sg13_lv_nmos ad=0.1463p pd=1.15u as=0.2618p ps=2.22u w=0.77u l=0.21u
X1 a_80_n77# G S1 sub sg13_lv_nmos ad=0.2618p pd=2.22u as=0.1463p ps=1.15u w=0.77u l=0.21u
.ends

.subckt rppd_2ZAP6P B R2 R1
X0 R1 R2 B rppd l=13.09u w=1u
.ends

.subckt rppd_ACUNYL B R2 R1
X0 R1 R2 B rppd l=2.72u w=1u
.ends

.subckt cml_drvb VDD INP OUTN OUTP INN VSS
Xxamp.xn INP VSS OUTN OUTN xrtail/R1 sg13_lv_nmos_5A5R5E
Xxamp.xp INN VSS OUTP OUTP xrtail/R1 sg13_lv_nmos_5A5R5E
Xxlp.xrl VSS OUTP VDD rppd_2ZAP6P
Xxrtail VSS VSS xrtail/R1 rppd_ACUNYL
Xxln.xrl VSS VDD OUTN rppd_2ZAP6P
.ends

.subckt sg13_lv_nmos_AD63GD G D8 D6 sub D4 D2 D0 S8 S7 S5 S3 S1
X0 S1 G D0 sub sg13_lv_nmos ad=63.19999f pd=0.74u as=0.1082p ps=1.34u w=0.26u l=0.38u
X1 S3 G D2 sub sg13_lv_nmos ad=63.19999f pd=0.74u as=63.19999f ps=0.74u w=0.26u l=0.38u
X2 D8 G S7 sub sg13_lv_nmos ad=63.19999f pd=0.74u as=63.19999f ps=0.74u w=0.26u l=0.38u
X3 D6 G S5 sub sg13_lv_nmos ad=63.19999f pd=0.74u as=63.19999f ps=0.74u w=0.26u l=0.38u
X4 D4 G S3 sub sg13_lv_nmos ad=63.19999f pd=0.74u as=63.19999f ps=0.74u w=0.26u l=0.38u
X5 S5 G D4 sub sg13_lv_nmos ad=63.19999f pd=0.74u as=63.19999f ps=0.74u w=0.26u l=0.38u
X6 S7 G D6 sub sg13_lv_nmos ad=63.19999f pd=0.74u as=63.19999f ps=0.74u w=0.26u l=0.38u
X7 D2 G S1 sub sg13_lv_nmos ad=63.19999f pd=0.74u as=63.19999f ps=0.74u w=0.26u l=0.38u
X8 S8 G D8 sub sg13_lv_nmos ad=0.1082p pd=1.34u as=63.19999f ps=0.74u w=0.26u l=0.38u
.ends

.subckt rppd_6K5NNH B R2 R1
X0 R1 R2 B rppd l=5.17u w=1u
.ends

.subckt sg13_lv_nmos_72NHQF D10 G S12 S11 D8 D6 sub D4 D2 D0 S9 S7 S5 S3 S1 D12
X0 D8 G S7 sub sg13_lv_nmos ad=89.3f pd=0.85u as=89.3f ps=0.85u w=0.47u l=0.16u
X1 S9 G D8 sub sg13_lv_nmos ad=89.3f pd=0.85u as=89.3f ps=0.85u w=0.47u l=0.16u
X2 S7 G D6 sub sg13_lv_nmos ad=89.3f pd=0.85u as=89.3f ps=0.85u w=0.47u l=0.16u
X3 D10 G S9 sub sg13_lv_nmos ad=89.3f pd=0.85u as=89.3f ps=0.85u w=0.47u l=0.16u
X4 S11 G D10 sub sg13_lv_nmos ad=89.3f pd=0.85u as=89.3f ps=0.85u w=0.47u l=0.16u
X5 D12 G S11 sub sg13_lv_nmos ad=89.3f pd=0.85u as=89.3f ps=0.85u w=0.47u l=0.16u
X6 D6 G S5 sub sg13_lv_nmos ad=89.3f pd=0.85u as=89.3f ps=0.85u w=0.47u l=0.16u
X7 S12 G D12 sub sg13_lv_nmos ad=0.1598p pd=1.62u as=89.3f ps=0.85u w=0.47u l=0.16u
X8 S5 G D4 sub sg13_lv_nmos ad=89.3f pd=0.85u as=89.3f ps=0.85u w=0.47u l=0.16u
X9 D4 G S3 sub sg13_lv_nmos ad=89.3f pd=0.85u as=89.3f ps=0.85u w=0.47u l=0.16u
X10 S3 G D2 sub sg13_lv_nmos ad=89.3f pd=0.85u as=89.3f ps=0.85u w=0.47u l=0.16u
X11 D2 G S1 sub sg13_lv_nmos ad=89.3f pd=0.85u as=89.3f ps=0.85u w=0.47u l=0.16u
X12 S1 G D0 sub sg13_lv_nmos ad=89.3f pd=0.85u as=0.1598p ps=1.62u w=0.47u l=0.16u
.ends

.subckt sg13_lv_nmos_KUKXB4 D22 S17 D10 D20 S15 G S13 S23 S11 S21 D8 D6 sub D4 D2
+ D0 S9 S7 D18 S5 a_1420_n17# D16 S3 D14 S19 S1 D12
X0 S7 G D6 sub sg13_lv_nmos ad=56.9f pd=0.74u as=56.9f ps=0.74u w=0.17u l=0.17u
X1 D16 G S15 sub sg13_lv_nmos ad=56.9f pd=0.74u as=56.9f ps=0.74u w=0.17u l=0.17u
X2 S21 G D20 sub sg13_lv_nmos ad=56.9f pd=0.74u as=56.9f ps=0.74u w=0.17u l=0.17u
X3 D18 G S17 sub sg13_lv_nmos ad=56.9f pd=0.74u as=56.9f ps=0.74u w=0.17u l=0.17u
X4 S23 G D22 sub sg13_lv_nmos ad=56.9f pd=0.74u as=56.9f ps=0.74u w=0.17u l=0.17u
X5 D20 G S19 sub sg13_lv_nmos ad=56.9f pd=0.74u as=56.9f ps=0.74u w=0.17u l=0.17u
X6 S3 G D2 sub sg13_lv_nmos ad=56.9f pd=0.74u as=56.9f ps=0.74u w=0.17u l=0.17u
X7 S5 G D4 sub sg13_lv_nmos ad=56.9f pd=0.74u as=56.9f ps=0.74u w=0.17u l=0.17u
X8 S15 G D14 sub sg13_lv_nmos ad=56.9f pd=0.74u as=56.9f ps=0.74u w=0.17u l=0.17u
X9 D10 G S9 sub sg13_lv_nmos ad=56.9f pd=0.74u as=56.9f ps=0.74u w=0.17u l=0.17u
X10 D8 G S7 sub sg13_lv_nmos ad=56.9f pd=0.74u as=56.9f ps=0.74u w=0.17u l=0.17u
X11 S13 G D12 sub sg13_lv_nmos ad=56.9f pd=0.74u as=56.9f ps=0.74u w=0.17u l=0.17u
X12 S11 G D10 sub sg13_lv_nmos ad=56.9f pd=0.74u as=56.9f ps=0.74u w=0.17u l=0.17u
X13 S17 G D16 sub sg13_lv_nmos ad=56.9f pd=0.74u as=56.9f ps=0.74u w=0.17u l=0.17u
X14 S1 G D0 sub sg13_lv_nmos ad=56.9f pd=0.74u as=0.1019p ps=1.34u w=0.17u l=0.17u
X15 D22 G S21 sub sg13_lv_nmos ad=56.9f pd=0.74u as=56.9f ps=0.74u w=0.17u l=0.17u
X16 S19 G D18 sub sg13_lv_nmos ad=56.9f pd=0.74u as=56.9f ps=0.74u w=0.17u l=0.17u
X17 D14 G S13 sub sg13_lv_nmos ad=56.9f pd=0.74u as=56.9f ps=0.74u w=0.17u l=0.17u
X18 a_1420_n17# G S23 sub sg13_lv_nmos ad=0.1019p pd=1.34u as=56.9f ps=0.74u w=0.17u l=0.17u
X19 D4 G S3 sub sg13_lv_nmos ad=56.9f pd=0.74u as=56.9f ps=0.74u w=0.17u l=0.17u
X20 D6 G S5 sub sg13_lv_nmos ad=56.9f pd=0.74u as=56.9f ps=0.74u w=0.17u l=0.17u
X21 D2 G S1 sub sg13_lv_nmos ad=56.9f pd=0.74u as=56.9f ps=0.74u w=0.17u l=0.17u
X22 D12 G S11 sub sg13_lv_nmos ad=56.9f pd=0.74u as=56.9f ps=0.74u w=0.17u l=0.17u
X23 S9 G D8 sub sg13_lv_nmos ad=56.9f pd=0.74u as=56.9f ps=0.74u w=0.17u l=0.17u
.ends

.subckt sg13_lv_nmos_98SV2Z G sub D2 a_166_n823# D0 S3 S1
X0 S3 G D2 sub sg13_lv_nmos ad=1.5637p pd=8.61u as=1.5637p ps=8.61u w=8.23u l=0.13u
X1 D2 G S1 sub sg13_lv_nmos ad=1.5637p pd=8.61u as=1.5637p ps=8.61u w=8.23u l=0.13u
X2 a_166_n823# G S3 sub sg13_lv_nmos ad=2.7982p pd=17.14u as=1.5637p ps=8.61u w=8.23u l=0.13u
X3 S1 G D0 sub sg13_lv_nmos ad=1.5637p pd=8.61u as=2.7982p ps=17.14u w=8.23u l=0.13u
.ends

.subckt cml_tlatch VDD OUTN OUTP CKN CKP INP INN POLN VSS
Xxamp.xn INN xmux.xn/S9 xmux.xn/S9 VSS xmux.xn/S9 xmux.xn/S9 xmux.xn/S9 OUTP OUTP
+ OUTP OUTP OUTP sg13_lv_nmos_AD63GD
Xxamp.xp INP xmux.xn/S9 xmux.xn/S9 VSS xmux.xn/S9 xmux.xn/S9 xmux.xn/S9 OUTN OUTN
+ OUTN OUTN OUTN sg13_lv_nmos_AD63GD
Xxlp.xrl VSS OUTP VDD rppd_6K5NNH
Xxmux.xn xtail/S3 CKP xmux.xn/S9 xmux.xn/S9 xtail/S3 xtail/S3 VSS xtail/S3 xtail/S3
+ xtail/S3 xmux.xn/S9 xmux.xn/S9 xmux.xn/S9 xmux.xn/S9 xmux.xn/S9 xtail/S3 sg13_lv_nmos_72NHQF
Xxmux.xp xtail/S3 CKN xmux.xp/S9 xmux.xp/S9 xtail/S3 xtail/S3 VSS xtail/S3 xtail/S3
+ xtail/S3 xmux.xp/S9 xmux.xp/S9 xmux.xp/S9 xmux.xp/S9 xmux.xp/S9 xtail/S3 sg13_lv_nmos_72NHQF
Xxln.xrl VSS OUTN VDD rppd_6K5NNH
Xxmem.xn xmux.xp/S9 OUTN xmux.xp/S9 xmux.xp/S9 OUTN OUTP OUTN OUTN OUTN OUTN xmux.xp/S9
+ xmux.xp/S9 VSS xmux.xp/S9 xmux.xp/S9 xmux.xp/S9 OUTN OUTN xmux.xp/S9 OUTN xmux.xp/S9
+ xmux.xp/S9 OUTN xmux.xp/S9 OUTN OUTN xmux.xp/S9 sg13_lv_nmos_KUKXB4
Xxmem.xp xmux.xp/S9 OUTP xmux.xp/S9 xmux.xp/S9 OUTP OUTN OUTP OUTP OUTP OUTP xmux.xp/S9
+ xmux.xp/S9 VSS xmux.xp/S9 xmux.xp/S9 xmux.xp/S9 OUTP OUTP xmux.xp/S9 OUTP xmux.xp/S9
+ xmux.xp/S9 OUTP xmux.xp/S9 OUTP OUTP xmux.xp/S9 sg13_lv_nmos_KUKXB4
Xxtail POLN VSS VSS VSS VSS xtail/S3 xtail/S3 sg13_lv_nmos_98SV2Z
.ends

.subckt sg13_lv_nmos_GS4QVZ D10 G S11 D8 D6 sub D4 D2 D0 a_640_9# S9 S7 S5 S3 S1
X0 S7 G D6 sub sg13_lv_nmos ad=56.9f pd=0.74u as=56.9f ps=0.74u w=0.17u l=0.13u
X1 D4 G S3 sub sg13_lv_nmos ad=56.9f pd=0.74u as=56.9f ps=0.74u w=0.17u l=0.13u
X2 D10 G S9 sub sg13_lv_nmos ad=56.9f pd=0.74u as=56.9f ps=0.74u w=0.17u l=0.13u
X3 S5 G D4 sub sg13_lv_nmos ad=56.9f pd=0.74u as=56.9f ps=0.74u w=0.17u l=0.13u
X4 D6 G S5 sub sg13_lv_nmos ad=56.9f pd=0.74u as=56.9f ps=0.74u w=0.17u l=0.13u
X5 S9 G D8 sub sg13_lv_nmos ad=56.9f pd=0.74u as=56.9f ps=0.74u w=0.17u l=0.13u
X6 D8 G S7 sub sg13_lv_nmos ad=56.9f pd=0.74u as=56.9f ps=0.74u w=0.17u l=0.13u
X7 S1 G D0 sub sg13_lv_nmos ad=56.9f pd=0.74u as=0.1019p ps=1.34u w=0.17u l=0.13u
X8 D2 G S1 sub sg13_lv_nmos ad=56.9f pd=0.74u as=56.9f ps=0.74u w=0.17u l=0.13u
X9 a_640_9# G S11 sub sg13_lv_nmos ad=0.1019p pd=1.34u as=56.9f ps=0.74u w=0.17u l=0.13u
X10 S3 G D2 sub sg13_lv_nmos ad=56.9f pd=0.74u as=56.9f ps=0.74u w=0.17u l=0.13u
X11 S11 G D10 sub sg13_lv_nmos ad=56.9f pd=0.74u as=56.9f ps=0.74u w=0.17u l=0.13u
.ends

.subckt rppd_XR79A4 B R2 R1
X0 R1 R2 B rppd l=7.35u w=1u
.ends

.subckt sg13_lv_nmos_3F3Z24 D10 G S11 D8 D6 sub D4 D2 D0 a_586_n53# S9 S7 S5 S3 S1
X0 D8 G S7 sub sg13_lv_nmos ad=0.1007p pd=0.91u as=0.1007p ps=0.91u w=0.53u l=0.14u
X1 D4 G S3 sub sg13_lv_nmos ad=0.1007p pd=0.91u as=0.1007p ps=0.91u w=0.53u l=0.14u
X2 S11 G D10 sub sg13_lv_nmos ad=0.1007p pd=0.91u as=0.1007p ps=0.91u w=0.53u l=0.14u
X3 D6 G S5 sub sg13_lv_nmos ad=0.1007p pd=0.91u as=0.1007p ps=0.91u w=0.53u l=0.14u
X4 S1 G D0 sub sg13_lv_nmos ad=0.1007p pd=0.91u as=0.1802p ps=1.74u w=0.53u l=0.14u
X5 S9 G D8 sub sg13_lv_nmos ad=0.1007p pd=0.91u as=0.1007p ps=0.91u w=0.53u l=0.14u
X6 S3 G D2 sub sg13_lv_nmos ad=0.1007p pd=0.91u as=0.1007p ps=0.91u w=0.53u l=0.14u
X7 a_586_n53# G S11 sub sg13_lv_nmos ad=0.1802p pd=1.74u as=0.1007p ps=0.91u w=0.53u l=0.14u
X8 D10 G S9 sub sg13_lv_nmos ad=0.1007p pd=0.91u as=0.1007p ps=0.91u w=0.53u l=0.14u
X9 S5 G D4 sub sg13_lv_nmos ad=0.1007p pd=0.91u as=0.1007p ps=0.91u w=0.53u l=0.14u
X10 D2 G S1 sub sg13_lv_nmos ad=0.1007p pd=0.91u as=0.1007p ps=0.91u w=0.53u l=0.14u
X11 S7 G D6 sub sg13_lv_nmos ad=0.1007p pd=0.91u as=0.1007p ps=0.91u w=0.53u l=0.14u
.ends

.subckt rppd_L5CC98 B R2 R1
X0 R1 R2 B rppd l=3.34u w=1u
.ends

.subckt cml_mux2 VDD AN AP XN XP BN BP SN SP VSS
Xxampa.xn.b XN AP xmux.xp/D8 XN XN VSS XN XN XN XN xmux.xp/D8 xmux.xp/D8 xmux.xp/D8
+ xmux.xp/D8 xmux.xp/D8 sg13_lv_nmos_GS4QVZ
Xxlp.xrl VSS XP VDD rppd_XR79A4
Xxampb.xp.b XP BN xmux.xn/D8 XP XP VSS XP XP XP XP xmux.xn/D8 xmux.xn/D8 xmux.xn/D8
+ xmux.xn/D8 xmux.xn/D8 sg13_lv_nmos_GS4QVZ
Xxampb.xp.a XP BN xmux.xn/D8 XP XP VSS XP XP XP XP xmux.xn/D8 xmux.xn/D8 xmux.xn/D8
+ xmux.xn/D8 xmux.xn/D8 sg13_lv_nmos_GS4QVZ
Xxmux.xn xmux.xn/D8 SN xrtail/R1 xmux.xn/D8 xmux.xn/D8 VSS xmux.xn/D8 xmux.xn/D8 xmux.xn/D8
+ xmux.xn/D8 xrtail/R1 xrtail/R1 xrtail/R1 xrtail/R1 xrtail/R1 sg13_lv_nmos_3F3Z24
Xxampb.xn.a XN BP xmux.xn/D8 XN XN VSS XN XN XN XN xmux.xn/D8 xmux.xn/D8 xmux.xn/D8
+ xmux.xn/D8 xmux.xn/D8 sg13_lv_nmos_GS4QVZ
Xxrtail VSS VSS xrtail/R1 rppd_L5CC98
Xxampb.xn.b XN BP xmux.xn/D8 XN XN VSS XN XN XN XN xmux.xn/D8 xmux.xn/D8 xmux.xn/D8
+ xmux.xn/D8 xmux.xn/D8 sg13_lv_nmos_GS4QVZ
Xxmux.xp xmux.xp/D8 SP xrtail/R1 xmux.xp/D8 xmux.xp/D8 VSS xmux.xp/D8 xmux.xp/D8 xmux.xp/D8
+ xmux.xp/D8 xrtail/R1 xrtail/R1 xrtail/R1 xrtail/R1 xrtail/R1 sg13_lv_nmos_3F3Z24
Xxln.xrl VSS XN VDD rppd_XR79A4
Xxampa.xp.a XP AN xmux.xp/D8 XP XP VSS XP XP XP XP xmux.xp/D8 xmux.xp/D8 xmux.xp/D8
+ xmux.xp/D8 xmux.xp/D8 sg13_lv_nmos_GS4QVZ
Xxampa.xp.b XP AN xmux.xp/D8 XP XP VSS XP XP XP XP xmux.xp/D8 xmux.xp/D8 xmux.xp/D8
+ xmux.xp/D8 xmux.xp/D8 sg13_lv_nmos_GS4QVZ
Xxampa.xn.a XN AP xmux.xp/D8 XN XN VSS XN XN XN XN xmux.xp/D8 xmux.xp/D8 xmux.xp/D8
+ xmux.xp/D8 xmux.xp/D8 sg13_lv_nmos_GS4QVZ
.ends

.subckt rppd_RFWDE4 B R2 R1
X0 R1 R2 B rppd l=4.25u w=1u
.ends

.subckt sg13_lv_nmos_2HGZLP G D8 D6 sub D4 a_1722_n1090# D2 D0 S9 S7 S5 S3 S1
X0 D6 G S5 sub sg13_lv_nmos ad=2.071p pd=11.28u as=2.071p ps=11.28u w=10.9u l=1.38u
X1 D4 G S3 sub sg13_lv_nmos ad=2.071p pd=11.28u as=2.071p ps=11.28u w=10.9u l=1.38u
X2 S7 G D6 sub sg13_lv_nmos ad=2.071p pd=11.28u as=2.071p ps=11.28u w=10.9u l=1.38u
X3 S9 G D8 sub sg13_lv_nmos ad=2.071p pd=11.28u as=2.071p ps=11.28u w=10.9u l=1.38u
X4 S5 G D4 sub sg13_lv_nmos ad=2.071p pd=11.28u as=2.071p ps=11.28u w=10.9u l=1.38u
X5 S1 G D0 sub sg13_lv_nmos ad=2.071p pd=11.28u as=3.706p ps=22.48u w=10.9u l=1.38u
X6 D2 G S1 sub sg13_lv_nmos ad=2.071p pd=11.28u as=2.071p ps=11.28u w=10.9u l=1.38u
X7 S3 G D2 sub sg13_lv_nmos ad=2.071p pd=11.28u as=2.071p ps=11.28u w=10.9u l=1.38u
X8 D8 G S7 sub sg13_lv_nmos ad=2.071p pd=11.28u as=2.071p ps=11.28u w=10.9u l=1.38u
X9 a_1722_n1090# G S9 sub sg13_lv_nmos ad=3.706p pd=22.48u as=2.071p ps=11.28u w=10.9u l=1.38u
.ends

.subckt sg13_lv_nmos_G385L9 G a_166_n1000# sub D2 D0 S3 S1
X0 D2 G S1 sub sg13_lv_nmos ad=1.9p pd=10.38u as=1.9p ps=10.38u w=10u l=0.13u
X1 a_166_n1000# G S3 sub sg13_lv_nmos ad=3.4p pd=20.68u as=1.9p ps=10.38u w=10u l=0.13u
X2 S1 G D0 sub sg13_lv_nmos ad=1.9p pd=10.38u as=3.4p ps=20.68u w=10u l=0.13u
X3 S3 G D2 sub sg13_lv_nmos ad=1.9p pd=10.38u as=1.9p ps=10.38u w=10u l=0.13u
.ends

.subckt sg13_lv_nmos_B8H2RM G sub D2 D0 S2 S1
X0 D2 G S1 sub sg13_lv_nmos ad=0.228p pd=1.58u as=0.228p ps=1.58u w=1.2u l=0.2u
X1 S2 G D2 sub sg13_lv_nmos ad=0.408p pd=3.08u as=0.228p ps=1.58u w=1.2u l=0.2u
X2 S1 G D0 sub sg13_lv_nmos ad=0.228p pd=1.58u as=0.408p ps=3.08u w=1.2u l=0.2u
.ends

.subckt rppd_HNU9MK B R2 R1
X0 R1 R2 B rppd l=0.68u w=1u
.ends

.subckt hs_to_clk VDD INN INP OUTN OUTP POLN VSS
Xrppd_RFWDE4_0 VSS rppd_RFWDE4_1/R1 OUTN rppd_RFWDE4
Xrppd_RFWDE4_1 VSS OUTP rppd_RFWDE4_1/R1 rppd_RFWDE4
Xsg13_lv_nmos_2HGZLP_0 rppd_RFWDE4_1/R1 VSS VSS VSS VSS VSS VSS VSS VSS VSS VSS VSS
+ VSS sg13_lv_nmos_2HGZLP
Xsg13_lv_nmos_G385L9_0 POLN D2 VSS D2 D2 VSS VSS sg13_lv_nmos_G385L9
Xsg13_lv_nmos_B8H2RM_0 INN VSS D2 D2 OUTN OUTN sg13_lv_nmos_B8H2RM
Xrppd_HNU9MK_0 VSS rppd_RFWDE4_1/R1 VDD rppd_HNU9MK
X0 D2 INP OUTP VSS sg13_lv_nmos ad=0.228p pd=1.58u as=0.408p ps=3.08u w=1.2u l=0.2u
X1 D2 INP OUTP VSS sg13_lv_nmos ad=0.408p pd=3.08u as=0.228p ps=1.58u w=1.2u l=0.2u
X2 OUTP INP D2 VSS sg13_lv_nmos ad=0.228p pd=1.58u as=0.228p ps=1.58u w=1.2u l=0.2u
.ends

.subckt rppd_W2KASE B R2 R1
X0 R1 R2 B rppd l=7.42u w=1u
.ends

.subckt sg13_lv_nmos_FTPY57 D10 G S11 D8 D6 sub D4 D2 D0 S9 S7 S5 S3 a_574_n53# S1
X0 S5 G D4 sub sg13_lv_nmos ad=0.1007p pd=0.91u as=0.1007p ps=0.91u w=0.53u l=0.13u
X1 D4 G S3 sub sg13_lv_nmos ad=0.1007p pd=0.91u as=0.1007p ps=0.91u w=0.53u l=0.13u
X2 S3 G D2 sub sg13_lv_nmos ad=0.1007p pd=0.91u as=0.1007p ps=0.91u w=0.53u l=0.13u
X3 D2 G S1 sub sg13_lv_nmos ad=0.1007p pd=0.91u as=0.1007p ps=0.91u w=0.53u l=0.13u
X4 S1 G D0 sub sg13_lv_nmos ad=0.1007p pd=0.91u as=0.1802p ps=1.74u w=0.53u l=0.13u
X5 D8 G S7 sub sg13_lv_nmos ad=0.1007p pd=0.91u as=0.1007p ps=0.91u w=0.53u l=0.13u
X6 S9 G D8 sub sg13_lv_nmos ad=0.1007p pd=0.91u as=0.1007p ps=0.91u w=0.53u l=0.13u
X7 D10 G S9 sub sg13_lv_nmos ad=0.1007p pd=0.91u as=0.1007p ps=0.91u w=0.53u l=0.13u
X8 S11 G D10 sub sg13_lv_nmos ad=0.1007p pd=0.91u as=0.1007p ps=0.91u w=0.53u l=0.13u
X9 D6 G S5 sub sg13_lv_nmos ad=0.1007p pd=0.91u as=0.1007p ps=0.91u w=0.53u l=0.13u
X10 a_574_n53# G S11 sub sg13_lv_nmos ad=0.1802p pd=1.74u as=0.1007p ps=0.91u w=0.53u l=0.13u
X11 S7 G D6 sub sg13_lv_nmos ad=0.1007p pd=0.91u as=0.1007p ps=0.91u w=0.53u l=0.13u
.ends

.subckt rppd_XV6GFH B R2 R1
X0 R1 R2 B rppd l=4.86u w=1u
.ends

.subckt cml_gate2 VDD AN AP XN XP BN BP VSS
Xxlp.xrl VSS XP VDD rppd_W2KASE
Xsg13_lv_nmos_FTPY57_0 xmux.xn/S9 AN XP xmux.xn/S9 xmux.xn/S9 VSS xmux.xn/S9 xmux.xn/S9
+ xmux.xn/S9 XP XP XP XP xmux.xn/S9 XP sg13_lv_nmos_FTPY57
Xsg13_lv_nmos_FTPY57_1 xmux.xn/S9 AP XN xmux.xn/S9 xmux.xn/S9 VSS xmux.xn/S9 xmux.xn/S9
+ xmux.xn/S9 XN XN XN XN xmux.xn/S9 XN sg13_lv_nmos_FTPY57
Xxmux.xn xrtail/R1 BP xmux.xn/S9 xrtail/R1 xrtail/R1 VSS xrtail/R1 xrtail/R1 xrtail/R1
+ xmux.xn/S9 xmux.xn/S9 xmux.xn/S9 xmux.xn/S9 xrtail/R1 xmux.xn/S9 sg13_lv_nmos_FTPY57
Xxrtail VSS VSS xrtail/R1 rppd_XV6GFH
Xxmux.xp xrtail/R1 BN XP xrtail/R1 xrtail/R1 VSS xrtail/R1 xrtail/R1 xrtail/R1 XP
+ XP XP XP xrtail/R1 XP sg13_lv_nmos_FTPY57
Xxln.xrl VSS XN VDD rppd_W2KASE
.ends

.subckt sr16_tx VDD VSS CK_N CK_P CLK_W_N CLK_W_P MOT0_N MOT0_P MOT1_N MOT1_P MOT2_N
+ MOT2_P MOT3_N MOT3_P MOT4_N MOT4_P MOT5_N MOT5_P MOT6_N MOT6_P MOT7_N MOT7_P DOUT_N
+ DOUT_P POLN
Xcml_drvb_1 VDD LB_P cml_mux2_2/SN cml_mux2_2/SP LB_N VSS cml_drvb
Xcml_tlatch_19 VDD cml_mux2_6/AN cml_mux2_6/AP hs_to_clk_2/OUTP hs_to_clk_2/OUTN cml_tlatch_19/INP
+ cml_tlatch_19/INN POLN VSS cml_tlatch
Xcml_tlatch_3 VDD cml_tlatch_2/INN cml_tlatch_2/INP interco_h_0/INBN interco_h_0/INBP
+ CLK_W_P CLK_W_N POLN VSS cml_tlatch
Xcml_drvb_2 VDD cml_mux2_6/SP cml_mux2_5/SN cml_mux2_5/SP cml_mux2_6/SN VSS cml_drvb
Xcml_tlatch_4 VDD LB_N LB_P interco_h_0/INBN interco_h_0/INBP LD_A_P LD_A_N POLN VSS
+ cml_tlatch
Xcml_drvb_3 VDD LD_A_P cml_mux2_6/SN cml_mux2_6/SP LD_A_N VSS cml_drvb
Xcml_tlatch_5 VDD cml_mux2_0/BN cml_mux2_0/BP interco_h_9/INBP interco_h_9/INBN cml_tlatch_5/INP
+ cml_tlatch_5/INN POLN VSS cml_tlatch
Xcml_mux2_0 VDD cml_mux2_0/AN cml_mux2_0/AP cml_mux2_0/XN cml_mux2_0/XP cml_mux2_0/BN
+ cml_mux2_0/BP cml_mux2_1/SN cml_mux2_1/SP VSS cml_mux2
Xcml_tlatch_6 VDD cml_tlatch_5/INN cml_tlatch_5/INP interco_h_9/INBN interco_h_9/INBP
+ cml_mux2_1/XP cml_mux2_1/XN POLN VSS cml_tlatch
Xcml_mux2_1 VDD cml_mux2_1/AN cml_mux2_1/AP cml_mux2_1/XN cml_mux2_1/XP cml_mux2_1/BN
+ cml_mux2_1/BP cml_mux2_1/SN cml_mux2_1/SP VSS cml_mux2
Xcml_tlatch_7 VDD cml_mux2_1/BN cml_mux2_1/BP interco_h_9/INBP interco_h_9/INBN cml_tlatch_7/INP
+ cml_tlatch_7/INN POLN VSS cml_tlatch
Xcml_mux2_2 VDD cml_mux2_2/AN cml_mux2_2/AP cml_mux2_2/XN cml_mux2_2/XP cml_mux2_2/BN
+ cml_mux2_2/BP cml_mux2_2/SN cml_mux2_2/SP VSS cml_mux2
Xcml_tlatch_8 VDD cml_tlatch_7/INN cml_tlatch_7/INP interco_h_9/INBN interco_h_9/INBP
+ cml_mux2_2/XP cml_mux2_2/XN POLN VSS cml_tlatch
Xcml_mux2_3 VDD SA0_N SA0_P DOUT_N DOUT_P SB0_N SB0_P cml_mux2_3/SN cml_mux2_3/SP
+ VSS cml_mux2
Xcml_tlatch_9 VDD cml_mux2_2/BN cml_mux2_2/BP interco_h_9/INBP interco_h_9/INBN cml_tlatch_9/INP
+ cml_tlatch_9/INN POLN VSS cml_tlatch
Xcml_mux2_4 VDD cml_mux2_4/AN cml_mux2_4/AP cml_mux2_4/XN cml_mux2_4/XP cml_mux2_4/BN
+ cml_mux2_4/BP cml_mux2_5/SN cml_mux2_5/SP VSS cml_mux2
Xhs_to_clk_0 VDD CK_N CK_P interco_h_0/INBN interco_h_0/INBP POLN VSS hs_to_clk
Xcml_mux2_5 VDD cml_mux2_5/AN cml_mux2_5/AP cml_mux2_5/XN cml_mux2_5/XP cml_mux2_5/BN
+ cml_mux2_5/BP cml_mux2_5/SN cml_mux2_5/SP VSS cml_mux2
Xhs_to_clk_1 VDD CK_P CK_N interco_h_9/INBN interco_h_9/INBP POLN VSS hs_to_clk
Xcml_gate2_0 VDD cml_gate2_0/AN cml_gate2_0/AP LD_A_N LD_A_P cml_gate2_0/BN cml_gate2_0/BP
+ VSS cml_gate2
Xcml_mux2_6 VDD cml_mux2_6/AN cml_mux2_6/AP cml_mux2_6/XN cml_mux2_6/XP cml_mux2_6/BN
+ cml_mux2_6/BP cml_mux2_6/SN cml_mux2_6/SP VSS cml_mux2
Xhs_to_clk_2 VDD CLK_W_N CLK_W_P hs_to_clk_2/OUTN hs_to_clk_2/OUTP POLN VSS hs_to_clk
Xhs_to_clk_3 VDD CK_N CK_P cml_mux2_3/SN cml_mux2_3/SP POLN VSS hs_to_clk
Xcml_tlatch_30 VDD cml_tlatch_29/INN cml_tlatch_29/INP cml_mux2_3/SN cml_mux2_3/SP
+ cml_mux2_4/XP cml_mux2_4/XN POLN VSS cml_tlatch
Xcml_tlatch_20 VDD cml_tlatch_19/INN cml_tlatch_19/INP hs_to_clk_2/OUTN hs_to_clk_2/OUTP
+ MOT4_P MOT4_N POLN VSS cml_tlatch
Xcml_tlatch_31 VDD cml_mux2_4/BN cml_mux2_4/BP cml_mux2_3/SP cml_mux2_3/SN cml_tlatch_31/INP
+ cml_tlatch_31/INN POLN VSS cml_tlatch
Xcml_tlatch_10 VDD cml_tlatch_9/INN cml_tlatch_9/INP interco_h_9/INBN interco_h_9/INBP
+ interco_h_9/INP interco_h_9/INN POLN VSS cml_tlatch
Xcml_tlatch_21 VDD cml_mux2_1/AN cml_mux2_1/AP hs_to_clk_2/OUTP hs_to_clk_2/OUTN cml_tlatch_21/INP
+ cml_tlatch_21/INN POLN VSS cml_tlatch
Xcml_tlatch_32 VDD cml_tlatch_31/INN cml_tlatch_31/INP cml_mux2_3/SN cml_mux2_3/SP
+ cml_mux2_5/XP cml_mux2_5/XN POLN VSS cml_tlatch
Xcml_tlatch_11 VDD SB0_N SB0_P interco_h_9/INBP interco_h_9/INBN cml_tlatch_11/INP
+ cml_tlatch_11/INN POLN VSS cml_tlatch
Xcml_tlatch_22 VDD cml_tlatch_21/INN cml_tlatch_21/INP hs_to_clk_2/OUTN hs_to_clk_2/OUTP
+ MOT3_P MOT3_N POLN VSS cml_tlatch
Xcml_tlatch_33 VDD cml_mux2_5/BN cml_mux2_5/BP cml_mux2_3/SP cml_mux2_3/SN cml_tlatch_33/INP
+ cml_tlatch_33/INN POLN VSS cml_tlatch
Xcml_tlatch_12 VDD cml_tlatch_11/INN cml_tlatch_11/INP interco_h_9/INBN interco_h_9/INBP
+ cml_mux2_0/XP cml_mux2_0/XN POLN VSS cml_tlatch
Xcml_tlatch_23 VDD cml_mux2_5/AN cml_mux2_5/AP hs_to_clk_2/OUTP hs_to_clk_2/OUTN cml_tlatch_23/INP
+ cml_tlatch_23/INN POLN VSS cml_tlatch
Xcml_tlatch_34 VDD cml_tlatch_33/INN cml_tlatch_33/INP cml_mux2_3/SN cml_mux2_3/SP
+ cml_mux2_6/XP cml_mux2_6/XN POLN VSS cml_tlatch
Xcml_tlatch_13 VDD interco_h_9/INN interco_h_9/INP hs_to_clk_2/OUTP hs_to_clk_2/OUTN
+ cml_tlatch_13/INP cml_tlatch_13/INN POLN VSS cml_tlatch
Xcml_tlatch_24 VDD cml_tlatch_23/INN cml_tlatch_23/INP hs_to_clk_2/OUTN hs_to_clk_2/OUTP
+ MOT2_P MOT2_N POLN VSS cml_tlatch
Xcml_tlatch_35 VDD cml_mux2_6/BN cml_mux2_6/BP cml_mux2_3/SP cml_mux2_3/SN cml_tlatch_35/INP
+ cml_tlatch_35/INN POLN VSS cml_tlatch
Xcml_tlatch_14 VDD cml_tlatch_13/INN cml_tlatch_13/INP hs_to_clk_2/OUTN hs_to_clk_2/OUTP
+ MOT7_P MOT7_N POLN VSS cml_tlatch
Xcml_tlatch_25 VDD cml_mux2_0/AN cml_mux2_0/AP hs_to_clk_2/OUTP hs_to_clk_2/OUTN cml_tlatch_25/INP
+ cml_tlatch_25/INN POLN VSS cml_tlatch
Xcml_tlatch_36 VDD cml_tlatch_35/INN cml_tlatch_35/INP cml_mux2_3/SN cml_mux2_3/SP
+ interco_h_41/INP interco_h_41/INN POLN VSS cml_tlatch
Xcml_tlatch_15 VDD interco_h_41/INN interco_h_41/INP hs_to_clk_2/OUTP hs_to_clk_2/OUTN
+ cml_tlatch_15/INP cml_tlatch_15/INN POLN VSS cml_tlatch
Xcml_tlatch_26 VDD cml_tlatch_25/INN cml_tlatch_25/INP hs_to_clk_2/OUTN hs_to_clk_2/OUTP
+ MOT1_P MOT1_N POLN VSS cml_tlatch
Xcml_tlatch_16 VDD cml_tlatch_15/INN cml_tlatch_15/INP hs_to_clk_2/OUTN hs_to_clk_2/OUTP
+ MOT6_P MOT6_N POLN VSS cml_tlatch
Xcml_tlatch_27 VDD cml_mux2_4/AN cml_mux2_4/AP hs_to_clk_2/OUTP hs_to_clk_2/OUTN cml_tlatch_27/INP
+ cml_tlatch_27/INN POLN VSS cml_tlatch
Xcml_tlatch_0 VDD cml_gate2_0/BP cml_gate2_0/BN interco_h_0/INBP interco_h_0/INBN
+ cml_tlatch_0/INP cml_tlatch_0/INN POLN VSS cml_tlatch
Xcml_tlatch_17 VDD cml_mux2_2/AN cml_mux2_2/AP hs_to_clk_2/OUTP hs_to_clk_2/OUTN cml_tlatch_17/INP
+ cml_tlatch_17/INN POLN VSS cml_tlatch
Xcml_tlatch_28 VDD cml_tlatch_27/INN cml_tlatch_27/INP hs_to_clk_2/OUTN hs_to_clk_2/OUTP
+ MOT0_P MOT0_N POLN VSS cml_tlatch
Xcml_tlatch_1 VDD cml_tlatch_0/INN cml_tlatch_0/INP interco_h_0/INBN interco_h_0/INBP
+ cml_gate2_0/AP cml_gate2_0/AN POLN VSS cml_tlatch
Xcml_tlatch_18 VDD cml_tlatch_17/INN cml_tlatch_17/INP hs_to_clk_2/OUTN hs_to_clk_2/OUTP
+ MOT5_P MOT5_N POLN VSS cml_tlatch
Xcml_tlatch_29 VDD SA0_N SA0_P cml_mux2_3/SP cml_mux2_3/SN cml_tlatch_29/INP cml_tlatch_29/INN
+ POLN VSS cml_tlatch
Xcml_drvb_0 VDD cml_mux2_2/SP cml_mux2_1/SN cml_mux2_1/SP cml_mux2_2/SN VSS cml_drvb
Xcml_tlatch_2 VDD cml_gate2_0/AN cml_gate2_0/AP interco_h_0/INBP interco_h_0/INBN
+ cml_tlatch_2/INP cml_tlatch_2/INN POLN VSS cml_tlatch
.ends
